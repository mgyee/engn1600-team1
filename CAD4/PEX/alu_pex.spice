* NGSPICE file created from alu_flat.ext - technology: gf180mcuD

.subckt alu_flat CIN SEL1 SEL0 VDD Z VSS B0 B1 B2 B3 B4 B5 B6 B7 B8 B9 B10 B11 B12
+ B13 B14 B15 F N Y15 Y14 Y13 Y12 Y11 Y10 Y9 Y8 Y7 Y6 Y5 Y4 Y3 Y2 Y1 Y0 A0 A1 A2 A3
+ A4 A5 A6 A7 A8 A9 A10 A11 A12 A13 A14 A15
X0 a_64708_18391# A8.t0 a_62832_17312# VSS.t542 nfet_03v3 ad=0.1872p pd=1.24u as=0.3276p ps=2.35u w=0.72u l=0.28u
X1 a_75207_16571# a_72671_16853.t4 a_75051_16571# VSS nfet_03v3 ad=0.1332p pd=1.1u as=0.18p ps=1.72u w=0.36u l=0.28u
X2 VDD A2.t0 a_48995_19664# VDD pfet_03v3 ad=0.1872p pd=1.24u as=0.3168p ps=2.32u w=0.72u l=0.28u
X3 a_57315_19664# a_55723_19848# VDD VDD pfet_03v3 ad=0.3168p pd=2.32u as=0.1872p ps=1.24u w=0.72u l=0.28u
X4 a_71075_16575# a_41692_17389.t3 a_70263_16571# VSS nfet_03v3 ad=0.2034p pd=1.85u as=0.2016p ps=1.84u w=0.36u l=0.28u
X5 VSS.t597 a_69675_19664# a_70619_20124# VSS.t596 nfet_03v3 ad=0.1584p pd=1.6u as=93.59999f ps=0.88u w=0.36u l=0.28u
X6 a_48003_19664# a_47947_19620.t4 VDD VDD pfet_03v3 ad=86.39999f pd=0.96u as=0.3168p ps=2.32u w=0.72u l=0.28u
X7 a_69395_19216# A10.t0 a_68083_19104# VDD pfet_03v3 ad=0.1152p pd=1.04u as=0.1872p ps=1.24u w=0.72u l=0.28u
X8 a_53955_20792# B4.t0 VSS.t730 VSS.t729 nfet_03v3 ad=0.1872p pd=1.24u as=0.3168p ps=2.32u w=0.72u l=0.28u
X9 VSS.t19 B5.t0 a_57051_20452# VSS.t18 nfet_03v3 ad=0.3168p pd=2.32u as=0.1872p ps=1.24u w=0.72u l=0.28u
X10 a_68083_19848# a_67203_19664# a_68771_20124# VSS.t99 nfet_03v3 ad=93.59999f pd=0.88u as=93.59999f ps=0.88u w=0.36u l=0.28u
X11 VDD A9.t0 a_66299_19664# VDD pfet_03v3 ad=0.1872p pd=1.24u as=0.3168p ps=2.32u w=0.72u l=0.28u
X12 VDD a_70458_18464.t2 a_64632_14904.t1 VDD pfet_03v3 ad=5.5008p pd=16.72u as=3.5586p ps=10.605u w=0.72u l=0.28u
X13 a_75195_18828# a_75139_18700.t4 VSS.t687 VSS.t686 nfet_03v3 ad=43.2f pd=0.6u as=0.1584p ps=1.6u w=0.36u l=0.28u
X14 a_65610_17312# a_65963_16575# VDD.t249 VDD.t248 pfet_03v3 ad=0.1872p pd=1.24u as=0.3276p ps=2.35u w=0.72u l=0.28u
X15 a_71259_20792# B11.t0 VSS.t122 VSS.t121 nfet_03v3 ad=0.1872p pd=1.24u as=0.3168p ps=2.32u w=0.72u l=0.28u
X16 VSS.t148 B12.t0 a_74355_20452# VSS.t147 nfet_03v3 ad=0.3168p pd=2.32u as=0.1872p ps=1.24u w=0.72u l=0.28u
X17 a_69675_19664# a_68083_19848# VSS.t751 VSS.t750 nfet_03v3 ad=0.1584p pd=1.6u as=93.59999f ps=0.88u w=0.36u l=0.28u
X18 a_78659_19216# a_77611_18700.t4 VDD VDD pfet_03v3 ad=0.1872p pd=1.24u as=0.1872p ps=1.24u w=0.72u l=0.28u
X19 a_67987_18828# a_62791_16527.t2 a_67791_16571# VDD.t188 pfet_03v3 ad=0.4446p pd=3.19u as=0.1332p ps=1.1u w=0.36u l=0.28u
X20 a_48827_16575# a_41692_17389.t4 a_48211_19664# VSS nfet_03v3 ad=0.2034p pd=1.85u as=0.2016p ps=1.84u w=0.36u l=0.28u
X21 VSS.t235 a_80083_18700.t4 a_80507_20124# VSS.t234 nfet_03v3 ad=93.59999f pd=0.88u as=93.59999f ps=0.88u w=0.36u l=0.28u
X22 VDD a_79563_19664# a_80507_19664# VDD pfet_03v3 ad=0.3168p pd=2.32u as=0.1872p ps=1.24u w=0.72u l=0.28u
X23 a_65251_18700.t3 a_66315_20792# VSS.t635 VSS.t634 nfet_03v3 ad=0.1872p pd=1.24u as=0.1872p ps=1.24u w=0.72u l=0.28u
X24 VSS.t717 A14.t0 a_78659_20124# VSS.t716 nfet_03v3 ad=93.59999f pd=0.88u as=0.1584p ps=1.6u w=0.36u l=0.28u
X25 VDD a_45475_19620.t4 a_45899_19664# VDD pfet_03v3 ad=0.1872p pd=1.24u as=0.1872p ps=1.24u w=0.72u l=0.28u
X26 a_66923_18828# A9.t1 a_65611_19104# VSS.t10 nfet_03v3 ad=57.59999f pd=0.68u as=93.59999f ps=0.88u w=0.36u l=0.28u
X27 a_73285_18758# a_72147_19664# VSS.t91 VSS.t90 nfet_03v3 ad=0.198p pd=1.78u as=0.117p ps=0.97u w=0.45u l=0.28u
X28 a_66779_20792# B9.t0 a_65251_18700.t0 VDD pfet_03v3 ad=0.6336p pd=3.76u as=0.3744p ps=1.96u w=1.44u l=0.28u
X29 VSS.t646 a_45475_19620.t5 a_46132_17315# VSS.t645 nfet_03v3 ad=0.162p pd=1.62u as=93.59999f ps=0.88u w=0.36u l=0.28u
X30 a_66131_16575# a_41692_17389.t5 a_65319_16571# VSS nfet_03v3 ad=0.2034p pd=1.85u as=0.2016p ps=1.84u w=0.36u l=0.28u
X31 VDD.t457 a_54009_17863# a_52951_17316# VDD.t456 pfet_03v3 ad=0.324p pd=2.34u as=0.1872p ps=1.24u w=0.72u l=0.28u
X32 a_80139_19664# a_80083_18700.t5 VDD VDD pfet_03v3 ad=86.39999f pd=0.96u as=0.3168p ps=2.32u w=0.72u l=0.28u
X33 a_81291_20792# B15.t0 a_81147_20792# VDD pfet_03v3 ad=0.3744p pd=1.96u as=0.6336p ps=3.76u w=1.44u l=0.28u
X34 a_70555_19104# a_69675_18828# a_71243_19216# VDD pfet_03v3 ad=0.1872p pd=1.24u as=0.1872p ps=1.24u w=0.72u l=0.28u
X35 a_82973_18758# a_72671_16853.t5 a_82467_18780# VSS.t812 nfet_03v3 ad=0.243p pd=1.395u as=0.1918p ps=1.325u w=0.675u l=0.28u
X36 a_76667_20792# a_76203_20792# VDD VDD pfet_03v3 ad=0.3744p pd=1.96u as=0.3744p ps=1.96u w=1.44u l=0.28u
X37 a_71243_20124# a_70195_18700.t4 VSS.t381 VSS.t380 nfet_03v3 ad=93.59999f pd=0.88u as=93.59999f ps=0.88u w=0.36u l=0.28u
X38 VDD a_67723_18700.t4 a_68147_19216# VDD pfet_03v3 ad=0.1872p pd=1.24u as=0.1872p ps=1.24u w=0.72u l=0.28u
X39 a_68147_20124# a_68083_19848# a_67635_16571# VSS.t749 nfet_03v3 ad=93.59999f pd=0.88u as=93.59999f ps=0.88u w=0.36u l=0.28u
X40 VSS.t383 a_70195_18700.t5 a_71867_20124# VSS.t382 nfet_03v3 ad=93.59999f pd=0.88u as=57.59999f ps=0.68u w=0.36u l=0.28u
X41 a_51893_18395# a_51131_16575# a_50778_17315# VSS.t944 nfet_03v3 ad=0.1872p pd=1.24u as=0.3276p ps=2.35u w=0.72u l=0.28u
X42 VDD.t288 a_77970_17311# a_77873_18463.t0 VDD.t287 pfet_03v3 ad=0.324p pd=2.34u as=0.3312p ps=2.36u w=0.72u l=0.28u
X43 VDD.t166 a_60964_17311# a_60871_17378# VDD.t165 pfet_03v3 ad=0.3204p pd=2.33u as=0.3348p ps=2.37u w=0.72u l=0.28u
X44 VDD.t780 a_50419_19620.t4 a_51131_16575# VDD.t779 pfet_03v3 ad=0.324p pd=2.34u as=0.1872p ps=1.24u w=0.72u l=0.28u
X45 a_55717_17311# a_56075_16575# VDD.t534 VDD.t533 pfet_03v3 ad=0.1872p pd=1.24u as=0.3276p ps=2.35u w=0.72u l=0.28u
X46 a_75195_19664# a_75139_18700.t5 VDD VDD pfet_03v3 ad=86.39999f pd=0.96u as=0.3168p ps=2.32u w=0.72u l=0.28u
X47 a_43163_20124# A0.t0 a_43059_20124# VSS.t450 nfet_03v3 ad=43.2f pd=0.6u as=43.2f ps=0.6u w=0.36u l=0.28u
X48 a_48995_20124# a_47947_19620.t5 VSS.t879 VSS.t878 nfet_03v3 ad=93.59999f pd=0.88u as=93.59999f ps=0.88u w=0.36u l=0.28u
X49 a_49619_19664# A2.t1 a_48307_19848# VDD pfet_03v3 ad=0.1152p pd=1.04u as=0.1872p ps=1.24u w=0.72u l=0.28u
X50 a_65611_19104# a_62735_18464# a_66299_19216# VDD pfet_03v3 ad=0.1872p pd=1.24u as=0.1872p ps=1.24u w=0.72u l=0.28u
X51 a_41692_17389.t0 SEL0.t4 a_40610_17389.t1 VDD.t468 pfet_03v3 ad=0.6264p pd=4.2u as=0.162p ps=1.62u w=0.36u l=0.28u
X52 VDD.t199 a_80083_18700.t6 a_80795_16575# VDD.t198 pfet_03v3 ad=0.324p pd=2.34u as=0.1872p ps=1.24u w=0.72u l=0.28u
X53 VSS.t205 a_77611_18700.t5 a_79539_18391# VSS.t204 nfet_03v3 ad=0.324p pd=2.34u as=0.1872p ps=1.24u w=0.72u l=0.28u
X54 VSS.t95 a_53163_16571# a_52803_16571.t1 VSS.t94 nfet_03v3 ad=0.171p pd=1.67u as=0.1746p ps=1.69u w=0.36u l=0.28u
X55 a_58715_16575# a_41233_17389.t3 a_58547_16575# VSS nfet_03v3 ad=0.2232p pd=1.96u as=0.2016p ps=1.84u w=0.36u l=0.28u
X56 a_70555_17312# a_70907_16575# VDD.t733 VDD.t732 pfet_03v3 ad=0.1872p pd=1.24u as=0.3276p ps=2.35u w=0.72u l=0.28u
X57 a_54579_20452# CIN.t0 a_54009_17863# VSS.t652 nfet_03v3 ad=0.1872p pd=1.24u as=0.1872p ps=1.24u w=0.72u l=0.28u
X58 a_66299_20124# a_65251_18700.t4 VSS.t666 VSS.t665 nfet_03v3 ad=93.59999f pd=0.88u as=93.59999f ps=0.88u w=0.36u l=0.28u
X59 a_66923_19664# A9.t2 a_65611_19848# VDD pfet_03v3 ad=0.1152p pd=1.04u as=0.1872p ps=1.24u w=0.72u l=0.28u
X60 VDD a_57835_18700.t4 a_59507_19216# VDD pfet_03v3 ad=0.1872p pd=1.24u as=0.1152p ps=1.04u w=0.72u l=0.28u
X61 a_71883_20452# CIN.t1 a_70195_18700.t3 VSS.t673 nfet_03v3 ad=0.1872p pd=1.24u as=0.1872p ps=1.24u w=0.72u l=0.28u
X62 a_50843_19664# A3.t0 VDD VDD pfet_03v3 ad=0.1872p pd=1.24u as=0.1872p ps=1.24u w=0.72u l=0.28u
X63 a_70355_19216# A11.t0 a_70251_19216# VDD pfet_03v3 ad=86.39999f pd=0.96u as=86.39999f ps=0.96u w=0.72u l=0.28u
X64 VDD a_72147_18828# a_72579_19228# VDD pfet_03v3 ad=0.234p pd=1.42u as=0.468p ps=2.84u w=0.9u l=0.28u
X65 VDD a_75139_18700.t6 a_76811_19216# VDD pfet_03v3 ad=0.1872p pd=1.24u as=0.1152p ps=1.04u w=0.72u l=0.28u
X66 VDD.t540 a_45475_19620.t6 a_46187_16575# VDD.t539 pfet_03v3 ad=0.324p pd=2.34u as=0.1872p ps=1.24u w=0.72u l=0.28u
X67 a_65515_18828# a_62735_18464# a_65411_18828# VSS.t863 nfet_03v3 ad=93.59999f pd=0.88u as=43.2f ps=0.6u w=0.36u l=0.28u
X68 a_43660_17315# A0.t1 VSS.t452 VSS.t451 nfet_03v3 ad=93.59999f pd=0.88u as=0.1638p ps=1.63u w=0.36u l=0.28u
X69 a_46355_16575# a_42244_17389.t3 a_46132_17315# VSS nfet_03v3 ad=0.2232p pd=1.96u as=0.2016p ps=1.84u w=0.36u l=0.28u
X70 a_63890_17859# CIN.t2 a_64307_20792# VDD pfet_03v3 ad=0.3744p pd=1.96u as=0.3744p ps=1.96u w=1.44u l=0.28u
X71 a_55787_19216# A5.t0 VDD VDD pfet_03v3 ad=0.1872p pd=1.24u as=0.1872p ps=1.24u w=0.72u l=0.28u
X72 a_73325_17311# A12.t0 VSS.t417 VSS.t416 nfet_03v3 ad=93.59999f pd=0.88u as=0.1638p ps=1.63u w=0.36u l=0.28u
X73 a_73285_19138# a_62783_16853.t4 a_72671_16853.t3 VDD pfet_03v3 ad=0.558p pd=2.43u as=0.486p ps=2.07u w=1.35u l=0.28u
X74 a_63659_16575# a_42244_17389.t4 a_63437_17311# VSS nfet_03v3 ad=0.2232p pd=1.96u as=0.2016p ps=1.84u w=0.36u l=0.28u
X75 a_80083_18700.t1 CIN.t3 a_81611_20792# VDD pfet_03v3 ad=0.3744p pd=1.96u as=0.3744p ps=1.96u w=1.44u l=0.28u
X76 a_62832_17312# A8.t1 VDD.t464 VDD.t463 pfet_03v3 ad=0.1872p pd=1.24u as=0.4284p ps=1.91u w=0.72u l=0.28u
X77 VDD.t124 a_72939_16571# a_72579_16571.t0 VDD.t123 pfet_03v3 ad=0.324p pd=2.34u as=0.3312p ps=2.36u w=0.72u l=0.28u
X78 VSS.t166 a_68083_17312# a_67986_18464.t1 VSS.t165 nfet_03v3 ad=0.171p pd=1.67u as=0.1746p ps=1.69u w=0.36u l=0.28u
X79 VSS.t98 a_67203_19664# a_68147_20124# VSS.t97 nfet_03v3 ad=0.1584p pd=1.6u as=93.59999f ps=0.88u w=0.36u l=0.28u
X80 a_53163_16571# a_52895_16853.t2 a_52959_16571# VSS nfet_03v3 ad=0.4446p pd=3.19u as=0.1332p ps=1.1u w=0.36u l=0.28u
X81 VDD A3.t1 a_51467_19664# VDD pfet_03v3 ad=0.1872p pd=1.24u as=0.3168p ps=2.32u w=0.72u l=0.28u
X82 a_60363_18828# a_60307_18700.t4 VSS.t321 VSS.t320 nfet_03v3 ad=43.2f pd=0.6u as=0.1584p ps=1.6u w=0.36u l=0.28u
X83 VSS.t931 a_43003_19620.t4 a_44931_18395# VSS.t930 nfet_03v3 ad=0.324p pd=2.34u as=0.1872p ps=1.24u w=0.72u l=0.28u
X84 a_70619_18828# A11.t1 VSS.t895 VSS.t894 nfet_03v3 ad=93.59999f pd=0.88u as=93.59999f ps=0.88u w=0.36u l=0.28u
X85 a_68787_20792# B10.t0 VSS.t511 VSS.t510 nfet_03v3 ad=0.1872p pd=1.24u as=0.3168p ps=2.32u w=0.72u l=0.28u
X86 VSS.t5 A1.t0 a_46523_20124# VSS.t4 nfet_03v3 ad=93.59999f pd=0.88u as=0.1584p ps=1.6u w=0.36u l=0.28u
X87 a_45835_19848# a_44955_19664# a_46523_19664# VDD pfet_03v3 ad=0.1872p pd=1.24u as=0.1872p ps=1.24u w=0.72u l=0.28u
X88 a_48211_19664# a_47427_19664# a_48107_19664# VDD pfet_03v3 ad=0.1872p pd=1.24u as=86.39999f ps=0.96u w=0.72u l=0.28u
X89 a_69251_20792# a_68787_20792# VDD VDD pfet_03v3 ad=0.3744p pd=1.96u as=0.3744p ps=1.96u w=1.44u l=0.28u
X90 a_65163_16571# a_63344_17378# a_65411_19664# VDD pfet_03v3 ad=0.1872p pd=1.24u as=86.39999f ps=0.96u w=0.72u l=0.28u
X91 a_51299_16575# a_41692_17389.t6 a_50683_19664# VSS nfet_03v3 ad=0.2034p pd=1.85u as=0.2016p ps=1.84u w=0.36u l=0.28u
X92 a_65908_17312# A9.t3 VSS.t12 VSS.t11 nfet_03v3 ad=93.59999f pd=0.88u as=0.1638p ps=1.63u w=0.36u l=0.28u
X93 a_51947_20792# B3.t0 a_50419_19620.t3 VDD pfet_03v3 ad=0.6336p pd=3.76u as=0.3744p ps=1.96u w=1.44u l=0.28u
X94 a_82035_18828# a_80443_19104# VDD VDD pfet_03v3 ad=0.3168p pd=2.32u as=0.1872p ps=1.24u w=0.72u l=0.28u
X95 a_78819_20792# B14.t0 a_78675_20792# VDD pfet_03v3 ad=0.3744p pd=1.96u as=0.6336p ps=3.76u w=1.44u l=0.28u
X96 VDD a_59787_18828# a_60731_19216# VDD pfet_03v3 ad=0.3168p pd=2.32u as=0.1872p ps=1.24u w=0.72u l=0.28u
X97 VDD.t597 a_45475_19620.t7 a_46489_17382# VDD.t596 pfet_03v3 ad=0.648p pd=3.78u as=0.3744p ps=1.96u w=1.44u l=0.28u
X98 a_77523_16571# a_77091_19664# a_77771_20124# VSS.t868 nfet_03v3 ad=93.59999f pd=0.88u as=43.2f ps=0.6u w=0.36u l=0.28u
X99 a_65675_18828# A9.t4 VSS.t14 VSS.t13 nfet_03v3 ad=93.59999f pd=0.88u as=93.59999f ps=0.88u w=0.36u l=0.28u
X100 a_53771_16575# a_40765_17389.t3 a_53163_16571# VSS nfet_03v3 ad=0.2232p pd=1.96u as=0.2016p ps=1.84u w=0.36u l=0.28u
X101 a_81557_18391# a_80795_16575# a_80442_17311# VSS.t318 nfet_03v3 ad=0.1872p pd=1.24u as=0.3276p ps=2.35u w=0.72u l=0.28u
X102 a_43059_19664# a_43003_19620.t5 VDD VDD pfet_03v3 ad=86.39999f pd=0.96u as=0.3168p ps=2.32u w=0.72u l=0.28u
X103 a_71075_16575# a_40765_17389.t4 a_70555_17312# VSS nfet_03v3 ad=0.2232p pd=1.96u as=0.2016p ps=1.84u w=0.36u l=0.28u
X104 VDD a_70195_18700.t6 a_70619_19216# VDD pfet_03v3 ad=0.1872p pd=1.24u as=0.1872p ps=1.24u w=0.72u l=0.28u
X105 a_45635_19664# A1.t1 a_45531_19664# VDD pfet_03v3 ad=86.39999f pd=0.96u as=86.39999f ps=0.96u w=0.72u l=0.28u
X106 a_60363_19664# a_60307_18700.t5 VDD VDD pfet_03v3 ad=86.39999f pd=0.96u as=0.3168p ps=2.32u w=0.72u l=0.28u
X107 VDD A10.t1 a_68771_19216# VDD pfet_03v3 ad=0.1872p pd=1.24u as=0.3168p ps=2.32u w=0.72u l=0.28u
X108 a_70619_20124# a_70555_19848# a_70107_16571# VSS.t307 nfet_03v3 ad=93.59999f pd=0.88u as=93.59999f ps=0.88u w=0.36u l=0.28u
X109 a_70619_19664# A11.t2 VDD VDD pfet_03v3 ad=0.1872p pd=1.24u as=0.1872p ps=1.24u w=0.72u l=0.28u
X110 VSS.t80 a_82035_18828# a_82467_18780# VSS.t79 nfet_03v3 ad=0.117p pd=0.97u as=0.234p ps=1.94u w=0.45u l=0.28u
X111 VDD.t162 a_77611_18700.t6 a_78323_16575# VDD.t161 pfet_03v3 ad=0.324p pd=2.34u as=0.1872p ps=1.24u w=0.72u l=0.28u
X112 VSS.t675 CIN.t4 a_56427_20792# VSS.t674 nfet_03v3 ad=0.1872p pd=1.24u as=0.1872p ps=1.24u w=0.72u l=0.28u
X113 a_56015_17311# A5.t1 VSS.t66 VSS.t65 nfet_03v3 ad=93.59999f pd=0.88u as=0.1638p ps=1.63u w=0.36u l=0.28u
X114 VSS.t207 a_77611_18700.t7 a_79283_18828# VSS.t206 nfet_03v3 ad=93.59999f pd=0.88u as=57.59999f ps=0.68u w=0.36u l=0.28u
X115 a_48827_16575# a_40765_17389.t5 a_48306_17315# VSS nfet_03v3 ad=0.2232p pd=1.96u as=0.2016p ps=1.84u w=0.36u l=0.28u
X116 a_43883_16575# a_41233_17389.t4 a_43715_16575# VSS nfet_03v3 ad=0.2232p pd=1.96u as=0.2016p ps=1.84u w=0.36u l=0.28u
X117 VSS.t677 CIN.t5 a_73731_20792# VSS.t676 nfet_03v3 ad=0.1872p pd=1.24u as=0.1872p ps=1.24u w=0.72u l=0.28u
X118 a_51467_20124# a_50419_19620.t5 VSS.t935 VSS.t934 nfet_03v3 ad=93.59999f pd=0.88u as=93.59999f ps=0.88u w=0.36u l=0.28u
X119 a_57995_20124# A6.t0 a_57891_20124# VSS.t515 nfet_03v3 ad=43.2f pd=0.6u as=43.2f ps=0.6u w=0.36u l=0.28u
X120 a_65307_19216# a_65251_18700.t5 VDD VDD pfet_03v3 ad=86.39999f pd=0.96u as=0.3168p ps=2.32u w=0.72u l=0.28u
X121 a_73778_17859# CIN.t6 a_74195_20792# VDD pfet_03v3 ad=0.3744p pd=1.96u as=0.3744p ps=1.96u w=1.44u l=0.28u
X122 a_72124_18392# A11.t3 a_70907_16575# VSS.t896 nfet_03v3 ad=0.1872p pd=1.24u as=0.3276p ps=2.35u w=0.72u l=0.28u
X123 a_48371_20124# a_48307_19848# a_48211_19664# VSS.t218 nfet_03v3 ad=93.59999f pd=0.88u as=93.59999f ps=0.88u w=0.36u l=0.28u
X124 a_48371_19664# A2.t2 VDD VDD pfet_03v3 ad=0.1872p pd=1.24u as=0.1872p ps=1.24u w=0.72u l=0.28u
X125 VDD a_79563_18828# a_83173_19616# VDD pfet_03v3 ad=0.234p pd=1.42u as=0.558p ps=2.43u w=0.9u l=0.28u
X126 VDD.t75 a_53163_16571# a_52803_16571.t0 VDD.t74 pfet_03v3 ad=0.324p pd=2.34u as=0.3312p ps=2.36u w=0.72u l=0.28u
X127 a_74520_16039# a_72579_16571.t4 VSS VSS nfet_03v3 ad=7.1172p pd=11.325u as=12.7512p ps=20.59u w=1.44u l=0.28u
X128 VDD CIN.t7 a_66459_20792# VDD pfet_03v3 ad=0.3744p pd=1.96u as=0.3744p ps=1.96u w=1.44u l=0.28u
X129 a_65675_20124# a_65611_19848# a_65163_16571# VSS.t527 nfet_03v3 ad=93.59999f pd=0.88u as=93.59999f ps=0.88u w=0.36u l=0.28u
X130 a_65675_19664# A9.t5 VDD VDD pfet_03v3 ad=0.1872p pd=1.24u as=0.1872p ps=1.24u w=0.72u l=0.28u
X131 a_77771_18828# A14.t1 a_77667_18828# VSS.t718 nfet_03v3 ad=43.2f pd=0.6u as=43.2f ps=0.6u w=0.36u l=0.28u
X132 a_72147_18828# a_70555_19104# VSS.t440 VSS.t439 nfet_03v3 ad=0.1584p pd=1.6u as=93.59999f ps=0.88u w=0.36u l=0.28u
X133 a_72939_16571# a_72671_16853.t6 a_72735_16571# VSS nfet_03v3 ad=0.4446p pd=3.19u as=0.1332p ps=1.1u w=0.36u l=0.28u
X134 a_73285_19138# a_72147_19664# VDD VDD pfet_03v3 ad=0.396p pd=2.68u as=0.234p ps=1.42u w=0.9u l=0.28u
X135 a_44017_17382# A0.t2 a_43660_17315# VDD.t387 pfet_03v3 ad=0.3744p pd=1.96u as=0.6408p ps=3.77u w=1.44u l=0.28u
X136 a_46889_16039# a_45737_18467.t2 a_44856_16039# VSS nfet_03v3 ad=7.1172p pd=11.325u as=7.1172p ps=11.325u w=1.44u l=0.28u
X137 a_56411_19216# a_55363_18700.t4 VDD VDD pfet_03v3 ad=0.1872p pd=1.24u as=0.1872p ps=1.24u w=0.72u l=0.28u
X138 a_43003_19620.t0 a_44067_20792# VSS.t203 VSS.t202 nfet_03v3 ad=0.1872p pd=1.24u as=0.1872p ps=1.24u w=0.72u l=0.28u
X139 VSS.t68 A5.t2 a_56411_20124# VSS.t67 nfet_03v3 ad=93.59999f pd=0.88u as=0.1584p ps=1.6u w=0.36u l=0.28u
X140 VDD.t156 a_48511_17382# a_48306_17315# VDD.t155 pfet_03v3 ad=0.4284p pd=1.91u as=0.1872p ps=1.24u w=0.72u l=0.28u
X141 a_67203_18828# a_65611_19104# VSS.t133 VSS.t132 nfet_03v3 ad=0.1584p pd=1.6u as=93.59999f ps=0.88u w=0.36u l=0.28u
X142 a_54744_14904.t1 a_58097_18463.t2 VDD VDD pfet_03v3 ad=3.5586p pd=10.605u as=3.5586p ps=10.605u w=0.72u l=0.28u
X143 a_43883_16575# a_41692_17389.t7 a_43267_19664# VSS nfet_03v3 ad=0.2034p pd=1.85u as=0.2016p ps=1.84u w=0.36u l=0.28u
X144 VSS.t282 a_72720_17312# a_72623_18464# VSS.t281 nfet_03v3 ad=0.171p pd=1.67u as=0.1746p ps=1.69u w=0.36u l=0.28u
X145 a_60307_18700.t0 a_61371_20792# VSS.t195 VSS.t194 nfet_03v3 ad=0.1872p pd=1.24u as=0.1872p ps=1.24u w=0.72u l=0.28u
X146 VDD a_77611_18700.t8 a_79283_19664# VDD pfet_03v3 ad=0.1872p pd=1.24u as=0.1152p ps=1.04u w=0.72u l=0.28u
X147 a_57891_18828# a_57835_18700.t5 VSS.t479 VSS.t478 nfet_03v3 ad=43.2f pd=0.6u as=0.1584p ps=1.6u w=0.36u l=0.28u
X148 VSS.t3 a_70555_17312# a_70458_18464.t1 VSS.t2 nfet_03v3 ad=0.171p pd=1.67u as=0.1746p ps=1.69u w=0.36u l=0.28u
X149 a_61835_20792# B7.t0 a_60307_18700.t1 VDD pfet_03v3 ad=0.6336p pd=3.76u as=0.3744p ps=1.96u w=1.44u l=0.28u
X150 a_79299_20452# CIN.t8 a_77611_18700.t3 VSS.t719 nfet_03v3 ad=0.1872p pd=1.24u as=0.1872p ps=1.24u w=0.72u l=0.28u
X151 a_67987_18828# a_62783_16853.t5 a_67791_16571# VSS nfet_03v3 ad=0.4446p pd=3.19u as=0.1332p ps=1.1u w=0.36u l=0.28u
X152 a_71075_16575# a_41233_17389.t5 a_70907_16575# VSS nfet_03v3 ad=0.2232p pd=1.96u as=0.2016p ps=1.84u w=0.36u l=0.28u
X153 VSS.t271 A13.t0 a_76187_18828# VSS.t270 nfet_03v3 ad=93.59999f pd=0.88u as=0.1584p ps=1.6u w=0.36u l=0.28u
X154 a_54419_20792# a_53955_20792# VDD VDD pfet_03v3 ad=0.3744p pd=1.96u as=0.3744p ps=1.96u w=1.44u l=0.28u
X155 a_70251_20124# a_70195_18700.t7 VSS.t385 VSS.t384 nfet_03v3 ad=43.2f pd=0.6u as=0.1584p ps=1.6u w=0.36u l=0.28u
X156 a_50683_19664# a_49899_19664# a_50579_19664# VDD pfet_03v3 ad=0.1872p pd=1.24u as=86.39999f ps=0.96u w=0.72u l=0.28u
X157 a_77771_19664# A14.t2 a_77667_19664# VDD pfet_03v3 ad=86.39999f pd=0.96u as=86.39999f ps=0.96u w=0.72u l=0.28u
X158 a_71723_20792# a_71259_20792# VDD VDD pfet_03v3 ad=0.3744p pd=1.96u as=0.3744p ps=1.96u w=1.44u l=0.28u
X159 a_72147_19664# a_70555_19848# VDD VDD pfet_03v3 ad=0.3168p pd=2.32u as=0.1872p ps=1.24u w=0.72u l=0.28u
X160 VDD.t105 a_63890_17859# a_63794_17378# VDD.t104 pfet_03v3 ad=0.648p pd=3.78u as=0.3744p ps=1.96u w=1.44u l=0.28u
X161 a_63987_20792# B8.t0 a_63843_20792# VDD pfet_03v3 ad=0.3744p pd=1.96u as=0.6336p ps=3.76u w=1.44u l=0.28u
X162 a_55627_18828# a_52854_18468# a_55523_19216# VDD pfet_03v3 ad=0.1872p pd=1.24u as=86.39999f ps=0.96u w=0.72u l=0.28u
X163 VDD a_57315_18828# a_58259_19216# VDD pfet_03v3 ad=0.3168p pd=2.32u as=0.1872p ps=1.24u w=0.72u l=0.28u
X164 VSS.t48 a_46039_17382# a_46949_18395# VSS.t47 nfet_03v3 ad=0.324p pd=2.34u as=0.1872p ps=1.24u w=0.72u l=0.28u
X165 a_80151_16571# a_72679_16527.t2 a_79995_16571# VDD.t514 pfet_03v3 ad=0.1332p pd=1.1u as=0.18p ps=1.72u w=0.36u l=0.28u
X166 a_80442_17311# a_80795_16575# VDD.t273 VDD.t272 pfet_03v3 ad=0.1872p pd=1.24u as=0.3276p ps=2.35u w=0.72u l=0.28u
X167 a_74596_18391# A12.t1 a_72720_17312# VSS.t418 nfet_03v3 ad=0.1872p pd=1.24u as=0.3276p ps=2.35u w=0.72u l=0.28u
X168 VDD.t17 a_60307_18700.t6 a_61321_17378# VDD.t16 pfet_03v3 ad=0.648p pd=3.78u as=0.3744p ps=1.96u w=1.44u l=0.28u
X169 a_49475_20792# a_49011_20792# VDD VDD pfet_03v3 ad=0.3744p pd=1.96u as=0.3744p ps=1.96u w=1.44u l=0.28u
X170 a_44051_20124# a_43003_19620.t6 VSS.t933 VSS.t932 nfet_03v3 ad=93.59999f pd=0.88u as=93.59999f ps=0.88u w=0.36u l=0.28u
X171 VDD a_73232_17378# a_75563_19216# VDD pfet_03v3 ad=0.3168p pd=2.32u as=0.1872p ps=1.24u w=0.72u l=0.28u
X172 VSS.t529 a_46132_17315# a_46039_17382# VSS.t528 nfet_03v3 ad=0.1638p pd=1.63u as=0.1638p ps=1.63u w=0.36u l=0.28u
X173 a_68603_16575# a_40765_17389.t6 a_68083_17312# VSS nfet_03v3 ad=0.2232p pd=1.96u as=0.2016p ps=1.84u w=0.36u l=0.28u
X174 VDD.t430 a_75500_17311# a_75403_18463.t0 VDD.t429 pfet_03v3 ad=0.324p pd=2.34u as=0.3312p ps=2.36u w=0.72u l=0.28u
X175 VSS.t359 a_43003_19620.t7 a_44675_20124# VSS.t358 nfet_03v3 ad=93.59999f pd=0.88u as=57.59999f ps=0.68u w=0.36u l=0.28u
X176 a_57891_19664# a_57835_18700.t6 VDD VDD pfet_03v3 ad=86.39999f pd=0.96u as=0.3168p ps=2.32u w=0.72u l=0.28u
X177 a_67203_19664# a_65611_19848# VDD VDD pfet_03v3 ad=0.3168p pd=2.32u as=0.1872p ps=1.24u w=0.72u l=0.28u
X178 a_79283_19216# A14.t3 a_77971_19104# VDD pfet_03v3 ad=0.1152p pd=1.04u as=0.1872p ps=1.24u w=0.72u l=0.28u
X179 VSS.t365 B9.t1 a_66939_20452# VSS.t364 nfet_03v3 ad=0.3168p pd=2.32u as=0.1872p ps=1.24u w=0.72u l=0.28u
X180 a_57035_20124# A5.t3 a_55723_19848# VSS.t69 nfet_03v3 ad=57.59999f pd=0.68u as=93.59999f ps=0.88u w=0.36u l=0.28u
X181 a_77971_19848# a_77091_19664# a_78659_20124# VSS.t867 nfet_03v3 ad=93.59999f pd=0.88u as=93.59999f ps=0.88u w=0.36u l=0.28u
X182 VDD A13.t1 a_76187_19664# VDD pfet_03v3 ad=0.1872p pd=1.24u as=0.3168p ps=2.32u w=0.72u l=0.28u
X183 VDD a_80345_18463.t2 a_74520_14904.t3 VDD pfet_03v3 ad=5.5008p pd=16.72u as=3.5586p ps=10.605u w=0.72u l=0.28u
X184 a_59507_18828# A6.t1 a_58195_19104# VSS.t516 nfet_03v3 ad=57.59999f pd=0.68u as=93.59999f ps=0.88u w=0.36u l=0.28u
X185 VDD.t237 a_68381_17312# a_68288_17379# VDD.t236 pfet_03v3 ad=0.3204p pd=2.33u as=0.3348p ps=2.37u w=0.72u l=0.28u
X186 a_81147_20792# B15.t1 VSS.t459 VSS.t458 nfet_03v3 ad=0.1872p pd=1.24u as=0.3168p ps=2.32u w=0.72u l=0.28u
X187 a_79563_19664# a_77971_19848# VSS.t279 VSS.t278 nfet_03v3 ad=0.1584p pd=1.6u as=93.59999f ps=0.88u w=0.36u l=0.28u
X188 a_81131_18828# a_80083_18700.t7 VSS.t237 VSS.t236 nfet_03v3 ad=93.59999f pd=0.88u as=93.59999f ps=0.88u w=0.36u l=0.28u
X189 a_77875_18828# a_72671_16853.t7 a_77679_16571# VDD.t451 pfet_03v3 ad=0.4446p pd=3.19u as=0.1332p ps=1.1u w=0.36u l=0.28u
X190 a_58715_16575# a_41692_17389.t8 a_57903_16571# VSS nfet_03v3 ad=0.2034p pd=1.85u as=0.2016p ps=1.84u w=0.36u l=0.28u
X191 Y5.t0 a_56243_16575# VDD.t140 VDD.t139 pfet_03v3 ad=0.3312p pd=2.36u as=0.3168p ps=2.32u w=0.72u l=0.28u
X192 a_70907_16575# A11.t4 VDD.t753 VDD.t752 pfet_03v3 ad=0.1872p pd=1.24u as=0.4284p ps=1.91u w=0.72u l=0.28u
X193 a_69652_18392# A10.t2 a_68435_16575# VSS.t691 nfet_03v3 ad=0.1872p pd=1.24u as=0.3276p ps=2.35u w=0.72u l=0.28u
X194 a_75139_18700.t0 a_76203_20792# VSS.t229 VSS.t228 nfet_03v3 ad=0.1872p pd=1.24u as=0.1872p ps=1.24u w=0.72u l=0.28u
X195 VSS.t151 a_80083_18700.t8 a_81755_18828# VSS.t150 nfet_03v3 ad=93.59999f pd=0.88u as=57.59999f ps=0.68u w=0.36u l=0.28u
X196 a_76811_18828# A13.t2 a_75499_19104# VSS.t272 nfet_03v3 ad=57.59999f pd=0.68u as=93.59999f ps=0.88u w=0.36u l=0.28u
X197 a_76019_16575# a_41692_17389.t9 a_75207_16571# VSS nfet_03v3 ad=0.2034p pd=1.85u as=0.2016p ps=1.84u w=0.36u l=0.28u
X198 Y12.t0 a_73547_16575# VDD.t459 VDD.t458 pfet_03v3 ad=0.3312p pd=2.36u as=0.3168p ps=2.32u w=0.72u l=0.28u
X199 VDD CIN.t9 a_51627_20792# VDD pfet_03v3 ad=0.3744p pd=1.96u as=0.3744p ps=1.96u w=1.44u l=0.28u
X200 a_76615_18391# a_75851_16575# a_75500_17311# VSS.t502 nfet_03v3 ad=0.1872p pd=1.24u as=0.3276p ps=2.35u w=0.72u l=0.28u
X201 a_67179_18392# A9.t6 a_65963_16575# VSS.t15 nfet_03v3 ad=0.1872p pd=1.24u as=0.3276p ps=2.35u w=0.72u l=0.28u
X202 a_60731_19216# a_60667_19104# a_60571_18828# VDD pfet_03v3 ad=0.1872p pd=1.24u as=0.1872p ps=1.24u w=0.72u l=0.28u
X203 a_78268_17311# A14.t4 VSS.t700 VSS.t699 nfet_03v3 ad=93.59999f pd=0.88u as=0.1638p ps=1.63u w=0.36u l=0.28u
X204 a_44477_18395# a_43715_16575# a_43362_17315# VSS.t319 nfet_03v3 ad=0.1872p pd=1.24u as=0.3276p ps=2.35u w=0.72u l=0.28u
X205 a_73547_16575# a_41233_17389.t6 a_72720_17312# VSS nfet_03v3 ad=0.2232p pd=1.96u as=0.2016p ps=1.84u w=0.36u l=0.28u
X206 VSS.t637 a_63051_16571# a_62691_16571.t2 VSS.t636 nfet_03v3 ad=0.171p pd=1.67u as=0.1746p ps=1.69u w=0.36u l=0.28u
X207 VSS.t56 a_50778_17315# a_50681_18467.t1 VSS.t55 nfet_03v3 ad=0.171p pd=1.67u as=0.1746p ps=1.69u w=0.36u l=0.28u
X208 VSS.t464 a_55363_18700.t5 a_55787_20124# VSS.t463 nfet_03v3 ad=93.59999f pd=0.88u as=93.59999f ps=0.88u w=0.36u l=0.28u
X209 VDD a_45475_19620.t8 a_47147_19664# VDD pfet_03v3 ad=0.1872p pd=1.24u as=0.1152p ps=1.04u w=0.72u l=0.28u
X210 VDD A15.t0 a_81131_19216# VDD pfet_03v3 ad=0.1872p pd=1.24u as=0.3168p ps=2.32u w=0.72u l=0.28u
X211 a_42244_17389.t1 SEL0.t5 VSS.t554 VSS.t553 nfet_03v3 ad=0.1818p pd=1.37u as=0.162p ps=1.62u w=0.36u l=0.28u
X212 a_58883_20124# a_57835_18700.t7 VSS.t951 VSS.t950 nfet_03v3 ad=93.59999f pd=0.88u as=93.59999f ps=0.88u w=0.36u l=0.28u
X213 a_59507_19664# A6.t2 a_58195_19848# VDD pfet_03v3 ad=0.1152p pd=1.04u as=0.1872p ps=1.24u w=0.72u l=0.28u
X214 a_80347_18828# a_79563_18828# a_80243_18828# VSS.t302 nfet_03v3 ad=93.59999f pd=0.88u as=43.2f ps=0.6u w=0.36u l=0.28u
X215 a_81131_19664# a_80083_18700.t9 VDD VDD pfet_03v3 ad=0.1872p pd=1.24u as=0.1872p ps=1.24u w=0.72u l=0.28u
X216 a_64467_20452# CIN.t10 a_63890_17859# VSS.t720 nfet_03v3 ad=0.1872p pd=1.24u as=0.1872p ps=1.24u w=0.72u l=0.28u
X217 VSS.t795 A7.t0 a_61355_18828# VSS.t794 nfet_03v3 ad=93.59999f pd=0.88u as=0.1584p ps=1.6u w=0.36u l=0.28u
X218 Y9.t1 a_66131_16575# VSS VSS nfet_03v3 ad=0.1656p pd=1.64u as=0.1584p ps=1.6u w=0.36u l=0.28u
X219 a_68603_16575# a_41233_17389.t7 a_68435_16575# VSS nfet_03v3 ad=0.2232p pd=1.96u as=0.2016p ps=1.84u w=0.36u l=0.28u
X220 VDD a_65513_18464.t2 a_64632_14904.t3 VDD pfet_03v3 ad=3.5586p pd=10.605u as=3.5586p ps=10.605u w=0.72u l=0.28u
X221 a_76187_20124# a_75139_18700.t7 VSS.t722 VSS.t721 nfet_03v3 ad=93.59999f pd=0.88u as=93.59999f ps=0.88u w=0.36u l=0.28u
X222 a_76811_19664# A13.t3 a_75499_19848# VDD pfet_03v3 ad=0.1152p pd=1.04u as=0.1872p ps=1.24u w=0.72u l=0.28u
X223 VDD a_80083_18700.t10 a_81755_19664# VDD pfet_03v3 ad=0.1872p pd=1.24u as=0.1152p ps=1.04u w=0.72u l=0.28u
X224 a_81771_20452# CIN.t11 a_80083_18700.t2 VSS.t780 nfet_03v3 ad=0.1872p pd=1.24u as=0.1872p ps=1.24u w=0.72u l=0.28u
X225 a_58099_18828# a_57315_18828# a_57995_18828# VSS.t112 nfet_03v3 ad=93.59999f pd=0.88u as=43.2f ps=0.6u w=0.36u l=0.28u
X226 VSS.t222 a_65610_17312# a_65513_18464.t1 VSS.t221 nfet_03v3 ad=0.171p pd=1.67u as=0.1746p ps=1.69u w=0.36u l=0.28u
X227 a_57286_18391# A5.t4 a_56075_16575# VSS.t70 nfet_03v3 ad=0.1872p pd=1.24u as=0.3276p ps=2.35u w=0.72u l=0.28u
X228 a_80243_19216# A15.t1 a_80139_19216# VDD pfet_03v3 ad=86.39999f pd=0.96u as=86.39999f ps=0.96u w=0.72u l=0.28u
X229 VDD a_82035_18828# a_82467_19228# VDD pfet_03v3 ad=0.234p pd=1.42u as=0.468p ps=2.84u w=0.9u l=0.28u
X230 a_75403_18828# a_73232_17378# a_75299_18828# VSS.t189 nfet_03v3 ad=93.59999f pd=0.88u as=43.2f ps=0.6u w=0.36u l=0.28u
X231 VSS.t350 a_77091_18828# a_78035_18828# VSS.t349 nfet_03v3 ad=0.1584p pd=1.6u as=93.59999f ps=0.88u w=0.36u l=0.28u
X232 a_56243_16575# a_42244_17389.t5 a_56015_17311# VSS nfet_03v3 ad=0.2232p pd=1.96u as=0.2016p ps=1.84u w=0.36u l=0.28u
X233 a_83173_19138# a_72671_16853.t8 a_82973_18758# VDD pfet_03v3 ad=0.558p pd=2.43u as=0.486p ps=2.07u w=1.35u l=0.28u
X234 a_73547_16575# a_42244_17389.t6 a_73325_17311# VSS nfet_03v3 ad=0.2232p pd=1.96u as=0.2016p ps=1.84u w=0.36u l=0.28u
X235 VDD.t794 a_57835_18700.t8 a_58849_17378# VDD.t793 pfet_03v3 ad=0.648p pd=3.78u as=0.3744p ps=1.96u w=1.44u l=0.28u
X236 a_43427_20124# A0.t3 VSS.t454 VSS.t453 nfet_03v3 ad=93.59999f pd=0.88u as=93.59999f ps=0.88u w=0.36u l=0.28u
X237 VSS.t466 a_55363_18700.t6 a_57035_18828# VSS.t465 nfet_03v3 ad=93.59999f pd=0.88u as=57.59999f ps=0.68u w=0.36u l=0.28u
X238 a_72720_17312# A12.t2 VDD.t365 VDD.t364 pfet_03v3 ad=0.1872p pd=1.24u as=0.4284p ps=1.91u w=0.72u l=0.28u
X239 a_50475_20124# a_50419_19620.t6 VSS.t937 VSS.t936 nfet_03v3 ad=43.2f pd=0.6u as=0.1584p ps=1.6u w=0.36u l=0.28u
X240 a_44856_14904.t3 a_50681_18467.t2 a_48922_16039# VSS nfet_03v3 ad=12.0384p pd=19.6u as=7.1172p ps=11.325u w=1.44u l=0.28u
X241 a_67723_18700.t3 a_68787_20792# VSS.t809 VSS.t808 nfet_03v3 ad=0.1872p pd=1.24u as=0.1872p ps=1.24u w=0.72u l=0.28u
X242 a_60731_20124# A7.t1 VSS.t797 VSS.t796 nfet_03v3 ad=93.59999f pd=0.88u as=93.59999f ps=0.88u w=0.36u l=0.28u
X243 a_52371_19664.t0 a_50779_19848# VDD VDD pfet_03v3 ad=0.3168p pd=2.32u as=0.1872p ps=1.24u w=0.72u l=0.28u
X244 a_79995_16571# a_79563_19664# a_80243_19664# VDD pfet_03v3 ad=0.1872p pd=1.24u as=86.39999f ps=0.96u w=0.72u l=0.28u
X245 VSS.t966 B3.t1 a_52107_20452# VSS.t965 nfet_03v3 ad=0.3168p pd=2.32u as=0.1872p ps=1.24u w=0.72u l=0.28u
X246 VDD A7.t2 a_61355_19664# VDD pfet_03v3 ad=0.1872p pd=1.24u as=0.3168p ps=2.32u w=0.72u l=0.28u
X247 a_48604_17315# A2.t3 VSS.t839 VSS.t838 nfet_03v3 ad=93.59999f pd=0.88u as=0.1638p ps=1.63u w=0.36u l=0.28u
X248 VDD.t453 a_46132_17315# a_46039_17382# VDD.t452 pfet_03v3 ad=0.3204p pd=2.33u as=0.3348p ps=2.37u w=0.72u l=0.28u
X249 a_55523_18828# A5.t5 a_55419_18828# VSS.t954 nfet_03v3 ad=43.2f pd=0.6u as=43.2f ps=0.6u w=0.36u l=0.28u
X250 a_78675_20792# B14.t1 VSS.t162 VSS.t161 nfet_03v3 ad=0.1872p pd=1.24u as=0.3168p ps=2.32u w=0.72u l=0.28u
X251 a_57747_16571# a_57315_19664# a_57995_19664# VDD pfet_03v3 ad=0.1872p pd=1.24u as=86.39999f ps=0.96u w=0.72u l=0.28u
X252 a_80507_18828# A15.t2 VSS.t849 VSS.t848 nfet_03v3 ad=93.59999f pd=0.88u as=93.59999f ps=0.88u w=0.36u l=0.28u
X253 a_60375_16571# a_52895_16853.t3 a_60219_16571# VDD.t671 pfet_03v3 ad=0.1332p pd=1.1u as=0.18p ps=1.72u w=0.36u l=0.28u
X254 VSS.t690 a_83272_18186# a_83049_17431# VSS.t689 nfet_03v3 ad=0.1872p pd=1.24u as=0.1872p ps=1.24u w=0.72u l=0.28u
X255 a_80443_19848# a_79563_19664# a_81131_20124# VSS.t610 nfet_03v3 ad=93.59999f pd=0.88u as=93.59999f ps=0.88u w=0.36u l=0.28u
X256 a_68435_16575# A10.t3 VDD.t585 VDD.t584 pfet_03v3 ad=0.1872p pd=1.24u as=0.4284p ps=1.91u w=0.72u l=0.28u
X257 a_55363_18700.t2 CIN.t12 a_56891_20792# VDD pfet_03v3 ad=0.3744p pd=1.96u as=0.3744p ps=1.96u w=1.44u l=0.28u
X258 a_79139_20792# a_78675_20792# VDD VDD pfet_03v3 ad=0.3744p pd=1.96u as=0.3744p ps=1.96u w=1.44u l=0.28u
X259 VSS.t301 a_79563_18828# a_83173_20131# VSS.t300 nfet_03v3 ad=0.117p pd=0.97u as=0.279p ps=1.755u w=0.45u l=0.28u
X260 a_61979_18828# A7.t3 a_60667_19104# VSS.t798 nfet_03v3 ad=57.59999f pd=0.68u as=93.59999f ps=0.88u w=0.36u l=0.28u
X261 VDD.t9 a_70853_17312# a_70760_17379# VDD.t8 pfet_03v3 ad=0.3204p pd=2.33u as=0.3348p ps=2.37u w=0.72u l=0.28u
X262 VSS.t209 a_77611_18700.t9 a_78035_20124# VSS.t208 nfet_03v3 ad=93.59999f pd=0.88u as=93.59999f ps=0.88u w=0.36u l=0.28u
X263 a_75051_16571# a_72623_18464# a_75299_19664# VDD pfet_03v3 ad=0.1872p pd=1.24u as=86.39999f ps=0.96u w=0.72u l=0.28u
X264 VDD a_77091_19664# a_78035_19664# VDD pfet_03v3 ad=0.3168p pd=2.32u as=0.1872p ps=1.24u w=0.72u l=0.28u
X265 a_63397_18758# a_52371_19664.t2 a_62783_16853.t3 VSS.t660 nfet_03v3 ad=0.279p pd=1.755u as=0.243p ps=1.395u w=0.675u l=0.28u
X266 VSS.t820 a_58492_17311# a_58399_17378# VSS.t819 nfet_03v3 ad=0.1638p pd=1.63u as=0.1638p ps=1.63u w=0.36u l=0.28u
X267 a_58259_18828# A6.t3 VSS.t767 VSS.t766 nfet_03v3 ad=93.59999f pd=0.88u as=93.59999f ps=0.88u w=0.36u l=0.28u
X268 a_75500_17311# a_75851_16575# VDD.t425 VDD.t424 pfet_03v3 ad=0.1872p pd=1.24u as=0.3276p ps=2.35u w=0.72u l=0.28u
X269 a_65963_16575# A9.t7 VDD.t128 VDD.t127 pfet_03v3 ad=0.1872p pd=1.24u as=0.4284p ps=1.91u w=0.72u l=0.28u
X270 VDD a_55363_18700.t7 a_57035_19664# VDD pfet_03v3 ad=0.1872p pd=1.24u as=0.1152p ps=1.04u w=0.72u l=0.28u
X271 VDD a_69675_18828# a_70619_19216# VDD pfet_03v3 ad=0.3168p pd=2.32u as=0.1872p ps=1.24u w=0.72u l=0.28u
X272 a_75563_18828# A13.t4 VSS.t761 VSS.t760 nfet_03v3 ad=93.59999f pd=0.88u as=93.59999f ps=0.88u w=0.36u l=0.28u
X273 VSS.t524 a_80442_17311# a_80345_18463.t1 VSS.t523 nfet_03v3 ad=0.171p pd=1.67u as=0.1746p ps=1.69u w=0.36u l=0.28u
X274 VDD.t1 a_55717_17311# a_55620_18463.t0 VDD.t0 pfet_03v3 ad=0.324p pd=2.34u as=0.3312p ps=2.36u w=0.72u l=0.28u
X275 a_68083_19104# a_67203_18828# a_68771_19216# VDD pfet_03v3 ad=0.1872p pd=1.24u as=0.1872p ps=1.24u w=0.72u l=0.28u
X276 a_63659_16575# a_40765_17389.t7 a_63051_16571# VSS nfet_03v3 ad=0.2232p pd=1.96u as=0.2016p ps=1.84u w=0.36u l=0.28u
X277 a_69675_18828# a_68083_19104# VDD VDD pfet_03v3 ad=0.3168p pd=2.32u as=0.1872p ps=1.24u w=0.72u l=0.28u
X278 a_41233_17389.t2 SEL1.t1 SEL0.t3 VDD.t797 pfet_03v3 ad=0.4536p pd=3.24u as=93.59999f ps=0.88u w=0.36u l=0.28u
X279 a_80963_16575# a_40765_17389.t8 a_80442_17311# VSS nfet_03v3 ad=0.2232p pd=1.96u as=0.2016p ps=1.84u w=0.36u l=0.28u
X280 VSS.t403 a_67723_18700.t5 a_69395_20124# VSS.t402 nfet_03v3 ad=93.59999f pd=0.88u as=57.59999f ps=0.68u w=0.36u l=0.28u
X281 VDD a_80083_18700.t11 a_80507_19216# VDD pfet_03v3 ad=0.1872p pd=1.24u as=0.1872p ps=1.24u w=0.72u l=0.28u
X282 Y4.t0 a_53771_16575# VDD.t7 VDD.t6 pfet_03v3 ad=0.3312p pd=2.36u as=0.3168p ps=2.32u w=0.72u l=0.28u
X283 a_74355_20452# CIN.t13 a_73778_17859# VSS.t781 nfet_03v3 ad=0.1872p pd=1.24u as=0.1872p ps=1.24u w=0.72u l=0.28u
X284 a_52091_20124# A3.t2 a_50779_19848# VSS.t875 nfet_03v3 ad=57.59999f pd=0.68u as=93.59999f ps=0.88u w=0.36u l=0.28u
X285 a_55523_19664# A5.t6 a_55419_19664# VDD pfet_03v3 ad=86.39999f pd=0.96u as=86.39999f ps=0.96u w=0.72u l=0.28u
X286 VDD A14.t5 a_78659_19216# VDD pfet_03v3 ad=0.1872p pd=1.24u as=0.3168p ps=2.32u w=0.72u l=0.28u
X287 VDD.t41 a_50778_17315# a_50681_18467.t0 VDD.t40 pfet_03v3 ad=0.324p pd=2.34u as=0.3312p ps=2.36u w=0.72u l=0.28u
X288 VSS.t783 CIN.t14 a_66315_20792# VSS.t782 nfet_03v3 ad=0.1872p pd=1.24u as=0.1872p ps=1.24u w=0.72u l=0.28u
X289 a_80507_20124# a_80443_19848# a_79995_16571# VSS.t449 nfet_03v3 ad=93.59999f pd=0.88u as=93.59999f ps=0.88u w=0.36u l=0.28u
X290 a_80507_19664# A15.t3 VDD VDD pfet_03v3 ad=0.1872p pd=1.24u as=0.1872p ps=1.24u w=0.72u l=0.28u
X291 a_52895_16853.t1 a_52371_19664.t3 VDD VDD pfet_03v3 ad=0.7488p pd=3.52u as=0.3168p ps=2.32u w=0.72u l=0.28u
X292 a_58715_16575# a_40765_17389.t9 a_58194_17311# VSS nfet_03v3 ad=0.2232p pd=1.96u as=0.2016p ps=1.84u w=0.36u l=0.28u
X293 a_44531_20792# B0.t0 a_43003_19620.t1 VDD pfet_03v3 ad=0.6336p pd=3.76u as=0.3744p ps=1.96u w=1.44u l=0.28u
X294 a_61355_20124# a_60307_18700.t7 VSS.t27 VSS.t26 nfet_03v3 ad=93.59999f pd=0.88u as=93.59999f ps=0.88u w=0.36u l=0.28u
X295 a_61979_19664# A7.t4 a_60667_19848# VDD pfet_03v3 ad=0.1152p pd=1.04u as=0.1872p ps=1.24u w=0.72u l=0.28u
X296 VSS.t769 A6.t4 a_58883_18828# VSS.t768 nfet_03v3 ad=93.59999f pd=0.88u as=0.1584p ps=1.6u w=0.36u l=0.28u
X297 a_53771_16575# a_41233_17389.t8 a_52951_17316# VSS nfet_03v3 ad=0.2232p pd=1.96u as=0.2016p ps=1.84u w=0.36u l=0.28u
X298 Y3.t1 a_51299_16575# VSS VSS nfet_03v3 ad=0.1656p pd=1.64u as=0.1584p ps=1.6u w=0.36u l=0.28u
X299 a_52951_17316# A4.t0 VDD.t517 VDD.t516 pfet_03v3 ad=0.1872p pd=1.24u as=0.4284p ps=1.91u w=0.72u l=0.28u
X300 a_67883_20124# A10.t4 a_67779_20124# VSS.t692 nfet_03v3 ad=43.2f pd=0.6u as=43.2f ps=0.6u w=0.36u l=0.28u
X301 a_56075_16575# A5.t7 VDD.t801 VDD.t800 pfet_03v3 ad=0.1872p pd=1.24u as=0.4284p ps=1.91u w=0.72u l=0.28u
X302 a_58259_20124# a_58195_19848# a_57747_16571# VSS.t602 nfet_03v3 ad=93.59999f pd=0.88u as=93.59999f ps=0.88u w=0.36u l=0.28u
X303 a_58259_19664# A6.t5 VDD VDD pfet_03v3 ad=0.1872p pd=1.24u as=0.1872p ps=1.24u w=0.72u l=0.28u
X304 a_71243_19216# a_70195_18700.t8 VDD VDD pfet_03v3 ad=0.1872p pd=1.24u as=0.1872p ps=1.24u w=0.72u l=0.28u
X305 a_72671_16853.t0 a_62791_16527.t3 a_72579_19228# VDD pfet_03v3 ad=0.486p pd=2.07u as=0.38363p ps=2u w=1.35u l=0.28u
X306 VSS.t357 a_83137_17311# a_83673_18427# VSS.t356 nfet_03v3 ad=0.3168p pd=2.32u as=0.1872p ps=1.24u w=0.72u l=0.28u
X307 VDD CIN.t15 a_76347_20792# VDD pfet_03v3 ad=0.3744p pd=1.96u as=0.3744p ps=1.96u w=1.44u l=0.28u
X308 a_75563_20124# a_75499_19848# a_75051_16571# VSS.t178 nfet_03v3 ad=93.59999f pd=0.88u as=93.59999f ps=0.88u w=0.36u l=0.28u
X309 a_75563_19664# A13.t5 VDD VDD pfet_03v3 ad=0.1872p pd=1.24u as=0.1872p ps=1.24u w=0.72u l=0.28u
X310 a_60571_18828# a_59787_18828# a_60467_18828# VSS.t328 nfet_03v3 ad=93.59999f pd=0.88u as=43.2f ps=0.6u w=0.36u l=0.28u
X311 a_68147_19216# a_68083_19104# a_67987_18828# VDD pfet_03v3 ad=0.1872p pd=1.24u as=0.1872p ps=1.24u w=0.72u l=0.28u
X312 VDD a_70195_18700.t9 a_71867_19216# VDD pfet_03v3 ad=0.1872p pd=1.24u as=0.1152p ps=1.04u w=0.72u l=0.28u
X313 a_80151_16571# a_72671_16853.t9 a_79995_16571# VSS nfet_03v3 ad=0.1332p pd=1.1u as=0.18p ps=1.72u w=0.36u l=0.28u
X314 a_51131_16575# A3.t3 VDD.t742 VDD.t741 pfet_03v3 ad=0.1872p pd=1.24u as=0.4284p ps=1.91u w=0.72u l=0.28u
X315 a_56777_16039# a_55620_18463.t2 a_54744_16039# VSS nfet_03v3 ad=7.1172p pd=11.325u as=7.1172p ps=11.325u w=1.44u l=0.28u
X316 a_62847_16571# a_62783_16853.t6 a_62691_16571.t3 VDD.t684 pfet_03v3 ad=0.1332p pd=1.1u as=0.18p ps=1.72u w=0.36u l=0.28u
X317 VSS.t837 A2.t4 a_48995_20124# VSS.t836 nfet_03v3 ad=93.59999f pd=0.88u as=0.1584p ps=1.6u w=0.36u l=0.28u
X318 a_57315_19664# a_55723_19848# VSS.t443 VSS.t442 nfet_03v3 ad=0.1584p pd=1.6u as=93.59999f ps=0.88u w=0.36u l=0.28u
X319 a_55627_18828# a_52371_19664.t4 a_55431_16571# VDD.t557 pfet_03v3 ad=0.4446p pd=3.19u as=0.1332p ps=1.1u w=0.36u l=0.28u
X320 a_79539_18391# A14.t6 a_78323_16575# VSS.t701 nfet_03v3 ad=0.1872p pd=1.24u as=0.3276p ps=2.35u w=0.72u l=0.28u
X321 VSS.t616 B7.t1 a_61995_20452# VSS.t615 nfet_03v3 ad=0.3168p pd=2.32u as=0.1872p ps=1.24u w=0.72u l=0.28u
X322 a_48003_20124# a_47947_19620.t6 VSS.t881 VSS.t880 nfet_03v3 ad=43.2f pd=0.6u as=0.1584p ps=1.6u w=0.36u l=0.28u
X323 a_66299_19216# a_65251_18700.t6 VDD VDD pfet_03v3 ad=0.1872p pd=1.24u as=0.1872p ps=1.24u w=0.72u l=0.28u
X324 a_54009_17863# a_53955_20792# VSS.t21 VSS.t20 nfet_03v3 ad=0.1872p pd=1.24u as=0.1872p ps=1.24u w=0.72u l=0.28u
X325 a_49899_19664# a_48307_19848# VDD VDD pfet_03v3 ad=0.3168p pd=2.32u as=0.1872p ps=1.24u w=0.72u l=0.28u
X326 VDD.t93 a_63437_17311# a_63344_17378# VDD.t92 pfet_03v3 ad=0.3204p pd=2.33u as=0.3348p ps=2.37u w=0.72u l=0.28u
X327 VSS.t168 A9.t8 a_66299_20124# VSS.t167 nfet_03v3 ad=93.59999f pd=0.88u as=0.1584p ps=1.6u w=0.36u l=0.28u
X328 a_53771_16575# a_41692_17389.t10 a_52959_16571# VSS nfet_03v3 ad=0.2034p pd=1.85u as=0.2016p ps=1.84u w=0.36u l=0.28u
X329 a_70195_18700.t0 a_71259_20792# VSS.t76 VSS.t75 nfet_03v3 ad=0.1872p pd=1.24u as=0.1872p ps=1.24u w=0.72u l=0.28u
X330 VDD A6.t6 a_58883_19664# VDD pfet_03v3 ad=0.1872p pd=1.24u as=0.3168p ps=2.32u w=0.72u l=0.28u
X331 a_77091_18828# a_75499_19104# VSS.t181 VSS.t180 nfet_03v3 ad=0.1584p pd=1.6u as=93.59999f ps=0.88u w=0.36u l=0.28u
X332 a_64632_14904.t2 a_67986_18464.t2 VDD VDD pfet_03v3 ad=3.5586p pd=10.605u as=3.5586p ps=10.605u w=0.72u l=0.28u
X333 a_67779_18828# a_67723_18700.t6 VSS.t405 VSS.t404 nfet_03v3 ad=43.2f pd=0.6u as=0.1584p ps=1.6u w=0.36u l=0.28u
X334 a_46187_16575# A1.t2 VDD.t5 VDD.t4 pfet_03v3 ad=0.1872p pd=1.24u as=0.4284p ps=1.91u w=0.72u l=0.28u
X335 a_77875_18828# a_72679_16527.t3 a_77679_16571# VSS nfet_03v3 ad=0.4446p pd=3.19u as=0.1332p ps=1.1u w=0.36u l=0.28u
X336 a_57903_16571# a_52895_16853.t4 a_57747_16571# VDD.t672 pfet_03v3 ad=0.1332p pd=1.1u as=0.18p ps=1.72u w=0.36u l=0.28u
X337 a_53163_16571# a_52951_17316# VDD.t384 VDD.t383 pfet_03v3 ad=0.1872p pd=1.24u as=0.3276p ps=2.35u w=0.72u l=0.28u
X338 a_63843_20792# B8.t1 VSS.t501 VSS.t500 nfet_03v3 ad=0.1872p pd=1.24u as=0.3168p ps=2.32u w=0.72u l=0.28u
X339 VSS.t703 a_45475_19620.t9 a_45899_20124# VSS.t702 nfet_03v3 ad=93.59999f pd=0.88u as=93.59999f ps=0.88u w=0.36u l=0.28u
X340 VSS.t609 a_79563_19664# a_80507_20124# VSS.t608 nfet_03v3 ad=0.1584p pd=1.6u as=93.59999f ps=0.88u w=0.36u l=0.28u
X341 a_43267_19664# CIN.t16 a_43163_19664# VDD pfet_03v3 ad=0.1872p pd=1.24u as=86.39999f ps=0.96u w=0.72u l=0.28u
X342 VDD a_44955_19664# a_45899_19664# VDD pfet_03v3 ad=0.3168p pd=2.32u as=0.1872p ps=1.24u w=0.72u l=0.28u
X343 a_64307_20792# a_63843_20792# VDD VDD pfet_03v3 ad=0.3744p pd=1.96u as=0.3744p ps=1.96u w=1.44u l=0.28u
X344 a_48961_17382# A2.t5 a_48604_17315# VDD.t227 pfet_03v3 ad=0.3744p pd=1.96u as=0.6408p ps=3.77u w=1.44u l=0.28u
X345 VSS.t284 a_60871_17378# a_61781_18391# VSS.t283 nfet_03v3 ad=0.324p pd=2.34u as=0.1872p ps=1.24u w=0.72u l=0.28u
X346 a_80139_20124# a_80083_18700.t12 VSS.t153 VSS.t152 nfet_03v3 ad=43.2f pd=0.6u as=0.1584p ps=1.6u w=0.36u l=0.28u
X347 a_60219_16571# a_59787_19664# a_60467_19664# VDD pfet_03v3 ad=0.1872p pd=1.24u as=86.39999f ps=0.96u w=0.72u l=0.28u
X348 a_47947_19620.t0 a_49011_20792# VSS.t46 VSS.t45 nfet_03v3 ad=0.1872p pd=1.24u as=0.1872p ps=1.24u w=0.72u l=0.28u
X349 a_40610_17389.t2 SEL1.t2 VDD.t799 VDD.t798 pfet_03v3 ad=0.324p pd=2.34u as=0.324p ps=2.34u w=0.72u l=0.28u
X350 VDD.t45 a_73778_17859# a_73682_17378# VDD.t44 pfet_03v3 ad=0.648p pd=3.78u as=0.3744p ps=1.96u w=1.44u l=0.28u
X351 a_81611_20792# a_81147_20792# VDD VDD pfet_03v3 ad=0.3744p pd=1.96u as=0.3744p ps=1.96u w=1.44u l=0.28u
X352 a_78035_18828# a_77971_19104# a_77875_18828# VSS.t42 nfet_03v3 ad=93.59999f pd=0.88u as=93.59999f ps=0.88u w=0.36u l=0.28u
X353 VSS.t334 a_77970_17311# a_77873_18463.t1 VSS.t333 nfet_03v3 ad=0.171p pd=1.67u as=0.1746p ps=1.69u w=0.36u l=0.28u
X354 VSS.t211 a_60964_17311# a_60871_17378# VSS.t210 nfet_03v3 ad=0.1638p pd=1.63u as=0.1638p ps=1.63u w=0.36u l=0.28u
X355 a_76667_20792# B13.t0 a_75139_18700.t3 VDD pfet_03v3 ad=0.6336p pd=3.76u as=0.3744p ps=1.96u w=1.44u l=0.28u
X356 VDD a_67203_18828# a_68147_19216# VDD pfet_03v3 ad=0.3168p pd=2.32u as=0.1872p ps=1.24u w=0.72u l=0.28u
X357 a_59363_20792# a_58899_20792# VDD VDD pfet_03v3 ad=0.3744p pd=1.96u as=0.3744p ps=1.96u w=1.44u l=0.28u
X358 a_46355_16575# a_41233_17389.t9 a_46187_16575# VSS nfet_03v3 ad=0.2232p pd=1.96u as=0.2016p ps=1.84u w=0.36u l=0.28u
X359 a_79085_18391# a_78323_16575# a_77970_17311# VSS.t265 nfet_03v3 ad=0.1872p pd=1.24u as=0.3276p ps=2.35u w=0.72u l=0.28u
X360 a_75195_20124# a_75139_18700.t8 VSS.t724 VSS.t723 nfet_03v3 ad=43.2f pd=0.6u as=0.1584p ps=1.6u w=0.36u l=0.28u
X361 a_78491_16575# a_40765_17389.t10 a_77970_17311# VSS nfet_03v3 ad=0.2232p pd=1.96u as=0.2016p ps=1.84u w=0.36u l=0.28u
X362 a_49619_20124# A2.t6 a_48307_19848# VSS.t835 nfet_03v3 ad=57.59999f pd=0.68u as=93.59999f ps=0.88u w=0.36u l=0.28u
X363 a_46523_19664# a_45475_19620.t10 VDD VDD pfet_03v3 ad=0.1872p pd=1.24u as=0.1872p ps=1.24u w=0.72u l=0.28u
X364 a_77091_19664# a_75499_19848# VDD VDD pfet_03v3 ad=0.3168p pd=2.32u as=0.1872p ps=1.24u w=0.72u l=0.28u
X365 a_67779_19664# a_67723_18700.t7 VDD VDD pfet_03v3 ad=86.39999f pd=0.96u as=0.3168p ps=2.32u w=0.72u l=0.28u
X366 VSS.t586 CIN.t17 a_51483_20792# VSS.t585 nfet_03v3 ad=0.1872p pd=1.24u as=0.1872p ps=1.24u w=0.72u l=0.28u
X367 a_50419_19620.t1 CIN.t18 a_51947_20792# VDD pfet_03v3 ad=0.3744p pd=1.96u as=0.3744p ps=1.96u w=1.44u l=0.28u
X368 a_66923_20124# A9.t9 a_65611_19848# VSS.t169 nfet_03v3 ad=57.59999f pd=0.68u as=93.59999f ps=0.88u w=0.36u l=0.28u
X369 a_83173_20131# a_72679_16527.t4 a_82973_19616# VSS.t611 nfet_03v3 ad=0.279p pd=1.755u as=0.243p ps=1.395u w=0.675u l=0.28u
X370 VSS.t259 a_40610_17389.t3 a_40765_17389.t1 VSS.t258 nfet_03v3 ad=93.59999f pd=0.88u as=93.59999f ps=0.88u w=0.36u l=0.28u
X371 Y2.t1 a_48827_16575# VSS VSS nfet_03v3 ad=0.1656p pd=1.64u as=0.1584p ps=1.6u w=0.36u l=0.28u
X372 a_50843_20124# A3.t4 VSS.t877 VSS.t876 nfet_03v3 ad=93.59999f pd=0.88u as=93.59999f ps=0.88u w=0.36u l=0.28u
X373 VDD.t565 a_65251_18700.t7 a_66265_17379# VDD.t564 pfet_03v3 ad=0.648p pd=3.78u as=0.3744p ps=1.96u w=1.44u l=0.28u
X374 a_77875_18828# a_77091_18828# a_77771_19216# VDD pfet_03v3 ad=0.1872p pd=1.24u as=86.39999f ps=0.96u w=0.72u l=0.28u
X375 a_51299_16575# a_42244_17389.t7 a_51076_17315# VSS nfet_03v3 ad=0.2232p pd=1.96u as=0.2016p ps=1.84u w=0.36u l=0.28u
X376 a_78035_19664# a_77971_19848# a_77523_16571# VDD pfet_03v3 ad=0.1872p pd=1.24u as=0.1872p ps=1.24u w=0.72u l=0.28u
X377 VSS.t655 a_65251_18700.t8 a_65675_18828# VSS.t654 nfet_03v3 ad=93.59999f pd=0.88u as=93.59999f ps=0.88u w=0.36u l=0.28u
X378 a_83150_14862# a_54744_14904.t5 a_82708_14862# VDD pfet_03v3 ad=2.1096p pd=4.345u as=2.7792p ps=4.81u w=2.88u l=0.28u
X379 a_68771_18828# a_67723_18700.t8 VSS.t401 VSS.t400 nfet_03v3 ad=93.59999f pd=0.88u as=93.59999f ps=0.88u w=0.36u l=0.28u
X380 a_45475_19620.t3 CIN.t19 a_47003_20792# VDD pfet_03v3 ad=0.3744p pd=1.96u as=0.3744p ps=1.96u w=1.44u l=0.28u
X381 a_70619_19216# a_70555_19104# a_70459_18828# VDD pfet_03v3 ad=0.1872p pd=1.24u as=0.1872p ps=1.24u w=0.72u l=0.28u
X382 VSS.t269 a_43362_17315# a_43265_18467.t1 VSS.t268 nfet_03v3 ad=0.171p pd=1.67u as=0.1746p ps=1.69u w=0.36u l=0.28u
X383 VSS.t164 a_72939_16571# a_72579_16571.t1 VSS.t163 nfet_03v3 ad=0.171p pd=1.67u as=0.1746p ps=1.69u w=0.36u l=0.28u
X384 a_78323_16575# A14.t7 VDD.t595 VDD.t594 pfet_03v3 ad=0.1872p pd=1.24u as=0.4284p ps=1.91u w=0.72u l=0.28u
X385 a_57995_19216# A6.t7 a_57891_19216# VDD pfet_03v3 ad=86.39999f pd=0.96u as=86.39999f ps=0.96u w=0.72u l=0.28u
X386 VDD.t524 a_80740_17311# a_80647_17378# VDD.t523 pfet_03v3 ad=0.3204p pd=2.33u as=0.3348p ps=2.37u w=0.72u l=0.28u
X387 VSS.t871 A3.t5 a_51467_20124# VSS.t870 nfet_03v3 ad=93.59999f pd=0.88u as=0.1584p ps=1.6u w=0.36u l=0.28u
X388 a_50779_19848# a_49899_19664# a_51467_19664# VDD pfet_03v3 ad=0.1872p pd=1.24u as=0.1872p ps=1.24u w=0.72u l=0.28u
X389 Y14.t0 a_78491_16575# VDD.t790 VDD.t789 pfet_03v3 ad=0.3312p pd=2.36u as=0.3168p ps=2.32u w=0.72u l=0.28u
X390 a_82011_18391# A15.t4 a_80795_16575# VSS.t850 nfet_03v3 ad=0.1872p pd=1.24u as=0.3276p ps=2.35u w=0.72u l=0.28u
X391 VDD.t395 a_55363_18700.t8 a_56372_17378# VDD.t394 pfet_03v3 ad=0.648p pd=3.78u as=0.3744p ps=1.96u w=1.44u l=0.28u
X392 a_45835_19848# a_44955_19664# a_46523_20124# VSS.t128 nfet_03v3 ad=93.59999f pd=0.88u as=93.59999f ps=0.88u w=0.36u l=0.28u
X393 a_48211_19664# a_47427_19664# a_48107_20124# VSS.t87 nfet_03v3 ad=93.59999f pd=0.88u as=43.2f ps=0.6u w=0.36u l=0.28u
X394 VDD a_47947_19620.t7 a_48371_19664# VDD pfet_03v3 ad=0.1872p pd=1.24u as=0.1872p ps=1.24u w=0.72u l=0.28u
X395 a_62259_18828# a_60667_19104# VSS.t324 VSS.t323 nfet_03v3 ad=0.1584p pd=1.6u as=93.59999f ps=0.88u w=0.36u l=0.28u
X396 a_60375_16571# a_52371_19664.t5 a_60219_16571# VSS nfet_03v3 ad=0.1332p pd=1.1u as=0.18p ps=1.72u w=0.36u l=0.28u
X397 a_65675_19216# a_65611_19104# a_65515_18828# VDD pfet_03v3 ad=0.1872p pd=1.24u as=0.1872p ps=1.24u w=0.72u l=0.28u
X398 Y13.t1 a_76019_16575# VSS VSS nfet_03v3 ad=0.1656p pd=1.64u as=0.1584p ps=1.6u w=0.36u l=0.28u
X399 a_78491_16575# a_41233_17389.t10 a_78323_16575# VSS nfet_03v3 ad=0.2232p pd=1.96u as=0.2016p ps=1.84u w=0.36u l=0.28u
X400 a_65163_16571# a_63344_17378# a_65411_20124# VSS.t748 nfet_03v3 ad=93.59999f pd=0.88u as=43.2f ps=0.6u w=0.36u l=0.28u
X401 VDD a_65251_18700.t9 a_65675_19664# VDD pfet_03v3 ad=0.1872p pd=1.24u as=0.1872p ps=1.24u w=0.72u l=0.28u
X402 VSS.t890 A11.t5 a_71243_18828# VSS.t889 nfet_03v3 ad=93.59999f pd=0.88u as=0.1584p ps=1.6u w=0.36u l=0.28u
X403 VDD.t695 a_70195_18700.t10 a_71210_17379# VDD.t694 pfet_03v3 ad=0.648p pd=3.78u as=0.3744p ps=1.96u w=1.44u l=0.28u
X404 VDD.t247 a_60871_17378# a_60666_17311# VDD.t246 pfet_03v3 ad=0.4284p pd=1.91u as=0.1872p ps=1.24u w=0.72u l=0.28u
X405 a_59763_18391# A6.t8 a_58547_16575# VSS.t149 nfet_03v3 ad=0.1872p pd=1.24u as=0.3276p ps=2.35u w=0.72u l=0.28u
X406 a_68771_19664# a_67723_18700.t9 VDD VDD pfet_03v3 ad=0.1872p pd=1.24u as=0.1872p ps=1.24u w=0.72u l=0.28u
X407 a_66131_16575# a_42244_17389.t8 a_65908_17312# VSS nfet_03v3 ad=0.2232p pd=1.96u as=0.2016p ps=1.84u w=0.36u l=0.28u
X408 VDD A5.t8 a_56411_19216# VDD pfet_03v3 ad=0.1872p pd=1.24u as=0.3168p ps=2.32u w=0.72u l=0.28u
X409 a_43059_20124# a_43003_19620.t8 VSS.t361 VSS.t360 nfet_03v3 ad=43.2f pd=0.6u as=0.1584p ps=1.6u w=0.36u l=0.28u
X410 a_48306_17315# a_48659_16575# VDD.t118 VDD.t117 pfet_03v3 ad=0.1872p pd=1.24u as=0.3276p ps=2.35u w=0.72u l=0.28u
X411 a_44856_14904.t1 a_43265_18467.t2 VDD VDD pfet_03v3 ad=3.5586p pd=10.605u as=6.3756p ps=19.15u w=0.72u l=0.28u
X412 a_77970_17311# a_78323_16575# VDD.t224 VDD.t223 pfet_03v3 ad=0.1872p pd=1.24u as=0.3276p ps=2.35u w=0.72u l=0.28u
X413 a_45635_20124# A1.t3 a_45531_20124# VSS.t351 nfet_03v3 ad=43.2f pd=0.6u as=43.2f ps=0.6u w=0.36u l=0.28u
X414 a_60363_20124# a_60307_18700.t8 VSS.t29 VSS.t28 nfet_03v3 ad=43.2f pd=0.6u as=0.1584p ps=1.6u w=0.36u l=0.28u
X415 a_54744_14904.t2 a_60569_18463.t2 a_58810_16039# VSS nfet_03v3 ad=12.0384p pd=19.6u as=7.1172p ps=11.325u w=1.44u l=0.28u
X416 a_57051_20452# CIN.t20 a_55363_18700.t3 VSS.t587 nfet_03v3 ad=0.1872p pd=1.24u as=0.1872p ps=1.24u w=0.72u l=0.28u
X417 a_77611_18700.t1 a_78675_20792# VSS.t374 VSS.t373 nfet_03v3 ad=0.1872p pd=1.24u as=0.1872p ps=1.24u w=0.72u l=0.28u
X418 a_70619_20124# A11.t6 VSS.t892 VSS.t891 nfet_03v3 ad=93.59999f pd=0.88u as=93.59999f ps=0.88u w=0.36u l=0.28u
X419 a_62259_19664# a_60667_19848# VDD VDD pfet_03v3 ad=0.3168p pd=2.32u as=0.1872p ps=1.24u w=0.72u l=0.28u
X420 a_70251_19216# a_70195_18700.t11 VDD VDD pfet_03v3 ad=86.39999f pd=0.96u as=0.3168p ps=2.32u w=0.72u l=0.28u
X421 a_78491_16575# a_41692_17389.t11 a_77679_16571# VSS nfet_03v3 ad=0.2034p pd=1.85u as=0.2016p ps=1.84u w=0.36u l=0.28u
X422 VDD A11.t7 a_71243_19664# VDD pfet_03v3 ad=0.1872p pd=1.24u as=0.3168p ps=2.32u w=0.72u l=0.28u
X423 a_65411_18828# A9.t10 a_65307_18828# VSS.t170 nfet_03v3 ad=43.2f pd=0.6u as=43.2f ps=0.6u w=0.36u l=0.28u
X424 VDD.t713 a_47947_19620.t8 a_48659_16575# VDD.t712 pfet_03v3 ad=0.324p pd=2.34u as=0.1872p ps=1.24u w=0.72u l=0.28u
X425 a_70263_16571# a_62783_16853.t7 a_70107_16571# VDD.t685 pfet_03v3 ad=0.1332p pd=1.1u as=0.18p ps=1.72u w=0.36u l=0.28u
X426 a_48371_20124# A2.t7 VSS.t834 VSS.t833 nfet_03v3 ad=93.59999f pd=0.88u as=93.59999f ps=0.88u w=0.36u l=0.28u
X427 a_45899_19664# a_45835_19848# a_45739_19664# VDD pfet_03v3 ad=0.1872p pd=1.24u as=0.1872p ps=1.24u w=0.72u l=0.28u
X428 a_82708_14862# a_44856_14904.t5 VDD VDD pfet_03v3 ad=2.7792p pd=4.81u as=2.7504p ps=7.67u w=2.88u l=0.28u
X429 a_48827_16575# a_42244_17389.t9 a_48604_17315# VSS nfet_03v3 ad=0.2232p pd=1.96u as=0.2016p ps=1.84u w=0.36u l=0.28u
X430 a_65251_18700.t2 CIN.t21 a_66779_20792# VDD pfet_03v3 ad=0.3744p pd=1.96u as=0.3744p ps=1.96u w=1.44u l=0.28u
X431 a_65675_20124# A9.t11 VSS.t172 VSS.t171 nfet_03v3 ad=93.59999f pd=0.88u as=93.59999f ps=0.88u w=0.36u l=0.28u
X432 a_71867_18828# A11.t8 a_70555_19104# VSS.t893 nfet_03v3 ad=57.59999f pd=0.68u as=93.59999f ps=0.88u w=0.36u l=0.28u
X433 a_61321_17378# A7.t5 a_60964_17311# VDD.t675 pfet_03v3 ad=0.3744p pd=1.96u as=0.6408p ps=3.77u w=1.44u l=0.28u
X434 VDD CIN.t22 a_49155_20792# VDD pfet_03v3 ad=0.3744p pd=1.96u as=0.3744p ps=1.96u w=1.44u l=0.28u
X435 a_68147_18828# A10.t5 VSS.t694 VSS.t693 nfet_03v3 ad=93.59999f pd=0.88u as=93.59999f ps=0.88u w=0.36u l=0.28u
X436 a_62847_16571# a_62791_16527.t4 a_62691_16571.t0 VSS nfet_03v3 ad=0.1332p pd=1.1u as=0.18p ps=1.72u w=0.36u l=0.28u
X437 a_44955_19664# a_43363_19848# VDD VDD pfet_03v3 ad=0.3168p pd=2.32u as=0.1872p ps=1.24u w=0.72u l=0.28u
X438 Z.t3 a_74520_14904.t5 a_83499_14862# VDD pfet_03v3 ad=2.7216p pd=7.65u as=2.1816p ps=4.395u w=2.88u l=0.28u
X439 a_57035_19216# A5.t9 a_55723_19104# VDD pfet_03v3 ad=0.1152p pd=1.04u as=0.1872p ps=1.24u w=0.72u l=0.28u
X440 a_77971_19104# a_77091_18828# a_78659_19216# VDD pfet_03v3 ad=0.1872p pd=1.24u as=0.1872p ps=1.24u w=0.72u l=0.28u
X441 a_55627_18828# a_52895_16853.t5 a_55431_16571# VSS nfet_03v3 ad=0.4446p pd=3.19u as=0.1332p ps=1.1u w=0.36u l=0.28u
X442 Y1.t0 a_46355_16575# VDD.t376 VDD.t375 pfet_03v3 ad=0.3312p pd=2.36u as=0.3168p ps=2.32u w=0.72u l=0.28u
X443 VSS.t953 B0.t1 a_44691_20452# VSS.t952 nfet_03v3 ad=0.3168p pd=2.32u as=0.1872p ps=1.24u w=0.72u l=0.28u
X444 a_48107_19664# A2.t8 a_48003_19664# VDD pfet_03v3 ad=86.39999f pd=0.96u as=86.39999f ps=0.96u w=0.72u l=0.28u
X445 a_79563_18828# a_77971_19104# VDD VDD pfet_03v3 ad=0.3168p pd=2.32u as=0.1872p ps=1.24u w=0.72u l=0.28u
X446 VSS.t257 a_53463_17382# a_54373_18395# VSS.t256 nfet_03v3 ad=0.324p pd=2.34u as=0.1872p ps=1.24u w=0.72u l=0.28u
X447 a_77069_18391# A13.t6 a_75851_16575# VSS.t762 nfet_03v3 ad=0.1872p pd=1.24u as=0.3276p ps=2.35u w=0.72u l=0.28u
X448 VDD.t233 a_43362_17315# a_43265_18467.t0 VDD.t232 pfet_03v3 ad=0.324p pd=2.34u as=0.3312p ps=2.36u w=0.72u l=0.28u
X449 Y8.t0 a_63659_16575# VDD.t520 VDD.t519 pfet_03v3 ad=0.3312p pd=2.36u as=0.3168p ps=2.32u w=0.72u l=0.28u
X450 VSS.t50 a_77611_18700.t10 a_79283_20124# VSS.t49 nfet_03v3 ad=93.59999f pd=0.88u as=57.59999f ps=0.68u w=0.36u l=0.28u
X451 a_65411_19664# A9.t12 a_65307_19664# VDD pfet_03v3 ad=86.39999f pd=0.96u as=86.39999f ps=0.96u w=0.72u l=0.28u
X452 a_58195_19104# a_57315_18828# a_58883_18828# VSS.t111 nfet_03v3 ad=93.59999f pd=0.88u as=93.59999f ps=0.88u w=0.36u l=0.28u
X453 a_80795_16575# A15.t5 VDD.t761 VDD.t198 pfet_03v3 ad=0.1872p pd=1.24u as=0.4284p ps=1.91u w=0.72u l=0.28u
X454 a_59787_18828# a_58195_19104# VSS.t765 VSS.t764 nfet_03v3 ad=0.1584p pd=1.6u as=93.59999f ps=0.88u w=0.36u l=0.28u
X455 VSS.t580 CIN.t23 a_76203_20792# VSS.t579 nfet_03v3 ad=0.1872p pd=1.24u as=0.1872p ps=1.24u w=0.72u l=0.28u
X456 a_75499_19104# a_73232_17378# a_76187_18828# VSS.t188 nfet_03v3 ad=93.59999f pd=0.88u as=93.59999f ps=0.88u w=0.36u l=0.28u
X457 VSS.t641 a_53556_17315# a_53463_17382# VSS.t640 nfet_03v3 ad=0.1638p pd=1.63u as=0.1638p ps=1.63u w=0.36u l=0.28u
X458 a_57903_16571# a_52371_19664.t6 a_57747_16571# VSS nfet_03v3 ad=0.1332p pd=1.1u as=0.18p ps=1.72u w=0.36u l=0.28u
X459 a_51627_20792# B3.t2 a_51483_20792# VDD pfet_03v3 ad=0.3744p pd=1.96u as=0.6336p ps=3.76u w=1.44u l=0.28u
X460 a_54419_20792# B4.t1 a_54009_17863# VDD pfet_03v3 ad=0.6336p pd=3.76u as=0.3744p ps=1.96u w=1.44u l=0.28u
X461 a_63659_16575# a_41233_17389.t11 a_62832_17312# VSS nfet_03v3 ad=0.2232p pd=1.96u as=0.2016p ps=1.84u w=0.36u l=0.28u
X462 Y7.t1 a_61187_16575# VSS VSS nfet_03v3 ad=0.1656p pd=1.64u as=0.1584p ps=1.6u w=0.36u l=0.28u
X463 VDD.t351 a_67723_18700.t10 a_68738_17379# VDD.t350 pfet_03v3 ad=0.648p pd=3.78u as=0.3744p ps=1.96u w=1.44u l=0.28u
X464 VSS.t145 a_63890_17859# a_63437_17311# VSS.t144 nfet_03v3 ad=0.162p pd=1.62u as=93.59999f ps=0.88u w=0.36u l=0.28u
X465 a_50683_19664# a_49899_19664# a_50579_20124# VSS.t539 nfet_03v3 ad=93.59999f pd=0.88u as=43.2f ps=0.6u w=0.36u l=0.28u
X466 a_77771_20124# A14.t8 a_77667_20124# VSS.t711 nfet_03v3 ad=43.2f pd=0.6u as=43.2f ps=0.6u w=0.36u l=0.28u
X467 VDD a_50419_19620.t7 a_50843_19664# VDD pfet_03v3 ad=0.1872p pd=1.24u as=0.1872p ps=1.24u w=0.72u l=0.28u
X468 a_71867_19664# A11.t9 a_70555_19848# VDD pfet_03v3 ad=0.1152p pd=1.04u as=0.1872p ps=1.24u w=0.72u l=0.28u
X469 a_82467_19616# a_79563_19664# VDD VDD pfet_03v3 ad=0.38363p pd=2u as=0.234p ps=1.42u w=0.9u l=0.28u
X470 a_58547_16575# A6.t9 VDD.t109 VDD.t108 pfet_03v3 ad=0.1872p pd=1.24u as=0.4284p ps=1.91u w=0.72u l=0.28u
X471 a_72147_19664# a_70555_19848# VSS.t306 VSS.t305 nfet_03v3 ad=0.1584p pd=1.6u as=93.59999f ps=0.88u w=0.36u l=0.28u
X472 VSS.t193 a_52854_18468# a_55787_18828# VSS.t192 nfet_03v3 ad=0.1584p pd=1.6u as=93.59999f ps=0.88u w=0.36u l=0.28u
X473 a_76019_16575# a_42244_17389.t10 a_75798_17311# VSS nfet_03v3 ad=0.2232p pd=1.96u as=0.2016p ps=1.84u w=0.36u l=0.28u
X474 a_71723_20792# B11.t1 a_70195_18700.t1 VDD pfet_03v3 ad=0.6336p pd=3.76u as=0.3744p ps=1.96u w=1.44u l=0.28u
X475 a_68147_19664# A10.t6 VDD VDD pfet_03v3 ad=0.1872p pd=1.24u as=0.1872p ps=1.24u w=0.72u l=0.28u
X476 a_80963_16575# a_41233_17389.t12 a_80795_16575# VSS nfet_03v3 ad=0.2232p pd=1.96u as=0.2016p ps=1.84u w=0.36u l=0.28u
X477 VDD a_55363_18700.t9 a_55787_19216# VDD pfet_03v3 ad=0.1872p pd=1.24u as=0.1872p ps=1.24u w=0.72u l=0.28u
X478 a_54744_14904.t0 a_52803_16571.t4 VDD VDD pfet_03v3 ad=3.5586p pd=10.605u as=6.3756p ps=19.15u w=0.72u l=0.28u
X479 VSS.t31 a_60307_18700.t9 a_60964_17311# VSS.t30 nfet_03v3 ad=0.162p pd=1.62u as=93.59999f ps=0.88u w=0.36u l=0.28u
X480 a_45531_19664# a_45475_19620.t11 VDD VDD pfet_03v3 ad=86.39999f pd=0.96u as=0.3168p ps=2.32u w=0.72u l=0.28u
X481 a_70459_18828# a_69675_18828# a_70355_18828# VSS.t137 nfet_03v3 ad=93.59999f pd=0.88u as=43.2f ps=0.6u w=0.36u l=0.28u
X482 a_83193_16859# F.t4 a_83049_16859# VDD.t307 pfet_03v3 ad=0.3744p pd=1.96u as=0.6336p ps=3.76u w=1.44u l=0.28u
X483 VSS.t294 a_51076_17315# a_50983_17382# VSS.t293 nfet_03v3 ad=0.1638p pd=1.63u as=0.1638p ps=1.63u w=0.36u l=0.28u
X484 VSS.t506 a_75500_17311# a_75403_18463.t1 VSS.t505 nfet_03v3 ad=0.171p pd=1.67u as=0.1746p ps=1.69u w=0.36u l=0.28u
X485 a_46683_20792# B1.t0 a_46539_20792# VDD pfet_03v3 ad=0.3744p pd=1.96u as=0.6336p ps=3.76u w=1.44u l=0.28u
X486 a_49475_20792# B2.t0 a_47947_19620.t3 VDD pfet_03v3 ad=0.6336p pd=3.76u as=0.3744p ps=1.96u w=1.44u l=0.28u
X487 a_58883_19216# a_57835_18700.t9 VDD VDD pfet_03v3 ad=0.1872p pd=1.24u as=0.1872p ps=1.24u w=0.72u l=0.28u
X488 VDD.t805 a_75798_17311# a_75705_17378# VDD.t804 pfet_03v3 ad=0.3204p pd=2.33u as=0.3348p ps=2.37u w=0.72u l=0.28u
X489 a_67203_19664# a_65611_19848# VSS.t526 VSS.t525 nfet_03v3 ad=0.1584p pd=1.6u as=93.59999f ps=0.88u w=0.36u l=0.28u
X490 a_58195_19848# a_57315_19664# a_58883_19664# VDD pfet_03v3 ad=0.1872p pd=1.24u as=0.1872p ps=1.24u w=0.72u l=0.28u
X491 a_76187_19216# a_75139_18700.t9 VDD VDD pfet_03v3 ad=0.1872p pd=1.24u as=0.1872p ps=1.24u w=0.72u l=0.28u
X492 a_50778_17315# a_51131_16575# VDD.t786 VDD.t785 pfet_03v3 ad=0.1872p pd=1.24u as=0.3276p ps=2.35u w=0.72u l=0.28u
X493 a_65515_18828# a_62791_16527.t5 a_65319_16571# VDD.t189 pfet_03v3 ad=0.4446p pd=3.19u as=0.1332p ps=1.1u w=0.36u l=0.28u
X494 a_57891_20124# a_57835_18700.t10 VSS.t342 VSS.t341 nfet_03v3 ad=43.2f pd=0.6u as=0.1584p ps=1.6u w=0.36u l=0.28u
X495 a_59787_19664# a_58195_19848# VDD VDD pfet_03v3 ad=0.3168p pd=2.32u as=0.1872p ps=1.24u w=0.72u l=0.28u
X496 VDD.t683 a_73325_17311# a_73232_17378# VDD.t682 pfet_03v3 ad=0.3204p pd=2.33u as=0.3348p ps=2.37u w=0.72u l=0.28u
X497 VSS.t274 a_68381_17312# a_68288_17379# VSS.t273 nfet_03v3 ad=0.1638p pd=1.63u as=0.1638p ps=1.63u w=0.36u l=0.28u
X498 a_63890_17859# a_63843_20792# VSS.t227 VSS.t226 nfet_03v3 ad=0.1872p pd=1.24u as=0.1872p ps=1.24u w=0.72u l=0.28u
X499 VSS.t103 A13.t7 a_76187_20124# VSS.t102 nfet_03v3 ad=93.59999f pd=0.88u as=0.1584p ps=1.6u w=0.36u l=0.28u
X500 a_75499_19848# a_72623_18464# a_76187_19664# VDD pfet_03v3 ad=0.1872p pd=1.24u as=0.1872p ps=1.24u w=0.72u l=0.28u
X501 a_44931_18395# A0.t4 a_43715_16575# VSS.t455 nfet_03v3 ad=0.1872p pd=1.24u as=0.3276p ps=2.35u w=0.72u l=0.28u
X502 a_74520_14904.t2 a_77873_18463.t2 VDD VDD pfet_03v3 ad=3.5586p pd=10.605u as=3.5586p ps=10.605u w=0.72u l=0.28u
X503 a_63659_16575# a_41692_17389.t12 a_62847_16571# VSS nfet_03v3 ad=0.2034p pd=1.85u as=0.2016p ps=1.84u w=0.36u l=0.28u
X504 a_80083_18700.t3 a_81147_20792# VSS.t859 VSS.t858 nfet_03v3 ad=0.1872p pd=1.24u as=0.1872p ps=1.24u w=0.72u l=0.28u
X505 a_62783_16853.t1 a_52895_16853.t6 a_62691_18780# VSS.t368 nfet_03v3 ad=0.243p pd=1.395u as=0.1918p ps=1.325u w=0.675u l=0.28u
X506 a_77667_18828# a_77611_18700.t11 VSS.t52 VSS.t51 nfet_03v3 ad=43.2f pd=0.6u as=0.1584p ps=1.6u w=0.36u l=0.28u
X507 a_81755_18828# A15.t6 a_80443_19104# VSS.t902 nfet_03v3 ad=57.59999f pd=0.68u as=93.59999f ps=0.88u w=0.36u l=0.28u
X508 a_80963_16575# a_41692_17389.t13 a_80151_16571# VSS nfet_03v3 ad=0.2034p pd=1.85u as=0.2016p ps=1.84u w=0.36u l=0.28u
X509 a_67791_16571# a_62783_16853.t8 a_67635_16571# VDD.t326 pfet_03v3 ad=0.1332p pd=1.1u as=0.18p ps=1.72u w=0.36u l=0.28u
X510 VSS.t631 B13.t1 a_76827_20452# VSS.t630 nfet_03v3 ad=0.3168p pd=2.32u as=0.1872p ps=1.24u w=0.72u l=0.28u
X511 VDD a_53463_17382# a_55787_19664# VDD pfet_03v3 ad=0.3168p pd=2.32u as=0.1872p ps=1.24u w=0.72u l=0.28u
X512 a_78035_18828# A14.t9 VSS.t713 VSS.t712 nfet_03v3 ad=93.59999f pd=0.88u as=93.59999f ps=0.88u w=0.36u l=0.28u
X513 a_57835_18700.t0 a_58899_20792# VSS.t639 VSS.t638 nfet_03v3 ad=0.1872p pd=1.24u as=0.1872p ps=1.24u w=0.72u l=0.28u
X514 a_70107_16571# a_69675_19664# a_70355_19664# VDD pfet_03v3 ad=0.1872p pd=1.24u as=86.39999f ps=0.96u w=0.72u l=0.28u
X515 a_72679_16527.t0 a_72671_16853.t10 VDD VDD pfet_03v3 ad=1.147p pd=4.58u as=0.682p ps=3.98u w=1.55u l=0.28u
X516 a_58849_17378# A6.t10 a_58492_17311# VDD.t110 pfet_03v3 ad=0.3744p pd=1.96u as=0.6408p ps=3.77u w=1.44u l=0.28u
X517 a_60731_19216# A7.t6 VDD VDD pfet_03v3 ad=0.1872p pd=1.24u as=0.1872p ps=1.24u w=0.72u l=0.28u
X518 a_83173_18758# a_82035_19664# VSS.t338 VSS.t337 nfet_03v3 ad=0.198p pd=1.78u as=0.117p ps=0.97u w=0.45u l=0.28u
X519 a_47147_19664# A1.t4 a_45835_19848# VDD pfet_03v3 ad=0.1152p pd=1.04u as=0.1872p ps=1.24u w=0.72u l=0.28u
X520 VDD a_50419_19620.t8 a_52091_19664# VDD pfet_03v3 ad=0.1872p pd=1.24u as=0.1152p ps=1.04u w=0.72u l=0.28u
X521 N.t3 Y15.t2 a_83513_16859# VDD.t547 pfet_03v3 ad=0.3744p pd=1.96u as=0.3744p ps=1.96u w=1.44u l=0.28u
X522 VSS.t705 a_45475_19620.t12 a_47147_20124# VSS.t704 nfet_03v3 ad=93.59999f pd=0.88u as=57.59999f ps=0.68u w=0.36u l=0.28u
X523 a_56243_16575# a_41233_17389.t13 a_56075_16575# VSS nfet_03v3 ad=0.2232p pd=1.96u as=0.2016p ps=1.84u w=0.36u l=0.28u
X524 VDD.t191 a_80083_18700.t13 a_81097_17378# VDD.t190 pfet_03v3 ad=0.648p pd=3.78u as=0.3744p ps=1.96u w=1.44u l=0.28u
X525 a_52107_20452# CIN.t24 a_50419_19620.t0 VSS.t581 nfet_03v3 ad=0.1872p pd=1.24u as=0.1872p ps=1.24u w=0.72u l=0.28u
X526 a_75851_16575# A13.t8 VDD.t81 VDD.t80 pfet_03v3 ad=0.1872p pd=1.24u as=0.4284p ps=1.91u w=0.72u l=0.28u
X527 a_80443_19104# a_79563_18828# a_81131_19216# VDD pfet_03v3 ad=0.1872p pd=1.24u as=0.1872p ps=1.24u w=0.72u l=0.28u
X528 a_59507_20124# A6.t11 a_58195_19848# VSS.t285 nfet_03v3 ad=57.59999f pd=0.68u as=93.59999f ps=0.88u w=0.36u l=0.28u
X529 a_81131_20124# a_80083_18700.t14 VSS.t231 VSS.t230 nfet_03v3 ad=93.59999f pd=0.88u as=93.59999f ps=0.88u w=0.36u l=0.28u
X530 a_50579_19664# A3.t6 a_50475_19664# VDD pfet_03v3 ad=86.39999f pd=0.96u as=86.39999f ps=0.96u w=0.72u l=0.28u
X531 a_77667_19664# a_77611_18700.t12 VDD VDD pfet_03v3 ad=86.39999f pd=0.96u as=0.3168p ps=2.32u w=0.72u l=0.28u
X532 a_81755_19664# A15.t7 a_80443_19848# VDD pfet_03v3 ad=0.1152p pd=1.04u as=0.1872p ps=1.24u w=0.72u l=0.28u
X533 VDD a_77611_18700.t13 a_78035_19216# VDD pfet_03v3 ad=0.1872p pd=1.24u as=0.1872p ps=1.24u w=0.72u l=0.28u
X534 VDD.t309 a_43003_19620.t9 a_43715_16575# VDD.t308 pfet_03v3 ad=0.324p pd=2.34u as=0.1872p ps=1.24u w=0.72u l=0.28u
X535 a_76811_20124# A13.t9 a_75499_19848# VSS.t104 nfet_03v3 ad=57.59999f pd=0.68u as=93.59999f ps=0.88u w=0.36u l=0.28u
X536 VSS.t233 a_80083_18700.t15 a_81755_20124# VSS.t232 nfet_03v3 ad=93.59999f pd=0.88u as=57.59999f ps=0.68u w=0.36u l=0.28u
X537 a_78035_19664# A14.t10 VDD VDD pfet_03v3 ad=0.1872p pd=1.24u as=0.1872p ps=1.24u w=0.72u l=0.28u
X538 a_60667_19104# a_59787_18828# a_61355_18828# VSS.t327 nfet_03v3 ad=93.59999f pd=0.88u as=93.59999f ps=0.88u w=0.36u l=0.28u
X539 VSS.t862 a_62735_18464# a_65675_18828# VSS.t861 nfet_03v3 ad=0.1584p pd=1.6u as=93.59999f ps=0.88u w=0.36u l=0.28u
X540 a_43883_16575# a_42244_17389.t11 a_43660_17315# VSS nfet_03v3 ad=0.2232p pd=1.96u as=0.2016p ps=1.84u w=0.36u l=0.28u
X541 VSS.t344 a_57835_18700.t11 a_58259_18828# VSS.t343 nfet_03v3 ad=93.59999f pd=0.88u as=93.59999f ps=0.88u w=0.36u l=0.28u
X542 Y6.t1 a_58715_16575# VSS VSS nfet_03v3 ad=0.1656p pd=1.64u as=0.1584p ps=1.6u w=0.36u l=0.28u
X543 a_47163_20452# CIN.t25 a_45475_19620.t2 VSS.t582 nfet_03v3 ad=0.1872p pd=1.24u as=0.1872p ps=1.24u w=0.72u l=0.28u
X544 a_61187_16575# a_42244_17389.t12 a_60964_17311# VSS nfet_03v3 ad=0.2232p pd=1.96u as=0.2016p ps=1.84u w=0.36u l=0.28u
X545 VDD.t532 a_53556_17315# a_53463_17382# VDD.t531 pfet_03v3 ad=0.3204p pd=2.33u as=0.3348p ps=2.37u w=0.72u l=0.28u
X546 VSS.t726 a_75139_18700.t10 a_75563_18828# VSS.t725 nfet_03v3 ad=93.59999f pd=0.88u as=93.59999f ps=0.88u w=0.36u l=0.28u
X547 a_67987_18828# a_67203_18828# a_67883_18828# VSS.t793 nfet_03v3 ad=93.59999f pd=0.88u as=43.2f ps=0.6u w=0.36u l=0.28u
X548 a_76553_16039# a_75403_18463.t2 a_74520_16039# VSS nfet_03v3 ad=7.1172p pd=11.325u as=7.1172p ps=11.325u w=1.44u l=0.28u
X549 VDD.t176 a_56015_17311# a_55922_17378# VDD.t175 pfet_03v3 ad=0.3204p pd=2.33u as=0.3348p ps=2.37u w=0.72u l=0.28u
X550 VSS.t346 a_57835_18700.t12 a_58492_17311# VSS.t345 nfet_03v3 ad=0.162p pd=1.62u as=93.59999f ps=0.88u w=0.36u l=0.28u
X551 a_55723_19104# a_52854_18468# a_56411_18828# VSS.t191 nfet_03v3 ad=93.59999f pd=0.88u as=93.59999f ps=0.88u w=0.36u l=0.28u
X552 VDD a_67723_18700.t11 a_69395_19216# VDD pfet_03v3 ad=0.1872p pd=1.24u as=0.1152p ps=1.04u w=0.72u l=0.28u
X553 VSS.t141 a_62259_19664# a_63397_18758# VSS.t140 nfet_03v3 ad=0.117p pd=0.97u as=0.279p ps=1.755u w=0.45u l=0.28u
X554 a_80507_19216# a_80443_19104# a_80347_18828# VDD pfet_03v3 ad=0.1872p pd=1.24u as=0.1872p ps=1.24u w=0.72u l=0.28u
X555 a_79995_16571# a_79563_19664# a_80243_20124# VSS.t607 nfet_03v3 ad=93.59999f pd=0.88u as=43.2f ps=0.6u w=0.36u l=0.28u
X556 VSS.t407 a_70760_17379# a_71670_18392# VSS.t406 nfet_03v3 ad=0.324p pd=2.34u as=0.1872p ps=1.24u w=0.72u l=0.28u
X557 a_52371_19664.t1 a_50779_19848# VSS.t225 VSS.t224 nfet_03v3 ad=0.1584p pd=1.6u as=93.59999f ps=0.88u w=0.36u l=0.28u
X558 a_61355_19216# a_60307_18700.t10 VDD VDD pfet_03v3 ad=0.1872p pd=1.24u as=0.1872p ps=1.24u w=0.72u l=0.28u
X559 a_67883_19216# A10.t7 a_67779_19216# VDD pfet_03v3 ad=86.39999f pd=0.96u as=86.39999f ps=0.96u w=0.72u l=0.28u
X560 VDD.t253 a_51076_17315# a_50983_17382# VDD.t252 pfet_03v3 ad=0.3204p pd=2.33u as=0.3348p ps=2.37u w=0.72u l=0.28u
X561 a_48922_16039# a_48209_18467.t2 a_46889_16039# VSS nfet_03v3 ad=7.1172p pd=11.325u as=7.1172p ps=11.325u w=1.44u l=0.28u
X562 VSS.t800 A7.t7 a_61355_20124# VSS.t799 nfet_03v3 ad=93.59999f pd=0.88u as=0.1584p ps=1.6u w=0.36u l=0.28u
X563 a_60667_19848# a_59787_19664# a_61355_19664# VDD pfet_03v3 ad=0.1872p pd=1.24u as=0.1872p ps=1.24u w=0.72u l=0.28u
X564 VDD a_63344_17378# a_65675_19664# VDD pfet_03v3 ad=0.3168p pd=2.32u as=0.1872p ps=1.24u w=0.72u l=0.28u
X565 a_58259_19216# a_58195_19104# a_58099_18828# VDD pfet_03v3 ad=0.1872p pd=1.24u as=0.1872p ps=1.24u w=0.72u l=0.28u
X566 VSS.t657 a_65251_18700.t10 a_66923_18828# VSS.t656 nfet_03v3 ad=93.59999f pd=0.88u as=57.59999f ps=0.68u w=0.36u l=0.28u
X567 a_83499_14862# a_64632_14904.t5 a_83150_14862# VDD pfet_03v3 ad=2.1816p pd=4.395u as=2.1096p ps=4.345u w=2.88u l=0.28u
X568 VSS.t9 a_70853_17312# a_70760_17379# VSS.t8 nfet_03v3 ad=0.1638p pd=1.63u as=0.1638p ps=1.63u w=0.36u l=0.28u
X569 a_57747_16571# a_57315_19664# a_57995_20124# VSS.t25 nfet_03v3 ad=93.59999f pd=0.88u as=43.2f ps=0.6u w=0.36u l=0.28u
X570 VDD a_57835_18700.t13 a_58259_19664# VDD pfet_03v3 ad=0.1872p pd=1.24u as=0.1872p ps=1.24u w=0.72u l=0.28u
X571 a_75563_19216# a_75499_19104# a_75403_18828# VDD pfet_03v3 ad=0.1872p pd=1.24u as=0.1872p ps=1.24u w=0.72u l=0.28u
X572 VSS.t264 a_48306_17315# a_48209_18467.t1 VSS.t263 nfet_03v3 ad=0.171p pd=1.67u as=0.1746p ps=1.69u w=0.36u l=0.28u
X573 a_70263_16571# a_62791_16527.t6 a_70107_16571# VSS nfet_03v3 ad=0.1332p pd=1.1u as=0.18p ps=1.72u w=0.36u l=0.28u
X574 a_76347_20792# B13.t2 a_76203_20792# VDD pfet_03v3 ad=0.3744p pd=1.96u as=0.6336p ps=3.76u w=1.44u l=0.28u
X575 VDD A0.t5 a_44051_19664# VDD pfet_03v3 ad=0.1872p pd=1.24u as=0.3168p ps=2.32u w=0.72u l=0.28u
X576 a_52959_16571# a_52895_16853.t7 a_52803_16571.t2 VDD.t318 pfet_03v3 ad=0.1332p pd=1.1u as=0.18p ps=1.72u w=0.36u l=0.28u
X577 a_75051_16571# a_72623_18464# a_75299_20124# VSS.t120 nfet_03v3 ad=93.59999f pd=0.88u as=43.2f ps=0.6u w=0.36u l=0.28u
X578 VSS.t866 a_77091_19664# a_78035_20124# VSS.t865 nfet_03v3 ad=0.1584p pd=1.6u as=93.59999f ps=0.88u w=0.36u l=0.28u
X579 VDD a_75139_18700.t11 a_75563_19664# VDD pfet_03v3 ad=0.1872p pd=1.24u as=0.1872p ps=1.24u w=0.72u l=0.28u
X580 a_67635_16571# a_67203_19664# a_67883_19664# VDD pfet_03v3 ad=0.1872p pd=1.24u as=86.39999f ps=0.96u w=0.72u l=0.28u
X581 a_55787_18828# a_55723_19104# a_55627_18828# VSS.t923 nfet_03v3 ad=93.59999f pd=0.88u as=93.59999f ps=0.88u w=0.36u l=0.28u
X582 VSS.t1 a_55717_17311# a_55620_18463.t1 VSS.t0 nfet_03v3 ad=0.171p pd=1.67u as=0.1746p ps=1.69u w=0.36u l=0.28u
X583 a_57315_18828# a_55723_19104# VDD VDD pfet_03v3 ad=0.3168p pd=2.32u as=0.1872p ps=1.24u w=0.72u l=0.28u
X584 a_55723_19848# a_53463_17382# a_56411_19664# VDD pfet_03v3 ad=0.1872p pd=1.24u as=0.1872p ps=1.24u w=0.72u l=0.28u
X585 a_46949_18395# a_46187_16575# a_45834_17315# VSS.t146 nfet_03v3 ad=0.1872p pd=1.24u as=0.3276p ps=2.35u w=0.72u l=0.28u
X586 VSS.t544 a_55363_18700.t10 a_57035_20124# VSS.t543 nfet_03v3 ad=93.59999f pd=0.88u as=57.59999f ps=0.68u w=0.36u l=0.28u
X587 a_83137_17311# a_82973_19616# VDD VDD pfet_03v3 ad=1.147p pd=4.58u as=0.682p ps=3.98u w=1.55u l=0.28u
X588 VDD A9.t13 a_66299_19216# VDD pfet_03v3 ad=0.1872p pd=1.24u as=0.3168p ps=2.32u w=0.72u l=0.28u
X589 VDD a_47947_19620.t9 a_49619_19664# VDD pfet_03v3 ad=0.1872p pd=1.24u as=0.1152p ps=1.04u w=0.72u l=0.28u
X590 VDD a_79563_18828# a_80507_19216# VDD pfet_03v3 ad=0.3168p pd=2.32u as=0.1872p ps=1.24u w=0.72u l=0.28u
X591 a_55523_20124# A5.t10 a_55419_20124# VSS.t512 nfet_03v3 ad=43.2f pd=0.6u as=43.2f ps=0.6u w=0.36u l=0.28u
X592 VDD a_65251_18700.t11 a_66923_19664# VDD pfet_03v3 ad=0.1872p pd=1.24u as=0.1152p ps=1.04u w=0.72u l=0.28u
X593 a_64632_14904.t0 a_70458_18464.t3 a_68698_16039# VSS nfet_03v3 ad=12.0384p pd=19.6u as=7.1172p ps=11.325u w=1.44u l=0.28u
X594 a_80507_20124# A15.t8 VSS.t900 VSS.t899 nfet_03v3 ad=93.59999f pd=0.88u as=93.59999f ps=0.88u w=0.36u l=0.28u
X595 VSS.t261 a_40610_17389.t4 a_42244_17389.t0 VSS.t260 nfet_03v3 ad=0.162p pd=1.62u as=0.1818p ps=1.37u w=0.36u l=0.28u
X596 a_66939_20452# CIN.t26 a_65251_18700.t1 VSS.t576 nfet_03v3 ad=0.1872p pd=1.24u as=0.1872p ps=1.24u w=0.72u l=0.28u
X597 a_45899_19664# A1.t5 VDD VDD pfet_03v3 ad=0.1872p pd=1.24u as=0.1872p ps=1.24u w=0.72u l=0.28u
X598 a_80139_19216# a_80083_18700.t16 VDD VDD pfet_03v3 ad=86.39999f pd=0.96u as=0.3168p ps=2.32u w=0.72u l=0.28u
X599 VSS.t533 a_54009_17863# a_53556_17315# VSS.t532 nfet_03v3 ad=0.162p pd=1.62u as=93.59999f ps=0.88u w=0.36u l=0.28u
X600 VDD CIN.t27 a_63987_20792# VDD pfet_03v3 ad=0.3744p pd=1.96u as=0.3744p ps=1.96u w=1.44u l=0.28u
X601 a_83193_17431# a_83137_17311# a_83049_17431# VDD.t307 pfet_03v3 ad=0.3744p pd=1.96u as=0.6336p ps=3.76u w=1.44u l=0.28u
X602 VSS.t578 CIN.t28 a_49011_20792# VSS.t577 nfet_03v3 ad=0.1872p pd=1.24u as=0.1872p ps=1.24u w=0.72u l=0.28u
X603 a_61979_20124# A7.t8 a_60667_19848# VSS.t801 nfet_03v3 ad=57.59999f pd=0.68u as=93.59999f ps=0.88u w=0.36u l=0.28u
X604 a_72679_16527.t1 a_72671_16853.t11 VSS.t435 VSS.t434 nfet_03v3 ad=0.5735p pd=3.03u as=0.341p ps=2.43u w=0.775u l=0.28u
X605 a_75299_18828# A13.t10 a_75195_18828# VSS.t105 nfet_03v3 ad=43.2f pd=0.6u as=43.2f ps=0.6u w=0.36u l=0.28u
X606 VDD CIN.t29 a_81291_20792# VDD pfet_03v3 ad=0.3744p pd=1.96u as=0.3744p ps=1.96u w=1.44u l=0.28u
X607 a_82467_20154# a_79563_19664# VSS.t606 VSS.t605 nfet_03v3 ad=0.1918p pd=1.325u as=0.117p ps=0.97u w=0.45u l=0.28u
X608 a_55787_19664# a_55723_19848# a_55275_16571# VDD pfet_03v3 ad=0.1872p pd=1.24u as=0.1872p ps=1.24u w=0.72u l=0.28u
X609 Y0.t1 a_43883_16575# VSS VSS nfet_03v3 ad=0.1656p pd=1.64u as=0.1584p ps=1.6u w=0.36u l=0.28u
X610 a_58259_20124# A6.t12 VSS.t287 VSS.t286 nfet_03v3 ad=93.59999f pd=0.88u as=93.59999f ps=0.88u w=0.36u l=0.28u
X611 a_58715_16575# a_42244_17389.t13 a_58492_17311# VSS nfet_03v3 ad=0.2232p pd=1.96u as=0.2016p ps=1.84u w=0.36u l=0.28u
X612 a_75139_18700.t2 CIN.t30 a_76667_20792# VDD pfet_03v3 ad=0.3744p pd=1.96u as=0.3744p ps=1.96u w=1.44u l=0.28u
X613 a_44675_19664# A0.t6 a_43363_19848# VDD pfet_03v3 ad=0.1152p pd=1.04u as=0.1872p ps=1.24u w=0.72u l=0.28u
X614 VSS.t241 a_60307_18700.t11 a_60731_18828# VSS.t240 nfet_03v3 ad=93.59999f pd=0.88u as=93.59999f ps=0.88u w=0.36u l=0.28u
X615 VSS.t747 a_63344_17378# a_64254_18391# VSS.t746 nfet_03v3 ad=0.324p pd=2.34u as=0.1872p ps=1.24u w=0.72u l=0.28u
X616 a_75563_20124# A13.t11 VSS.t276 VSS.t275 nfet_03v3 ad=93.59999f pd=0.88u as=93.59999f ps=0.88u w=0.36u l=0.28u
X617 a_75195_19216# a_75139_18700.t12 VDD VDD pfet_03v3 ad=86.39999f pd=0.96u as=0.3168p ps=2.32u w=0.72u l=0.28u
X618 VSS.t855 a_50983_17382# a_51893_18395# VSS.t854 nfet_03v3 ad=0.324p pd=2.34u as=0.1872p ps=1.24u w=0.72u l=0.28u
X619 VDD.t664 a_75139_18700.t13 a_76155_17378# VDD.t663 pfet_03v3 ad=0.648p pd=3.78u as=0.3744p ps=1.96u w=1.44u l=0.28u
X620 VDD CIN.t31 a_59043_20792# VDD pfet_03v3 ad=0.3744p pd=1.96u as=0.3744p ps=1.96u w=1.44u l=0.28u
X621 a_82973_18758# a_72679_16527.t5 a_82467_19228# VDD pfet_03v3 ad=0.486p pd=2.07u as=0.38363p ps=2u w=1.35u l=0.28u
X622 VDD.t35 a_46039_17382# a_45834_17315# VDD.t34 pfet_03v3 ad=0.4284p pd=1.91u as=0.1872p ps=1.24u w=0.72u l=0.28u
X623 VSS.t130 a_63437_17311# a_63344_17378# VSS.t129 nfet_03v3 ad=0.1638p pd=1.63u as=0.1638p ps=1.63u w=0.36u l=0.28u
X624 a_55419_18828# a_55363_18700.t11 VSS.t546 VSS.t545 nfet_03v3 ad=43.2f pd=0.6u as=0.1584p ps=1.6u w=0.36u l=0.28u
X625 a_66923_19216# A9.t14 a_65611_19104# VDD pfet_03v3 ad=0.1152p pd=1.04u as=0.1872p ps=1.24u w=0.72u l=0.28u
X626 a_51483_20792# B3.t3 VSS.t509 VSS.t508 nfet_03v3 ad=0.1872p pd=1.24u as=0.3168p ps=2.32u w=0.72u l=0.28u
X627 a_49899_19664# a_48307_19848# VSS.t217 VSS.t216 nfet_03v3 ad=0.1584p pd=1.6u as=93.59999f ps=0.88u w=0.36u l=0.28u
X628 a_65515_18828# a_62783_16853.t9 a_65319_16571# VSS nfet_03v3 ad=0.4446p pd=3.19u as=0.1332p ps=1.1u w=0.36u l=0.28u
X629 VDD.t355 a_70760_17379# a_70555_17312# VDD.t354 pfet_03v3 ad=0.4284p pd=1.91u as=0.1872p ps=1.24u w=0.72u l=0.28u
X630 VSS.t732 B4.t2 a_54579_20452# VSS.t731 nfet_03v3 ad=0.3168p pd=2.32u as=0.1872p ps=1.24u w=0.72u l=0.28u
X631 VDD.t25 a_78268_17311# a_78175_17378# VDD.t24 pfet_03v3 ad=0.3204p pd=2.33u as=0.3348p ps=2.37u w=0.72u l=0.28u
X632 VSS.t124 B11.t2 a_71883_20452# VSS.t123 nfet_03v3 ad=0.3168p pd=2.32u as=0.1872p ps=1.24u w=0.72u l=0.28u
X633 VSS.t289 A6.t13 a_58883_20124# VSS.t288 nfet_03v3 ad=93.59999f pd=0.88u as=0.1584p ps=1.6u w=0.36u l=0.28u
X634 VDD a_49899_19664# a_50843_19664# VDD pfet_03v3 ad=0.3168p pd=2.32u as=0.1872p ps=1.24u w=0.72u l=0.28u
X635 a_75299_19664# A13.t12 a_75195_19664# VDD pfet_03v3 ad=86.39999f pd=0.96u as=86.39999f ps=0.96u w=0.72u l=0.28u
X636 a_83173_19138# a_82035_19664# VDD VDD pfet_03v3 ad=0.396p pd=2.68u as=0.234p ps=1.42u w=0.9u l=0.28u
X637 a_46355_16575# a_41692_17389.t14 a_45739_19664# VSS nfet_03v3 ad=0.2034p pd=1.85u as=0.2016p ps=1.84u w=0.36u l=0.28u
X638 a_43267_19664# CIN.t32 a_43163_20124# VSS.t575 nfet_03v3 ad=93.59999f pd=0.88u as=43.2f ps=0.6u w=0.36u l=0.28u
X639 VSS.t127 a_44955_19664# a_45899_20124# VSS.t126 nfet_03v3 ad=0.1584p pd=1.6u as=93.59999f ps=0.88u w=0.36u l=0.28u
X640 VDD a_43003_19620.t10 a_43427_19664# VDD pfet_03v3 ad=0.1872p pd=1.24u as=0.1872p ps=1.24u w=0.72u l=0.28u
X641 a_67791_16571# a_62791_16527.t7 a_67635_16571# VSS nfet_03v3 ad=0.1332p pd=1.1u as=0.18p ps=1.72u w=0.36u l=0.28u
X642 a_83049_16859# F.t5 VSS VSS nfet_03v3 ad=0.1872p pd=1.24u as=0.3168p ps=2.32u w=0.72u l=0.28u
X643 a_64307_20792# B8.t2 a_63890_17859# VDD pfet_03v3 ad=0.6336p pd=3.76u as=0.3744p ps=1.96u w=1.44u l=0.28u
X644 Y11.t1 a_71075_16575# VSS VSS nfet_03v3 ad=0.1656p pd=1.64u as=0.1584p ps=1.6u w=0.36u l=0.28u
X645 F.t2 a_83272_18186# a_83513_17431# VDD.t547 pfet_03v3 ad=0.3744p pd=1.96u as=0.3744p ps=1.96u w=1.44u l=0.28u
X646 VSS.t60 a_73778_17859# a_73325_17311# VSS.t59 nfet_03v3 ad=0.162p pd=1.62u as=93.59999f ps=0.88u w=0.36u l=0.28u
X647 a_46539_20792# B1.t1 VSS.t431 VSS.t430 nfet_03v3 ad=0.1872p pd=1.24u as=0.3168p ps=2.32u w=0.72u l=0.28u
X648 VSS.t643 B2.t1 a_49635_20452# VSS.t642 nfet_03v3 ad=0.3168p pd=2.32u as=0.1872p ps=1.24u w=0.72u l=0.28u
X649 a_60219_16571# a_59787_19664# a_60467_20124# VSS.t918 nfet_03v3 ad=93.59999f pd=0.88u as=43.2f ps=0.6u w=0.36u l=0.28u
X650 VDD a_60307_18700.t12 a_60731_19664# VDD pfet_03v3 ad=0.1872p pd=1.24u as=0.1872p ps=1.24u w=0.72u l=0.28u
X651 a_81611_20792# B15.t2 a_80083_18700.t0 VDD pfet_03v3 ad=0.6336p pd=3.76u as=0.3744p ps=1.96u w=1.44u l=0.28u
X652 VDD.t222 a_48306_17315# a_48209_18467.t0 VDD.t221 pfet_03v3 ad=0.324p pd=2.34u as=0.3312p ps=2.36u w=0.72u l=0.28u
X653 a_64632_14904.t4 a_62691_16571.t4 VDD VDD pfet_03v3 ad=3.5586p pd=10.605u as=6.3756p ps=19.15u w=0.72u l=0.28u
X654 VSS.t648 SEL1.t3 a_41692_17389.t2 VSS.t647 nfet_03v3 ad=0.162p pd=1.62u as=0.1818p ps=1.37u w=0.36u l=0.28u
X655 a_55419_19664# a_55363_18700.t12 VDD VDD pfet_03v3 ad=86.39999f pd=0.96u as=0.3168p ps=2.32u w=0.72u l=0.28u
X656 a_56571_20792# B5.t1 a_56427_20792# VDD pfet_03v3 ad=0.3744p pd=1.96u as=0.6336p ps=3.76u w=1.44u l=0.28u
X657 a_43362_17315# a_43715_16575# VDD.t275 VDD.t274 pfet_03v3 ad=0.1872p pd=1.24u as=0.3276p ps=2.35u w=0.72u l=0.28u
X658 a_58099_18828# a_52371_19664.t7 a_57903_16571# VDD.t548 pfet_03v3 ad=0.4446p pd=3.19u as=0.1332p ps=1.1u w=0.36u l=0.28u
X659 a_59363_20792# B6.t0 a_57835_18700.t1 VDD pfet_03v3 ad=0.6336p pd=3.76u as=0.3744p ps=1.96u w=1.44u l=0.28u
X660 VSS.t243 a_60307_18700.t13 a_61979_18828# VSS.t242 nfet_03v3 ad=93.59999f pd=0.88u as=57.59999f ps=0.68u w=0.36u l=0.28u
X661 a_73875_20792# B12.t1 a_73731_20792# VDD pfet_03v3 ad=0.3744p pd=1.96u as=0.6336p ps=3.76u w=1.44u l=0.28u
X662 a_46523_20124# a_45475_19620.t13 VSS.t707 VSS.t706 nfet_03v3 ad=93.59999f pd=0.88u as=93.59999f ps=0.88u w=0.36u l=0.28u
X663 a_67779_20124# a_67723_18700.t12 VSS.t395 VSS.t394 nfet_03v3 ad=43.2f pd=0.6u as=0.1584p ps=1.6u w=0.36u l=0.28u
X664 a_77091_19664# a_75499_19848# VSS.t177 VSS.t176 nfet_03v3 ad=0.1584p pd=1.6u as=93.59999f ps=0.88u w=0.36u l=0.28u
X665 a_65515_18828# a_62735_18464# a_65411_19216# VDD pfet_03v3 ad=0.1872p pd=1.24u as=86.39999f ps=0.96u w=0.72u l=0.28u
X666 a_75403_18828# a_72671_16853.t12 a_75207_16571# VDD.t448 pfet_03v3 ad=0.4446p pd=3.19u as=0.1332p ps=1.1u w=0.36u l=0.28u
X667 VDD.t203 a_65908_17312# a_65815_17379# VDD.t202 pfet_03v3 ad=0.3204p pd=2.33u as=0.3348p ps=2.37u w=0.72u l=0.28u
X668 VDD a_62259_19664# a_63397_19138# VDD pfet_03v3 ad=0.234p pd=1.42u as=0.558p ps=2.43u w=0.9u l=0.28u
X669 a_71210_17379# A11.t10 a_70853_17312# VDD.t749 pfet_03v3 ad=0.3744p pd=1.96u as=0.6408p ps=3.77u w=1.44u l=0.28u
X670 a_73547_16575# a_41692_17389.t15 a_72735_16571# VSS nfet_03v3 ad=0.2034p pd=1.85u as=0.2016p ps=1.84u w=0.36u l=0.28u
X671 VSS.t659 a_65251_18700.t12 a_65908_17312# VSS.t658 nfet_03v3 ad=0.162p pd=1.62u as=93.59999f ps=0.88u w=0.36u l=0.28u
X672 a_60467_18828# A7.t9 a_60363_18828# VSS.t802 nfet_03v3 ad=43.2f pd=0.6u as=43.2f ps=0.6u w=0.36u l=0.28u
X673 a_77679_16571# a_72679_16527.t6 a_77523_16571# VDD.t515 pfet_03v3 ad=0.1332p pd=1.1u as=0.18p ps=1.72u w=0.36u l=0.28u
X674 VDD.t455 a_54009_17863# a_53913_17382# VDD.t454 pfet_03v3 ad=0.648p pd=3.78u as=0.3744p ps=1.96u w=1.44u l=0.28u
X675 a_78035_20124# a_77971_19848# a_77523_16571# VSS.t277 nfet_03v3 ad=93.59999f pd=0.88u as=93.59999f ps=0.88u w=0.36u l=0.28u
X676 a_83673_16519# Y15.t3 N.t2 VSS nfet_03v3 ad=0.1872p pd=1.24u as=0.1872p ps=1.24u w=0.72u l=0.28u
X677 VSS.t370 a_80647_17378# a_81557_18391# VSS.t369 nfet_03v3 ad=0.324p pd=2.34u as=0.1872p ps=1.24u w=0.72u l=0.28u
X678 a_83272_18186# a_82973_18758# VDD VDD pfet_03v3 ad=1.147p pd=4.58u as=0.682p ps=3.98u w=1.55u l=0.28u
X679 VDD.t624 a_63344_17378# a_63051_16571# VDD.t623 pfet_03v3 ad=0.4284p pd=1.91u as=0.1872p ps=1.24u w=0.72u l=0.28u
X680 a_60363_19216# a_60307_18700.t14 VDD VDD pfet_03v3 ad=86.39999f pd=0.96u as=0.3168p ps=2.32u w=0.72u l=0.28u
X681 a_69395_18828# A10.t8 a_68083_19104# VSS.t695 nfet_03v3 ad=57.59999f pd=0.68u as=93.59999f ps=0.88u w=0.36u l=0.28u
X682 VDD CIN.t33 a_44211_20792# VDD pfet_03v3 ad=0.3744p pd=1.96u as=0.3744p ps=1.96u w=1.44u l=0.28u
X683 a_70619_19216# A11.t11 VDD VDD pfet_03v3 ad=0.1872p pd=1.24u as=0.1872p ps=1.24u w=0.72u l=0.28u
X684 VSS.t843 a_47947_19620.t10 a_48604_17315# VSS.t842 nfet_03v3 ad=0.162p pd=1.62u as=93.59999f ps=0.88u w=0.36u l=0.28u
X685 a_49875_18395# A2.t9 a_48659_16575# VSS.t841 nfet_03v3 ad=0.1872p pd=1.24u as=0.3276p ps=2.35u w=0.72u l=0.28u
X686 a_68603_16575# a_41692_17389.t16 a_67791_16571# VSS nfet_03v3 ad=0.2034p pd=1.85u as=0.2016p ps=1.84u w=0.36u l=0.28u
X687 Y9.t0 a_66131_16575# VDD.t73 VDD.t72 pfet_03v3 ad=0.3312p pd=2.36u as=0.3168p ps=2.32u w=0.72u l=0.28u
X688 VSS.t633 a_80740_17311# a_80647_17378# VSS.t632 nfet_03v3 ad=0.1638p pd=1.63u as=0.1638p ps=1.63u w=0.36u l=0.28u
X689 VDD a_60307_18700.t15 a_61979_19664# VDD pfet_03v3 ad=0.1872p pd=1.24u as=0.1152p ps=1.04u w=0.72u l=0.28u
X690 VSS.t822 a_58399_17378# a_59309_18391# VSS.t821 nfet_03v3 ad=0.324p pd=2.34u as=0.1872p ps=1.24u w=0.72u l=0.28u
X691 VDD CIN.t34 a_61515_20792# VDD pfet_03v3 ad=0.3744p pd=1.96u as=0.3744p ps=1.96u w=1.44u l=0.28u
X692 a_78659_18828# a_77611_18700.t14 VSS.t54 VSS.t53 nfet_03v3 ad=93.59999f pd=0.88u as=93.59999f ps=0.88u w=0.36u l=0.28u
X693 VSS.t468 a_55363_18700.t13 a_56015_17311# VSS.t467 nfet_03v3 ad=0.162p pd=1.62u as=93.59999f ps=0.88u w=0.36u l=0.28u
X694 a_66131_16575# a_41233_17389.t14 a_65963_16575# VSS nfet_03v3 ad=0.2232p pd=1.96u as=0.2016p ps=1.84u w=0.36u l=0.28u
X695 a_50779_19848# a_49899_19664# a_51467_20124# VSS.t538 nfet_03v3 ad=93.59999f pd=0.88u as=93.59999f ps=0.88u w=0.36u l=0.28u
X696 a_45739_19664# a_44955_19664# a_45635_19664# VDD pfet_03v3 ad=0.1872p pd=1.24u as=86.39999f ps=0.96u w=0.72u l=0.28u
X697 VSS.t424 a_70195_18700.t12 a_70853_17312# VSS.t423 nfet_03v3 ad=0.162p pd=1.62u as=93.59999f ps=0.88u w=0.36u l=0.28u
X698 VSS.t845 a_47947_19620.t11 a_48371_20124# VSS.t844 nfet_03v3 ad=93.59999f pd=0.88u as=93.59999f ps=0.88u w=0.36u l=0.28u
X699 VDD a_47427_19664# a_48371_19664# VDD pfet_03v3 ad=0.3168p pd=2.32u as=0.1872p ps=1.24u w=0.72u l=0.28u
X700 a_60467_19664# A7.t10 a_60363_19664# VDD pfet_03v3 ad=86.39999f pd=0.96u as=86.39999f ps=0.96u w=0.72u l=0.28u
X701 a_65675_19216# A9.t15 VDD VDD pfet_03v3 ad=0.1872p pd=1.24u as=0.1872p ps=1.24u w=0.72u l=0.28u
X702 a_41692_17389.t1 SEL0.t6 VSS.t556 VSS.t555 nfet_03v3 ad=0.1818p pd=1.37u as=0.162p ps=1.62u w=0.36u l=0.28u
X703 a_70555_19104# a_69675_18828# a_71243_18828# VSS.t136 nfet_03v3 ad=93.59999f pd=0.88u as=93.59999f ps=0.88u w=0.36u l=0.28u
X704 a_52959_16571# a_52371_19664.t8 a_52803_16571.t3 VSS nfet_03v3 ad=0.1332p pd=1.1u as=0.18p ps=1.72u w=0.36u l=0.28u
X705 VSS.t668 a_65251_18700.t13 a_65675_20124# VSS.t667 nfet_03v3 ad=93.59999f pd=0.88u as=93.59999f ps=0.88u w=0.36u l=0.28u
X706 Y10.t1 a_68603_16575# VSS VSS nfet_03v3 ad=0.1656p pd=1.64u as=0.1584p ps=1.6u w=0.36u l=0.28u
X707 VSS.t397 a_67723_18700.t13 a_68147_18828# VSS.t396 nfet_03v3 ad=93.59999f pd=0.88u as=93.59999f ps=0.88u w=0.36u l=0.28u
X708 a_49155_20792# B2.t2 a_49011_20792# VDD pfet_03v3 ad=0.3744p pd=1.96u as=0.6336p ps=3.76u w=1.44u l=0.28u
X709 a_68771_20124# a_67723_18700.t14 VSS.t399 VSS.t398 nfet_03v3 ad=93.59999f pd=0.88u as=93.59999f ps=0.88u w=0.36u l=0.28u
X710 a_69395_19664# A10.t9 a_68083_19848# VDD pfet_03v3 ad=0.1152p pd=1.04u as=0.1872p ps=1.24u w=0.72u l=0.28u
X711 a_71075_16575# a_42244_17389.t14 a_70853_17312# VSS nfet_03v3 ad=0.2232p pd=1.96u as=0.2016p ps=1.84u w=0.36u l=0.28u
X712 a_51299_16575# a_40765_17389.t11 a_50778_17315# VSS nfet_03v3 ad=0.2232p pd=1.96u as=0.2016p ps=1.84u w=0.36u l=0.28u
X713 a_78659_19664# a_77611_18700.t15 VDD VDD pfet_03v3 ad=0.1872p pd=1.24u as=0.1872p ps=1.24u w=0.72u l=0.28u
X714 a_65611_19104# a_62735_18464# a_66299_18828# VSS.t860 nfet_03v3 ad=93.59999f pd=0.88u as=93.59999f ps=0.88u w=0.36u l=0.28u
X715 VDD a_77611_18700.t16 a_79283_19216# VDD pfet_03v3 ad=0.1872p pd=1.24u as=0.1152p ps=1.04u w=0.72u l=0.28u
X716 VSS.t89 a_72147_19664# a_73285_18758# VSS.t88 nfet_03v3 ad=0.117p pd=0.97u as=0.279p ps=1.755u w=0.45u l=0.28u
X717 a_46132_17315# A1.t6 VSS.t353 VSS.t352 nfet_03v3 ad=93.59999f pd=0.88u as=0.1638p ps=1.63u w=0.36u l=0.28u
X718 a_76203_20792# B13.t3 VSS.t624 VSS.t623 nfet_03v3 ad=0.1872p pd=1.24u as=0.3168p ps=2.32u w=0.72u l=0.28u
X719 a_62259_19664# a_60667_19848# VSS.t250 VSS.t249 nfet_03v3 ad=0.1584p pd=1.6u as=93.59999f ps=0.88u w=0.36u l=0.28u
X720 VSS.t330 a_57835_18700.t14 a_59507_18828# VSS.t329 nfet_03v3 ad=93.59999f pd=0.88u as=57.59999f ps=0.68u w=0.36u l=0.28u
X721 a_58810_16039# a_58097_18463.t3 a_56777_16039# VSS nfet_03v3 ad=7.1172p pd=11.325u as=7.1172p ps=11.325u w=1.44u l=0.28u
X722 a_60571_18828# a_52371_19664.t9 a_60375_16571# VDD.t467 pfet_03v3 ad=0.4446p pd=3.19u as=0.1332p ps=1.1u w=0.36u l=0.28u
X723 a_70355_18828# A11.t12 a_70251_18828# VSS.t888 nfet_03v3 ad=43.2f pd=0.6u as=43.2f ps=0.6u w=0.36u l=0.28u
X724 a_77771_19216# A14.t11 a_77667_19216# VDD pfet_03v3 ad=86.39999f pd=0.96u as=86.39999f ps=0.96u w=0.72u l=0.28u
X725 a_46355_16575# a_40765_17389.t12 a_45834_17315# VSS nfet_03v3 ad=0.2232p pd=1.96u as=0.2016p ps=1.84u w=0.36u l=0.28u
X726 VSS.t884 A11.t13 a_71243_20124# VSS.t883 nfet_03v3 ad=93.59999f pd=0.88u as=0.1584p ps=1.6u w=0.36u l=0.28u
X727 a_70555_19848# a_69675_19664# a_71243_19664# VDD pfet_03v3 ad=0.1872p pd=1.24u as=0.1872p ps=1.24u w=0.72u l=0.28u
X728 VDD a_79563_19664# a_82467_19616# VDD pfet_03v3 ad=0.234p pd=1.42u as=0.468p ps=2.84u w=0.9u l=0.28u
X729 a_72147_18828# a_70555_19104# VDD VDD pfet_03v3 ad=0.3168p pd=2.32u as=0.1872p ps=1.24u w=0.72u l=0.28u
X730 VSS.t785 a_75139_18700.t14 a_76811_18828# VSS.t784 nfet_03v3 ad=93.59999f pd=0.88u as=57.59999f ps=0.68u w=0.36u l=0.28u
X731 a_68738_17379# A10.t10 a_68381_17312# VDD.t618 pfet_03v3 ad=0.3744p pd=1.96u as=0.6408p ps=3.77u w=1.44u l=0.28u
X732 a_82973_19616# a_72671_16853.t13 a_82467_20154# VSS.t959 nfet_03v3 ad=0.243p pd=1.395u as=0.1918p ps=1.325u w=0.675u l=0.28u
X733 a_50843_19664# a_50779_19848# a_50683_19664# VDD pfet_03v3 ad=0.1872p pd=1.24u as=0.1872p ps=1.24u w=0.72u l=0.28u
X734 a_45899_20124# a_45835_19848# a_45739_19664# VSS.t756 nfet_03v3 ad=93.59999f pd=0.88u as=93.59999f ps=0.88u w=0.36u l=0.28u
X735 VDD a_67723_18700.t15 a_68147_19664# VDD pfet_03v3 ad=0.1872p pd=1.24u as=0.1872p ps=1.24u w=0.72u l=0.28u
X736 a_83173_19616# a_72671_16853.t14 a_82973_19616# VDD pfet_03v3 ad=0.558p pd=2.43u as=0.486p ps=2.07u w=1.35u l=0.28u
X737 a_55787_18828# A5.t11 VSS.t514 VSS.t513 nfet_03v3 ad=93.59999f pd=0.88u as=93.59999f ps=0.88u w=0.36u l=0.28u
X738 a_60964_17311# A7.t11 VSS.t804 VSS.t803 nfet_03v3 ad=93.59999f pd=0.88u as=0.1638p ps=1.63u w=0.36u l=0.28u
X739 a_48307_19848# a_47427_19664# a_48995_19664# VDD pfet_03v3 ad=0.1872p pd=1.24u as=0.1872p ps=1.24u w=0.72u l=0.28u
X740 VDD.t321 a_80647_17378# a_80442_17311# VDD.t320 pfet_03v3 ad=0.4284p pd=1.91u as=0.1872p ps=1.24u w=0.72u l=0.28u
X741 a_47947_19620.t2 CIN.t35 a_49475_20792# VDD pfet_03v3 ad=0.3744p pd=1.96u as=0.3744p ps=1.96u w=1.44u l=0.28u
X742 a_65611_19848# a_63344_17378# a_66299_19664# VDD pfet_03v3 ad=0.1872p pd=1.24u as=0.1872p ps=1.24u w=0.72u l=0.28u
X743 a_57891_19216# a_57835_18700.t15 VDD VDD pfet_03v3 ad=86.39999f pd=0.96u as=0.3168p ps=2.32u w=0.72u l=0.28u
X744 a_67203_18828# a_65611_19104# VDD VDD pfet_03v3 ad=0.3168p pd=2.32u as=0.1872p ps=1.24u w=0.72u l=0.28u
X745 Y3.t0 a_51299_16575# VDD.t622 VDD.t621 pfet_03v3 ad=0.3312p pd=2.36u as=0.3168p ps=2.32u w=0.72u l=0.28u
X746 a_44955_19664# a_43363_19848# VSS.t310 VSS.t309 nfet_03v3 ad=0.1584p pd=1.6u as=93.59999f ps=0.88u w=0.36u l=0.28u
X747 VDD A13.t13 a_76187_19216# VDD pfet_03v3 ad=0.1872p pd=1.24u as=0.3168p ps=2.32u w=0.72u l=0.28u
X748 VDD.t703 a_58399_17378# a_58194_17311# VDD.t702 pfet_03v3 ad=0.4284p pd=1.91u as=0.1872p ps=1.24u w=0.72u l=0.28u
X749 VSS.t488 CIN.t36 a_63843_20792# VSS.t487 nfet_03v3 ad=0.1872p pd=1.24u as=0.1872p ps=1.24u w=0.72u l=0.28u
X750 a_48107_20124# A2.t10 a_48003_20124# VSS.t840 nfet_03v3 ad=43.2f pd=0.6u as=43.2f ps=0.6u w=0.36u l=0.28u
X751 VDD a_57835_18700.t16 a_59507_19664# VDD pfet_03v3 ad=0.1872p pd=1.24u as=0.1152p ps=1.04u w=0.72u l=0.28u
X752 a_73285_18758# a_62791_16527.t8 a_72671_16853.t2 VSS.t429 nfet_03v3 ad=0.279p pd=1.755u as=0.243p ps=1.395u w=0.675u l=0.28u
X753 VSS.t939 a_50419_19620.t9 a_51076_17315# VSS.t938 nfet_03v3 ad=0.162p pd=1.62u as=93.59999f ps=0.88u w=0.36u l=0.28u
X754 a_70355_19664# A11.t14 a_70251_19664# VDD pfet_03v3 ad=86.39999f pd=0.96u as=86.39999f ps=0.96u w=0.72u l=0.28u
X755 VDD.t717 a_47947_19620.t12 a_48961_17382# VDD.t716 pfet_03v3 ad=0.648p pd=3.78u as=0.3744p ps=1.96u w=1.44u l=0.28u
X756 VSS.t490 CIN.t37 a_81147_20792# VSS.t489 nfet_03v3 ad=0.1872p pd=1.24u as=0.1872p ps=1.24u w=0.72u l=0.28u
X757 VDD a_75139_18700.t15 a_76811_19664# VDD pfet_03v3 ad=0.1872p pd=1.24u as=0.1152p ps=1.04u w=0.72u l=0.28u
X758 a_51299_16575# a_41233_17389.t15 a_51131_16575# VSS nfet_03v3 ad=0.2232p pd=1.96u as=0.2016p ps=1.84u w=0.36u l=0.28u
X759 a_65411_20124# A9.t16 a_65307_20124# VSS.t83 nfet_03v3 ad=43.2f pd=0.6u as=43.2f ps=0.6u w=0.36u l=0.28u
X760 a_74520_14904.t4 a_80345_18463.t3 a_78586_16039# VSS nfet_03v3 ad=12.0384p pd=19.6u as=7.1172p ps=11.325u w=1.44u l=0.28u
X761 a_76827_20452# CIN.t38 a_75139_18700.t1 VSS.t491 nfet_03v3 ad=0.1872p pd=1.24u as=0.1872p ps=1.24u w=0.72u l=0.28u
X762 a_55787_19664# A5.t12 VDD VDD pfet_03v3 ad=0.1872p pd=1.24u as=0.1872p ps=1.24u w=0.72u l=0.28u
X763 a_82035_18828# a_80443_19104# VSS.t947 VSS.t946 nfet_03v3 ad=0.1584p pd=1.6u as=93.59999f ps=0.88u w=0.36u l=0.28u
X764 VSS.t393 a_67723_18700.t16 a_68381_17312# VSS.t392 nfet_03v3 ad=0.162p pd=1.62u as=93.59999f ps=0.88u w=0.36u l=0.28u
X765 a_40765_17389.t2 SEL1.t4 SEL0.t2 VSS.t649 nfet_03v3 ad=93.59999f pd=0.88u as=0.1656p ps=1.64u w=0.36u l=0.28u
X766 a_51947_20792# a_51483_20792# VDD VDD pfet_03v3 ad=0.3744p pd=1.96u as=0.3744p ps=1.96u w=1.44u l=0.28u
X767 a_71867_20124# A11.t15 a_70555_19848# VSS.t885 nfet_03v3 ad=57.59999f pd=0.68u as=93.59999f ps=0.88u w=0.36u l=0.28u
X768 VSS.t326 a_59787_18828# a_60731_18828# VSS.t325 nfet_03v3 ad=0.1584p pd=1.6u as=93.59999f ps=0.88u w=0.36u l=0.28u
X769 VSS.t493 CIN.t39 a_58899_20792# VSS.t492 nfet_03v3 ad=0.1872p pd=1.24u as=0.1872p ps=1.24u w=0.72u l=0.28u
X770 VSS.t941 a_50419_19620.t10 a_50843_20124# VSS.t940 nfet_03v3 ad=93.59999f pd=0.88u as=93.59999f ps=0.88u w=0.36u l=0.28u
X771 a_62691_18780# a_62259_18828# VSS.t828 VSS.t827 nfet_03v3 ad=0.1918p pd=1.325u as=0.117p ps=0.97u w=0.45u l=0.28u
X772 a_83272_18186# a_82973_18758# VSS.t771 VSS.t770 nfet_03v3 ad=0.5735p pd=3.03u as=0.341p ps=2.43u w=0.775u l=0.28u
X773 VSS.t670 a_65251_18700.t14 a_67179_18392# VSS.t669 nfet_03v3 ad=0.324p pd=2.34u as=0.1872p ps=1.24u w=0.72u l=0.28u
X774 a_68147_20124# A10.t11 VSS.t734 VSS.t733 nfet_03v3 ad=93.59999f pd=0.88u as=93.59999f ps=0.88u w=0.36u l=0.28u
X775 VSS.t336 a_82035_19664# a_83173_18758# VSS.t335 nfet_03v3 ad=0.117p pd=0.97u as=0.279p ps=1.755u w=0.45u l=0.28u
X776 VSS.t662 a_43567_17382# a_44477_18395# VSS.t661 nfet_03v3 ad=0.324p pd=2.34u as=0.1872p ps=1.24u w=0.72u l=0.28u
X777 a_68603_16575# a_42244_17389.t15 a_68381_17312# VSS nfet_03v3 ad=0.2232p pd=1.96u as=0.2016p ps=1.84u w=0.36u l=0.28u
X778 VSS.t426 a_70195_18700.t13 a_70619_18828# VSS.t425 nfet_03v3 ad=93.59999f pd=0.88u as=93.59999f ps=0.88u w=0.36u l=0.28u
X779 VSS.t956 a_75798_17311# a_75705_17378# VSS.t955 nfet_03v3 ad=0.1638p pd=1.63u as=0.1638p ps=1.63u w=0.36u l=0.28u
X780 VSS.t187 a_73232_17378# a_74142_18391# VSS.t186 nfet_03v3 ad=0.324p pd=2.34u as=0.1872p ps=1.24u w=0.72u l=0.28u
X781 a_45531_20124# a_45475_19620.t14 VSS.t738 VSS.t737 nfet_03v3 ad=43.2f pd=0.6u as=0.1584p ps=1.6u w=0.36u l=0.28u
X782 VSS.t736 A10.t12 a_68771_18828# VSS.t735 nfet_03v3 ad=93.59999f pd=0.88u as=0.1584p ps=1.6u w=0.36u l=0.28u
X783 a_83513_16859# a_83049_16859# VDD.t313 VDD.t312 pfet_03v3 ad=0.3744p pd=1.96u as=0.3744p ps=1.96u w=1.44u l=0.28u
X784 a_81097_17378# A15.t9 a_80740_17311# VDD.t760 pfet_03v3 ad=0.3744p pd=1.96u as=0.6408p ps=3.77u w=1.44u l=0.28u
X785 a_47003_20792# a_46539_20792# VDD VDD pfet_03v3 ad=0.3744p pd=1.96u as=0.3744p ps=1.96u w=1.44u l=0.28u
X786 VDD CIN.t40 a_68931_20792# VDD pfet_03v3 ad=0.3744p pd=1.96u as=0.3744p ps=1.96u w=1.44u l=0.28u
X787 a_47427_19664# a_45835_19848# VDD VDD pfet_03v3 ad=0.3168p pd=2.32u as=0.1872p ps=1.24u w=0.72u l=0.28u
X788 a_59507_19216# A6.t14 a_58195_19104# VDD pfet_03v3 ad=0.1152p pd=1.04u as=0.1872p ps=1.24u w=0.72u l=0.28u
X789 a_81131_19216# a_80083_18700.t17 VDD VDD pfet_03v3 ad=0.1872p pd=1.24u as=0.1872p ps=1.24u w=0.72u l=0.28u
X790 VSS.t679 a_43660_17315# a_43567_17382# VSS.t678 nfet_03v3 ad=0.1638p pd=1.63u as=0.1638p ps=1.63u w=0.36u l=0.28u
X791 a_58099_18828# a_52895_16853.t8 a_57903_16571# VSS nfet_03v3 ad=0.4446p pd=3.19u as=0.1332p ps=1.1u w=0.36u l=0.28u
X792 a_58195_19848# a_57315_19664# a_58883_20124# VSS.t24 nfet_03v3 ad=93.59999f pd=0.88u as=93.59999f ps=0.88u w=0.36u l=0.28u
X793 a_65307_18828# a_65251_18700.t15 VSS.t672 VSS.t671 nfet_03v3 ad=43.2f pd=0.6u as=0.1584p ps=1.6u w=0.36u l=0.28u
X794 VSS.t811 a_73325_17311# a_73232_17378# VSS.t810 nfet_03v3 ad=0.1638p pd=1.63u as=0.1638p ps=1.63u w=0.36u l=0.28u
X795 a_76811_19216# A13.t14 a_75499_19104# VDD pfet_03v3 ad=0.1152p pd=1.04u as=0.1872p ps=1.24u w=0.72u l=0.28u
X796 VDD a_80083_18700.t18 a_81755_19216# VDD pfet_03v3 ad=0.1872p pd=1.24u as=0.1152p ps=1.04u w=0.72u l=0.28u
X797 a_75403_18828# a_72679_16527.t7 a_75207_16571# VSS nfet_03v3 ad=0.4446p pd=3.19u as=0.1332p ps=1.1u w=0.36u l=0.28u
X798 a_55431_16571# a_52895_16853.t9 a_55275_16571# VDD.t319 pfet_03v3 ad=0.1332p pd=1.1u as=0.18p ps=1.72u w=0.36u l=0.28u
X799 VSS.t267 B8.t3 a_64467_20452# VSS.t266 nfet_03v3 ad=0.3168p pd=2.32u as=0.1872p ps=1.24u w=0.72u l=0.28u
X800 a_59787_19664# a_58195_19848# VSS.t601 VSS.t600 nfet_03v3 ad=0.1584p pd=1.6u as=93.59999f ps=0.88u w=0.36u l=0.28u
X801 a_75499_19848# a_72623_18464# a_76187_20124# VSS.t119 nfet_03v3 ad=93.59999f pd=0.88u as=93.59999f ps=0.88u w=0.36u l=0.28u
X802 a_82035_19664# a_80443_19848# VDD VDD pfet_03v3 ad=0.3168p pd=2.32u as=0.1872p ps=1.24u w=0.72u l=0.28u
X803 a_46489_17382# A1.t7 a_46132_17315# VDD.t305 pfet_03v3 ad=0.3744p pd=1.96u as=0.6408p ps=3.77u w=1.44u l=0.28u
X804 VSS.t477 B15.t3 a_81771_20452# VSS.t476 nfet_03v3 ad=0.3168p pd=2.32u as=0.1872p ps=1.24u w=0.72u l=0.28u
X805 VDD a_59787_19664# a_60731_19664# VDD pfet_03v3 ad=0.3168p pd=2.32u as=0.1872p ps=1.24u w=0.72u l=0.28u
X806 a_66665_16039# a_65513_18464.t3 a_64632_16039# VSS nfet_03v3 ad=7.1172p pd=11.325u as=7.1172p ps=11.325u w=1.44u l=0.28u
X807 a_72735_16571# a_72671_16853.t15 a_72579_16571.t2 VDD.t447 pfet_03v3 ad=0.1332p pd=1.1u as=0.18p ps=1.72u w=0.36u l=0.28u
X808 VSS.t470 a_55363_18700.t14 a_57286_18391# VSS.t469 nfet_03v3 ad=0.324p pd=2.34u as=0.1872p ps=1.24u w=0.72u l=0.28u
X809 VSS.t255 a_53463_17382# a_55787_20124# VSS.t254 nfet_03v3 ad=0.1584p pd=1.6u as=93.59999f ps=0.88u w=0.36u l=0.28u
X810 a_77679_16571# a_72671_16853.t16 a_77523_16571# VSS nfet_03v3 ad=0.1332p pd=1.1u as=0.18p ps=1.72u w=0.36u l=0.28u
X811 Y15.t1 a_80963_16575# VSS VSS nfet_03v3 ad=0.1656p pd=1.64u as=0.1584p ps=1.6u w=0.36u l=0.28u
X812 a_58492_17311# A6.t15 VSS.t520 VSS.t519 nfet_03v3 ad=93.59999f pd=0.88u as=0.1638p ps=1.63u w=0.36u l=0.28u
X813 a_70107_16571# a_69675_19664# a_70355_20124# VSS.t595 nfet_03v3 ad=93.59999f pd=0.88u as=43.2f ps=0.6u w=0.36u l=0.28u
X814 VDD a_70195_18700.t14 a_70619_19664# VDD pfet_03v3 ad=0.1872p pd=1.24u as=0.1872p ps=1.24u w=0.72u l=0.28u
X815 a_56427_20792# B5.t2 VSS.t17 VSS.t16 nfet_03v3 ad=0.1872p pd=1.24u as=0.3168p ps=2.32u w=0.72u l=0.28u
X816 VSS.t824 B6.t1 a_59523_20452# VSS.t823 nfet_03v3 ad=0.3168p pd=2.32u as=0.1872p ps=1.24u w=0.72u l=0.28u
X817 VDD A10.t13 a_68771_19664# VDD pfet_03v3 ad=0.1872p pd=1.24u as=0.3168p ps=2.32u w=0.72u l=0.28u
X818 a_56411_18828# a_55363_18700.t15 VSS.t574 VSS.t573 nfet_03v3 ad=93.59999f pd=0.88u as=93.59999f ps=0.88u w=0.36u l=0.28u
X819 a_80347_18828# a_79563_18828# a_80243_19216# VDD pfet_03v3 ad=0.1872p pd=1.24u as=86.39999f ps=0.96u w=0.72u l=0.28u
X820 a_73731_20792# B12.t2 VSS.t433 VSS.t432 nfet_03v3 ad=0.1872p pd=1.24u as=0.3168p ps=2.32u w=0.72u l=0.28u
X821 a_74520_14904.t0 a_72579_16571.t5 VDD VDD pfet_03v3 ad=3.5586p pd=10.605u as=6.3756p ps=19.15u w=0.72u l=0.28u
X822 VSS.t589 a_80083_18700.t19 a_80740_17311# VSS.t588 nfet_03v3 ad=0.162p pd=1.62u as=93.59999f ps=0.88u w=0.36u l=0.28u
X823 a_47147_20124# A1.t8 a_45835_19848# VSS.t772 nfet_03v3 ad=57.59999f pd=0.68u as=93.59999f ps=0.88u w=0.36u l=0.28u
X824 VSS.t943 a_50419_19620.t11 a_52091_20124# VSS.t942 nfet_03v3 ad=93.59999f pd=0.88u as=57.59999f ps=0.68u w=0.36u l=0.28u
X825 Y2.t0 a_48827_16575# VDD.t61 VDD.t60 pfet_03v3 ad=0.3312p pd=2.36u as=0.3168p ps=2.32u w=0.72u l=0.28u
X826 VDD.t53 a_58194_17311# a_58097_18463.t0 VDD.t52 pfet_03v3 ad=0.324p pd=2.34u as=0.3312p ps=2.36u w=0.72u l=0.28u
X827 a_74195_20792# a_73731_20792# VDD VDD pfet_03v3 ad=0.3744p pd=1.96u as=0.3744p ps=1.96u w=1.44u l=0.28u
X828 a_65307_19664# a_65251_18700.t16 VDD VDD pfet_03v3 ad=86.39999f pd=0.96u as=0.3168p ps=2.32u w=0.72u l=0.28u
X829 VDD A7.t12 a_61355_19216# VDD pfet_03v3 ad=0.1872p pd=1.24u as=0.3168p ps=2.32u w=0.72u l=0.28u
X830 a_66459_20792# B9.t2 a_66315_20792# VDD pfet_03v3 ad=0.3744p pd=1.96u as=0.6336p ps=3.76u w=1.44u l=0.28u
X831 a_69251_20792# B10.t1 a_67723_18700.t0 VDD pfet_03v3 ad=0.6336p pd=3.76u as=0.3744p ps=1.96u w=1.44u l=0.28u
X832 a_58099_18828# a_57315_18828# a_57995_19216# VDD pfet_03v3 ad=0.1872p pd=1.24u as=86.39999f ps=0.96u w=0.72u l=0.28u
X833 a_48827_16575# a_41233_17389.t16 a_48659_16575# VSS nfet_03v3 ad=0.2232p pd=1.96u as=0.2016p ps=1.84u w=0.36u l=0.28u
X834 a_50579_20124# A3.t7 a_50475_20124# VSS.t872 nfet_03v3 ad=43.2f pd=0.6u as=43.2f ps=0.6u w=0.36u l=0.28u
X835 VDD a_45737_18467.t3 a_44856_14904.t0 VDD pfet_03v3 ad=3.5586p pd=10.605u as=3.5586p ps=10.605u w=0.72u l=0.28u
X836 a_77667_20124# a_77611_18700.t17 VSS.t197 VSS.t196 nfet_03v3 ad=43.2f pd=0.6u as=0.1584p ps=1.6u w=0.36u l=0.28u
X837 a_81755_20124# A15.t10 a_80443_19848# VSS.t901 nfet_03v3 ad=57.59999f pd=0.68u as=93.59999f ps=0.88u w=0.36u l=0.28u
X838 a_75403_18828# a_73232_17378# a_75299_19216# VDD pfet_03v3 ad=0.1872p pd=1.24u as=86.39999f ps=0.96u w=0.72u l=0.28u
X839 VDD a_77091_18828# a_78035_19216# VDD pfet_03v3 ad=0.3168p pd=2.32u as=0.1872p ps=1.24u w=0.72u l=0.28u
X840 a_42244_17389.t2 SEL0.t7 SEL1.t0 VDD.t469 pfet_03v3 ad=0.6264p pd=4.2u as=0.162p ps=1.62u w=0.36u l=0.28u
X841 VDD.t294 a_50419_19620.t12 a_51433_17382# VDD.t293 pfet_03v3 ad=0.648p pd=3.78u as=0.3744p ps=1.96u w=1.44u l=0.28u
X842 VDD a_72147_19664# a_73285_19138# VDD pfet_03v3 ad=0.234p pd=1.42u as=0.558p ps=2.43u w=0.9u l=0.28u
X843 a_78035_20124# A14.t12 VSS.t715 VSS.t714 nfet_03v3 ad=93.59999f pd=0.88u as=93.59999f ps=0.88u w=0.36u l=0.28u
X844 a_55627_18828# a_52854_18468# a_55523_18828# VSS.t190 nfet_03v3 ad=93.59999f pd=0.88u as=43.2f ps=0.6u w=0.36u l=0.28u
X845 VSS.t110 a_57315_18828# a_58259_18828# VSS.t109 nfet_03v3 ad=0.1584p pd=1.6u as=93.59999f ps=0.88u w=0.36u l=0.28u
X846 VSS.t568 CIN.t41 a_44067_20792# VSS.t567 nfet_03v3 ad=0.1872p pd=1.24u as=0.1872p ps=1.24u w=0.72u l=0.28u
X847 a_56411_19664# a_55363_18700.t16 VDD VDD pfet_03v3 ad=0.1872p pd=1.24u as=0.1872p ps=1.24u w=0.72u l=0.28u
X848 VDD a_55363_18700.t17 a_57035_19216# VDD pfet_03v3 ad=0.1872p pd=1.24u as=0.1152p ps=1.04u w=0.72u l=0.28u
X849 VSS.t215 a_56015_17311# a_55922_17378# VSS.t214 nfet_03v3 ad=0.1638p pd=1.63u as=0.1638p ps=1.63u w=0.36u l=0.28u
X850 VDD.t571 a_65251_18700.t17 a_65963_16575# VDD.t570 pfet_03v3 ad=0.324p pd=2.34u as=0.1872p ps=1.24u w=0.72u l=0.28u
X851 a_63397_19138# a_52895_16853.t10 a_62783_16853.t2 VDD pfet_03v3 ad=0.558p pd=2.43u as=0.486p ps=2.07u w=1.35u l=0.28u
X852 VSS.t185 a_73232_17378# a_75563_18828# VSS.t184 nfet_03v3 ad=0.1584p pd=1.6u as=93.59999f ps=0.88u w=0.36u l=0.28u
X853 a_53771_16575# a_42244_17389.t16 a_53556_17315# VSS nfet_03v3 ad=0.2232p pd=1.96u as=0.2016p ps=1.84u w=0.36u l=0.28u
X854 VSS.t570 CIN.t42 a_61371_20792# VSS.t569 nfet_03v3 ad=0.1872p pd=1.24u as=0.1872p ps=1.24u w=0.72u l=0.28u
X855 VSS.t531 a_54009_17863# a_54827_18395# VSS.t530 nfet_03v3 ad=0.324p pd=2.34u as=0.1872p ps=1.24u w=0.72u l=0.28u
X856 VDD.t142 a_73232_17378# a_72939_16571# VDD.t141 pfet_03v3 ad=0.4284p pd=1.91u as=0.1872p ps=1.24u w=0.72u l=0.28u
X857 a_55523_19216# A5.t13 a_55419_19216# VDD pfet_03v3 ad=86.39999f pd=0.96u as=86.39999f ps=0.96u w=0.72u l=0.28u
X858 a_79283_18828# A14.t13 a_77971_19104# VSS.t696 nfet_03v3 ad=57.59999f pd=0.68u as=93.59999f ps=0.88u w=0.36u l=0.28u
X859 VDD CIN.t43 a_54099_20792# VDD pfet_03v3 ad=0.3744p pd=1.96u as=0.3744p ps=1.96u w=1.44u l=0.28u
X860 a_80507_19216# A15.t11 VDD VDD pfet_03v3 ad=0.1872p pd=1.24u as=0.1872p ps=1.24u w=0.72u l=0.28u
X861 Y13.t0 a_76019_16575# VDD.t27 VDD.t26 pfet_03v3 ad=0.3312p pd=2.36u as=0.3168p ps=2.32u w=0.72u l=0.28u
X862 VDD CIN.t44 a_71403_20792# VDD pfet_03v3 ad=0.3744p pd=1.96u as=0.3744p ps=1.96u w=1.44u l=0.28u
X863 a_63794_17378# A8.t2 a_63437_17311# VDD.t462 pfet_03v3 ad=0.3744p pd=1.96u as=0.6408p ps=3.77u w=1.44u l=0.28u
X864 a_61979_19216# A7.t13 a_60667_19104# VDD pfet_03v3 ad=0.1152p pd=1.04u as=0.1872p ps=1.24u w=0.72u l=0.28u
X865 a_60571_18828# a_52895_16853.t11 a_60375_16571# VSS nfet_03v3 ad=0.4446p pd=3.19u as=0.1332p ps=1.1u w=0.36u l=0.28u
X866 a_60667_19848# a_59787_19664# a_61355_20124# VSS.t917 nfet_03v3 ad=93.59999f pd=0.88u as=93.59999f ps=0.88u w=0.36u l=0.28u
X867 a_58259_19216# A6.t16 VDD VDD pfet_03v3 ad=0.1872p pd=1.24u as=0.1872p ps=1.24u w=0.72u l=0.28u
X868 VDD.t573 a_43660_17315# a_43567_17382# VDD.t572 pfet_03v3 ad=0.3204p pd=2.33u as=0.3348p ps=2.37u w=0.72u l=0.28u
X869 VSS.t340 a_50419_19620.t13 a_52347_18395# VSS.t339 nfet_03v3 ad=0.324p pd=2.34u as=0.1872p ps=1.24u w=0.72u l=0.28u
X870 VSS a_54744_14904.t6 Z.t1 VSS nfet_03v3 ad=0.2637p pd=1.825u as=0.3474p ps=2.29u w=0.36u l=0.28u
X871 a_49011_20792# B2.t3 VSS.t620 VSS.t619 nfet_03v3 ad=0.1872p pd=1.24u as=0.3168p ps=2.32u w=0.72u l=0.28u
X872 VSS.t745 a_63344_17378# a_65675_20124# VSS.t744 nfet_03v3 ad=0.1584p pd=1.6u as=93.59999f ps=0.88u w=0.36u l=0.28u
X873 VSS.t604 a_79563_19664# a_82467_20154# VSS.t603 nfet_03v3 ad=0.117p pd=0.97u as=0.234p ps=1.94u w=0.45u l=0.28u
X874 VDD.t421 a_55363_18700.t18 a_56075_16575# VDD.t420 pfet_03v3 ad=0.324p pd=2.34u as=0.1872p ps=1.24u w=0.72u l=0.28u
X875 VSS.t332 a_57835_18700.t17 a_58259_20124# VSS.t331 nfet_03v3 ad=93.59999f pd=0.88u as=93.59999f ps=0.88u w=0.36u l=0.28u
X876 a_55275_16571# a_53463_17382# a_55523_19664# VDD pfet_03v3 ad=0.1872p pd=1.24u as=86.39999f ps=0.96u w=0.72u l=0.28u
X877 VDD a_57315_19664# a_58259_19664# VDD pfet_03v3 ad=0.3168p pd=2.32u as=0.1872p ps=1.24u w=0.72u l=0.28u
X878 VSS.t925 A0.t7 a_44051_20124# VSS.t924 nfet_03v3 ad=93.59999f pd=0.88u as=0.1584p ps=1.6u w=0.36u l=0.28u
X879 a_43363_19848# CIN.t45 a_44051_19664# VDD pfet_03v3 ad=0.1872p pd=1.24u as=0.1872p ps=1.24u w=0.72u l=0.28u
X880 a_75563_19216# A13.t15 VDD VDD pfet_03v3 ad=0.1872p pd=1.24u as=0.1872p ps=1.24u w=0.72u l=0.28u
X881 VSS.t787 a_75139_18700.t16 a_75563_20124# VSS.t786 nfet_03v3 ad=93.59999f pd=0.88u as=93.59999f ps=0.88u w=0.36u l=0.28u
X882 VDD a_72623_18464# a_75563_19664# VDD pfet_03v3 ad=0.3168p pd=2.32u as=0.1872p ps=1.24u w=0.72u l=0.28u
X883 a_60731_18828# a_60667_19104# a_60571_18828# VSS.t322 nfet_03v3 ad=93.59999f pd=0.88u as=93.59999f ps=0.88u w=0.36u l=0.28u
X884 a_64254_18391# a_62832_17312# a_63051_16571# VSS.t175 nfet_03v3 ad=0.1872p pd=1.24u as=0.3276p ps=2.35u w=0.72u l=0.28u
X885 a_67635_16571# a_67203_19664# a_67883_20124# VSS.t96 nfet_03v3 ad=93.59999f pd=0.88u as=43.2f ps=0.6u w=0.36u l=0.28u
X886 a_80963_16575# a_42244_17389.t17 a_80740_17311# VSS nfet_03v3 ad=0.2232p pd=1.96u as=0.2016p ps=1.84u w=0.36u l=0.28u
X887 a_76155_17378# A13.t16 a_75798_17311# VDD.t428 pfet_03v3 ad=0.3744p pd=1.96u as=0.6408p ps=3.77u w=1.44u l=0.28u
X888 a_55723_19848# a_53463_17382# a_56411_20124# VSS.t253 nfet_03v3 ad=93.59999f pd=0.88u as=93.59999f ps=0.88u w=0.36u l=0.28u
X889 a_79283_19664# A14.t14 a_77971_19848# VDD pfet_03v3 ad=0.1152p pd=1.04u as=0.1872p ps=1.24u w=0.72u l=0.28u
X890 VSS.t740 a_45475_19620.t15 a_47403_18395# VSS.t739 nfet_03v3 ad=0.324p pd=2.34u as=0.1872p ps=1.24u w=0.72u l=0.28u
X891 VSS.t898 A15.t12 a_81131_18828# VSS.t897 nfet_03v3 ad=93.59999f pd=0.88u as=0.1584p ps=1.6u w=0.36u l=0.28u
X892 VSS.t847 a_47947_19620.t13 a_49619_20124# VSS.t846 nfet_03v3 ad=93.59999f pd=0.88u as=57.59999f ps=0.68u w=0.36u l=0.28u
X893 VDD A6.t17 a_58883_19216# VDD pfet_03v3 ad=0.1872p pd=1.24u as=0.3168p ps=2.32u w=0.72u l=0.28u
X894 a_62691_19228# a_62259_18828# VDD VDD pfet_03v3 ad=0.38363p pd=2u as=0.234p ps=1.42u w=0.9u l=0.28u
X895 VSS.t156 a_65251_18700.t18 a_66923_20124# VSS.t155 nfet_03v3 ad=93.59999f pd=0.88u as=57.59999f ps=0.68u w=0.36u l=0.28u
X896 VDD a_82035_19664# a_83173_19138# VDD pfet_03v3 ad=0.234p pd=1.42u as=0.558p ps=2.43u w=0.9u l=0.28u
X897 VDD.t261 a_60666_17311# a_60569_18463.t0 VDD.t260 pfet_03v3 ad=0.324p pd=2.34u as=0.3312p ps=2.36u w=0.72u l=0.28u
X898 VDD.t217 a_53463_17382# a_53163_16571# VDD.t216 pfet_03v3 ad=0.4284p pd=1.91u as=0.1872p ps=1.24u w=0.72u l=0.28u
X899 a_45899_20124# A1.t9 VSS.t774 VSS.t773 nfet_03v3 ad=93.59999f pd=0.88u as=93.59999f ps=0.88u w=0.36u l=0.28u
X900 a_43427_19664# a_43363_19848# a_43267_19664# VDD pfet_03v3 ad=0.1872p pd=1.24u as=0.1872p ps=1.24u w=0.72u l=0.28u
X901 a_60571_18828# a_59787_18828# a_60467_19216# VDD pfet_03v3 ad=0.1872p pd=1.24u as=86.39999f ps=0.96u w=0.72u l=0.28u
X902 a_80243_18828# A15.t13 a_80139_18828# VSS.t960 nfet_03v3 ad=43.2f pd=0.6u as=43.2f ps=0.6u w=0.36u l=0.28u
X903 a_68698_16039# a_67986_18464.t3 a_66665_16039# VSS nfet_03v3 ad=7.1172p pd=11.325u as=7.1172p ps=11.325u w=1.44u l=0.28u
X904 a_70459_18828# a_62791_16527.t9 a_70263_16571# VDD.t373 pfet_03v3 ad=0.4446p pd=3.19u as=0.1332p ps=1.1u w=0.36u l=0.28u
X905 a_56243_16575# a_40765_17389.t13 a_55717_17311# VSS nfet_03v3 ad=0.2232p pd=1.96u as=0.2016p ps=1.84u w=0.36u l=0.28u
X906 VSS.t33 a_60307_18700.t16 a_62235_18391# VSS.t32 nfet_03v3 ad=0.324p pd=2.34u as=0.1872p ps=1.24u w=0.72u l=0.28u
X907 a_60731_19664# a_60667_19848# a_60219_16571# VDD pfet_03v3 ad=0.1872p pd=1.24u as=0.1872p ps=1.24u w=0.72u l=0.28u
X908 a_83513_17431# a_83049_17431# VDD.t617 VDD.t312 pfet_03v3 ad=0.3744p pd=1.96u as=0.3744p ps=1.96u w=1.44u l=0.28u
X909 VDD.t154 a_77611_18700.t18 a_78625_17378# VDD.t153 pfet_03v3 ad=0.648p pd=3.78u as=0.3744p ps=1.96u w=1.44u l=0.28u
X910 a_49635_20452# CIN.t46 a_47947_19620.t1 VSS.t462 nfet_03v3 ad=0.1872p pd=1.24u as=0.1872p ps=1.24u w=0.72u l=0.28u
X911 a_73547_16575# a_40765_17389.t14 a_72939_16571# VSS nfet_03v3 ad=0.2232p pd=1.96u as=0.2016p ps=1.84u w=0.36u l=0.28u
X912 a_55787_20124# a_55723_19848# a_55275_16571# VSS.t441 nfet_03v3 ad=93.59999f pd=0.88u as=93.59999f ps=0.88u w=0.36u l=0.28u
X913 VSS.t101 a_68288_17379# a_69198_18392# VSS.t100 nfet_03v3 ad=0.324p pd=2.34u as=0.1872p ps=1.24u w=0.72u l=0.28u
X914 a_44675_20124# A0.t8 a_43363_19848# VSS.t926 nfet_03v3 ad=57.59999f pd=0.68u as=93.59999f ps=0.88u w=0.36u l=0.28u
X915 a_52895_16853.t0 a_52371_19664.t10 VSS.t548 VSS.t547 nfet_03v3 ad=0.3384p pd=2.6u as=0.1584p ps=1.6u w=0.36u l=0.28u
X916 VSS.t681 a_75139_18700.t17 a_75798_17311# VSS.t680 nfet_03v3 ad=0.162p pd=1.62u as=93.59999f ps=0.88u w=0.36u l=0.28u
X917 VDD A15.t14 a_81131_19664# VDD pfet_03v3 ad=0.1872p pd=1.24u as=0.3168p ps=2.32u w=0.72u l=0.28u
X918 a_57835_18700.t2 CIN.t47 a_59363_20792# VDD pfet_03v3 ad=0.3744p pd=1.96u as=0.3744p ps=1.96u w=1.44u l=0.28u
X919 a_77091_18828# a_75499_19104# VDD VDD pfet_03v3 ad=0.3168p pd=2.32u as=0.1872p ps=1.24u w=0.72u l=0.28u
X920 VSS.t72 a_78175_17378# a_79085_18391# VSS.t71 nfet_03v3 ad=0.324p pd=2.34u as=0.1872p ps=1.24u w=0.72u l=0.28u
X921 a_67779_19216# a_67723_18700.t17 VDD VDD pfet_03v3 ad=86.39999f pd=0.96u as=0.3168p ps=2.32u w=0.72u l=0.28u
X922 VSS.t409 a_43003_19620.t11 a_43660_17315# VSS.t408 nfet_03v3 ad=0.162p pd=1.62u as=93.59999f ps=0.88u w=0.36u l=0.28u
X923 Y7.t0 a_61187_16575# VDD.t269 VDD.t268 pfet_03v3 ad=0.3312p pd=2.36u as=0.3168p ps=2.32u w=0.72u l=0.28u
X924 Z.t2 a_44856_14904.t6 VSS VSS nfet_03v3 ad=0.3474p pd=2.29u as=0.3438p ps=2.63u w=0.36u l=0.28u
X925 a_50419_19620.t2 a_51483_20792# VSS.t857 VSS.t856 nfet_03v3 ad=0.1872p pd=1.24u as=0.1872p ps=1.24u w=0.72u l=0.28u
X926 a_83173_18758# a_72679_16527.t8 a_82973_18758# VSS.t614 nfet_03v3 ad=0.279p pd=1.755u as=0.243p ps=1.395u w=0.675u l=0.28u
X927 a_55431_16571# a_52371_19664.t11 a_55275_16571# VSS nfet_03v3 ad=0.1332p pd=1.1u as=0.18p ps=1.72u w=0.36u l=0.28u
X928 VSS.t37 a_78268_17311# a_78175_17378# VSS.t36 nfet_03v3 ad=0.1638p pd=1.63u as=0.1638p ps=1.63u w=0.36u l=0.28u
X929 a_80243_19664# A15.t15 a_80139_19664# VDD pfet_03v3 ad=86.39999f pd=0.96u as=86.39999f ps=0.96u w=0.72u l=0.28u
X930 a_41233_17389.t1 SEL1.t5 VSS.t651 VSS.t650 nfet_03v3 ad=95.39999f pd=0.89u as=93.59999f ps=0.88u w=0.36u l=0.28u
X931 a_61187_16575# a_41233_17389.t17 a_61019_16575# VSS nfet_03v3 ad=0.2232p pd=1.96u as=0.2016p ps=1.84u w=0.36u l=0.28u
X932 VSS.t537 a_49899_19664# a_50843_20124# VSS.t536 nfet_03v3 ad=0.1584p pd=1.6u as=93.59999f ps=0.88u w=0.36u l=0.28u
X933 a_75299_20124# A13.t17 a_75195_20124# VSS.t106 nfet_03v3 ad=43.2f pd=0.6u as=43.2f ps=0.6u w=0.36u l=0.28u
X934 a_72735_16571# a_72679_16527.t9 a_72579_16571.t3 VSS nfet_03v3 ad=0.1332p pd=1.1u as=0.18p ps=1.72u w=0.36u l=0.28u
X935 a_78035_19216# a_77971_19104# a_77875_18828# VDD pfet_03v3 ad=0.1872p pd=1.24u as=0.1872p ps=1.24u w=0.72u l=0.28u
X936 a_43715_16575# A0.t9 VDD.t774 VDD.t773 pfet_03v3 ad=0.1872p pd=1.24u as=0.4284p ps=1.91u w=0.72u l=0.28u
X937 VDD a_50681_18467.t3 a_44856_14904.t2 VDD pfet_03v3 ad=5.5008p pd=16.72u as=3.5586p ps=10.605u w=0.72u l=0.28u
X938 VSS.t411 a_43003_19620.t12 a_43427_20124# VSS.t410 nfet_03v3 ad=93.59999f pd=0.88u as=93.59999f ps=0.88u w=0.36u l=0.28u
X939 VDD CIN.t48 a_43427_19664# VDD pfet_03v3 ad=0.3168p pd=2.32u as=0.1872p ps=1.24u w=0.72u l=0.28u
X940 VSS a_74520_14904.t6 Z.t4 VSS nfet_03v3 ad=0.3402p pd=2.61u as=0.2727p ps=1.875u w=0.36u l=0.28u
X941 N.t0 a_83049_16859# VSS VSS nfet_03v3 ad=0.1872p pd=1.24u as=0.1872p ps=1.24u w=0.72u l=0.28u
X942 a_63051_16571# a_62832_17312# VDD.t134 VDD.t133 pfet_03v3 ad=0.1872p pd=1.24u as=0.3276p ps=2.35u w=0.72u l=0.28u
X943 VSS.t484 CIN.t49 a_68787_20792# VSS.t483 nfet_03v3 ad=0.1872p pd=1.24u as=0.1872p ps=1.24u w=0.72u l=0.28u
X944 VSS.t35 a_60307_18700.t17 a_60731_20124# VSS.t34 nfet_03v3 ad=93.59999f pd=0.88u as=93.59999f ps=0.88u w=0.36u l=0.28u
X945 VSS.t135 a_69675_18828# a_70619_18828# VSS.t134 nfet_03v3 ad=0.1584p pd=1.6u as=93.59999f ps=0.88u w=0.36u l=0.28u
X946 a_72579_18780# a_72147_18828# VSS.t779 VSS.t778 nfet_03v3 ad=0.1918p pd=1.325u as=0.117p ps=0.97u w=0.45u l=0.28u
X947 VDD.t132 a_62832_17312# a_62735_18464# VDD.t131 pfet_03v3 ad=0.324p pd=2.34u as=0.3312p ps=2.36u w=0.72u l=0.28u
X948 a_45475_19620.t0 a_46539_20792# VSS.t292 VSS.t291 nfet_03v3 ad=0.1872p pd=1.24u as=0.1872p ps=1.24u w=0.72u l=0.28u
X949 a_68083_19104# a_67203_18828# a_68771_18828# VSS.t792 nfet_03v3 ad=93.59999f pd=0.88u as=93.59999f ps=0.88u w=0.36u l=0.28u
X950 a_44211_20792# B0.t2 a_44067_20792# VDD pfet_03v3 ad=0.3744p pd=1.96u as=0.6336p ps=3.76u w=1.44u l=0.28u
X951 a_47003_20792# B1.t2 a_45475_19620.t1 VDD pfet_03v3 ad=0.6336p pd=3.76u as=0.3744p ps=1.96u w=1.44u l=0.28u
X952 a_69675_18828# a_68083_19104# VSS.t475 VSS.t474 nfet_03v3 ad=0.1584p pd=1.6u as=93.59999f ps=0.88u w=0.36u l=0.28u
X953 a_78491_16575# a_42244_17389.t18 a_78268_17311# VSS nfet_03v3 ad=0.2232p pd=1.96u as=0.2016p ps=1.84u w=0.36u l=0.28u
X954 VSS.t317 a_65815_17379# a_66725_18392# VSS.t316 nfet_03v3 ad=0.324p pd=2.34u as=0.1872p ps=1.24u w=0.72u l=0.28u
X955 a_59309_18391# a_58547_16575# a_58194_17311# VSS.t929 nfet_03v3 ad=0.1872p pd=1.24u as=0.3276p ps=2.35u w=0.72u l=0.28u
X956 a_61515_20792# B7.t2 a_61371_20792# VDD pfet_03v3 ad=0.3744p pd=1.96u as=0.6336p ps=3.76u w=1.44u l=0.28u
X957 VSS.t591 a_80083_18700.t20 a_80507_18828# VSS.t590 nfet_03v3 ad=93.59999f pd=0.88u as=93.59999f ps=0.88u w=0.36u l=0.28u
X958 a_83049_17431# a_83137_17311# VSS.t355 VSS.t354 nfet_03v3 ad=0.1872p pd=1.24u as=0.3168p ps=2.32u w=0.72u l=0.28u
X959 a_55419_20124# a_55363_18700.t19 VSS.t495 VSS.t494 nfet_03v3 ad=43.2f pd=0.6u as=0.1584p ps=1.6u w=0.36u l=0.28u
X960 VSS.t698 A14.t15 a_78659_18828# VSS.t697 nfet_03v3 ad=93.59999f pd=0.88u as=0.1584p ps=1.6u w=0.36u l=0.28u
X961 a_56891_20792# a_56427_20792# VDD VDD pfet_03v3 ad=0.3744p pd=1.96u as=0.3744p ps=1.96u w=1.44u l=0.28u
X962 a_80347_18828# a_72671_16853.t17 a_80151_16571# VDD.t446 pfet_03v3 ad=0.4446p pd=3.19u as=0.1332p ps=1.1u w=0.36u l=0.28u
X963 VSS.t239 a_65908_17312# a_65815_17379# VSS.t238 nfet_03v3 ad=0.1638p pd=1.63u as=0.1638p ps=1.63u w=0.36u l=0.28u
X964 a_70853_17312# A11.t16 VSS.t887 VSS.t886 nfet_03v3 ad=93.59999f pd=0.88u as=0.1638p ps=1.63u w=0.36u l=0.28u
X965 VDD a_65251_18700.t19 a_65675_19216# VDD pfet_03v3 ad=0.1872p pd=1.24u as=0.1872p ps=1.24u w=0.72u l=0.28u
X966 a_65319_16571# a_62783_16853.t10 a_65163_16571# VDD.t327 pfet_03v3 ad=0.1332p pd=1.1u as=0.18p ps=1.72u w=0.36u l=0.28u
X967 a_71243_18828# a_70195_18700.t15 VSS.t428 VSS.t427 nfet_03v3 ad=93.59999f pd=0.88u as=93.59999f ps=0.88u w=0.36u l=0.28u
X968 VSS.t201 a_48511_17382# a_49421_18395# VSS.t200 nfet_03v3 ad=0.324p pd=2.34u as=0.1872p ps=1.24u w=0.72u l=0.28u
X969 VDD.t211 a_60307_18700.t18 a_61019_16575# VDD.t210 pfet_03v3 ad=0.324p pd=2.34u as=0.1872p ps=1.24u w=0.72u l=0.28u
X970 a_68771_19216# a_67723_18700.t18 VDD VDD pfet_03v3 ad=0.1872p pd=1.24u as=0.1872p ps=1.24u w=0.72u l=0.28u
X971 VSS.t377 a_70195_18700.t16 a_71867_18828# VSS.t376 nfet_03v3 ad=93.59999f pd=0.88u as=57.59999f ps=0.68u w=0.36u l=0.28u
X972 VSS.t62 a_57835_18700.t18 a_59763_18391# VSS.t61 nfet_03v3 ad=0.324p pd=2.34u as=0.1872p ps=1.24u w=0.72u l=0.28u
X973 VDD a_69675_19664# a_70619_19664# VDD pfet_03v3 ad=0.3168p pd=2.32u as=0.1872p ps=1.24u w=0.72u l=0.28u
X974 a_68147_18828# a_68083_19104# a_67987_18828# VSS.t473 nfet_03v3 ad=93.59999f pd=0.88u as=93.59999f ps=0.88u w=0.36u l=0.28u
X975 a_68083_19848# a_67203_19664# a_68771_19664# VDD pfet_03v3 ad=0.1872p pd=1.24u as=0.1872p ps=1.24u w=0.72u l=0.28u
X976 SEL0.t0 a_40610_17389.t5 a_40765_17389.t0 VDD.t220 pfet_03v3 ad=93.59999f pd=0.88u as=0.4536p ps=3.24u w=0.36u l=0.28u
X977 VSS.t830 a_55922_17378# a_56832_18391# VSS.t829 nfet_03v3 ad=0.324p pd=2.34u as=0.1872p ps=1.24u w=0.72u l=0.28u
X978 VSS.t758 a_48604_17315# a_48511_17382# VSS.t757 nfet_03v3 ad=0.1638p pd=1.63u as=0.1638p ps=1.63u w=0.36u l=0.28u
X979 VDD.t79 a_68288_17379# a_68083_17312# VDD.t78 pfet_03v3 ad=0.4284p pd=1.91u as=0.1872p ps=1.24u w=0.72u l=0.28u
X980 a_73778_17859# a_73731_20792# VSS.t372 VSS.t371 nfet_03v3 ad=0.1872p pd=1.24u as=0.1872p ps=1.24u w=0.72u l=0.28u
X981 a_83137_17311# a_82973_19616# VSS.t832 VSS.t831 nfet_03v3 ad=0.5735p pd=3.03u as=0.341p ps=2.43u w=0.775u l=0.28u
X982 a_69675_19664# a_68083_19848# VDD VDD pfet_03v3 ad=0.3168p pd=2.32u as=0.1872p ps=1.24u w=0.72u l=0.28u
X983 a_66315_20792# B9.t3 VSS.t363 VSS.t362 nfet_03v3 ad=0.1872p pd=1.24u as=0.3168p ps=2.32u w=0.72u l=0.28u
X984 VSS.t958 B10.t2 a_69411_20452# VSS.t957 nfet_03v3 ad=0.3168p pd=2.32u as=0.1872p ps=1.24u w=0.72u l=0.28u
X985 VDD a_80083_18700.t21 a_80507_19664# VDD pfet_03v3 ad=0.1872p pd=1.24u as=0.1872p ps=1.24u w=0.72u l=0.28u
X986 a_40610_17389.t0 SEL1.t6 VSS.t628 VSS.t627 nfet_03v3 ad=0.162p pd=1.62u as=0.162p ps=1.62u w=0.36u l=0.28u
X987 VDD A14.t16 a_78659_19664# VDD pfet_03v3 ad=0.1872p pd=1.24u as=0.3168p ps=2.32u w=0.72u l=0.28u
X988 a_66299_18828# a_65251_18700.t20 VSS.t158 VSS.t157 nfet_03v3 ad=93.59999f pd=0.88u as=93.59999f ps=0.88u w=0.36u l=0.28u
X989 a_72671_16853.t1 a_62783_16853.t11 a_72579_18780# VSS.t375 nfet_03v3 ad=0.243p pd=1.395u as=0.1918p ps=1.325u w=0.675u l=0.28u
X990 VDD.t51 a_78175_17378# a_77970_17311# VDD.t50 pfet_03v3 ad=0.4284p pd=1.91u as=0.1872p ps=1.24u w=0.72u l=0.28u
X991 a_43003_19620.t3 CIN.t50 a_44531_20792# VDD pfet_03v3 ad=0.3744p pd=1.96u as=0.3744p ps=1.96u w=1.44u l=0.28u
X992 a_62259_18828# a_60667_19104# VDD VDD pfet_03v3 ad=0.3168p pd=2.32u as=0.1872p ps=1.24u w=0.72u l=0.28u
X993 a_44856_16039# a_43265_18467.t3 VSS VSS nfet_03v3 ad=7.1172p pd=11.325u as=12.7512p ps=20.59u w=1.44u l=0.28u
X994 Y6.t0 a_58715_16575# VDD.t368 VDD.t367 pfet_03v3 ad=0.3312p pd=2.36u as=0.3168p ps=2.32u w=0.72u l=0.28u
X995 a_60307_18700.t2 CIN.t51 a_61835_20792# VDD pfet_03v3 ad=0.3744p pd=1.96u as=0.3744p ps=1.96u w=1.44u l=0.28u
X996 VSS.t245 a_60307_18700.t19 a_61979_20124# VSS.t244 nfet_03v3 ad=93.59999f pd=0.88u as=57.59999f ps=0.68u w=0.36u l=0.28u
X997 VDD A11.t17 a_71243_19216# VDD pfet_03v3 ad=0.1872p pd=1.24u as=0.3168p ps=2.32u w=0.72u l=0.28u
X998 a_83673_18427# a_83272_18186# F.t1 VSS.t688 nfet_03v3 ad=0.1872p pd=1.24u as=0.1872p ps=1.24u w=0.72u l=0.28u
X999 a_79139_20792# B14.t2 a_77611_18700.t0 VDD pfet_03v3 ad=0.6336p pd=3.76u as=0.3744p ps=1.96u w=1.44u l=0.28u
X1000 a_71243_19664# a_70195_18700.t17 VDD VDD pfet_03v3 ad=0.1872p pd=1.24u as=0.1872p ps=1.24u w=0.72u l=0.28u
X1001 VDD.t357 a_43003_19620.t13 a_44017_17382# VDD.t356 pfet_03v3 ad=0.648p pd=3.78u as=0.3744p ps=1.96u w=1.44u l=0.28u
X1002 VDD a_55620_18463.t3 a_54744_14904.t4 VDD pfet_03v3 ad=3.5586p pd=10.605u as=3.5586p ps=10.605u w=0.72u l=0.28u
X1003 Y5.t1 a_56243_16575# VSS VSS nfet_03v3 ad=0.1656p pd=1.64u as=0.1584p ps=1.6u w=0.36u l=0.28u
X1004 a_45739_19664# a_44955_19664# a_45635_20124# VSS.t125 nfet_03v3 ad=93.59999f pd=0.88u as=43.2f ps=0.6u w=0.36u l=0.28u
X1005 VSS.t86 a_47427_19664# a_48371_20124# VSS.t85 nfet_03v3 ad=0.1584p pd=1.6u as=93.59999f ps=0.88u w=0.36u l=0.28u
X1006 a_60467_20124# A7.t14 a_60363_20124# VSS.t315 nfet_03v3 ad=43.2f pd=0.6u as=43.2f ps=0.6u w=0.36u l=0.28u
X1007 a_68147_19664# a_68083_19848# a_67635_16571# VDD pfet_03v3 ad=0.1872p pd=1.24u as=0.1872p ps=1.24u w=0.72u l=0.28u
X1008 VDD a_70195_18700.t18 a_71867_19664# VDD pfet_03v3 ad=0.1872p pd=1.24u as=0.1152p ps=1.04u w=0.72u l=0.28u
X1009 a_53556_17315# A4.t1 VSS.t622 VSS.t621 nfet_03v3 ad=93.59999f pd=0.88u as=0.1638p ps=1.63u w=0.36u l=0.28u
X1010 VSS.t143 a_63890_17859# a_64708_18391# VSS.t142 nfet_03v3 ad=0.324p pd=2.34u as=0.1872p ps=1.24u w=0.72u l=0.28u
X1011 Y12.t1 a_73547_16575# VSS VSS nfet_03v3 ad=0.1656p pd=1.64u as=0.1584p ps=1.6u w=0.36u l=0.28u
X1012 a_76019_16575# a_41233_17389.t18 a_75851_16575# VSS nfet_03v3 ad=0.2232p pd=1.96u as=0.2016p ps=1.84u w=0.36u l=0.28u
X1013 a_48995_19664# a_47947_19620.t14 VDD VDD pfet_03v3 ad=0.1872p pd=1.24u as=0.1872p ps=1.24u w=0.72u l=0.28u
X1014 a_43163_19664# A0.t10 a_43059_19664# VDD pfet_03v3 ad=86.39999f pd=0.96u as=86.39999f ps=0.96u w=0.72u l=0.28u
X1015 VSS.t791 a_67203_18828# a_68147_18828# VSS.t790 nfet_03v3 ad=0.1584p pd=1.6u as=93.59999f ps=0.88u w=0.36u l=0.28u
X1016 VSS.t486 CIN.t52 a_53955_20792# VSS.t485 nfet_03v3 ad=0.1872p pd=1.24u as=0.1872p ps=1.24u w=0.72u l=0.28u
X1017 a_69395_20124# A10.t14 a_68083_19848# VSS.t905 nfet_03v3 ad=57.59999f pd=0.68u as=93.59999f ps=0.88u w=0.36u l=0.28u
X1018 a_66299_19664# a_65251_18700.t21 VDD VDD pfet_03v3 ad=0.1872p pd=1.24u as=0.1872p ps=1.24u w=0.72u l=0.28u
X1019 VSS.t565 CIN.t53 a_71259_20792# VSS.t564 nfet_03v3 ad=0.1872p pd=1.24u as=0.1872p ps=1.24u w=0.72u l=0.28u
X1020 VDD.t271 a_65815_17379# a_65610_17312# VDD.t270 pfet_03v3 ad=0.4284p pd=1.91u as=0.1872p ps=1.24u w=0.72u l=0.28u
X1021 a_51076_17315# A3.t8 VSS.t874 VSS.t873 nfet_03v3 ad=93.59999f pd=0.88u as=0.1638p ps=1.63u w=0.36u l=0.28u
X1022 a_58194_17311# a_58547_16575# VDD.t776 VDD.t775 pfet_03v3 ad=0.1872p pd=1.24u as=0.3276p ps=2.35u w=0.72u l=0.28u
X1023 a_59043_20792# B6.t2 a_58899_20792# VDD pfet_03v3 ad=0.3744p pd=1.96u as=0.6336p ps=3.76u w=1.44u l=0.28u
X1024 a_65411_19216# A9.t17 a_65307_19216# VDD pfet_03v3 ad=86.39999f pd=0.96u as=86.39999f ps=0.96u w=0.72u l=0.28u
X1025 a_45834_17315# a_46187_16575# VDD.t107 VDD.t106 pfet_03v3 ad=0.1872p pd=1.24u as=0.3276p ps=2.35u w=0.72u l=0.28u
X1026 VSS.t683 a_75139_18700.t18 a_77069_18391# VSS.t682 nfet_03v3 ad=0.324p pd=2.34u as=0.1872p ps=1.24u w=0.72u l=0.28u
X1027 a_78659_20124# a_77611_18700.t19 VSS.t199 VSS.t198 nfet_03v3 ad=93.59999f pd=0.88u as=93.59999f ps=0.88u w=0.36u l=0.28u
X1028 a_61781_18391# a_61019_16575# a_60666_17311# VSS.t653 nfet_03v3 ad=0.1872p pd=1.24u as=0.3276p ps=2.35u w=0.72u l=0.28u
X1029 a_73682_17378# A12.t3 a_73325_17311# VDD.t366 pfet_03v3 ad=0.3744p pd=1.96u as=0.6408p ps=3.77u w=1.44u l=0.28u
X1030 a_68381_17312# A10.t15 VSS.t907 VSS.t906 nfet_03v3 ad=93.59999f pd=0.88u as=0.1638p ps=1.63u w=0.36u l=0.28u
X1031 a_71867_19216# A11.t18 a_70555_19104# VDD pfet_03v3 ad=0.1152p pd=1.04u as=0.1872p ps=1.24u w=0.72u l=0.28u
X1032 a_77875_18828# a_77091_18828# a_77771_18828# VSS.t348 nfet_03v3 ad=93.59999f pd=0.88u as=43.2f ps=0.6u w=0.36u l=0.28u
X1033 a_70459_18828# a_62783_16853.t12 a_70263_16571# VSS nfet_03v3 ad=0.4446p pd=3.19u as=0.1332p ps=1.1u w=0.36u l=0.28u
X1034 a_50843_20124# a_50779_19848# a_50683_19664# VSS.t223 nfet_03v3 ad=93.59999f pd=0.88u as=93.59999f ps=0.88u w=0.36u l=0.28u
X1035 a_70555_19848# a_69675_19664# a_71243_20124# VSS.t594 nfet_03v3 ad=93.59999f pd=0.88u as=93.59999f ps=0.88u w=0.36u l=0.28u
X1036 VSS.t826 a_62259_18828# a_62691_18780# VSS.t825 nfet_03v3 ad=0.117p pd=0.97u as=0.234p ps=1.94u w=0.45u l=0.28u
X1037 a_68147_19216# A10.t16 VDD VDD pfet_03v3 ad=0.1872p pd=1.24u as=0.1872p ps=1.24u w=0.72u l=0.28u
X1038 VDD.t47 a_57835_18700.t19 a_58547_16575# VDD.t46 pfet_03v3 ad=0.324p pd=2.34u as=0.1872p ps=1.24u w=0.72u l=0.28u
X1039 VSS.t387 a_67723_18700.t19 a_68147_20124# VSS.t386 nfet_03v3 ad=93.59999f pd=0.88u as=93.59999f ps=0.88u w=0.36u l=0.28u
X1040 VDD a_67203_19664# a_68147_19664# VDD pfet_03v3 ad=0.3168p pd=2.32u as=0.1872p ps=1.24u w=0.72u l=0.28u
X1041 VDD.t126 a_68083_17312# a_67986_18464.t0 VDD.t125 pfet_03v3 ad=0.324p pd=2.34u as=0.3312p ps=2.36u w=0.72u l=0.28u
X1042 VDD.t709 a_55922_17378# a_55717_17311# VDD.t708 pfet_03v3 ad=0.4284p pd=1.91u as=0.1872p ps=1.24u w=0.72u l=0.28u
X1043 a_74142_18391# a_72720_17312# a_72939_16571# VSS.t280 nfet_03v3 ad=0.1872p pd=1.24u as=0.3276p ps=2.35u w=0.72u l=0.28u
X1044 a_48307_19848# a_47427_19664# a_48995_20124# VSS.t84 nfet_03v3 ad=93.59999f pd=0.88u as=93.59999f ps=0.88u w=0.36u l=0.28u
X1045 VDD A1.t10 a_46523_19664# VDD pfet_03v3 ad=0.1872p pd=1.24u as=0.3168p ps=2.32u w=0.72u l=0.28u
X1046 a_70619_18828# a_70555_19104# a_70459_18828# VSS.t438 nfet_03v3 ad=93.59999f pd=0.88u as=93.59999f ps=0.88u w=0.36u l=0.28u
X1047 VDD.t762 Y15.t4 a_83193_16859# VDD.t582 pfet_03v3 ad=0.3744p pd=1.96u as=0.3744p ps=1.96u w=1.44u l=0.28u
X1048 a_54744_16039# a_52803_16571.t5 VSS VSS nfet_03v3 ad=7.1172p pd=11.325u as=12.7512p ps=20.59u w=1.44u l=0.28u
X1049 VDD CIN.t54 a_46683_20792# VDD pfet_03v3 ad=0.3744p pd=1.96u as=0.3744p ps=1.96u w=1.44u l=0.28u
X1050 a_58195_19104# a_57315_18828# a_58883_19216# VDD pfet_03v3 ad=0.1872p pd=1.24u as=0.1872p ps=1.24u w=0.72u l=0.28u
X1051 VDD.t634 a_48604_17315# a_48511_17382# VDD.t633 pfet_03v3 ad=0.3204p pd=2.33u as=0.3348p ps=2.37u w=0.72u l=0.28u
X1052 a_65611_19848# a_63344_17378# a_66299_20124# VSS.t743 nfet_03v3 ad=93.59999f pd=0.88u as=93.59999f ps=0.88u w=0.36u l=0.28u
X1053 a_57995_18828# A6.t18 a_57891_18828# VSS.t507 nfet_03v3 ad=43.2f pd=0.6u as=43.2f ps=0.6u w=0.36u l=0.28u
X1054 Z.t0 a_64632_14904.t6 VSS VSS nfet_03v3 ad=0.2727p pd=1.875u as=0.2637p ps=1.825u w=0.36u l=0.28u
X1055 a_59787_18828# a_58195_19104# VDD VDD pfet_03v3 ad=0.3168p pd=2.32u as=0.1872p ps=1.24u w=0.72u l=0.28u
X1056 a_75499_19104# a_73232_17378# a_76187_19216# VDD pfet_03v3 ad=0.1872p pd=1.24u as=0.1872p ps=1.24u w=0.72u l=0.28u
X1057 VDD.t725 a_50983_17382# a_50778_17315# VDD.t724 pfet_03v3 ad=0.4284p pd=1.91u as=0.1872p ps=1.24u w=0.72u l=0.28u
X1058 a_66265_17379# A9.t18 a_65908_17312# VDD.t179 pfet_03v3 ad=0.3744p pd=1.96u as=0.6408p ps=3.77u w=1.44u l=0.28u
X1059 VSS.t64 a_57835_18700.t20 a_59507_20124# VSS.t63 nfet_03v3 ad=93.59999f pd=0.88u as=57.59999f ps=0.68u w=0.36u l=0.28u
X1060 Y0.t0 a_43883_16575# VDD.t267 VDD.t266 pfet_03v3 ad=0.3312p pd=2.36u as=0.3168p ps=2.32u w=0.72u l=0.28u
X1061 a_72579_19228# a_72147_18828# VDD VDD pfet_03v3 ad=0.38363p pd=2u as=0.234p ps=1.42u w=0.9u l=0.28u
X1062 a_65675_18828# a_65611_19104# a_65515_18828# VSS.t131 nfet_03v3 ad=93.59999f pd=0.88u as=93.59999f ps=0.88u w=0.36u l=0.28u
X1063 a_70355_20124# A11.t19 a_70251_20124# VSS.t882 nfet_03v3 ad=43.2f pd=0.6u as=43.2f ps=0.6u w=0.36u l=0.28u
X1064 a_77523_16571# a_77091_19664# a_77771_19664# VDD pfet_03v3 ad=0.1872p pd=1.24u as=86.39999f ps=0.96u w=0.72u l=0.28u
X1065 VSS.t685 a_75139_18700.t19 a_76811_20124# VSS.t684 nfet_03v3 ad=93.59999f pd=0.88u as=57.59999f ps=0.68u w=0.36u l=0.28u
X1066 VDD a_52854_18468# a_55787_19216# VDD pfet_03v3 ad=0.3168p pd=2.32u as=0.1872p ps=1.24u w=0.72u l=0.28u
X1067 a_55787_20124# A5.t14 VSS.t518 VSS.t517 nfet_03v3 ad=93.59999f pd=0.88u as=93.59999f ps=0.88u w=0.36u l=0.28u
X1068 a_70459_18828# a_69675_18828# a_70355_19216# VDD pfet_03v3 ad=0.1872p pd=1.24u as=86.39999f ps=0.96u w=0.72u l=0.28u
X1069 a_78586_16039# a_77873_18463.t3 a_76553_16039# VSS nfet_03v3 ad=7.1172p pd=11.325u as=7.1172p ps=11.325u w=1.44u l=0.28u
X1070 VDD.t103 a_63890_17859# a_62832_17312# VDD.t102 pfet_03v3 ad=0.324p pd=2.34u as=0.1872p ps=1.24u w=0.72u l=0.28u
X1071 a_62783_16853.t0 a_52371_19664.t12 a_62691_19228# VDD pfet_03v3 ad=0.486p pd=2.07u as=0.38363p ps=2u w=1.35u l=0.28u
X1072 a_66131_16575# a_40765_17389.t15 a_65610_17312# VSS nfet_03v3 ad=0.2232p pd=1.96u as=0.2016p ps=1.84u w=0.36u l=0.28u
X1073 a_59523_20452# CIN.t55 a_57835_18700.t3 VSS.t566 nfet_03v3 ad=0.1872p pd=1.24u as=0.1872p ps=1.24u w=0.72u l=0.28u
X1074 a_70619_19664# a_70555_19848# a_70107_16571# VDD pfet_03v3 ad=0.1872p pd=1.24u as=0.1872p ps=1.24u w=0.72u l=0.28u
X1075 VSS.t522 A5.t15 a_56411_18828# VSS.t521 nfet_03v3 ad=93.59999f pd=0.88u as=0.1584p ps=1.6u w=0.36u l=0.28u
X1076 a_53913_17382# A4.t2 a_53556_17315# VDD.t518 pfet_03v3 ad=0.3744p pd=1.96u as=0.6408p ps=3.77u w=1.44u l=0.28u
X1077 a_51467_19664# a_50419_19620.t14 VDD VDD pfet_03v3 ad=0.1872p pd=1.24u as=0.1872p ps=1.24u w=0.72u l=0.28u
X1078 a_57995_19664# A6.t19 a_57891_19664# VDD pfet_03v3 ad=86.39999f pd=0.96u as=86.39999f ps=0.96u w=0.72u l=0.28u
X1079 a_80740_17311# A15.t16 VSS.t912 VSS.t911 nfet_03v3 ad=93.59999f pd=0.88u as=0.1638p ps=1.63u w=0.36u l=0.28u
X1080 a_56372_17378# A5.t16 a_56015_17311# VDD.t439 pfet_03v3 ad=0.3744p pd=1.96u as=0.6408p ps=3.77u w=1.44u l=0.28u
X1081 a_48371_19664# a_48307_19848# a_48211_19664# VDD pfet_03v3 ad=0.1872p pd=1.24u as=0.1872p ps=1.24u w=0.72u l=0.28u
X1082 VSS.t446 a_52951_17316# a_52854_18468# VSS.t445 nfet_03v3 ad=0.171p pd=1.67u as=0.1746p ps=1.69u w=0.36u l=0.28u
X1083 a_83513_16859# F.t6 N.t1 VDD.t306 pfet_03v3 ad=0.6336p pd=3.76u as=0.3744p ps=1.96u w=1.44u l=0.28u
X1084 a_47427_19664# a_45835_19848# VSS.t755 VSS.t754 nfet_03v3 ad=0.1584p pd=1.6u as=93.59999f ps=0.88u w=0.36u l=0.28u
X1085 a_67723_18700.t2 CIN.t56 a_69251_20792# VDD pfet_03v3 ad=0.3744p pd=1.96u as=0.3744p ps=1.96u w=1.44u l=0.28u
X1086 a_65675_19664# a_65611_19848# a_65163_16571# VDD pfet_03v3 ad=0.1872p pd=1.24u as=0.1872p ps=1.24u w=0.72u l=0.28u
X1087 a_70251_18828# a_70195_18700.t19 VSS.t379 VSS.t378 nfet_03v3 ad=43.2f pd=0.6u as=0.1584p ps=1.6u w=0.36u l=0.28u
X1088 a_77667_19216# a_77611_18700.t20 VDD VDD pfet_03v3 ad=86.39999f pd=0.96u as=0.3168p ps=2.32u w=0.72u l=0.28u
X1089 Y4.t1 a_53771_16575# VSS VSS nfet_03v3 ad=0.1656p pd=1.64u as=0.1584p ps=1.6u w=0.36u l=0.28u
X1090 VDD.t575 a_75139_18700.t20 a_75851_16575# VDD.t574 pfet_03v3 ad=0.324p pd=2.34u as=0.1872p ps=1.24u w=0.72u l=0.28u
X1091 a_81755_19216# A15.t17 a_80443_19104# VDD pfet_03v3 ad=0.1152p pd=1.04u as=0.1872p ps=1.24u w=0.72u l=0.28u
X1092 a_80347_18828# a_72679_16527.t10 a_80151_16571# VSS nfet_03v3 ad=0.4446p pd=3.19u as=0.1332p ps=1.1u w=0.36u l=0.28u
X1093 Y11.t0 a_71075_16575# VDD.t423 VDD.t422 pfet_03v3 ad=0.3312p pd=2.36u as=0.3168p ps=2.32u w=0.72u l=0.28u
X1094 a_60666_17311# a_61019_16575# VDD.t546 VDD.t545 pfet_03v3 ad=0.1872p pd=1.24u as=0.3276p ps=2.35u w=0.72u l=0.28u
X1095 a_78035_19216# A14.t17 VDD VDD pfet_03v3 ad=0.1872p pd=1.24u as=0.1872p ps=1.24u w=0.72u l=0.28u
X1096 a_51433_17382# A3.t9 a_51076_17315# VDD.t736 pfet_03v3 ad=0.3744p pd=1.96u as=0.6408p ps=3.77u w=1.44u l=0.28u
X1097 a_63051_16571# a_62791_16527.t10 a_62847_16571# VDD.t374 pfet_03v3 ad=0.4446p pd=3.19u as=0.1332p ps=1.1u w=0.36u l=0.28u
X1098 VDD CIN.t57 a_78819_20792# VDD pfet_03v3 ad=0.3744p pd=1.96u as=0.3744p ps=1.96u w=1.44u l=0.28u
X1099 a_82035_19664# a_80443_19848# VSS.t448 VSS.t447 nfet_03v3 ad=0.1584p pd=1.6u as=93.59999f ps=0.88u w=0.36u l=0.28u
X1100 a_65319_16571# a_62791_16527.t11 a_65163_16571# VSS nfet_03v3 ad=0.1332p pd=1.1u as=0.18p ps=1.72u w=0.36u l=0.28u
X1101 a_61187_16575# a_41692_17389.t17 a_60375_16571# VSS nfet_03v3 ad=0.2034p pd=1.85u as=0.2016p ps=1.84u w=0.36u l=0.28u
X1102 a_44067_20792# B0.t3 VSS.t962 VSS.t961 nfet_03v3 ad=0.1872p pd=1.24u as=0.3168p ps=2.32u w=0.72u l=0.28u
X1103 VSS.t552 B1.t3 a_47163_20452# VSS.t551 nfet_03v3 ad=0.3168p pd=2.32u as=0.1872p ps=1.24u w=0.72u l=0.28u
X1104 VSS.t916 a_59787_19664# a_60731_20124# VSS.t915 nfet_03v3 ad=0.1584p pd=1.6u as=93.59999f ps=0.88u w=0.36u l=0.28u
X1105 VDD A5.t17 a_56411_19664# VDD pfet_03v3 ad=0.1872p pd=1.24u as=0.3168p ps=2.32u w=0.72u l=0.28u
X1106 a_82973_19616# a_72679_16527.t11 a_82467_19616# VDD pfet_03v3 ad=0.486p pd=2.07u as=0.38363p ps=2u w=1.35u l=0.28u
X1107 VDD a_60569_18463.t3 a_54744_14904.t3 VDD pfet_03v3 ad=5.5008p pd=16.72u as=3.5586p ps=10.605u w=0.72u l=0.28u
X1108 a_61371_20792# B7.t3 VSS.t504 VSS.t503 nfet_03v3 ad=0.1872p pd=1.24u as=0.3168p ps=2.32u w=0.72u l=0.28u
X1109 a_54827_18395# A4.t3 a_52951_17316# VSS.t629 nfet_03v3 ad=0.1872p pd=1.24u as=0.3276p ps=2.35u w=0.72u l=0.28u
X1110 a_72939_16571# a_72720_17312# VDD.t245 VDD.t244 pfet_03v3 ad=0.1872p pd=1.24u as=0.3276p ps=2.35u w=0.72u l=0.28u
X1111 VDD.t243 a_72720_17312# a_72623_18464# VDD.t242 pfet_03v3 ad=0.324p pd=2.34u as=0.3312p ps=2.36u w=0.72u l=0.28u
X1112 a_55363_18700.t1 a_56427_20792# VSS.t753 VSS.t752 nfet_03v3 ad=0.1872p pd=1.24u as=0.1872p ps=1.24u w=0.72u l=0.28u
X1113 VSS.t814 a_70195_18700.t20 a_70619_20124# VSS.t813 nfet_03v3 ad=93.59999f pd=0.88u as=93.59999f ps=0.88u w=0.36u l=0.28u
X1114 a_57035_18828# A5.t18 a_55723_19104# VSS.t251 nfet_03v3 ad=57.59999f pd=0.68u as=93.59999f ps=0.88u w=0.36u l=0.28u
X1115 a_63397_18758# a_62259_19664# VSS.t139 VSS.t138 nfet_03v3 ad=0.198p pd=1.78u as=0.117p ps=0.97u w=0.45u l=0.28u
X1116 a_77971_19104# a_77091_18828# a_78659_18828# VSS.t347 nfet_03v3 ad=93.59999f pd=0.88u as=93.59999f ps=0.88u w=0.36u l=0.28u
X1117 a_82467_18780# a_82035_18828# VSS.t78 VSS.t77 nfet_03v3 ad=0.1918p pd=1.325u as=0.117p ps=0.97u w=0.45u l=0.28u
X1118 VDD.t3 a_70555_17312# a_70458_18464.t0 VDD.t2 pfet_03v3 ad=0.324p pd=2.34u as=0.3312p ps=2.36u w=0.72u l=0.28u
X1119 a_54099_20792# B4.t3 a_53955_20792# VDD pfet_03v3 ad=0.3744p pd=1.96u as=0.6336p ps=3.76u w=1.44u l=0.28u
X1120 VSS.t909 A10.t17 a_68771_20124# VSS.t908 nfet_03v3 ad=93.59999f pd=0.88u as=0.1584p ps=1.6u w=0.36u l=0.28u
X1121 a_56243_16575# a_41692_17389.t18 a_55431_16571# VSS nfet_03v3 ad=0.2034p pd=1.85u as=0.2016p ps=1.84u w=0.36u l=0.28u
X1122 VSS.t74 a_58194_17311# a_58097_18463.t1 VSS.t73 nfet_03v3 ad=0.171p pd=1.67u as=0.1746p ps=1.69u w=0.36u l=0.28u
X1123 a_56891_20792# B5.t3 a_55363_18700.t0 VDD pfet_03v3 ad=0.6336p pd=3.76u as=0.3744p ps=1.96u w=1.44u l=0.28u
X1124 a_70251_19664# a_70195_18700.t21 VDD VDD pfet_03v3 ad=86.39999f pd=0.96u as=0.3168p ps=2.32u w=0.72u l=0.28u
X1125 a_79563_18828# a_77971_19104# VSS.t41 VSS.t40 nfet_03v3 ad=0.1584p pd=1.6u as=93.59999f ps=0.88u w=0.36u l=0.28u
X1126 a_48659_16575# A2.t11 VDD.t226 VDD.t225 pfet_03v3 ad=0.1872p pd=1.24u as=0.4284p ps=1.91u w=0.72u l=0.28u
X1127 VSS.t816 a_70195_18700.t22 a_72124_18392# VSS.t815 nfet_03v3 ad=0.324p pd=2.34u as=0.1872p ps=1.24u w=0.72u l=0.28u
X1128 a_71403_20792# B11.t3 a_71259_20792# VDD pfet_03v3 ad=0.3744p pd=1.96u as=0.6336p ps=3.76u w=1.44u l=0.28u
X1129 a_74195_20792# B12.t3 a_73778_17859# VDD pfet_03v3 ad=0.6336p pd=3.76u as=0.3744p ps=1.96u w=1.44u l=0.28u
X1130 a_65307_20124# a_65251_18700.t22 VSS.t160 VSS.t159 nfet_03v3 ad=43.2f pd=0.6u as=0.1584p ps=1.6u w=0.36u l=0.28u
X1131 a_83173_19616# a_79563_18828# VDD VDD pfet_03v3 ad=0.396p pd=2.68u as=0.234p ps=1.42u w=0.9u l=0.28u
X1132 a_60667_19104# a_59787_18828# a_61355_19216# VDD pfet_03v3 ad=0.1872p pd=1.24u as=0.1872p ps=1.24u w=0.72u l=0.28u
X1133 VDD a_62735_18464# a_65675_19216# VDD pfet_03v3 ad=0.3168p pd=2.32u as=0.1872p ps=1.24u w=0.72u l=0.28u
X1134 a_66779_20792# a_66315_20792# VDD VDD pfet_03v3 ad=0.3744p pd=1.96u as=0.3744p ps=1.96u w=1.44u l=0.28u
X1135 VDD a_57835_18700.t21 a_58259_19216# VDD pfet_03v3 ad=0.1872p pd=1.24u as=0.1872p ps=1.24u w=0.72u l=0.28u
X1136 a_52347_18395# A3.t10 a_51131_16575# VSS.t869 nfet_03v3 ad=0.1872p pd=1.24u as=0.3276p ps=2.35u w=0.72u l=0.28u
X1137 VDD a_75139_18700.t21 a_75563_19216# VDD pfet_03v3 ad=0.1872p pd=1.24u as=0.1872p ps=1.24u w=0.72u l=0.28u
X1138 a_75207_16571# a_72679_16527.t12 a_75051_16571# VDD.t535 pfet_03v3 ad=0.1332p pd=1.1u as=0.18p ps=1.72u w=0.36u l=0.28u
X1139 a_44051_19664# a_43003_19620.t14 VDD VDD pfet_03v3 ad=0.1872p pd=1.24u as=0.1872p ps=1.24u w=0.72u l=0.28u
X1140 a_62791_16527.t0 a_62783_16853.t13 VDD VDD pfet_03v3 ad=1.147p pd=4.58u as=0.682p ps=3.98u w=1.55u l=0.28u
X1141 VDD a_43003_19620.t15 a_44675_19664# VDD pfet_03v3 ad=0.1872p pd=1.24u as=0.1152p ps=1.04u w=0.72u l=0.28u
X1142 a_67987_18828# a_67203_18828# a_67883_19216# VDD pfet_03v3 ad=0.1872p pd=1.24u as=86.39999f ps=0.96u w=0.72u l=0.28u
X1143 a_55723_19104# a_52854_18468# a_56411_19216# VDD pfet_03v3 ad=0.1872p pd=1.24u as=0.1872p ps=1.24u w=0.72u l=0.28u
X1144 VSS.t497 a_55363_18700.t20 a_55787_18828# VSS.t496 nfet_03v3 ad=93.59999f pd=0.88u as=93.59999f ps=0.88u w=0.36u l=0.28u
X1145 a_44691_20452# CIN.t58 a_43003_19620.t2 VSS.t460 nfet_03v3 ad=0.1872p pd=1.24u as=0.1872p ps=1.24u w=0.72u l=0.28u
X1146 a_77971_19848# a_77091_19664# a_78659_19664# VDD pfet_03v3 ad=0.1872p pd=1.24u as=0.1872p ps=1.24u w=0.72u l=0.28u
X1147 a_47403_18395# A1.t11 a_46187_16575# VSS.t775 nfet_03v3 ad=0.1872p pd=1.24u as=0.3276p ps=2.35u w=0.72u l=0.28u
X1148 a_54373_18395# a_52951_17316# a_53163_16571# VSS.t444 nfet_03v3 ad=0.1872p pd=1.24u as=0.3276p ps=2.35u w=0.72u l=0.28u
X1149 a_56411_20124# a_55363_18700.t21 VSS.t472 VSS.t471 nfet_03v3 ad=93.59999f pd=0.88u as=93.59999f ps=0.88u w=0.36u l=0.28u
X1150 a_57035_19664# A5.t19 a_55723_19848# VDD pfet_03v3 ad=0.1152p pd=1.04u as=0.1872p ps=1.24u w=0.72u l=0.28u
X1151 a_61995_20452# CIN.t59 a_60307_18700.t3 VSS.t461 nfet_03v3 ad=0.1872p pd=1.24u as=0.1872p ps=1.24u w=0.72u l=0.28u
X1152 a_79563_19664# a_77971_19848# VDD VDD pfet_03v3 ad=0.3168p pd=2.32u as=0.1872p ps=1.24u w=0.72u l=0.28u
X1153 a_58883_18828# a_57835_18700.t22 VSS.t213 VSS.t212 nfet_03v3 ad=93.59999f pd=0.88u as=93.59999f ps=0.88u w=0.36u l=0.28u
X1154 VDD a_62259_18828# a_62691_19228# VDD pfet_03v3 ad=0.234p pd=1.42u as=0.468p ps=2.84u w=0.9u l=0.28u
X1155 VSS.t964 B14.t3 a_79299_20452# VSS.t963 nfet_03v3 ad=0.3168p pd=2.32u as=0.1872p ps=1.24u w=0.72u l=0.28u
X1156 VDD a_65251_18700.t23 a_66923_19216# VDD pfet_03v3 ad=0.1872p pd=1.24u as=0.1152p ps=1.04u w=0.72u l=0.28u
X1157 a_76187_18828# a_75139_18700.t22 VSS.t709 VSS.t708 nfet_03v3 ad=93.59999f pd=0.88u as=93.59999f ps=0.88u w=0.36u l=0.28u
X1158 a_54009_17863# CIN.t60 a_54419_20792# VDD pfet_03v3 ad=0.3744p pd=1.96u as=0.3744p ps=1.96u w=1.44u l=0.28u
X1159 a_63437_17311# A8.t3 VSS.t541 VSS.t540 nfet_03v3 ad=93.59999f pd=0.88u as=0.1638p ps=1.63u w=0.36u l=0.28u
X1160 VDD.t382 a_52951_17316# a_52854_18468# VDD.t381 pfet_03v3 ad=0.324p pd=2.34u as=0.3312p ps=2.36u w=0.72u l=0.28u
X1161 Y10.t0 a_68603_16575# VDD.t31 VDD.t30 pfet_03v3 ad=0.3312p pd=2.36u as=0.3168p ps=2.32u w=0.72u l=0.28u
X1162 a_70195_18700.t2 CIN.t61 a_71723_20792# VDD pfet_03v3 ad=0.3744p pd=1.96u as=0.3744p ps=1.96u w=1.44u l=0.28u
X1163 a_62235_18391# A7.t15 a_61019_16575# VSS.t805 nfet_03v3 ad=0.1872p pd=1.24u as=0.3276p ps=2.35u w=0.72u l=0.28u
X1164 VDD.t583 a_83272_18186# a_83193_17431# VDD.t582 pfet_03v3 ad=0.3744p pd=1.96u as=0.3744p ps=1.96u w=1.44u l=0.28u
X1165 a_78625_17378# A14.t18 a_78268_17311# VDD.t606 pfet_03v3 ad=0.3744p pd=1.96u as=0.6408p ps=3.77u w=1.44u l=0.28u
X1166 a_55787_19216# a_55723_19104# a_55627_18828# VDD pfet_03v3 ad=0.1872p pd=1.24u as=0.1872p ps=1.24u w=0.72u l=0.28u
X1167 VDD.t528 a_63051_16571# a_62691_16571.t1 VDD.t527 pfet_03v3 ad=0.324p pd=2.34u as=0.3312p ps=2.36u w=0.72u l=0.28u
X1168 a_55275_16571# a_53463_17382# a_55523_20124# VSS.t252 nfet_03v3 ad=93.59999f pd=0.88u as=43.2f ps=0.6u w=0.36u l=0.28u
X1169 VDD a_55363_18700.t22 a_55787_19664# VDD pfet_03v3 ad=0.1872p pd=1.24u as=0.1872p ps=1.24u w=0.72u l=0.28u
X1170 SEL0.t1 a_40610_17389.t6 a_41233_17389.t0 VSS.t262 nfet_03v3 ad=0.171p pd=1.67u as=95.39999f ps=0.89u w=0.36u l=0.28u
X1171 a_69198_18392# a_68435_16575# a_68083_17312# VSS.t759 nfet_03v3 ad=0.1872p pd=1.24u as=0.3276p ps=2.35u w=0.72u l=0.28u
X1172 VSS.t23 a_57315_19664# a_58259_20124# VSS.t22 nfet_03v3 ad=0.1584p pd=1.6u as=93.59999f ps=0.88u w=0.36u l=0.28u
X1173 VSS.t920 a_45834_17315# a_45737_18467.t1 VSS.t919 nfet_03v3 ad=0.171p pd=1.67u as=0.1746p ps=1.69u w=0.36u l=0.28u
X1174 VSS.t58 a_73778_17859# a_74596_18391# VSS.t57 nfet_03v3 ad=0.324p pd=2.34u as=0.1872p ps=1.24u w=0.72u l=0.28u
X1175 a_43363_19848# CIN.t62 a_44051_20124# VSS.t480 nfet_03v3 ad=93.59999f pd=0.88u as=93.59999f ps=0.88u w=0.36u l=0.28u
X1176 a_60731_18828# A7.t16 VSS.t807 VSS.t806 nfet_03v3 ad=93.59999f pd=0.88u as=93.59999f ps=0.88u w=0.36u l=0.28u
X1177 a_75798_17311# A13.t18 VSS.t108 VSS.t107 nfet_03v3 ad=93.59999f pd=0.88u as=0.1638p ps=1.63u w=0.36u l=0.28u
X1178 a_58899_20792# B6.t3 VSS.t928 VSS.t927 nfet_03v3 ad=0.1872p pd=1.24u as=0.3168p ps=2.32u w=0.72u l=0.28u
X1179 VSS.t118 a_72623_18464# a_75563_20124# VSS.t117 nfet_03v3 ad=0.1584p pd=1.6u as=93.59999f ps=0.88u w=0.36u l=0.28u
X1180 a_58883_19664# a_57835_18700.t23 VDD VDD pfet_03v3 ad=0.1872p pd=1.24u as=0.1872p ps=1.24u w=0.72u l=0.28u
X1181 a_79283_20124# A14.t19 a_77971_19848# VSS.t710 nfet_03v3 ad=57.59999f pd=0.68u as=93.59999f ps=0.88u w=0.36u l=0.28u
X1182 a_76187_19664# a_75139_18700.t23 VDD VDD pfet_03v3 ad=0.1872p pd=1.24u as=0.1872p ps=1.24u w=0.72u l=0.28u
X1183 a_80443_19104# a_79563_18828# a_81131_18828# VSS.t299 nfet_03v3 ad=93.59999f pd=0.88u as=93.59999f ps=0.88u w=0.36u l=0.28u
X1184 Y14.t1 a_78491_16575# VSS VSS nfet_03v3 ad=0.1656p pd=1.64u as=0.1584p ps=1.6u w=0.36u l=0.28u
X1185 VDD.t689 a_70195_18700.t23 a_70907_16575# VDD.t688 pfet_03v3 ad=0.324p pd=2.34u as=0.1872p ps=1.24u w=0.72u l=0.28u
X1186 VSS.t389 a_67723_18700.t20 a_69652_18392# VSS.t388 nfet_03v3 ad=0.324p pd=2.34u as=0.1872p ps=1.24u w=0.72u l=0.28u
X1187 a_68931_20792# B10.t3 a_68787_20792# VDD pfet_03v3 ad=0.3744p pd=1.96u as=0.6336p ps=3.76u w=1.44u l=0.28u
X1188 a_75299_19216# A13.t19 a_75195_19216# VDD pfet_03v3 ad=86.39999f pd=0.96u as=86.39999f ps=0.96u w=0.72u l=0.28u
X1189 VSS.t114 a_77611_18700.t21 a_78035_18828# VSS.t113 nfet_03v3 ad=93.59999f pd=0.88u as=93.59999f ps=0.88u w=0.36u l=0.28u
X1190 a_43883_16575# a_40765_17389.t16 a_43362_17315# VSS nfet_03v3 ad=0.2232p pd=1.96u as=0.2016p ps=1.84u w=0.36u l=0.28u
X1191 VDD.t181 a_65610_17312# a_65513_18464.t0 VDD.t180 pfet_03v3 ad=0.324p pd=2.34u as=0.3312p ps=2.36u w=0.72u l=0.28u
X1192 VSS.t304 a_60666_17311# a_60569_18463.t1 VSS.t303 nfet_03v3 ad=0.171p pd=1.67u as=0.1746p ps=1.69u w=0.36u l=0.28u
X1193 VSS.t599 a_75705_17378# a_76615_18391# VSS.t598 nfet_03v3 ad=0.324p pd=2.34u as=0.1872p ps=1.24u w=0.72u l=0.28u
X1194 a_43427_20124# a_43363_19848# a_43267_19664# VSS.t308 nfet_03v3 ad=93.59999f pd=0.88u as=93.59999f ps=0.88u w=0.36u l=0.28u
X1195 a_43427_19664# A0.t11 VDD VDD pfet_03v3 ad=0.1872p pd=1.24u as=0.1872p ps=1.24u w=0.72u l=0.28u
X1196 a_61187_16575# a_40765_17389.t17 a_60666_17311# VSS nfet_03v3 ad=0.2232p pd=1.96u as=0.2016p ps=1.84u w=0.36u l=0.28u
X1197 VSS.t116 a_77611_18700.t22 a_78268_17311# VSS.t115 nfet_03v3 ad=0.162p pd=1.62u as=93.59999f ps=0.88u w=0.36u l=0.28u
X1198 VDD a_60307_18700.t20 a_60731_19216# VDD pfet_03v3 ad=0.1872p pd=1.24u as=0.1872p ps=1.24u w=0.72u l=0.28u
X1199 VSS Y15.t5 a_83049_16859# VSS nfet_03v3 ad=0.1872p pd=1.24u as=0.1872p ps=1.24u w=0.72u l=0.28u
X1200 a_50475_19664# a_50419_19620.t15 VDD VDD pfet_03v3 ad=86.39999f pd=0.96u as=0.3168p ps=2.32u w=0.72u l=0.28u
X1201 a_83513_17431# a_83137_17311# F.t0 VDD.t306 pfet_03v3 ad=0.6336p pd=3.76u as=0.3744p ps=1.96u w=1.44u l=0.28u
X1202 VSS.t482 CIN.t63 a_46539_20792# VSS.t481 nfet_03v3 ad=0.1872p pd=1.24u as=0.1872p ps=1.24u w=0.72u l=0.28u
X1203 a_60731_20124# a_60667_19848# a_60219_16571# VSS.t248 nfet_03v3 ad=93.59999f pd=0.88u as=93.59999f ps=0.88u w=0.36u l=0.28u
X1204 a_60731_19664# A7.t17 VDD VDD pfet_03v3 ad=0.1872p pd=1.24u as=0.1872p ps=1.24u w=0.72u l=0.28u
X1205 VSS.t777 a_72147_18828# a_72579_18780# VSS.t776 nfet_03v3 ad=0.117p pd=0.97u as=0.234p ps=1.94u w=0.45u l=0.28u
X1206 a_53163_16571# a_52371_19664.t13 a_52959_16571# VDD.t276 pfet_03v3 ad=0.4446p pd=3.19u as=0.1332p ps=1.1u w=0.36u l=0.28u
X1207 a_55419_19216# a_55363_18700.t23 VDD VDD pfet_03v3 ad=86.39999f pd=0.96u as=0.3168p ps=2.32u w=0.72u l=0.28u
X1208 VSS.t391 a_67723_18700.t21 a_69395_18828# VSS.t390 nfet_03v3 ad=93.59999f pd=0.88u as=57.59999f ps=0.68u w=0.36u l=0.28u
X1209 a_66725_18392# a_65963_16575# a_65610_17312# VSS.t290 nfet_03v3 ad=0.1872p pd=1.24u as=0.3276p ps=2.35u w=0.72u l=0.28u
X1210 a_80507_18828# a_80443_19104# a_80347_18828# VSS.t945 nfet_03v3 ad=93.59999f pd=0.88u as=93.59999f ps=0.88u w=0.36u l=0.28u
X1211 a_64632_16039# a_62691_16571.t5 VSS VSS nfet_03v3 ad=7.1172p pd=11.325u as=12.7512p ps=20.59u w=1.44u l=0.28u
X1212 VDD CIN.t64 a_56571_20792# VDD pfet_03v3 ad=0.3744p pd=1.96u as=0.3744p ps=1.96u w=1.44u l=0.28u
X1213 VSS.t914 A15.t18 a_81131_20124# VSS.t913 nfet_03v3 ad=93.59999f pd=0.88u as=0.1584p ps=1.6u w=0.36u l=0.28u
X1214 a_80443_19848# a_79563_19664# a_81131_19664# VDD pfet_03v3 ad=0.1872p pd=1.24u as=0.1872p ps=1.24u w=0.72u l=0.28u
X1215 VDD.t559 a_43567_17382# a_43362_17315# VDD.t558 pfet_03v3 ad=0.4284p pd=1.91u as=0.1872p ps=1.24u w=0.72u l=0.28u
X1216 VDD a_77611_18700.t23 a_78035_19664# VDD pfet_03v3 ad=0.1872p pd=1.24u as=0.1872p ps=1.24u w=0.72u l=0.28u
X1217 a_61355_18828# a_60307_18700.t21 VSS.t247 VSS.t246 nfet_03v3 ad=93.59999f pd=0.88u as=93.59999f ps=0.88u w=0.36u l=0.28u
X1218 a_67883_18828# A10.t18 a_67779_18828# VSS.t910 nfet_03v3 ad=43.2f pd=0.6u as=43.2f ps=0.6u w=0.36u l=0.28u
X1219 VDD CIN.t65 a_73875_20792# VDD pfet_03v3 ad=0.3744p pd=1.96u as=0.3744p ps=1.96u w=1.44u l=0.28u
X1220 a_58259_18828# a_58195_19104# a_58099_18828# VSS.t763 nfet_03v3 ad=93.59999f pd=0.88u as=93.59999f ps=0.88u w=0.36u l=0.28u
X1221 a_63051_16571# a_62783_16853.t14 a_62847_16571# VSS nfet_03v3 ad=0.4446p pd=3.19u as=0.1332p ps=1.1u w=0.36u l=0.28u
X1222 a_63397_19138# a_62259_19664# VDD VDD pfet_03v3 ad=0.396p pd=2.68u as=0.234p ps=1.42u w=0.9u l=0.28u
X1223 a_62791_16527.t1 a_62783_16853.t15 VSS.t422 VSS.t421 nfet_03v3 ad=0.5735p pd=3.03u as=0.341p ps=2.43u w=0.775u l=0.28u
X1224 a_82467_19228# a_82035_18828# VDD VDD pfet_03v3 ad=0.38363p pd=2u as=0.234p ps=1.42u w=0.9u l=0.28u
X1225 a_49421_18395# a_48659_16575# a_48306_17315# VSS.t154 nfet_03v3 ad=0.1872p pd=1.24u as=0.3276p ps=2.35u w=0.72u l=0.28u
X1226 VDD a_75403_18463.t3 a_74520_14904.t1 VDD pfet_03v3 ad=3.5586p pd=10.605u as=3.5586p ps=10.605u w=0.72u l=0.28u
X1227 VDD.t701 a_58492_17311# a_58399_17378# VDD.t700 pfet_03v3 ad=0.3204p pd=2.33u as=0.3348p ps=2.37u w=0.72u l=0.28u
X1228 a_80243_20124# A15.t19 a_80139_20124# VSS.t851 nfet_03v3 ad=43.2f pd=0.6u as=43.2f ps=0.6u w=0.36u l=0.28u
X1229 a_75563_18828# a_75499_19104# a_75403_18828# VSS.t179 nfet_03v3 ad=93.59999f pd=0.88u as=93.59999f ps=0.88u w=0.36u l=0.28u
X1230 a_61019_16575# A7.t18 VDD.t172 VDD.t171 pfet_03v3 ad=0.1872p pd=1.24u as=0.4284p ps=1.91u w=0.72u l=0.28u
X1231 VDD.t443 a_80442_17311# a_80345_18463.t0 VDD.t442 pfet_03v3 ad=0.324p pd=2.34u as=0.3312p ps=2.36u w=0.72u l=0.28u
X1232 a_56832_18391# a_56075_16575# a_55717_17311# VSS.t644 nfet_03v3 ad=0.1872p pd=1.24u as=0.3276p ps=2.35u w=0.72u l=0.28u
X1233 VSS.t560 CIN.t66 a_43427_20124# VSS.t559 nfet_03v3 ad=0.1584p pd=1.6u as=93.59999f ps=0.88u w=0.36u l=0.28u
X1234 VDD.t43 a_73778_17859# a_72720_17312# VDD.t42 pfet_03v3 ad=0.324p pd=2.34u as=0.1872p ps=1.24u w=0.72u l=0.28u
X1235 a_68083_17312# a_68435_16575# VDD.t638 VDD.t637 pfet_03v3 ad=0.1872p pd=1.24u as=0.3276p ps=2.35u w=0.72u l=0.28u
X1236 VSS.t174 a_62832_17312# a_62735_18464# VSS.t173 nfet_03v3 ad=0.171p pd=1.67u as=0.1746p ps=1.69u w=0.36u l=0.28u
X1237 a_52091_19664# A3.t11 a_50779_19848# VDD pfet_03v3 ad=0.1152p pd=1.04u as=0.1872p ps=1.24u w=0.72u l=0.28u
X1238 VDD a_67723_18700.t22 a_69395_19664# VDD pfet_03v3 ad=0.1872p pd=1.24u as=0.1152p ps=1.04u w=0.72u l=0.28u
X1239 a_57315_18828# a_55723_19104# VSS.t922 VSS.t921 nfet_03v3 ad=0.1584p pd=1.6u as=93.59999f ps=0.88u w=0.36u l=0.28u
X1240 a_76019_16575# a_40765_17389.t18 a_75500_17311# VSS nfet_03v3 ad=0.2232p pd=1.96u as=0.2016p ps=1.84u w=0.36u l=0.28u
X1241 VSS F.t7 a_83673_16519# VSS nfet_03v3 ad=0.3168p pd=2.32u as=0.1872p ps=1.24u w=0.72u l=0.28u
X1242 a_44856_14904.t4 a_48209_18467.t3 VDD VDD pfet_03v3 ad=3.5586p pd=10.605u as=3.5586p ps=10.605u w=0.72u l=0.28u
X1243 VSS.t593 a_80083_18700.t22 a_82011_18391# VSS.t592 nfet_03v3 ad=0.324p pd=2.34u as=0.1872p ps=1.24u w=0.72u l=0.28u
X1244 a_80507_19664# a_80443_19848# a_79995_16571# VDD pfet_03v3 ad=0.1872p pd=1.24u as=0.1872p ps=1.24u w=0.72u l=0.28u
X1245 a_71670_18392# a_70907_16575# a_70555_17312# VSS.t864 nfet_03v3 ad=0.1872p pd=1.24u as=0.3276p ps=2.35u w=0.72u l=0.28u
X1246 a_69411_20452# CIN.t67 a_67723_18700.t1 VSS.t561 nfet_03v3 ad=0.1872p pd=1.24u as=0.1872p ps=1.24u w=0.72u l=0.28u
X1247 VSS.t220 A9.t19 a_66299_18828# VSS.t219 nfet_03v3 ad=93.59999f pd=0.88u as=0.1584p ps=1.6u w=0.36u l=0.28u
X1248 VSS.t818 a_47947_19620.t15 a_49875_18395# VSS.t817 nfet_03v3 ad=0.324p pd=2.34u as=0.1872p ps=1.24u w=0.72u l=0.28u
X1249 a_44531_20792# a_44067_20792# VDD VDD pfet_03v3 ad=0.3744p pd=1.96u as=0.3744p ps=1.96u w=1.44u l=0.28u
X1250 VDD a_60307_18700.t22 a_61979_19216# VDD pfet_03v3 ad=0.1872p pd=1.24u as=0.1152p ps=1.04u w=0.72u l=0.28u
X1251 VDD.t768 a_45834_17315# a_45737_18467.t0 VDD.t767 pfet_03v3 ad=0.324p pd=2.34u as=0.3312p ps=2.36u w=0.72u l=0.28u
X1252 a_61355_19664# a_60307_18700.t23 VDD VDD pfet_03v3 ad=0.1872p pd=1.24u as=0.1872p ps=1.24u w=0.72u l=0.28u
X1253 a_67883_19664# A10.t19 a_67779_19664# VDD pfet_03v3 ad=86.39999f pd=0.96u as=86.39999f ps=0.96u w=0.72u l=0.28u
X1254 VSS.t298 a_79563_18828# a_80507_18828# VSS.t297 nfet_03v3 ad=0.1584p pd=1.6u as=93.59999f ps=0.88u w=0.36u l=0.28u
X1255 Y1.t1 a_46355_16575# VSS VSS nfet_03v3 ad=0.1656p pd=1.64u as=0.1584p ps=1.6u w=0.36u l=0.28u
X1256 a_61835_20792# a_61371_20792# VDD VDD pfet_03v3 ad=0.3744p pd=1.96u as=0.3744p ps=1.96u w=1.44u l=0.28u
X1257 VSS.t563 CIN.t68 a_78675_20792# VSS.t562 nfet_03v3 ad=0.1872p pd=1.24u as=0.1872p ps=1.24u w=0.72u l=0.28u
X1258 a_58259_19664# a_58195_19848# a_57747_16571# VDD pfet_03v3 ad=0.1872p pd=1.24u as=0.1872p ps=1.24u w=0.72u l=0.28u
X1259 F.t3 a_83049_17431# VSS.t728 VSS.t727 nfet_03v3 ad=0.1872p pd=1.24u as=0.1872p ps=1.24u w=0.72u l=0.28u
X1260 VDD.t335 a_67723_18700.t23 a_68435_16575# VDD.t334 pfet_03v3 ad=0.324p pd=2.34u as=0.1872p ps=1.24u w=0.72u l=0.28u
X1261 a_77611_18700.t2 CIN.t69 a_79139_20792# VDD pfet_03v3 ad=0.3744p pd=1.96u as=0.3744p ps=1.96u w=1.44u l=0.28u
X1262 a_83173_20131# a_79563_18828# VSS.t296 VSS.t295 nfet_03v3 ad=0.198p pd=1.78u as=0.117p ps=0.97u w=0.45u l=0.28u
X1263 Y8.t1 a_63659_16575# VSS VSS nfet_03v3 ad=0.1656p pd=1.64u as=0.1584p ps=1.6u w=0.36u l=0.28u
X1264 a_75563_19664# a_75499_19848# a_75051_16571# VDD pfet_03v3 ad=0.1872p pd=1.24u as=0.1872p ps=1.24u w=0.72u l=0.28u
X1265 a_60467_19216# A7.t19 a_60363_19216# VDD pfet_03v3 ad=86.39999f pd=0.96u as=86.39999f ps=0.96u w=0.72u l=0.28u
X1266 a_80139_18828# a_80083_18700.t23 VSS.t584 VSS.t583 nfet_03v3 ad=43.2f pd=0.6u as=0.1584p ps=1.6u w=0.36u l=0.28u
X1267 Y15.t0 a_80963_16575# VDD.t361 VDD.t360 pfet_03v3 ad=0.3312p pd=2.36u as=0.3168p ps=2.32u w=0.72u l=0.28u
X1268 a_72939_16571# a_72679_16527.t13 a_72735_16571# VDD.t536 pfet_03v3 ad=0.4446p pd=3.19u as=0.1332p ps=1.1u w=0.36u l=0.28u
X1269 VDD.t505 a_75705_17378# a_75500_17311# VDD.t504 pfet_03v3 ad=0.4284p pd=1.91u as=0.1872p ps=1.24u w=0.72u l=0.28u
R0 A8.n1 A8.t3 95.0309
R1 A8.n0 A8.t0 90.0773
R2 A8.n0 A8.t1 39.8898
R3 A8.n1 A8.t2 30.2434
R4 A8.n2 A8.n0 22.6927
R5 A8 A8.n2 15.0434
R6 A8.n2 A8.n1 12.5005
R7 VSS.n386 VSS.n385 2.14868e+06
R8 VSS.t305 VSS.t432 7237.11
R9 VSS.t249 VSS.t500 7237.11
R10 VSS.n272 VSS.t729 5695.88
R11 VSS.n385 VSS.n206 3568.74
R12 VSS.t281 VSS.t776 3300.78
R13 VSS.t266 VSS.t159 2847.94
R14 VSS.t731 VSS.t494 2847.94
R15 VSS.t152 VSS.t278 2412.37
R16 VSS.t196 VSS.t176 2412.37
R17 VSS.t750 VSS.t384 2412.37
R18 VSS.t442 VSS.t341 2412.37
R19 VSS.t216 VSS.t936 2412.37
R20 VSS.t754 VSS.t880 2412.37
R21 VSS.n384 VSS.t147 1976.8
R22 VSS.t739 VSS.t263 1576.65
R23 VSS.t930 VSS.t919 1576.65
R24 VSS.n385 VSS.t447 1541.24
R25 VSS.t525 VSS.n252 1541.24
R26 VSS.t600 VSS.n262 1541.24
R27 VSS.t224 VSS.n272 1541.24
R28 VSS.n285 VSS.t309 1541.24
R29 VSS.t592 VSS.t79 1244.01
R30 VSS.t825 VSS.t32 1244.01
R31 VSS.t913 VSS.t608 1206.19
R32 VSS.t716 VSS.t865 1206.19
R33 VSS.t102 VSS.t117 1206.19
R34 VSS.t596 VSS.t883 1206.19
R35 VSS.t97 VSS.t908 1206.19
R36 VSS.t744 VSS.t167 1206.19
R37 VSS.t915 VSS.t799 1206.19
R38 VSS.t22 VSS.t288 1206.19
R39 VSS.t254 VSS.t67 1206.19
R40 VSS.t536 VSS.t870 1206.19
R41 VSS.t85 VSS.t836 1206.19
R42 VSS.t126 VSS.t4 1206.19
R43 VSS.t924 VSS.t559 1206.19
R44 VSS.t686 VSS.t57 1200.52
R45 VSS.t404 VSS.t669 1160.71
R46 VSS.t320 VSS.t61 1159.77
R47 VSS.t378 VSS.t388 1158.08
R48 VSS.t51 VSS.t682 1154.5
R49 VSS.t545 VSS.t530 1142.39
R50 VSS.n201 VSS.t55 1120.83
R51 VSS.n386 VSS.t268 1081.46
R52 VSS.t547 VSS.t339 1007.84
R53 VSS.t723 VSS.n384 871.135
R54 VSS.n252 VSS.t394 871.135
R55 VSS.n262 VSS.t28 871.135
R56 VSS.n285 VSS.t737 871.135
R57 VSS.n386 VSS.t360 871.135
R58 VSS.t418 VSS.t186 830.149
R59 VSS.t542 VSS.t746 830.149
R60 VSS.t94 VSS.t445 811.84
R61 VSS.t621 VSS.t640 795.972
R62 VSS.t444 VSS.t532 793.328
R63 VSS.t640 VSS.t94 788.039
R64 VSS.t629 VSS.t256 777.462
R65 VSS.t295 VSS.t831 759.74
R66 VSS.t611 VSS.t300 717.533
R67 VSS.t608 VSS.t899 670.104
R68 VSS.t899 VSS.t234 670.104
R69 VSS.t234 VSS.t449 670.104
R70 VSS.t449 VSS.t607 670.104
R71 VSS.t865 VSS.t714 670.104
R72 VSS.t714 VSS.t208 670.104
R73 VSS.t208 VSS.t277 670.104
R74 VSS.t277 VSS.t868 670.104
R75 VSS.t117 VSS.t275 670.104
R76 VSS.t275 VSS.t786 670.104
R77 VSS.t786 VSS.t178 670.104
R78 VSS.t178 VSS.t120 670.104
R79 VSS.t781 VSS.t147 670.104
R80 VSS.t371 VSS.t781 670.104
R81 VSS.t676 VSS.t371 670.104
R82 VSS.t432 VSS.t676 670.104
R83 VSS.t891 VSS.t596 670.104
R84 VSS.t813 VSS.t891 670.104
R85 VSS.t307 VSS.t813 670.104
R86 VSS.t595 VSS.t307 670.104
R87 VSS.t733 VSS.t97 670.104
R88 VSS.t386 VSS.t733 670.104
R89 VSS.t749 VSS.t386 670.104
R90 VSS.t96 VSS.t749 670.104
R91 VSS.t171 VSS.t744 670.104
R92 VSS.t667 VSS.t171 670.104
R93 VSS.t527 VSS.t667 670.104
R94 VSS.t748 VSS.t527 670.104
R95 VSS.t720 VSS.t266 670.104
R96 VSS.t226 VSS.t720 670.104
R97 VSS.t487 VSS.t226 670.104
R98 VSS.t500 VSS.t487 670.104
R99 VSS.t796 VSS.t915 670.104
R100 VSS.t34 VSS.t796 670.104
R101 VSS.t248 VSS.t34 670.104
R102 VSS.t918 VSS.t248 670.104
R103 VSS.t286 VSS.t22 670.104
R104 VSS.t331 VSS.t286 670.104
R105 VSS.t602 VSS.t331 670.104
R106 VSS.t25 VSS.t602 670.104
R107 VSS.t517 VSS.t254 670.104
R108 VSS.t463 VSS.t517 670.104
R109 VSS.t441 VSS.t463 670.104
R110 VSS.t252 VSS.t441 670.104
R111 VSS.t652 VSS.t731 670.104
R112 VSS.t20 VSS.t652 670.104
R113 VSS.t485 VSS.t20 670.104
R114 VSS.t729 VSS.t485 670.104
R115 VSS.t876 VSS.t536 670.104
R116 VSS.t940 VSS.t876 670.104
R117 VSS.t223 VSS.t940 670.104
R118 VSS.t539 VSS.t223 670.104
R119 VSS.t833 VSS.t85 670.104
R120 VSS.t844 VSS.t833 670.104
R121 VSS.t218 VSS.t844 670.104
R122 VSS.t87 VSS.t218 670.104
R123 VSS.t773 VSS.t126 670.104
R124 VSS.t702 VSS.t773 670.104
R125 VSS.t756 VSS.t702 670.104
R126 VSS.t125 VSS.t756 670.104
R127 VSS.t559 VSS.t453 670.104
R128 VSS.t453 VSS.t410 670.104
R129 VSS.t410 VSS.t308 670.104
R130 VSS.t308 VSS.t575 670.104
R131 VSS.n14 VSS.t142 649.436
R132 VSS.n55 VSS.t281 639.845
R133 VSS.n5 VSS.t469 622.061
R134 VSS.n56 VSS.t204 608.881
R135 VSS.n24 VSS.t815 604.1
R136 VSS.t901 VSS.t858 603.093
R137 VSS.t610 VSS.t489 603.093
R138 VSS.t230 VSS.t458 603.093
R139 VSS.t710 VSS.t373 603.093
R140 VSS.t867 VSS.t562 603.093
R141 VSS.t198 VSS.t161 603.093
R142 VSS.t104 VSS.t228 603.093
R143 VSS.t119 VSS.t579 603.093
R144 VSS.t721 VSS.t623 603.093
R145 VSS.t75 VSS.t885 603.093
R146 VSS.t564 VSS.t594 603.093
R147 VSS.t121 VSS.t380 603.093
R148 VSS.t808 VSS.t905 603.093
R149 VSS.t483 VSS.t99 603.093
R150 VSS.t510 VSS.t398 603.093
R151 VSS.t634 VSS.t169 603.093
R152 VSS.t782 VSS.t743 603.093
R153 VSS.t362 VSS.t665 603.093
R154 VSS.t194 VSS.t801 603.093
R155 VSS.t569 VSS.t917 603.093
R156 VSS.t503 VSS.t26 603.093
R157 VSS.t638 VSS.t285 603.093
R158 VSS.t492 VSS.t24 603.093
R159 VSS.t927 VSS.t950 603.093
R160 VSS.t752 VSS.t69 603.093
R161 VSS.t674 VSS.t253 603.093
R162 VSS.t16 VSS.t471 603.093
R163 VSS.t856 VSS.t875 603.093
R164 VSS.t585 VSS.t538 603.093
R165 VSS.t508 VSS.t934 603.093
R166 VSS.t45 VSS.t835 603.093
R167 VSS.t577 VSS.t84 603.093
R168 VSS.t619 VSS.t878 603.093
R169 VSS.t291 VSS.t772 603.093
R170 VSS.t481 VSS.t128 603.093
R171 VSS.t430 VSS.t706 603.093
R172 VSS.t926 VSS.t202 603.093
R173 VSS.t480 VSS.t567 603.093
R174 VSS.t932 VSS.t961 603.093
R175 VSS.t873 VSS.t293 593.96
R176 VSS.t757 VSS.t838 593.96
R177 VSS.t528 VSS.t352 593.96
R178 VSS.t678 VSS.t451 593.96
R179 VSS.t944 VSS.t938 591.986
R180 VSS.t842 VSS.t154 591.986
R181 VSS.t645 VSS.t146 591.986
R182 VSS.t408 VSS.t319 591.986
R183 VSS.t293 VSS.t55 588.039
R184 VSS.t263 VSS.t757 588.039
R185 VSS.t919 VSS.t528 588.039
R186 VSS.t268 VSS.t678 588.039
R187 VSS.t869 VSS.t854 580.146
R188 VSS.t200 VSS.t841 580.146
R189 VSS.t47 VSS.t775 580.146
R190 VSS.t661 VSS.t455 580.146
R191 VSS.t812 VSS.t614 564.726
R192 VSS.t429 VSS.t375 564.726
R193 VSS.t660 VSS.t368 564.726
R194 VSS.t671 VSS.n14 551.081
R195 VSS.n56 VSS.t583 550.893
R196 VSS.t478 VSS.n5 550.893
R197 VSS.t959 VSS.t611 527.597
R198 VSS.t77 VSS.t812 525.196
R199 VSS.t163 VSS.t778 519.548
R200 VSS.t636 VSS.t827 519.548
R201 VSS.t88 VSS.t810 496.959
R202 VSS.t140 VSS.t129 496.959
R203 VSS.t605 VSS.t959 490.666
R204 VSS.t434 VSS.t59 460.252
R205 VSS.t421 VSS.t144 460.252
R206 VSS.t817 VSS.n201 455.829
R207 VSS.t688 VSS.t356 451.781
R208 VSS.t354 VSS.t689 451.781
R209 VSS.t79 VSS.t77 451.781
R210 VSS.t57 VSS.t418 451.781
R211 VSS.t186 VSS.t280 451.781
R212 VSS.t142 VSS.t542 451.781
R213 VSS.t746 VSS.t175 451.781
R214 VSS.t447 VSS.t476 435.567
R215 VSS.t232 VSS.t780 435.567
R216 VSS.t607 VSS.t851 435.567
R217 VSS.t851 VSS.t152 435.567
R218 VSS.t278 VSS.t963 435.567
R219 VSS.t49 VSS.t719 435.567
R220 VSS.t868 VSS.t711 435.567
R221 VSS.t711 VSS.t196 435.567
R222 VSS.t176 VSS.t630 435.567
R223 VSS.t684 VSS.t491 435.567
R224 VSS.t120 VSS.t106 435.567
R225 VSS.t106 VSS.t723 435.567
R226 VSS.t123 VSS.t305 435.567
R227 VSS.t673 VSS.t382 435.567
R228 VSS.t882 VSS.t595 435.567
R229 VSS.t384 VSS.t882 435.567
R230 VSS.t957 VSS.t750 435.567
R231 VSS.t561 VSS.t402 435.567
R232 VSS.t692 VSS.t96 435.567
R233 VSS.t394 VSS.t692 435.567
R234 VSS.t364 VSS.t525 435.567
R235 VSS.t576 VSS.t155 435.567
R236 VSS.t83 VSS.t748 435.567
R237 VSS.t159 VSS.t83 435.567
R238 VSS.t615 VSS.t249 435.567
R239 VSS.t461 VSS.t244 435.567
R240 VSS.t315 VSS.t918 435.567
R241 VSS.t28 VSS.t315 435.567
R242 VSS.t823 VSS.t600 435.567
R243 VSS.t566 VSS.t63 435.567
R244 VSS.t515 VSS.t25 435.567
R245 VSS.t341 VSS.t515 435.567
R246 VSS.t18 VSS.t442 435.567
R247 VSS.t587 VSS.t543 435.567
R248 VSS.t512 VSS.t252 435.567
R249 VSS.t494 VSS.t512 435.567
R250 VSS.t965 VSS.t224 435.567
R251 VSS.t581 VSS.t942 435.567
R252 VSS.t872 VSS.t539 435.567
R253 VSS.t936 VSS.t872 435.567
R254 VSS.t642 VSS.t216 435.567
R255 VSS.t462 VSS.t846 435.567
R256 VSS.t840 VSS.t87 435.567
R257 VSS.t880 VSS.t840 435.567
R258 VSS.t551 VSS.t754 435.567
R259 VSS.t582 VSS.t704 435.567
R260 VSS.t351 VSS.t125 435.567
R261 VSS.t737 VSS.t351 435.567
R262 VSS.t309 VSS.t952 435.567
R263 VSS.t358 VSS.t460 435.567
R264 VSS.t575 VSS.t450 435.567
R265 VSS.t450 VSS.t360 435.567
R266 VSS.t530 VSS.t629 423.108
R267 VSS.t256 VSS.t444 423.108
R268 VSS.t532 VSS.t621 423.108
R269 VSS.t427 VSS.t889 422.079
R270 VSS.t423 VSS.t886 422.079
R271 VSS.t134 VSS.t894 422.079
R272 VSS.t425 VSS.t438 422.079
R273 VSS.t400 VSS.t735 422.079
R274 VSS.t392 VSS.t906 422.079
R275 VSS.t790 VSS.t693 422.079
R276 VSS.t396 VSS.t473 422.079
R277 VSS.t157 VSS.t219 422.079
R278 VSS.t658 VSS.t11 422.079
R279 VSS.t861 VSS.t13 422.079
R280 VSS.t654 VSS.t131 422.079
R281 VSS.t300 VSS.t295 422.079
R282 VSS.t603 VSS.t605 422.079
R283 VSS.t897 VSS.t236 421.736
R284 VSS.t911 VSS.t588 421.736
R285 VSS.t848 VSS.t297 421.736
R286 VSS.t945 VSS.t590 421.736
R287 VSS.t53 VSS.t697 421.736
R288 VSS.t115 VSS.t699 421.736
R289 VSS.t349 VSS.t712 421.736
R290 VSS.t113 VSS.t42 421.736
R291 VSS.t708 VSS.t270 421.736
R292 VSS.t680 VSS.t107 421.736
R293 VSS.t184 VSS.t760 421.736
R294 VSS.t725 VSS.t179 421.736
R295 VSS.t246 VSS.t794 421.736
R296 VSS.t30 VSS.t803 421.736
R297 VSS.t325 VSS.t806 421.736
R298 VSS.t240 VSS.t322 421.736
R299 VSS.t212 VSS.t768 421.736
R300 VSS.t345 VSS.t519 421.736
R301 VSS.t109 VSS.t766 421.736
R302 VSS.t343 VSS.t763 421.736
R303 VSS.t573 VSS.t521 421.736
R304 VSS.t467 VSS.t65 421.736
R305 VSS.t192 VSS.t513 421.736
R306 VSS.t496 VSS.t923 421.736
R307 VSS.t505 VSS.t189 403.286
R308 VSS.t2 VSS.t137 400.974
R309 VSS.t165 VSS.t793 400.974
R310 VSS.t221 VSS.t863 398.337
R311 VSS.t302 VSS.t523 398.014
R312 VSS.t333 VSS.t348 398.014
R313 VSS.t303 VSS.t328 398.014
R314 VSS.t73 VSS.t112 398.014
R315 VSS.t280 VSS.t434 386.839
R316 VSS.t175 VSS.t421 386.839
R317 VSS.t0 VSS.t190 384.834
R318 VSS.t682 VSS.t180 363.748
R319 VSS.t762 VSS.t784 363.748
R320 VSS.t815 VSS.t439 361.404
R321 VSS.t896 VSS.t376 361.404
R322 VSS.t388 VSS.t474 361.404
R323 VSS.t691 VSS.t390 361.404
R324 VSS.t669 VSS.t132 358.767
R325 VSS.t15 VSS.t656 358.767
R326 VSS.t946 VSS.t592 358.476
R327 VSS.t150 VSS.t850 358.476
R328 VSS.t204 VSS.t40 358.476
R329 VSS.t701 VSS.t206 358.476
R330 VSS.t32 VSS.t323 358.476
R331 VSS.t805 VSS.t242 358.476
R332 VSS.t61 VSS.t764 358.476
R333 VSS.t149 VSS.t329 358.476
R334 VSS.t59 VSS.t90 352.954
R335 VSS.t416 VSS.t88 352.954
R336 VSS.t144 VSS.t138 352.954
R337 VSS.t540 VSS.t140 352.954
R338 VSS.t827 VSS.t173 347.308
R339 VSS.t955 VSS.t725 345.296
R340 VSS.t469 VSS.t921 345.296
R341 VSS.t70 VSS.t465 345.296
R342 VSS.t8 VSS.t425 342.938
R343 VSS.t273 VSS.t396 342.938
R344 VSS.t238 VSS.t654 340.3
R345 VSS.t590 VSS.t632 340.024
R346 VSS.t36 VSS.t113 340.024
R347 VSS.t210 VSS.t240 340.024
R348 VSS.t819 VSS.t343 340.024
R349 VSS.t598 VSS.t188 326.846
R350 VSS.t502 VSS.t708 326.846
R351 VSS.t214 VSS.t496 326.846
R352 VSS.n387 VSS.t260 324.721
R353 VSS.t406 VSS.t136 324.473
R354 VSS.t864 VSS.t427 324.473
R355 VSS.t100 VSS.t792 324.473
R356 VSS.t759 VSS.t400 324.473
R357 VSS.t316 VSS.t860 321.834
R358 VSS.t290 VSS.t157 321.834
R359 VSS.t299 VSS.t369 321.574
R360 VSS.t236 VSS.t318 321.574
R361 VSS.t71 VSS.t347 321.574
R362 VSS.t265 VSS.t53 321.574
R363 VSS.t283 VSS.t327 321.574
R364 VSS.t653 VSS.t246 321.574
R365 VSS.t821 VSS.t111 321.574
R366 VSS.t929 VSS.t212 321.574
R367 VSS.t376 VSS.t893 316.558
R368 VSS.t390 VSS.t695 316.558
R369 VSS.t656 VSS.t10 316.558
R370 VSS.t902 VSS.t150 316.303
R371 VSS.t206 VSS.t696 316.303
R372 VSS.t784 VSS.t272 316.303
R373 VSS.t242 VSS.t798 316.303
R374 VSS.t329 VSS.t516 316.303
R375 VSS.t465 VSS.t251 316.303
R376 VSS.t339 VSS.t869 315.726
R377 VSS.t854 VSS.t944 315.726
R378 VSS.t938 VSS.t873 315.726
R379 VSS.t841 VSS.t817 315.726
R380 VSS.t154 VSS.t200 315.726
R381 VSS.t838 VSS.t842 315.726
R382 VSS.t775 VSS.t739 315.726
R383 VSS.t146 VSS.t47 315.726
R384 VSS.t352 VSS.t645 315.726
R385 VSS.t455 VSS.t930 315.726
R386 VSS.t319 VSS.t661 315.726
R387 VSS.t451 VSS.t408 315.726
R388 VSS.t829 VSS.t191 308.394
R389 VSS.t644 VSS.t573 308.394
R390 VSS.t107 VSS.t184 295.216
R391 VSS.t886 VSS.t134 292.817
R392 VSS.t906 VSS.t790 292.817
R393 VSS.t11 VSS.t861 290.18
R394 VSS.t297 VSS.t911 289.943
R395 VSS.t699 VSS.t349 289.943
R396 VSS.t803 VSS.t325 289.943
R397 VSS.t519 VSS.t109 289.943
R398 VSS.n385 VSS.t603 284.904
R399 VSS.t649 VSS.t627 282.731
R400 VSS.t555 VSS.t262 277.132
R401 VSS.t65 VSS.t192 276.764
R402 VSS.t954 VSS.t545 275.021
R403 VSS.t137 VSS.t888 274.351
R404 VSS.t888 VSS.t378 274.351
R405 VSS.t793 VSS.t910 274.351
R406 VSS.t910 VSS.t404 274.351
R407 VSS.t553 VSS.t647 274.332
R408 VSS.t960 VSS.t302 274.128
R409 VSS.t583 VSS.t960 274.128
R410 VSS.t348 VSS.t718 274.128
R411 VSS.t718 VSS.t51 274.128
R412 VSS.t105 VSS.t686 274.128
R413 VSS.t170 VSS.t671 274.128
R414 VSS.t328 VSS.t802 274.128
R415 VSS.t802 VSS.t320 274.128
R416 VSS.t507 VSS.t478 274.128
R417 VSS.t189 VSS.t105 274.128
R418 VSS.t112 VSS.t507 274.128
R419 VSS.t810 VSS.t429 271.07
R420 VSS.t129 VSS.t660 271.07
R421 VSS.t863 VSS.t170 265.115
R422 VSS.t727 VSS.t337 259.774
R423 VSS.t689 VSS.t335 259.774
R424 VSS.t190 VSS.t954 255.708
R425 VSS.t260 VSS.t553 240.742
R426 VSS.t647 VSS.t555 240.742
R427 VSS.t476 VSS.t232 234.536
R428 VSS.t963 VSS.t49 234.536
R429 VSS.t630 VSS.t684 234.536
R430 VSS.t382 VSS.t123 234.536
R431 VSS.t402 VSS.t957 234.536
R432 VSS.t155 VSS.t364 234.536
R433 VSS.t244 VSS.t615 234.536
R434 VSS.t63 VSS.t823 234.536
R435 VSS.t543 VSS.t18 234.536
R436 VSS.t942 VSS.t965 234.536
R437 VSS.t846 VSS.t642 234.536
R438 VSS.t704 VSS.t551 234.536
R439 VSS.t952 VSS.t358 234.536
R440 VSS.t337 VSS.t688 192.007
R441 VSS.t335 VSS.t727 192.007
R442 VSS.t778 VSS.n55 180.713
R443 VSS.t356 VSS.t770 169.418
R444 VSS.t445 VSS.t547 158.667
R445 VSS.t262 VSS.t650 151.163
R446 VSS.t650 VSS.t258 149.298
R447 VSS.t258 VSS.t649 149.298
R448 VSS.t251 VSS.t829 113.341
R449 VSS.t191 VSS.t644 113.341
R450 VSS.t173 VSS.t825 104.475
R451 VSS.t10 VSS.t316 100.245
R452 VSS.t860 VSS.t290 100.245
R453 VSS.t369 VSS.t902 100.162
R454 VSS.t318 VSS.t299 100.162
R455 VSS.t696 VSS.t71 100.162
R456 VSS.t347 VSS.t265 100.162
R457 VSS.t798 VSS.t283 100.162
R458 VSS.t327 VSS.t653 100.162
R459 VSS.t516 VSS.t821 100.162
R460 VSS.t111 VSS.t929 100.162
R461 VSS.t90 VSS.t416 98.8276
R462 VSS.t138 VSS.t540 98.8276
R463 VSS.t893 VSS.t406 97.606
R464 VSS.t136 VSS.t864 97.606
R465 VSS.t695 VSS.t100 97.606
R466 VSS.t792 VSS.t759 97.606
R467 VSS.t272 VSS.t598 94.891
R468 VSS.t188 VSS.t502 94.891
R469 VSS.t513 VSS.t214 94.891
R470 VSS.t13 VSS.t238 81.7781
R471 VSS.t632 VSS.t848 81.7118
R472 VSS.t712 VSS.t36 81.7118
R473 VSS.t806 VSS.t210 81.7118
R474 VSS.t766 VSS.t819 81.7118
R475 VSS.t894 VSS.t8 79.1401
R476 VSS.t693 VSS.t273 79.1401
R477 VSS.t760 VSS.t955 76.4401
R478 VSS.t921 VSS.t70 76.4401
R479 VSS.t780 VSS.t901 67.0108
R480 VSS.t858 VSS.t610 67.0108
R481 VSS.t489 VSS.t230 67.0108
R482 VSS.t458 VSS.t913 67.0108
R483 VSS.t719 VSS.t710 67.0108
R484 VSS.t373 VSS.t867 67.0108
R485 VSS.t562 VSS.t198 67.0108
R486 VSS.t161 VSS.t716 67.0108
R487 VSS.t491 VSS.t104 67.0108
R488 VSS.t228 VSS.t119 67.0108
R489 VSS.t579 VSS.t721 67.0108
R490 VSS.t623 VSS.t102 67.0108
R491 VSS.t885 VSS.t673 67.0108
R492 VSS.t594 VSS.t75 67.0108
R493 VSS.t380 VSS.t564 67.0108
R494 VSS.t883 VSS.t121 67.0108
R495 VSS.t905 VSS.t561 67.0108
R496 VSS.t99 VSS.t808 67.0108
R497 VSS.t398 VSS.t483 67.0108
R498 VSS.t908 VSS.t510 67.0108
R499 VSS.t169 VSS.t576 67.0108
R500 VSS.t743 VSS.t634 67.0108
R501 VSS.t665 VSS.t782 67.0108
R502 VSS.t167 VSS.t362 67.0108
R503 VSS.t801 VSS.t461 67.0108
R504 VSS.t917 VSS.t194 67.0108
R505 VSS.t26 VSS.t569 67.0108
R506 VSS.t799 VSS.t503 67.0108
R507 VSS.t285 VSS.t566 67.0108
R508 VSS.t24 VSS.t638 67.0108
R509 VSS.t950 VSS.t492 67.0108
R510 VSS.t288 VSS.t927 67.0108
R511 VSS.t69 VSS.t587 67.0108
R512 VSS.t253 VSS.t752 67.0108
R513 VSS.t471 VSS.t674 67.0108
R514 VSS.t67 VSS.t16 67.0108
R515 VSS.t875 VSS.t581 67.0108
R516 VSS.t538 VSS.t856 67.0108
R517 VSS.t934 VSS.t585 67.0108
R518 VSS.t870 VSS.t508 67.0108
R519 VSS.t835 VSS.t462 67.0108
R520 VSS.t84 VSS.t45 67.0108
R521 VSS.t878 VSS.t577 67.0108
R522 VSS.t836 VSS.t619 67.0108
R523 VSS.t772 VSS.t582 67.0108
R524 VSS.t128 VSS.t291 67.0108
R525 VSS.t706 VSS.t481 67.0108
R526 VSS.t4 VSS.t430 67.0108
R527 VSS.t460 VSS.t926 67.0108
R528 VSS.t202 VSS.t480 67.0108
R529 VSS.t567 VSS.t932 67.0108
R530 VSS.t961 VSS.t924 67.0108
R531 VSS.t132 VSS.t15 63.3122
R532 VSS.t850 VSS.t946 63.2608
R533 VSS.t40 VSS.t701 63.2608
R534 VSS.t323 VSS.t805 63.2608
R535 VSS.t764 VSS.t149 63.2608
R536 VSS.t439 VSS.t896 60.6742
R537 VSS.t474 VSS.t691 60.6742
R538 VSS.t521 VSS.t467 60.625
R539 VSS.t180 VSS.t762 57.9891
R540 VSS.t614 VSS.t354 56.4731
R541 VSS.t219 VSS.t658 47.4843
R542 VSS.t588 VSS.t897 47.4458
R543 VSS.t697 VSS.t115 47.4458
R544 VSS.t794 VSS.t30 47.4458
R545 VSS.t768 VSS.t345 47.4458
R546 VSS.t889 VSS.t423 44.8463
R547 VSS.t735 VSS.t392 44.8463
R548 VSS.t270 VSS.t680 42.1741
R549 VSS.t923 VSS.t0 36.9024
R550 VSS.t131 VSS.t221 23.7424
R551 VSS.t523 VSS.t945 23.7231
R552 VSS.t42 VSS.t333 23.7231
R553 VSS.t322 VSS.t303 23.7231
R554 VSS.t763 VSS.t73 23.7231
R555 VSS.t438 VSS.t2 21.1044
R556 VSS.t473 VSS.t165 21.1044
R557 VSS.t179 VSS.t505 18.4514
R558 VSS.n1 VSS.t269 11.3821
R559 VSS.n188 VSS.t920 11.3821
R560 VSS.n194 VSS.t264 11.3821
R561 VSS.n167 VSS.t1 11.3821
R562 VSS.n155 VSS.t74 11.3821
R563 VSS.n144 VSS.t304 11.3821
R564 VSS.n132 VSS.t637 11.3821
R565 VSS.n87 VSS.t164 11.3821
R566 VSS.n78 VSS.t506 11.3821
R567 VSS.n67 VSS.t334 11.3821
R568 VSS.n53 VSS.t524 11.3821
R569 VSS.n182 VSS.t56 11.3821
R570 VSS.n174 VSS.t95 11.3821
R571 VSS.n133 VSS.t174 11.3805
R572 VSS.n122 VSS.t222 11.3805
R573 VSS.n111 VSS.t166 11.3805
R574 VSS.n100 VSS.t3 11.3805
R575 VSS.n88 VSS.t282 11.3805
R576 VSS.n175 VSS.t446 11.3805
R577 VSS VSS.t628 11.213
R578 VSS.n392 VSS.t556 11.1876
R579 VSS.n390 VSS.t554 11.1876
R580 VSS.n391 VSS.t648 11.1519
R581 VSS.n389 VSS.t261 11.1519
R582 VSS.n183 VSS.t679 11.1196
R583 VSS.n184 VSS.t452 11.1196
R584 VSS.n189 VSS.t529 11.1196
R585 VSS.n190 VSS.t353 11.1196
R586 VSS.n195 VSS.t758 11.1196
R587 VSS.n196 VSS.t839 11.1196
R588 VSS.n165 VSS.t215 11.1196
R589 VSS.n164 VSS.t66 11.1196
R590 VSS.n153 VSS.t820 11.1196
R591 VSS.n152 VSS.t520 11.1196
R592 VSS.n142 VSS.t211 11.1196
R593 VSS.n141 VSS.t804 11.1196
R594 VSS.n131 VSS.t130 11.1196
R595 VSS.n130 VSS.t541 11.1196
R596 VSS.n86 VSS.t811 11.1196
R597 VSS.n85 VSS.t417 11.1196
R598 VSS.n76 VSS.t956 11.1196
R599 VSS.n75 VSS.t108 11.1196
R600 VSS.n65 VSS.t37 11.1196
R601 VSS.n64 VSS.t700 11.1196
R602 VSS.n51 VSS.t633 11.1196
R603 VSS.n50 VSS.t912 11.1196
R604 VSS.n181 VSS.t294 11.1196
R605 VSS.n180 VSS.t874 11.1196
R606 VSS.n173 VSS.t641 11.1196
R607 VSS.n172 VSS.t622 11.1196
R608 VSS.n120 VSS.t239 11.118
R609 VSS.n119 VSS.t12 11.118
R610 VSS.n109 VSS.t274 11.118
R611 VSS.n108 VSS.t907 11.118
R612 VSS.n98 VSS.t9 11.118
R613 VSS.n97 VSS.t887 11.118
R614 VSS.n140 VSS.t326 11.1009
R615 VSS.n151 VSS.t110 11.1009
R616 VSS.n163 VSS.t193 11.1009
R617 VSS.n49 VSS.t298 11.1009
R618 VSS.n63 VSS.t350 11.1009
R619 VSS.n74 VSS.t185 11.1009
R620 VSS.n292 VSS.t560 11.1009
R621 VSS.n301 VSS.t127 11.1009
R622 VSS.n309 VSS.t86 11.1009
R623 VSS.n317 VSS.t537 11.1009
R624 VSS.n329 VSS.t255 11.1009
R625 VSS.n337 VSS.t23 11.1009
R626 VSS.n346 VSS.t916 11.1009
R627 VSS.n357 VSS.t745 11.1009
R628 VSS.n366 VSS.t98 11.1009
R629 VSS.n374 VSS.t597 11.1009
R630 VSS.n240 VSS.t118 11.1009
R631 VSS.n232 VSS.t866 11.1009
R632 VSS.n224 VSS.t609 11.1009
R633 VSS.n96 VSS.t135 11.099
R634 VSS.n107 VSS.t791 11.099
R635 VSS.n118 VSS.t862 11.099
R636 VSS.n185 VSS.t409 11.0321
R637 VSS.n191 VSS.t646 11.0321
R638 VSS.n197 VSS.t843 11.0321
R639 VSS.n162 VSS.t468 11.0321
R640 VSS.n150 VSS.t346 11.0321
R641 VSS.n139 VSS.t31 11.0321
R642 VSS.n128 VSS.t145 11.0321
R643 VSS.n83 VSS.t60 11.0321
R644 VSS.n73 VSS.t681 11.0321
R645 VSS.n62 VSS.t116 11.0321
R646 VSS.n48 VSS.t589 11.0321
R647 VSS.n179 VSS.t939 11.0321
R648 VSS.n171 VSS.t533 11.0321
R649 VSS.n117 VSS.t659 11.0305
R650 VSS.n106 VSS.t393 11.0305
R651 VSS.n95 VSS.t424 11.0305
R652 VSS.n145 VSS.t321 11.0199
R653 VSS.n156 VSS.t479 11.0199
R654 VSS.n168 VSS.t546 11.0199
R655 VSS.n54 VSS.t584 11.0199
R656 VSS.n68 VSS.t52 11.0199
R657 VSS.n79 VSS.t687 11.0199
R658 VSS.n290 VSS.t361 11.0199
R659 VSS.n299 VSS.t738 11.0199
R660 VSS.n307 VSS.t881 11.0199
R661 VSS.n315 VSS.t937 11.0199
R662 VSS.n327 VSS.t495 11.0199
R663 VSS.n335 VSS.t342 11.0199
R664 VSS.n344 VSS.t29 11.0199
R665 VSS.n355 VSS.t160 11.0199
R666 VSS.n364 VSS.t395 11.0199
R667 VSS.n372 VSS.t385 11.0199
R668 VSS.n242 VSS.t724 11.0199
R669 VSS.n234 VSS.t197 11.0199
R670 VSS.n226 VSS.t153 11.0199
R671 VSS.n101 VSS.t379 11.0186
R672 VSS.n112 VSS.t405 11.0186
R673 VSS.n123 VSS.t672 11.0186
R674 VSS.n176 VSS.t548 10.9511
R675 VSS.n201 VSS.n200 10.5554
R676 VSS.n323 VSS.n272 10.5531
R677 VSS.n343 VSS.n262 10.5531
R678 VSS.n363 VSS.n252 10.5531
R679 VSS.n384 VSS.n383 10.5531
R680 VSS.n388 VSS.n387 10.5531
R681 VSS.n298 VSS.n285 10.5531
R682 VSS.n157 VSS.n5 10.5512
R683 VSS.n124 VSS.n14 10.5512
R684 VSS.n90 VSS.n24 10.5512
R685 VSS.n57 VSS.n56 10.5512
R686 VSS.n204 VSS.t832 8.78657
R687 VSS.n39 VSS.t357 8.75771
R688 VSS.n186 VSS.t662 8.74003
R689 VSS.n187 VSS.t931 8.74003
R690 VSS.n192 VSS.t48 8.74003
R691 VSS.n193 VSS.t740 8.74003
R692 VSS.n198 VSS.t201 8.74003
R693 VSS.n199 VSS.t818 8.74003
R694 VSS.n160 VSS.t830 8.74003
R695 VSS.n158 VSS.t470 8.74003
R696 VSS.n148 VSS.t822 8.74003
R697 VSS.n146 VSS.t62 8.74003
R698 VSS.n137 VSS.t284 8.74003
R699 VSS.n135 VSS.t33 8.74003
R700 VSS.n126 VSS.t747 8.74003
R701 VSS.n125 VSS.t143 8.74003
R702 VSS.n81 VSS.t187 8.74003
R703 VSS.n80 VSS.t58 8.74003
R704 VSS.n71 VSS.t599 8.74003
R705 VSS.n69 VSS.t683 8.74003
R706 VSS.n60 VSS.t72 8.74003
R707 VSS.n58 VSS.t205 8.74003
R708 VSS.n46 VSS.t370 8.74003
R709 VSS.n44 VSS.t593 8.74003
R710 VSS.n178 VSS.t855 8.74003
R711 VSS.n177 VSS.t340 8.74003
R712 VSS.n170 VSS.t257 8.74003
R713 VSS.n169 VSS.t531 8.74003
R714 VSS.n115 VSS.t317 8.73862
R715 VSS.n113 VSS.t670 8.73862
R716 VSS.n104 VSS.t101 8.73862
R717 VSS.n102 VSS.t389 8.73862
R718 VSS.n93 VSS.t407 8.73862
R719 VSS.n91 VSS.t816 8.73862
R720 VSS.n42 VSS.t355 8.68271
R721 VSS.n219 VSS.t477 8.68138
R722 VSS.n223 VSS.t459 8.68138
R723 VSS.n227 VSS.t964 8.68138
R724 VSS.n231 VSS.t162 8.68138
R725 VSS.n235 VSS.t631 8.68138
R726 VSS.n239 VSS.t624 8.68138
R727 VSS.n382 VSS.t148 8.68138
R728 VSS.n380 VSS.t433 8.68138
R729 VSS.n379 VSS.t124 8.68138
R730 VSS.n375 VSS.t122 8.68138
R731 VSS.n371 VSS.t958 8.68138
R732 VSS.n367 VSS.t511 8.68138
R733 VSS.n362 VSS.t365 8.68138
R734 VSS.n358 VSS.t363 8.68138
R735 VSS.n354 VSS.t267 8.68138
R736 VSS.n352 VSS.t501 8.68138
R737 VSS.n351 VSS.t616 8.68138
R738 VSS.n347 VSS.t504 8.68138
R739 VSS.n342 VSS.t824 8.68138
R740 VSS.n338 VSS.t928 8.68138
R741 VSS.n334 VSS.t19 8.68138
R742 VSS.n330 VSS.t17 8.68138
R743 VSS.n326 VSS.t732 8.68138
R744 VSS.n324 VSS.t730 8.68138
R745 VSS.n322 VSS.t966 8.68138
R746 VSS.n318 VSS.t509 8.68138
R747 VSS.n314 VSS.t643 8.68138
R748 VSS.n310 VSS.t620 8.68138
R749 VSS.n306 VSS.t552 8.68138
R750 VSS.n302 VSS.t431 8.68138
R751 VSS.n297 VSS.t953 8.68138
R752 VSS.n293 VSS.t962 8.68138
R753 VSS.n127 VSS.t422 8.57057
R754 VSS.n39 VSS.t771 8.57057
R755 VSS.n82 VSS.t435 8.57057
R756 VSS.n393 VSS.n0 6.62657
R757 VSS.n136 VSS.n11 6.55093
R758 VSS.n147 VSS.n8 6.55093
R759 VSS.n159 VSS.n4 6.55093
R760 VSS.n45 VSS.n35 6.55093
R761 VSS.n59 VSS.n32 6.55093
R762 VSS.n70 VSS.n29 6.55093
R763 VSS.n296 VSS.n286 6.55093
R764 VSS.n305 VSS.n281 6.55093
R765 VSS.n313 VSS.n277 6.55093
R766 VSS.n321 VSS.n273 6.55093
R767 VSS.n333 VSS.n267 6.55093
R768 VSS.n341 VSS.n263 6.55093
R769 VSS.n350 VSS.n258 6.55093
R770 VSS.n361 VSS.n253 6.55093
R771 VSS.n370 VSS.n248 6.55093
R772 VSS.n378 VSS.n244 6.55093
R773 VSS.n236 VSS.n210 6.55093
R774 VSS.n228 VSS.n214 6.55093
R775 VSS.n220 VSS.n218 6.55093
R776 VSS.n92 VSS.n23 6.54898
R777 VSS.n103 VSS.n20 6.54898
R778 VSS.n114 VSS.n17 6.54898
R779 VSS.n138 VSS.n10 6.46991
R780 VSS.n143 VSS.n9 6.46991
R781 VSS.n149 VSS.n7 6.46991
R782 VSS.n154 VSS.n6 6.46991
R783 VSS.n161 VSS.n3 6.46991
R784 VSS.n166 VSS.n2 6.46991
R785 VSS.n47 VSS.n34 6.46991
R786 VSS.n52 VSS.n33 6.46991
R787 VSS.n61 VSS.n31 6.46991
R788 VSS.n66 VSS.n30 6.46991
R789 VSS.n72 VSS.n28 6.46991
R790 VSS.n77 VSS.n27 6.46991
R791 VSS.n291 VSS.n289 6.46991
R792 VSS.n294 VSS.n288 6.46991
R793 VSS.n300 VSS.n284 6.46991
R794 VSS.n303 VSS.n283 6.46991
R795 VSS.n308 VSS.n280 6.46991
R796 VSS.n311 VSS.n279 6.46991
R797 VSS.n316 VSS.n276 6.46991
R798 VSS.n319 VSS.n275 6.46991
R799 VSS.n328 VSS.n270 6.46991
R800 VSS.n331 VSS.n269 6.46991
R801 VSS.n336 VSS.n266 6.46991
R802 VSS.n339 VSS.n265 6.46991
R803 VSS.n345 VSS.n261 6.46991
R804 VSS.n348 VSS.n260 6.46991
R805 VSS.n356 VSS.n256 6.46991
R806 VSS.n359 VSS.n255 6.46991
R807 VSS.n365 VSS.n251 6.46991
R808 VSS.n368 VSS.n250 6.46991
R809 VSS.n373 VSS.n247 6.46991
R810 VSS.n376 VSS.n246 6.46991
R811 VSS.n241 VSS.n207 6.46991
R812 VSS.n238 VSS.n208 6.46991
R813 VSS.n233 VSS.n211 6.46991
R814 VSS.n230 VSS.n212 6.46991
R815 VSS.n225 VSS.n215 6.46991
R816 VSS.n222 VSS.n216 6.46991
R817 VSS.n94 VSS.n22 6.46859
R818 VSS.n99 VSS.n21 6.46859
R819 VSS.n105 VSS.n19 6.46859
R820 VSS.n110 VSS.n18 6.46859
R821 VSS.n116 VSS.n16 6.46859
R822 VSS.n121 VSS.n15 6.46859
R823 VSS.n41 VSS.n37 6.40771
R824 VSS.n221 VSS.n217 6.40638
R825 VSS.n229 VSS.n213 6.40638
R826 VSS.n237 VSS.n209 6.40638
R827 VSS.n381 VSS.n243 6.40638
R828 VSS.n377 VSS.n245 6.40638
R829 VSS.n369 VSS.n249 6.40638
R830 VSS.n360 VSS.n254 6.40638
R831 VSS.n353 VSS.n257 6.40638
R832 VSS.n349 VSS.n259 6.40638
R833 VSS.n340 VSS.n264 6.40638
R834 VSS.n332 VSS.n268 6.40638
R835 VSS.n325 VSS.n271 6.40638
R836 VSS.n320 VSS.n274 6.40638
R837 VSS.n312 VSS.n278 6.40638
R838 VSS.n304 VSS.n282 6.40638
R839 VSS.n129 VSS.n13 6.40638
R840 VSS.n134 VSS.n12 6.40638
R841 VSS.n40 VSS.n38 6.40638
R842 VSS.n43 VSS.n36 6.40638
R843 VSS.n84 VSS.n26 6.40638
R844 VSS.n89 VSS.n25 6.40638
R845 VSS.n295 VSS.n287 6.40638
R846 VSS.n205 VSS.n202 6.40638
R847 VSS.n204 VSS.n203 6.40638
R848 VSS.t375 VSS.t163 5.64776
R849 VSS.t368 VSS.t636 5.64776
R850 VSS.n55 VSS.n24 5.27647
R851 VSS.n0 VSS.t651 4.5505
R852 VSS.n0 VSS.t259 4.5505
R853 VSS.n11 VSS.t324 4.5505
R854 VSS.n11 VSS.t243 4.5505
R855 VSS.n10 VSS.t247 4.5505
R856 VSS.n10 VSS.t795 4.5505
R857 VSS.n9 VSS.t807 4.5505
R858 VSS.n9 VSS.t241 4.5505
R859 VSS.n8 VSS.t765 4.5505
R860 VSS.n8 VSS.t330 4.5505
R861 VSS.n7 VSS.t213 4.5505
R862 VSS.n7 VSS.t769 4.5505
R863 VSS.n6 VSS.t767 4.5505
R864 VSS.n6 VSS.t344 4.5505
R865 VSS.n4 VSS.t922 4.5505
R866 VSS.n4 VSS.t466 4.5505
R867 VSS.n3 VSS.t574 4.5505
R868 VSS.n3 VSS.t522 4.5505
R869 VSS.n2 VSS.t514 4.5505
R870 VSS.n2 VSS.t497 4.5505
R871 VSS.n23 VSS.t440 4.5505
R872 VSS.n23 VSS.t377 4.5505
R873 VSS.n22 VSS.t428 4.5505
R874 VSS.n22 VSS.t890 4.5505
R875 VSS.n21 VSS.t895 4.5505
R876 VSS.n21 VSS.t426 4.5505
R877 VSS.n20 VSS.t475 4.5505
R878 VSS.n20 VSS.t391 4.5505
R879 VSS.n19 VSS.t401 4.5505
R880 VSS.n19 VSS.t736 4.5505
R881 VSS.n18 VSS.t694 4.5505
R882 VSS.n18 VSS.t397 4.5505
R883 VSS.n17 VSS.t133 4.5505
R884 VSS.n17 VSS.t657 4.5505
R885 VSS.n16 VSS.t158 4.5505
R886 VSS.n16 VSS.t220 4.5505
R887 VSS.n15 VSS.t14 4.5505
R888 VSS.n15 VSS.t655 4.5505
R889 VSS.n35 VSS.t947 4.5505
R890 VSS.n35 VSS.t151 4.5505
R891 VSS.n34 VSS.t237 4.5505
R892 VSS.n34 VSS.t898 4.5505
R893 VSS.n33 VSS.t849 4.5505
R894 VSS.n33 VSS.t591 4.5505
R895 VSS.n32 VSS.t41 4.5505
R896 VSS.n32 VSS.t207 4.5505
R897 VSS.n31 VSS.t54 4.5505
R898 VSS.n31 VSS.t698 4.5505
R899 VSS.n30 VSS.t713 4.5505
R900 VSS.n30 VSS.t114 4.5505
R901 VSS.n29 VSS.t181 4.5505
R902 VSS.n29 VSS.t785 4.5505
R903 VSS.n28 VSS.t709 4.5505
R904 VSS.n28 VSS.t271 4.5505
R905 VSS.n27 VSS.t761 4.5505
R906 VSS.n27 VSS.t726 4.5505
R907 VSS.n289 VSS.t454 4.5505
R908 VSS.n289 VSS.t411 4.5505
R909 VSS.n288 VSS.t933 4.5505
R910 VSS.n288 VSS.t925 4.5505
R911 VSS.n286 VSS.t310 4.5505
R912 VSS.n286 VSS.t359 4.5505
R913 VSS.n284 VSS.t774 4.5505
R914 VSS.n284 VSS.t703 4.5505
R915 VSS.n283 VSS.t707 4.5505
R916 VSS.n283 VSS.t5 4.5505
R917 VSS.n281 VSS.t755 4.5505
R918 VSS.n281 VSS.t705 4.5505
R919 VSS.n280 VSS.t834 4.5505
R920 VSS.n280 VSS.t845 4.5505
R921 VSS.n279 VSS.t879 4.5505
R922 VSS.n279 VSS.t837 4.5505
R923 VSS.n277 VSS.t217 4.5505
R924 VSS.n277 VSS.t847 4.5505
R925 VSS.n276 VSS.t877 4.5505
R926 VSS.n276 VSS.t941 4.5505
R927 VSS.n275 VSS.t935 4.5505
R928 VSS.n275 VSS.t871 4.5505
R929 VSS.n273 VSS.t225 4.5505
R930 VSS.n273 VSS.t943 4.5505
R931 VSS.n270 VSS.t518 4.5505
R932 VSS.n270 VSS.t464 4.5505
R933 VSS.n269 VSS.t472 4.5505
R934 VSS.n269 VSS.t68 4.5505
R935 VSS.n267 VSS.t443 4.5505
R936 VSS.n267 VSS.t544 4.5505
R937 VSS.n266 VSS.t287 4.5505
R938 VSS.n266 VSS.t332 4.5505
R939 VSS.n265 VSS.t951 4.5505
R940 VSS.n265 VSS.t289 4.5505
R941 VSS.n263 VSS.t601 4.5505
R942 VSS.n263 VSS.t64 4.5505
R943 VSS.n261 VSS.t797 4.5505
R944 VSS.n261 VSS.t35 4.5505
R945 VSS.n260 VSS.t27 4.5505
R946 VSS.n260 VSS.t800 4.5505
R947 VSS.n258 VSS.t250 4.5505
R948 VSS.n258 VSS.t245 4.5505
R949 VSS.n256 VSS.t172 4.5505
R950 VSS.n256 VSS.t668 4.5505
R951 VSS.n255 VSS.t666 4.5505
R952 VSS.n255 VSS.t168 4.5505
R953 VSS.n253 VSS.t526 4.5505
R954 VSS.n253 VSS.t156 4.5505
R955 VSS.n251 VSS.t734 4.5505
R956 VSS.n251 VSS.t387 4.5505
R957 VSS.n250 VSS.t399 4.5505
R958 VSS.n250 VSS.t909 4.5505
R959 VSS.n248 VSS.t751 4.5505
R960 VSS.n248 VSS.t403 4.5505
R961 VSS.n247 VSS.t892 4.5505
R962 VSS.n247 VSS.t814 4.5505
R963 VSS.n246 VSS.t381 4.5505
R964 VSS.n246 VSS.t884 4.5505
R965 VSS.n244 VSS.t306 4.5505
R966 VSS.n244 VSS.t383 4.5505
R967 VSS.n207 VSS.t276 4.5505
R968 VSS.n207 VSS.t787 4.5505
R969 VSS.n208 VSS.t722 4.5505
R970 VSS.n208 VSS.t103 4.5505
R971 VSS.n210 VSS.t177 4.5505
R972 VSS.n210 VSS.t685 4.5505
R973 VSS.n211 VSS.t715 4.5505
R974 VSS.n211 VSS.t209 4.5505
R975 VSS.n212 VSS.t199 4.5505
R976 VSS.n212 VSS.t717 4.5505
R977 VSS.n214 VSS.t279 4.5505
R978 VSS.n214 VSS.t50 4.5505
R979 VSS.n215 VSS.t900 4.5505
R980 VSS.n215 VSS.t235 4.5505
R981 VSS.n216 VSS.t231 4.5505
R982 VSS.n216 VSS.t914 4.5505
R983 VSS.n218 VSS.t448 4.5505
R984 VSS.n218 VSS.t233 4.5505
R985 VSS.n13 VSS.t139 3.6405
R986 VSS.n13 VSS.t141 3.6405
R987 VSS.n12 VSS.t828 3.6405
R988 VSS.n12 VSS.t826 3.6405
R989 VSS.n38 VSS.t338 3.6405
R990 VSS.n38 VSS.t336 3.6405
R991 VSS.n36 VSS.t78 3.6405
R992 VSS.n36 VSS.t80 3.6405
R993 VSS.n26 VSS.t91 3.6405
R994 VSS.n26 VSS.t89 3.6405
R995 VSS.n25 VSS.t779 3.6405
R996 VSS.n25 VSS.t777 3.6405
R997 VSS.n202 VSS.t606 3.6405
R998 VSS.n202 VSS.t604 3.6405
R999 VSS.n203 VSS.t296 3.6405
R1000 VSS.n203 VSS.t301 3.6405
R1001 VSS.n217 VSS.t859 2.2755
R1002 VSS.n217 VSS.t490 2.2755
R1003 VSS.n213 VSS.t374 2.2755
R1004 VSS.n213 VSS.t563 2.2755
R1005 VSS.n209 VSS.t229 2.2755
R1006 VSS.n209 VSS.t580 2.2755
R1007 VSS.n243 VSS.t372 2.2755
R1008 VSS.n243 VSS.t677 2.2755
R1009 VSS.n245 VSS.t76 2.2755
R1010 VSS.n245 VSS.t565 2.2755
R1011 VSS.n249 VSS.t809 2.2755
R1012 VSS.n249 VSS.t484 2.2755
R1013 VSS.n254 VSS.t635 2.2755
R1014 VSS.n254 VSS.t783 2.2755
R1015 VSS.n257 VSS.t227 2.2755
R1016 VSS.n257 VSS.t488 2.2755
R1017 VSS.n259 VSS.t195 2.2755
R1018 VSS.n259 VSS.t570 2.2755
R1019 VSS.n264 VSS.t639 2.2755
R1020 VSS.n264 VSS.t493 2.2755
R1021 VSS.n268 VSS.t753 2.2755
R1022 VSS.n268 VSS.t675 2.2755
R1023 VSS.n271 VSS.t21 2.2755
R1024 VSS.n271 VSS.t486 2.2755
R1025 VSS.n274 VSS.t857 2.2755
R1026 VSS.n274 VSS.t586 2.2755
R1027 VSS.n278 VSS.t46 2.2755
R1028 VSS.n278 VSS.t578 2.2755
R1029 VSS.n282 VSS.t292 2.2755
R1030 VSS.n282 VSS.t482 2.2755
R1031 VSS.n37 VSS.t728 2.2755
R1032 VSS.n37 VSS.t690 2.2755
R1033 VSS.n287 VSS.t203 2.2755
R1034 VSS.n287 VSS.t568 2.2755
R1035 VSS.n380 VSS.n379 1.2545
R1036 VSS.n352 VSS.n351 1.2545
R1037 VSS.n324 VSS.n323 0.9605
R1038 VSS.n387 VSS.n386 0.933604
R1039 VSS.n205 VSS.n204 0.614
R1040 VSS.n194 VSS.n193 0.60275
R1041 VSS.n188 VSS.n187 0.60275
R1042 VSS.n226 VSS.n225 0.5165
R1043 VSS.n234 VSS.n233 0.5165
R1044 VSS.n242 VSS.n241 0.5165
R1045 VSS.n373 VSS.n372 0.5165
R1046 VSS.n365 VSS.n364 0.5165
R1047 VSS.n356 VSS.n355 0.5165
R1048 VSS.n345 VSS.n344 0.5165
R1049 VSS.n336 VSS.n335 0.5165
R1050 VSS.n328 VSS.n327 0.5165
R1051 VSS.n316 VSS.n315 0.5165
R1052 VSS.n308 VSS.n307 0.5165
R1053 VSS.n300 VSS.n299 0.5165
R1054 VSS.n291 VSS.n290 0.5165
R1055 VSS.n388 VSS.n1 0.4895
R1056 VSS.n200 VSS.n182 0.48875
R1057 VSS VSS.n393 0.416
R1058 VSS.n79 VSS.n78 0.39425
R1059 VSS.n145 VSS.n144 0.39275
R1060 VSS.n156 VSS.n155 0.39275
R1061 VSS.n54 VSS.n53 0.39275
R1062 VSS.n68 VSS.n67 0.39275
R1063 VSS.n227 VSS.n226 0.3905
R1064 VSS.n235 VSS.n234 0.3905
R1065 VSS.n372 VSS.n371 0.3905
R1066 VSS.n355 VSS.n354 0.3905
R1067 VSS.n335 VSS.n334 0.3905
R1068 VSS.n327 VSS.n326 0.3905
R1069 VSS.n315 VSS.n314 0.3905
R1070 VSS.n307 VSS.n306 0.3905
R1071 VSS.n101 VSS.n100 0.390252
R1072 VSS.n112 VSS.n111 0.390252
R1073 VSS.n123 VSS.n122 0.389508
R1074 VSS.n168 VSS.n167 0.389
R1075 VSS.n382 VSS.n381 0.3605
R1076 VSS.n354 VSS.n353 0.3605
R1077 VSS.n326 VSS.n325 0.3605
R1078 VSS.n171 VSS.n170 0.3455
R1079 VSS.n179 VSS.n178 0.3455
R1080 VSS.n198 VSS.n197 0.3455
R1081 VSS.n192 VSS.n191 0.3455
R1082 VSS.n186 VSS.n185 0.3455
R1083 VSS.n393 VSS.n392 0.344
R1084 VSS.n127 VSS.n126 0.34325
R1085 VSS.n82 VSS.n81 0.34325
R1086 VSS.n135 VSS.n134 0.3425
R1087 VSS.n44 VSS.n43 0.3425
R1088 VSS.n126 VSS.n125 0.341
R1089 VSS.n81 VSS.n80 0.341
R1090 VSS.n170 VSS.n169 0.341
R1091 VSS.n178 VSS.n177 0.341
R1092 VSS.n199 VSS.n198 0.341
R1093 VSS.n193 VSS.n192 0.341
R1094 VSS.n187 VSS.n186 0.341
R1095 VSS.n72 VSS.n71 0.3335
R1096 VSS.n138 VSS.n137 0.332
R1097 VSS.n149 VSS.n148 0.332
R1098 VSS.n47 VSS.n46 0.332
R1099 VSS.n61 VSS.n60 0.332
R1100 VSS.n94 VSS.n93 0.330004
R1101 VSS.n105 VSS.n104 0.330004
R1102 VSS.n116 VSS.n115 0.32926
R1103 VSS.n161 VSS.n160 0.32825
R1104 VSS.n221 VSS.n220 0.3185
R1105 VSS.n229 VSS.n228 0.3185
R1106 VSS.n237 VSS.n236 0.3185
R1107 VSS.n378 VSS.n377 0.3185
R1108 VSS.n370 VSS.n369 0.3185
R1109 VSS.n361 VSS.n360 0.3185
R1110 VSS.n350 VSS.n349 0.3185
R1111 VSS.n341 VSS.n340 0.3185
R1112 VSS.n333 VSS.n332 0.3185
R1113 VSS.n321 VSS.n320 0.3185
R1114 VSS.n313 VSS.n312 0.3185
R1115 VSS.n305 VSS.n304 0.3185
R1116 VSS.n296 VSS.n295 0.3185
R1117 VSS.n390 VSS.n389 0.314
R1118 VSS.n392 VSS.n391 0.314
R1119 VSS.n43 VSS.n42 0.305
R1120 VSS.n219 VSS.n206 0.2945
R1121 VSS.n383 VSS.n382 0.2945
R1122 VSS.n363 VSS.n362 0.2945
R1123 VSS.n343 VSS.n342 0.2945
R1124 VSS.n323 VSS.n322 0.2945
R1125 VSS.n298 VSS.n297 0.2945
R1126 VSS.n42 VSS.n41 0.2405
R1127 VSS.n225 VSS.n224 0.2405
R1128 VSS.n233 VSS.n232 0.2405
R1129 VSS.n241 VSS.n240 0.2405
R1130 VSS.n381 VSS.n380 0.2405
R1131 VSS.n374 VSS.n373 0.2405
R1132 VSS.n366 VSS.n365 0.2405
R1133 VSS.n357 VSS.n356 0.2405
R1134 VSS.n353 VSS.n352 0.2405
R1135 VSS.n346 VSS.n345 0.2405
R1136 VSS.n337 VSS.n336 0.2405
R1137 VSS.n329 VSS.n328 0.2405
R1138 VSS.n325 VSS.n324 0.2405
R1139 VSS.n317 VSS.n316 0.2405
R1140 VSS.n309 VSS.n308 0.2405
R1141 VSS.n301 VSS.n300 0.2405
R1142 VSS.n292 VSS.n291 0.2405
R1143 VSS.n172 VSS.n171 0.23975
R1144 VSS.n180 VSS.n179 0.23975
R1145 VSS.n197 VSS.n196 0.23975
R1146 VSS.n191 VSS.n190 0.23975
R1147 VSS.n185 VSS.n184 0.23975
R1148 VSS.n133 VSS.n132 0.23225
R1149 VSS.n88 VSS.n87 0.23225
R1150 VSS.n175 VSS.n174 0.23225
R1151 VSS.n90 VSS.n89 0.229622
R1152 VSS.n206 VSS.n205 0.2285
R1153 VSS.n70 VSS.n69 0.224
R1154 VSS.n136 VSS.n135 0.2225
R1155 VSS.n147 VSS.n146 0.2225
R1156 VSS.n45 VSS.n44 0.2225
R1157 VSS.n59 VSS.n58 0.2225
R1158 VSS.n92 VSS.n91 0.221409
R1159 VSS.n103 VSS.n102 0.221409
R1160 VSS.n132 VSS.n131 0.221
R1161 VSS.n87 VSS.n86 0.221
R1162 VSS.n174 VSS.n173 0.221
R1163 VSS.n182 VSS.n181 0.221
R1164 VSS.n195 VSS.n194 0.221
R1165 VSS.n189 VSS.n188 0.221
R1166 VSS.n183 VSS.n1 0.221
R1167 VSS.n114 VSS.n113 0.220665
R1168 VSS.n159 VSS.n158 0.21875
R1169 VSS.n40 VSS.n39 0.2165
R1170 VSS.n129 VSS.n128 0.21425
R1171 VSS.n84 VSS.n83 0.21425
R1172 VSS.n146 VSS.n145 0.2105
R1173 VSS.n177 VSS.n176 0.2105
R1174 VSS.n80 VSS.n79 0.20975
R1175 VSS.n69 VSS.n68 0.209
R1176 VSS.n113 VSS.n112 0.208764
R1177 VSS.n102 VSS.n101 0.208021
R1178 VSS.n74 VSS.n73 0.2045
R1179 VSS.n169 VSS.n168 0.204185
R1180 VSS.n140 VSS.n139 0.203
R1181 VSS.n151 VSS.n150 0.203
R1182 VSS.n49 VSS.n48 0.203
R1183 VSS.n63 VSS.n62 0.203
R1184 VSS.n389 VSS.n388 0.20225
R1185 VSS.n96 VSS.n95 0.20207
R1186 VSS.n107 VSS.n106 0.20207
R1187 VSS.n118 VSS.n117 0.201326
R1188 VSS.n163 VSS.n162 0.19925
R1189 VSS.n176 VSS.n175 0.167
R1190 VSS.n222 VSS.n221 0.1325
R1191 VSS.n230 VSS.n229 0.1325
R1192 VSS.n238 VSS.n237 0.1325
R1193 VSS.n377 VSS.n376 0.1325
R1194 VSS.n369 VSS.n368 0.1325
R1195 VSS.n360 VSS.n359 0.1325
R1196 VSS.n349 VSS.n348 0.1325
R1197 VSS.n340 VSS.n339 0.1325
R1198 VSS.n332 VSS.n331 0.1325
R1199 VSS.n320 VSS.n319 0.1325
R1200 VSS.n312 VSS.n311 0.1325
R1201 VSS.n304 VSS.n303 0.1325
R1202 VSS.n295 VSS.n294 0.1325
R1203 VSS.n167 VSS.n166 0.128
R1204 VSS.n144 VSS.n143 0.12425
R1205 VSS.n155 VSS.n154 0.12425
R1206 VSS.n53 VSS.n52 0.12425
R1207 VSS.n67 VSS.n66 0.12425
R1208 VSS.n122 VSS.n121 0.123227
R1209 VSS.n160 VSS.n159 0.12275
R1210 VSS.n78 VSS.n77 0.12275
R1211 VSS.n100 VSS.n99 0.122483
R1212 VSS.n111 VSS.n110 0.122483
R1213 VSS.n137 VSS.n136 0.119
R1214 VSS.n148 VSS.n147 0.119
R1215 VSS.n46 VSS.n45 0.119
R1216 VSS.n60 VSS.n59 0.119
R1217 VSS.n115 VSS.n114 0.118021
R1218 VSS.n158 VSS.n157 0.1175
R1219 VSS.n71 VSS.n70 0.1175
R1220 VSS.n93 VSS.n92 0.117277
R1221 VSS.n104 VSS.n103 0.117277
R1222 VSS.n200 VSS.n199 0.1145
R1223 VSS.n58 VSS.n57 0.11375
R1224 VSS.n125 VSS.n124 0.112634
R1225 VSS.n91 VSS.n90 0.111326
R1226 VSS.n223 VSS.n222 0.1085
R1227 VSS.n224 VSS.n223 0.1085
R1228 VSS.n231 VSS.n230 0.1085
R1229 VSS.n232 VSS.n231 0.1085
R1230 VSS.n239 VSS.n238 0.1085
R1231 VSS.n240 VSS.n239 0.1085
R1232 VSS.n376 VSS.n375 0.1085
R1233 VSS.n375 VSS.n374 0.1085
R1234 VSS.n368 VSS.n367 0.1085
R1235 VSS.n367 VSS.n366 0.1085
R1236 VSS.n359 VSS.n358 0.1085
R1237 VSS.n358 VSS.n357 0.1085
R1238 VSS.n348 VSS.n347 0.1085
R1239 VSS.n347 VSS.n346 0.1085
R1240 VSS.n339 VSS.n338 0.1085
R1241 VSS.n338 VSS.n337 0.1085
R1242 VSS.n331 VSS.n330 0.1085
R1243 VSS.n330 VSS.n329 0.1085
R1244 VSS.n319 VSS.n318 0.1085
R1245 VSS.n318 VSS.n317 0.1085
R1246 VSS.n311 VSS.n310 0.1085
R1247 VSS.n310 VSS.n309 0.1085
R1248 VSS.n303 VSS.n302 0.1085
R1249 VSS.n302 VSS.n301 0.1085
R1250 VSS.n294 VSS.n293 0.1085
R1251 VSS.n293 VSS.n292 0.1085
R1252 VSS.n131 VSS.n130 0.107
R1253 VSS.n142 VSS.n141 0.107
R1254 VSS.n153 VSS.n152 0.107
R1255 VSS.n165 VSS.n164 0.107
R1256 VSS.n51 VSS.n50 0.107
R1257 VSS.n65 VSS.n64 0.107
R1258 VSS.n76 VSS.n75 0.107
R1259 VSS.n86 VSS.n85 0.107
R1260 VSS.n173 VSS.n172 0.107
R1261 VSS.n181 VSS.n180 0.107
R1262 VSS.n196 VSS.n195 0.107
R1263 VSS.n190 VSS.n189 0.107
R1264 VSS.n184 VSS.n183 0.107
R1265 VSS.n98 VSS.n97 0.10612
R1266 VSS.n109 VSS.n108 0.10612
R1267 VSS.n120 VSS.n119 0.10612
R1268 VSS.n391 VSS.n390 0.101
R1269 VSS.n77 VSS.n76 0.09875
R1270 VSS.n143 VSS.n142 0.09725
R1271 VSS.n154 VSS.n153 0.09725
R1272 VSS.n157 VSS.n156 0.09725
R1273 VSS.n52 VSS.n51 0.09725
R1274 VSS.n57 VSS.n54 0.09725
R1275 VSS.n66 VSS.n65 0.09725
R1276 VSS.n99 VSS.n98 0.0971942
R1277 VSS.n110 VSS.n109 0.0971942
R1278 VSS.n383 VSS.n242 0.0965
R1279 VSS.n364 VSS.n363 0.0965
R1280 VSS.n344 VSS.n343 0.0965
R1281 VSS.n299 VSS.n298 0.0965
R1282 VSS.n121 VSS.n120 0.0964504
R1283 VSS.n124 VSS.n123 0.0964504
R1284 VSS.n166 VSS.n165 0.0935
R1285 VSS.n41 VSS.n40 0.0695
R1286 VSS.n290 VSS 0.0455
R1287 VSS.n220 VSS.n219 0.0425
R1288 VSS.n228 VSS.n227 0.0425
R1289 VSS.n236 VSS.n235 0.0425
R1290 VSS.n379 VSS.n378 0.0425
R1291 VSS.n371 VSS.n370 0.0425
R1292 VSS.n362 VSS.n361 0.0425
R1293 VSS.n351 VSS.n350 0.0425
R1294 VSS.n342 VSS.n341 0.0425
R1295 VSS.n334 VSS.n333 0.0425
R1296 VSS.n322 VSS.n321 0.0425
R1297 VSS.n314 VSS.n313 0.0425
R1298 VSS.n306 VSS.n305 0.0425
R1299 VSS.n297 VSS.n296 0.0425
R1300 VSS.n164 VSS.n163 0.041
R1301 VSS.n141 VSS.n140 0.03725
R1302 VSS.n152 VSS.n151 0.03725
R1303 VSS.n50 VSS.n49 0.03725
R1304 VSS.n64 VSS.n63 0.03725
R1305 VSS.n119 VSS.n118 0.0369463
R1306 VSS.n97 VSS.n96 0.0362025
R1307 VSS.n108 VSS.n107 0.0362025
R1308 VSS.n75 VSS.n74 0.03575
R1309 VSS.n134 VSS.n133 0.02975
R1310 VSS.n89 VSS.n88 0.02975
R1311 VSS.n130 VSS.n129 0.026
R1312 VSS.n85 VSS.n84 0.026
R1313 VSS.n162 VSS.n161 0.01775
R1314 VSS.n139 VSS.n138 0.014
R1315 VSS.n150 VSS.n149 0.014
R1316 VSS.n48 VSS.n47 0.014
R1317 VSS.n62 VSS.n61 0.014
R1318 VSS.n117 VSS.n116 0.0138884
R1319 VSS.n95 VSS.n94 0.0131446
R1320 VSS.n106 VSS.n105 0.0131446
R1321 VSS.n73 VSS.n72 0.0125
R1322 VSS.n128 VSS.n127 0.00275
R1323 VSS.n83 VSS.n82 0.00275
R1324 a_72671_16853.n1 a_72671_16853.t8 71.6245
R1325 a_72671_16853.n2 a_72671_16853.t14 71.6245
R1326 a_72671_16853.n8 a_72671_16853.t4 63.412
R1327 a_72671_16853.n6 a_72671_16853.t16 63.412
R1328 a_72671_16853.n4 a_72671_16853.t9 63.412
R1329 a_72671_16853.n10 a_72671_16853.t15 36.3352
R1330 a_72671_16853.n12 a_72671_16853.t10 35.4953
R1331 a_72671_16853.n3 a_72671_16853.n2 28.7519
R1332 a_72671_16853.n10 a_72671_16853.t6 28.0755
R1333 a_72671_16853.n8 a_72671_16853.t12 27.8969
R1334 a_72671_16853.n6 a_72671_16853.t7 27.8969
R1335 a_72671_16853.n4 a_72671_16853.t17 27.8969
R1336 a_72671_16853.n11 a_72671_16853.n10 23.9543
R1337 a_72671_16853.n9 a_72671_16853.n8 20.3454
R1338 a_72671_16853.n7 a_72671_16853.n6 20.3454
R1339 a_72671_16853.n5 a_72671_16853.n4 20.3454
R1340 a_72671_16853.n3 a_72671_16853.n1 17.8201
R1341 a_72671_16853.n12 a_72671_16853.t11 15.9418
R1342 a_72671_16853.n1 a_72671_16853.t5 15.1219
R1343 a_72671_16853.n2 a_72671_16853.t13 14.9916
R1344 a_72671_16853.n13 a_72671_16853.n11 10.4759
R1345 a_72671_16853.n13 a_72671_16853.n12 8.0005
R1346 a_72671_16853.n14 a_72671_16853.n0 6.98137
R1347 a_72671_16853.n7 a_72671_16853.n5 3.97336
R1348 a_72671_16853.n9 a_72671_16853.n7 3.97336
R1349 a_72671_16853.n5 a_72671_16853.n3 3.56514
R1350 a_72671_16853.n0 a_72671_16853.t2 3.3605
R1351 a_72671_16853.n0 a_72671_16853.t1 3.3605
R1352 a_72671_16853.n15 a_72671_16853.n14 3.3518
R1353 a_72671_16853.n15 a_72671_16853.t3 1.86717
R1354 a_72671_16853.t0 a_72671_16853.n15 1.86717
R1355 a_72671_16853.n14 a_72671_16853.n13 1.26183
R1356 a_72671_16853.n11 a_72671_16853.n9 0.73175
R1357 A2.n3 A2.t8 130.792
R1358 A2.t1 A2.n4 109.704
R1359 A2.n0 A2.t3 95.0309
R1360 A2.n4 A2.n3 79.4894
R1361 A2.n2 A2.n1 59.8455
R1362 A2.t8 A2.t10 55.2719
R1363 A2.t2 A2.t7 55.2719
R1364 A2.t0 A2.t4 55.2719
R1365 A2.n1 A2.t11 39.8898
R1366 A2.n1 A2.n0 35.1927
R1367 A2.n5 A2.t1 30.3125
R1368 A2.n0 A2.t5 30.2434
R1369 A2.n2 A2.t9 24.5669
R1370 A2.n3 A2.t2 23.7255
R1371 A2.n4 A2.t0 23.7255
R1372 A2.n5 A2.t6 20.1446
R1373 A2.n6 A2.n2 18.669
R1374 A2.n6 A2.n5 12.5069
R1375 A2 A2.n6 1.86157
R1376 VDD.t539 VDD.t221 1192.54
R1377 VDD.t308 VDD.t767 1192.54
R1378 VDD.n39 VDD.t469 1070.67
R1379 VDD.t469 VDD.t468 975.265
R1380 VDD.n39 VDD.t232 935.52
R1381 VDD.t220 VDD.t798 818.021
R1382 VDD.t468 VDD.t797 810.955
R1383 VDD.n32 VDD.t40 798.508
R1384 VDD.n15 VDD.t307 726.104
R1385 VDD.n31 VDD.t557 525.317
R1386 VDD.n15 VDD.t360 522.937
R1387 VDD.n17 VDD.t536 518.75
R1388 VDD.n22 VDD.t189 517.673
R1389 VDD.t210 VDD.t684 451.099
R1390 VDD.t46 VDD.t671 451.099
R1391 VDD.t570 VDD.t326 450.649
R1392 VDD.t42 VDD.t535 450.101
R1393 VDD.t334 VDD.t685 449.651
R1394 VDD.t779 VDD.t318 449.305
R1395 VDD.t523 VDD.t760 449.255
R1396 VDD.t24 VDD.t606 449.255
R1397 VDD.t804 VDD.t428 449.255
R1398 VDD.t682 VDD.t366 449.255
R1399 VDD.t8 VDD.t749 449.255
R1400 VDD.t236 VDD.t618 449.255
R1401 VDD.t202 VDD.t179 449.255
R1402 VDD.t92 VDD.t462 449.255
R1403 VDD.t165 VDD.t675 449.255
R1404 VDD.t700 VDD.t110 449.255
R1405 VDD.t175 VDD.t439 449.255
R1406 VDD.t531 VDD.t518 449.255
R1407 VDD.t252 VDD.t736 449.255
R1408 VDD.t633 VDD.t227 449.255
R1409 VDD.t452 VDD.t305 449.255
R1410 VDD.t572 VDD.t387 449.255
R1411 VDD.t574 VDD.t515 449.103
R1412 VDD.t190 VDD.t272 447.762
R1413 VDD.t153 VDD.t223 447.762
R1414 VDD.t663 VDD.t424 447.762
R1415 VDD.t44 VDD.t244 447.762
R1416 VDD.t694 VDD.t732 447.762
R1417 VDD.t350 VDD.t637 447.762
R1418 VDD.t564 VDD.t248 447.762
R1419 VDD.t104 VDD.t133 447.762
R1420 VDD.t16 VDD.t545 447.762
R1421 VDD.t793 VDD.t775 447.762
R1422 VDD.t394 VDD.t533 447.762
R1423 VDD.t454 VDD.t383 447.762
R1424 VDD.t293 VDD.t785 447.762
R1425 VDD.t716 VDD.t117 447.762
R1426 VDD.t596 VDD.t106 447.762
R1427 VDD.t356 VDD.t274 447.762
R1428 VDD.t40 VDD.t252 444.776
R1429 VDD.t221 VDD.t633 444.776
R1430 VDD.t767 VDD.t452 444.776
R1431 VDD.t232 VDD.t572 444.776
R1432 VDD.t456 VDD.t319 441.353
R1433 VDD.t155 VDD.t225 438.807
R1434 VDD.t34 VDD.t4 438.807
R1435 VDD.t558 VDD.t773 438.807
R1436 VDD.t712 VDD.n32 394.031
R1437 VDD.t708 VDD.t800 365.615
R1438 VDD.t50 VDD.t594 363.142
R1439 VDD.t246 VDD.t171 363.142
R1440 VDD.t702 VDD.t108 363.142
R1441 VDD.t270 VDD.t127 362.99
R1442 VDD.t141 VDD.t364 362.649
R1443 VDD.t623 VDD.t463 362.649
R1444 VDD.t724 VDD.t741 362.536
R1445 VDD.t354 VDD.t752 362.495
R1446 VDD.t78 VDD.t584 362.495
R1447 VDD.t504 VDD.t80 362.154
R1448 VDD.t216 VDD.t516 358.548
R1449 VDD.t320 VDD.t198 349.897
R1450 VDD.t74 VDD.t531 332.613
R1451 VDD.t429 VDD.t804 330.539
R1452 VDD.t527 VDD.t92 330.045
R1453 VDD.t2 VDD.t8 329.815
R1454 VDD.t125 VDD.t236 329.815
R1455 VDD.t442 VDD.t523 329.55
R1456 VDD.t287 VDD.t24 329.55
R1457 VDD.t260 VDD.t165 329.55
R1458 VDD.t52 VDD.t700 329.55
R1459 VDD.t102 VDD.n23 292.416
R1460 VDD.t797 VDD.t220 282.685
R1461 VDD.t420 VDD.n27 263.474
R1462 VDD.t123 VDD.t682 256.841
R1463 VDD.t180 VDD.t202 255.019
R1464 VDD.t0 VDD.t175 249.891
R1465 VDD.t272 VDD.t320 238.806
R1466 VDD.t760 VDD.t190 238.806
R1467 VDD.t223 VDD.t50 238.806
R1468 VDD.t606 VDD.t153 238.806
R1469 VDD.t424 VDD.t504 238.806
R1470 VDD.t428 VDD.t663 238.806
R1471 VDD.t244 VDD.t141 238.806
R1472 VDD.t366 VDD.t44 238.806
R1473 VDD.t732 VDD.t354 238.806
R1474 VDD.t749 VDD.t694 238.806
R1475 VDD.t637 VDD.t78 238.806
R1476 VDD.t618 VDD.t350 238.806
R1477 VDD.t248 VDD.t270 238.806
R1478 VDD.t179 VDD.t564 238.806
R1479 VDD.t133 VDD.t623 238.806
R1480 VDD.t462 VDD.t104 238.806
R1481 VDD.t545 VDD.t246 238.806
R1482 VDD.t675 VDD.t16 238.806
R1483 VDD.t775 VDD.t702 238.806
R1484 VDD.t110 VDD.t793 238.806
R1485 VDD.t533 VDD.t708 238.806
R1486 VDD.t439 VDD.t394 238.806
R1487 VDD.t383 VDD.t216 238.806
R1488 VDD.t518 VDD.t454 238.806
R1489 VDD.t785 VDD.t724 238.806
R1490 VDD.t736 VDD.t293 238.806
R1491 VDD.t117 VDD.t155 238.806
R1492 VDD.t227 VDD.t716 238.806
R1493 VDD.t106 VDD.t34 238.806
R1494 VDD.t305 VDD.t596 238.806
R1495 VDD.t274 VDD.t558 238.806
R1496 VDD.t387 VDD.t356 238.806
R1497 VDD.t161 VDD.n16 226.548
R1498 VDD.t688 VDD.n18 225.325
R1499 VDD.n16 VDD.t514 224.552
R1500 VDD.n18 VDD.t447 224.327
R1501 VDD.n38 VDD.t266 220.184
R1502 VDD.n37 VDD.t375 220.184
R1503 VDD.n36 VDD.t60 220.184
R1504 VDD.t672 VDD.t548 211.358
R1505 VDD.t535 VDD.t448 206.7
R1506 VDD.t326 VDD.t188 204.945
R1507 VDD.t514 VDD.t446 203.594
R1508 VDD.t515 VDD.t451 203.594
R1509 VDD.t671 VDD.t467 203.594
R1510 VDD.t685 VDD.t373 203.391
R1511 VDD.n27 VDD.t672 192.615
R1512 VDD.n31 VDD.t0 189.874
R1513 VDD.n22 VDD.t180 189.19
R1514 VDD.n17 VDD.t123 187.5
R1515 VDD.t225 VDD.n36 177.613
R1516 VDD.t4 VDD.n37 177.613
R1517 VDD.t773 VDD.n38 177.613
R1518 VDD.t198 VDD.n15 165.138
R1519 VDD.t131 VDD.t374 162.675
R1520 VDD.n23 VDD.t327 157.685
R1521 VDD.t381 VDD.t276 155.071
R1522 VDD.t276 VDD.t74 150.1
R1523 VDD.t547 VDD.t306 147.06
R1524 VDD.t312 VDD.t547 147.06
R1525 VDD.t582 VDD.t312 147.06
R1526 VDD.t307 VDD.t582 147.06
R1527 VDD.t448 VDD.t429 144.712
R1528 VDD.t374 VDD.t527 143.714
R1529 VDD.t373 VDD.t2 143.57
R1530 VDD.t188 VDD.t125 143.57
R1531 VDD.t446 VDD.t442 142.715
R1532 VDD.t451 VDD.t287 142.715
R1533 VDD.t467 VDD.t260 142.715
R1534 VDD.t548 VDD.t52 142.715
R1535 VDD.t6 VDD.t456 112.326
R1536 VDD.t26 VDD.t574 106.787
R1537 VDD.t458 VDD.t42 105.788
R1538 VDD.t519 VDD.t102 105.788
R1539 VDD.t422 VDD.t688 105.683
R1540 VDD.t30 VDD.t334 105.683
R1541 VDD.t319 VDD.n31 105.368
R1542 VDD.t789 VDD.t161 104.79
R1543 VDD.t268 VDD.t210 104.79
R1544 VDD.t367 VDD.t46 104.79
R1545 VDD.t72 VDD.t570 104.686
R1546 VDD.t621 VDD.t779 104.374
R1547 VDD.t139 VDD.t420 99.8009
R1548 VDD.t327 VDD.n22 98.8029
R1549 VDD.n36 VDD.t712 61.1945
R1550 VDD.n37 VDD.t539 61.1945
R1551 VDD.n38 VDD.t308 61.1945
R1552 VDD.t800 VDD.t139 59.8807
R1553 VDD.t242 VDD.n17 58.824
R1554 VDD.t594 VDD.t789 54.8907
R1555 VDD.t171 VDD.t268 54.8907
R1556 VDD.t108 VDD.t367 54.8907
R1557 VDD.t127 VDD.t72 54.836
R1558 VDD.t741 VDD.t621 54.6725
R1559 VDD.t364 VDD.t458 53.8927
R1560 VDD.t463 VDD.t519 53.8927
R1561 VDD.t752 VDD.t422 53.839
R1562 VDD.t584 VDD.t30 53.839
R1563 VDD.t80 VDD.t26 52.8947
R1564 VDD.t318 VDD.t381 47.7142
R1565 VDD.t516 VDD.t6 46.7202
R1566 VDD.t684 VDD.t131 40.9187
R1567 VDD.t447 VDD.t242 40.8779
R1568 VDD.n85 VDD.n27 12.76
R1569 VDD.n16 VDD.n11 12.76
R1570 VDD.n130 VDD.n18 12.7593
R1571 VDD.n108 VDD.n23 12.7593
R1572 VDD.n62 VDD.n32 12.757
R1573 VDD.n40 VDD.n39 12.757
R1574 VDD.n40 VDD.t799 9.63897
R1575 VDD.n35 VDD.t559 8.99356
R1576 VDD.n34 VDD.t35 8.99356
R1577 VDD.n33 VDD.t156 8.99356
R1578 VDD.n29 VDD.t217 8.99356
R1579 VDD.n30 VDD.t725 8.99356
R1580 VDD.n24 VDD.t624 8.99356
R1581 VDD.n25 VDD.t247 8.99356
R1582 VDD.n26 VDD.t703 8.99356
R1583 VDD.n28 VDD.t709 8.99356
R1584 VDD.n19 VDD.t355 8.99356
R1585 VDD.n20 VDD.t79 8.99356
R1586 VDD.n21 VDD.t271 8.99356
R1587 VDD.n0 VDD.t321 8.99356
R1588 VDD.n12 VDD.t51 8.99356
R1589 VDD.n13 VDD.t505 8.99356
R1590 VDD.n14 VDD.t142 8.99356
R1591 VDD.n44 VDD.t275 8.03137
R1592 VDD.n51 VDD.t107 8.03137
R1593 VDD.n58 VDD.t118 8.03137
R1594 VDD.n74 VDD.t384 8.03137
R1595 VDD.n66 VDD.t786 8.03137
R1596 VDD.n104 VDD.t134 8.03137
R1597 VDD.n96 VDD.t546 8.03137
R1598 VDD.n89 VDD.t776 8.03137
R1599 VDD.n81 VDD.t534 8.03137
R1600 VDD.n126 VDD.t733 8.03137
R1601 VDD.n119 VDD.t638 8.03137
R1602 VDD.n112 VDD.t249 8.03137
R1603 VDD.n7 VDD.t273 8.03137
R1604 VDD.n149 VDD.t224 8.03137
R1605 VDD.n142 VDD.t425 8.03137
R1606 VDD.n135 VDD.t245 8.03137
R1607 VDD.n47 VDD.t309 7.98276
R1608 VDD.n54 VDD.t540 7.98276
R1609 VDD.n61 VDD.t713 7.98276
R1610 VDD.n77 VDD.t457 7.98276
R1611 VDD.n69 VDD.t780 7.98276
R1612 VDD.n107 VDD.t103 7.98276
R1613 VDD.n99 VDD.t211 7.98276
R1614 VDD.n92 VDD.t47 7.98276
R1615 VDD.n84 VDD.t421 7.98276
R1616 VDD.n129 VDD.t689 7.98276
R1617 VDD.n122 VDD.t335 7.98276
R1618 VDD.n115 VDD.t571 7.98276
R1619 VDD.n4 VDD.t199 7.98276
R1620 VDD.n152 VDD.t162 7.98276
R1621 VDD.n145 VDD.t575 7.98276
R1622 VDD.n138 VDD.t43 7.98276
R1623 VDD.n42 VDD.t573 7.89431
R1624 VDD.n49 VDD.t453 7.89431
R1625 VDD.n56 VDD.t634 7.89431
R1626 VDD.n72 VDD.t532 7.89431
R1627 VDD.n64 VDD.t253 7.89431
R1628 VDD.n102 VDD.t93 7.89431
R1629 VDD.n94 VDD.t166 7.89431
R1630 VDD.n87 VDD.t701 7.89431
R1631 VDD.n79 VDD.t176 7.89431
R1632 VDD.n124 VDD.t9 7.89431
R1633 VDD.n117 VDD.t237 7.89431
R1634 VDD.n110 VDD.t203 7.89431
R1635 VDD.n9 VDD.t524 7.89431
R1636 VDD.n147 VDD.t25 7.89431
R1637 VDD.n140 VDD.t805 7.89431
R1638 VDD.n133 VDD.t683 7.89431
R1639 VDD.n70 VDD.t382 7.88966
R1640 VDD.n100 VDD.t132 7.88966
R1641 VDD.n131 VDD.t243 7.88966
R1642 VDD.n41 VDD.t233 7.88811
R1643 VDD.n48 VDD.t768 7.88811
R1644 VDD.n55 VDD.t222 7.88811
R1645 VDD.n63 VDD.t41 7.88811
R1646 VDD.n71 VDD.t75 7.88811
R1647 VDD.n101 VDD.t528 7.88811
R1648 VDD.n93 VDD.t261 7.88811
R1649 VDD.n86 VDD.t53 7.88811
R1650 VDD.n78 VDD.t1 7.88811
R1651 VDD.n123 VDD.t3 7.88811
R1652 VDD.n116 VDD.t126 7.88811
R1653 VDD.n109 VDD.t181 7.88811
R1654 VDD.n10 VDD.t443 7.88811
R1655 VDD.n146 VDD.t288 7.88811
R1656 VDD.n139 VDD.t430 7.88811
R1657 VDD.n132 VDD.t124 7.88811
R1658 VDD.n46 VDD.t267 7.8848
R1659 VDD.n53 VDD.t376 7.8848
R1660 VDD.n60 VDD.t61 7.8848
R1661 VDD.n68 VDD.t622 7.8848
R1662 VDD.n76 VDD.t7 7.8848
R1663 VDD.n83 VDD.t140 7.8848
R1664 VDD.n91 VDD.t368 7.8848
R1665 VDD.n98 VDD.t269 7.8848
R1666 VDD.n106 VDD.t520 7.8848
R1667 VDD.n114 VDD.t73 7.8848
R1668 VDD.n121 VDD.t31 7.8848
R1669 VDD.n128 VDD.t423 7.8848
R1670 VDD.n137 VDD.t459 7.8848
R1671 VDD.n144 VDD.t27 7.8848
R1672 VDD.n151 VDD.t790 7.8848
R1673 VDD.n5 VDD.t361 7.8848
R1674 VDD.n43 VDD.t357 6.72042
R1675 VDD.n50 VDD.t597 6.72042
R1676 VDD.n57 VDD.t717 6.72042
R1677 VDD.n73 VDD.t455 6.72042
R1678 VDD.n65 VDD.t294 6.72042
R1679 VDD.n103 VDD.t105 6.72042
R1680 VDD.n95 VDD.t17 6.72042
R1681 VDD.n88 VDD.t794 6.72042
R1682 VDD.n80 VDD.t395 6.72042
R1683 VDD.n125 VDD.t695 6.72042
R1684 VDD.n118 VDD.t351 6.72042
R1685 VDD.n111 VDD.t565 6.72042
R1686 VDD.n8 VDD.t191 6.72042
R1687 VDD.n148 VDD.t154 6.72042
R1688 VDD.n141 VDD.t664 6.72042
R1689 VDD.n134 VDD.t45 6.72042
R1690 VDD.n45 VDD.n35 5.45498
R1691 VDD.n52 VDD.n34 5.45498
R1692 VDD.n59 VDD.n33 5.45498
R1693 VDD.n75 VDD.n29 5.45498
R1694 VDD.n67 VDD.n30 5.45498
R1695 VDD.n105 VDD.n24 5.45498
R1696 VDD.n97 VDD.n25 5.45498
R1697 VDD.n90 VDD.n26 5.45498
R1698 VDD.n82 VDD.n28 5.45498
R1699 VDD.n127 VDD.n19 5.45498
R1700 VDD.n120 VDD.n20 5.45498
R1701 VDD.n113 VDD.n21 5.45498
R1702 VDD.n6 VDD.n0 5.45498
R1703 VDD.n150 VDD.n12 5.45498
R1704 VDD.n143 VDD.n13 5.45498
R1705 VDD.n136 VDD.n14 5.45498
R1706 VDD.n3 VDD.n1 2.99767
R1707 VDD.n3 VDD.n2 2.84898
R1708 VDD.n35 VDD.t774 2.57689
R1709 VDD.n34 VDD.t5 2.57689
R1710 VDD.n33 VDD.t226 2.57689
R1711 VDD.n29 VDD.t517 2.57689
R1712 VDD.n30 VDD.t742 2.57689
R1713 VDD.n24 VDD.t464 2.57689
R1714 VDD.n25 VDD.t172 2.57689
R1715 VDD.n26 VDD.t109 2.57689
R1716 VDD.n28 VDD.t801 2.57689
R1717 VDD.n19 VDD.t753 2.57689
R1718 VDD.n20 VDD.t585 2.57689
R1719 VDD.n21 VDD.t128 2.57689
R1720 VDD.n0 VDD.t761 2.57689
R1721 VDD.n12 VDD.t595 2.57689
R1722 VDD.n13 VDD.t81 2.57689
R1723 VDD.n14 VDD.t365 2.57689
R1724 VDD.n2 VDD.t313 1.26439
R1725 VDD.n2 VDD.t762 1.26439
R1726 VDD.n1 VDD.t617 1.26439
R1727 VDD.n1 VDD.t583 1.26439
R1728 VDD.n4 VDD.n3 0.887
R1729 VDD.n139 VDD.n138 0.59975
R1730 VDD.n93 VDD.n92 0.599
R1731 VDD.n146 VDD.n145 0.5975
R1732 VDD.n48 VDD.n47 0.595323
R1733 VDD.n55 VDD.n54 0.595323
R1734 VDD.n116 VDD.n115 0.594798
R1735 VDD.n123 VDD.n122 0.594054
R1736 VDD.n78 VDD.n77 0.585573
R1737 VDD.n11 VDD.n10 0.48875
R1738 VDD.n86 VDD.n85 0.46475
R1739 VDD.n63 VDD.n62 0.461
R1740 VDD.n109 VDD.n108 0.43488
R1741 VDD.n100 VDD.n99 0.3695
R1742 VDD.n70 VDD.n69 0.362677
R1743 VDD.n41 VDD 0.35825
R1744 VDD.n103 VDD.n102 0.344
R1745 VDD.n95 VDD.n94 0.344
R1746 VDD.n88 VDD.n87 0.344
R1747 VDD.n80 VDD.n79 0.344
R1748 VDD.n9 VDD.n8 0.344
R1749 VDD.n148 VDD.n147 0.344
R1750 VDD.n141 VDD.n140 0.344
R1751 VDD.n134 VDD.n133 0.344
R1752 VDD.n125 VDD.n124 0.341161
R1753 VDD.n118 VDD.n117 0.341161
R1754 VDD.n111 VDD.n110 0.341161
R1755 VDD.n105 VDD.n104 0.34025
R1756 VDD.n97 VDD.n96 0.34025
R1757 VDD.n90 VDD.n89 0.34025
R1758 VDD.n82 VDD.n81 0.34025
R1759 VDD.n7 VDD.n6 0.34025
R1760 VDD.n150 VDD.n149 0.34025
R1761 VDD.n143 VDD.n142 0.34025
R1762 VDD.n136 VDD.n135 0.34025
R1763 VDD.n127 VDD.n126 0.337442
R1764 VDD.n120 VDD.n119 0.337442
R1765 VDD.n113 VDD.n112 0.337442
R1766 VDD.n43 VDD.n42 0.332919
R1767 VDD.n50 VDD.n49 0.332919
R1768 VDD.n57 VDD.n56 0.332919
R1769 VDD.n73 VDD.n72 0.332919
R1770 VDD.n65 VDD.n64 0.332919
R1771 VDD.n45 VDD.n44 0.32929
R1772 VDD.n52 VDD.n51 0.32929
R1773 VDD.n59 VDD.n58 0.32929
R1774 VDD.n75 VDD.n74 0.32929
R1775 VDD.n67 VDD.n66 0.32929
R1776 VDD.n131 VDD.n130 0.258878
R1777 VDD.n101 VDD.n100 0.23075
R1778 VDD.n132 VDD.n131 0.23075
R1779 VDD.n102 VDD.n101 0.227
R1780 VDD.n94 VDD.n93 0.227
R1781 VDD.n87 VDD.n86 0.227
R1782 VDD.n79 VDD.n78 0.227
R1783 VDD.n10 VDD.n9 0.227
R1784 VDD.n147 VDD.n146 0.227
R1785 VDD.n140 VDD.n139 0.227
R1786 VDD.n133 VDD.n132 0.227
R1787 VDD.n124 VDD.n123 0.225128
R1788 VDD.n117 VDD.n116 0.225128
R1789 VDD.n110 VDD.n109 0.225128
R1790 VDD.n42 VDD.n41 0.223419
R1791 VDD.n49 VDD.n48 0.223419
R1792 VDD.n56 VDD.n55 0.223419
R1793 VDD.n64 VDD.n63 0.223419
R1794 VDD.n71 VDD.n70 0.223323
R1795 VDD.n72 VDD.n71 0.219694
R1796 VDD.n145 VDD.n144 0.20075
R1797 VDD.n107 VDD.n106 0.2
R1798 VDD.n138 VDD.n137 0.2
R1799 VDD.n99 VDD.n98 0.19925
R1800 VDD.n92 VDD.n91 0.19925
R1801 VDD.n5 VDD.n4 0.19925
R1802 VDD.n152 VDD.n151 0.19925
R1803 VDD.n77 VDD.n76 0.198645
R1804 VDD.n129 VDD.n128 0.198351
R1805 VDD.n122 VDD.n121 0.198351
R1806 VDD.n115 VDD.n114 0.197607
R1807 VDD.n84 VDD.n83 0.1955
R1808 VDD.n47 VDD.n46 0.192839
R1809 VDD.n54 VDD.n53 0.192839
R1810 VDD.n61 VDD.n60 0.192839
R1811 VDD.n69 VDD.n68 0.192839
R1812 VDD.n108 VDD.n107 0.159866
R1813 VDD.n85 VDD.n84 0.1385
R1814 VDD.n62 VDD.n61 0.134823
R1815 VDD VDD.n40 0.128
R1816 VDD.n130 VDD.n129 0.109095
R1817 VDD.n104 VDD.n103 0.10475
R1818 VDD.n96 VDD.n95 0.10475
R1819 VDD.n89 VDD.n88 0.10475
R1820 VDD.n81 VDD.n80 0.10475
R1821 VDD.n8 VDD.n7 0.10475
R1822 VDD.n149 VDD.n148 0.10475
R1823 VDD.n142 VDD.n141 0.10475
R1824 VDD.n135 VDD.n134 0.10475
R1825 VDD.n126 VDD.n125 0.103888
R1826 VDD.n119 VDD.n118 0.103888
R1827 VDD.n112 VDD.n111 0.103888
R1828 VDD.n44 VDD.n43 0.101387
R1829 VDD.n51 VDD.n50 0.101387
R1830 VDD.n58 VDD.n57 0.101387
R1831 VDD.n74 VDD.n73 0.101387
R1832 VDD.n66 VDD.n65 0.101387
R1833 VDD VDD.n152 0.0935
R1834 VDD.n83 VDD.n82 0.047
R1835 VDD.n98 VDD.n97 0.04325
R1836 VDD.n91 VDD.n90 0.04325
R1837 VDD.n6 VDD.n5 0.04325
R1838 VDD.n151 VDD.n150 0.04325
R1839 VDD.n114 VDD.n113 0.0428967
R1840 VDD.n106 VDD.n105 0.0425
R1841 VDD.n137 VDD.n136 0.0425
R1842 VDD.n128 VDD.n127 0.0421529
R1843 VDD.n121 VDD.n120 0.0421529
R1844 VDD.n46 VDD.n45 0.041871
R1845 VDD.n53 VDD.n52 0.041871
R1846 VDD.n60 VDD.n59 0.041871
R1847 VDD.n68 VDD.n67 0.041871
R1848 VDD.n144 VDD.n143 0.04175
R1849 VDD.n76 VDD.n75 0.0360645
R1850 VDD VDD.n11 0.01775
R1851 a_41692_17389.n1 a_41692_17389.t13 32.0712
R1852 a_41692_17389.n15 a_41692_17389.t7 28.0984
R1853 a_41692_17389.n14 a_41692_17389.t14 28.0984
R1854 a_41692_17389.n13 a_41692_17389.t4 28.0984
R1855 a_41692_17389.n12 a_41692_17389.t6 28.0984
R1856 a_41692_17389.n11 a_41692_17389.t10 28.0984
R1857 a_41692_17389.n10 a_41692_17389.t18 28.0984
R1858 a_41692_17389.n9 a_41692_17389.t8 28.0984
R1859 a_41692_17389.n8 a_41692_17389.t17 28.0984
R1860 a_41692_17389.n7 a_41692_17389.t12 28.0984
R1861 a_41692_17389.n6 a_41692_17389.t5 28.0984
R1862 a_41692_17389.n5 a_41692_17389.t16 28.0984
R1863 a_41692_17389.n4 a_41692_17389.t3 28.0984
R1864 a_41692_17389.n3 a_41692_17389.t15 28.0984
R1865 a_41692_17389.n2 a_41692_17389.t9 28.0984
R1866 a_41692_17389.n1 a_41692_17389.t11 28.0984
R1867 a_41692_17389.n16 a_41692_17389.n15 23.2387
R1868 a_41692_17389.t0 a_41692_17389.n16 15.3259
R1869 a_41692_17389.n0 a_41692_17389.t2 8.838
R1870 a_41692_17389.n0 a_41692_17389.t1 8.838
R1871 a_41692_17389.n16 a_41692_17389.n0 7.24679
R1872 a_41692_17389.n2 a_41692_17389.n1 3.97336
R1873 a_41692_17389.n3 a_41692_17389.n2 3.97336
R1874 a_41692_17389.n4 a_41692_17389.n3 3.97336
R1875 a_41692_17389.n5 a_41692_17389.n4 3.97336
R1876 a_41692_17389.n6 a_41692_17389.n5 3.97336
R1877 a_41692_17389.n7 a_41692_17389.n6 3.97336
R1878 a_41692_17389.n8 a_41692_17389.n7 3.97336
R1879 a_41692_17389.n9 a_41692_17389.n8 3.97336
R1880 a_41692_17389.n10 a_41692_17389.n9 3.97336
R1881 a_41692_17389.n11 a_41692_17389.n10 3.97336
R1882 a_41692_17389.n12 a_41692_17389.n11 3.97336
R1883 a_41692_17389.n13 a_41692_17389.n12 3.97336
R1884 a_41692_17389.n14 a_41692_17389.n13 3.97336
R1885 a_41692_17389.n15 a_41692_17389.n14 3.97336
R1886 a_47947_19620.n5 a_47947_19620.n4 144.379
R1887 a_47947_19620.n4 a_47947_19620.t6 114.743
R1888 a_47947_19620.t13 a_47947_19620.n5 96.8993
R1889 a_47947_19620.n2 a_47947_19620.t10 77.6934
R1890 a_47947_19620.n1 a_47947_19620.t15 73.6523
R1891 a_47947_19620.n1 a_47947_19620.t8 56.3148
R1892 a_47947_19620.t6 a_47947_19620.t4 55.2719
R1893 a_47947_19620.t11 a_47947_19620.t7 55.2719
R1894 a_47947_19620.t5 a_47947_19620.t14 55.2719
R1895 a_47947_19620.n2 a_47947_19620.t12 47.5809
R1896 a_47947_19620.n6 a_47947_19620.t9 31.048
R1897 a_47947_19620.n6 a_47947_19620.t13 20.8801
R1898 a_47947_19620.n4 a_47947_19620.t11 19.0326
R1899 a_47947_19620.n5 a_47947_19620.t5 19.0326
R1900 a_47947_19620.n3 a_47947_19620.n2 17.8431
R1901 a_47947_19620.n3 a_47947_19620.n1 17.3514
R1902 a_47947_19620.n7 a_47947_19620.n6 12.5069
R1903 a_47947_19620.n7 a_47947_19620.n3 7.84572
R1904 a_47947_19620.n9 a_47947_19620.n8 6.77428
R1905 a_47947_19620.n8 a_47947_19620.n7 5.45675
R1906 a_47947_19620.n8 a_47947_19620.n0 3.47716
R1907 a_47947_19620.n9 a_47947_19620.t1 2.2755
R1908 a_47947_19620.t0 a_47947_19620.n9 2.2755
R1909 a_47947_19620.n0 a_47947_19620.t3 1.26439
R1910 a_47947_19620.n0 a_47947_19620.t2 1.26439
R1911 A10.n3 A10.t7 130.792
R1912 A10.n7 A10.t19 130.792
R1913 A10.t0 A10.n4 109.704
R1914 A10.t9 A10.n8 109.704
R1915 A10.n1 A10.t15 95.0309
R1916 A10.n0 A10.t2 90.0773
R1917 A10.n4 A10.n3 79.4894
R1918 A10.n8 A10.n7 79.4894
R1919 A10.t7 A10.t18 55.2719
R1920 A10.t16 A10.t5 55.2719
R1921 A10.t1 A10.t12 55.2719
R1922 A10.t19 A10.t4 55.2719
R1923 A10.t6 A10.t11 55.2719
R1924 A10.t13 A10.t17 55.2719
R1925 A10.n0 A10.t3 39.8898
R1926 A10.n5 A10.t0 30.3125
R1927 A10.n9 A10.t9 30.3125
R1928 A10.n1 A10.t10 30.2434
R1929 A10.n3 A10.t16 23.7255
R1930 A10.n4 A10.t1 23.7255
R1931 A10.n7 A10.t6 23.7255
R1932 A10.n8 A10.t13 23.7255
R1933 A10.n2 A10.n0 22.6927
R1934 A10.n5 A10.t8 20.1446
R1935 A10.n9 A10.t14 20.1446
R1936 A10.n6 A10.n5 12.5069
R1937 A10.n10 A10.n9 12.5069
R1938 A10.n2 A10.n1 12.5005
R1939 A10.n6 A10.n2 12.0868
R1940 A10 A10.n10 1.87443
R1941 A10.n10 A10.n6 1.54014
R1942 B4.n1 B4.t0 25.964
R1943 B4.n0 B4.t2 25.2616
R1944 B4.n0 B4.t1 24.4794
R1945 B4.n1 B4.t3 24.3998
R1946 B4.n2 B4.n1 9.39912
R1947 B4.n2 B4.n0 8.0005
R1948 B4 B4.n2 5.16907
R1949 B5.n1 B5.t2 25.964
R1950 B5.n0 B5.t0 25.2616
R1951 B5.n0 B5.t3 24.4794
R1952 B5.n1 B5.t1 24.3998
R1953 B5.n2 B5.n1 9.39912
R1954 B5.n2 B5.n0 8.0005
R1955 B5 B5.n2 5.16907
R1956 A9.n3 A9.t17 130.792
R1957 A9.n7 A9.t12 130.792
R1958 A9.t14 A9.n4 109.704
R1959 A9.t2 A9.n8 109.704
R1960 A9.n1 A9.t3 95.0309
R1961 A9.n0 A9.t6 90.0773
R1962 A9.n4 A9.n3 79.4894
R1963 A9.n8 A9.n7 79.4894
R1964 A9.t17 A9.t10 55.2719
R1965 A9.t15 A9.t4 55.2719
R1966 A9.t13 A9.t19 55.2719
R1967 A9.t12 A9.t16 55.2719
R1968 A9.t5 A9.t11 55.2719
R1969 A9.t0 A9.t8 55.2719
R1970 A9.n0 A9.t7 39.8898
R1971 A9.n5 A9.t14 30.3125
R1972 A9.n9 A9.t2 30.3125
R1973 A9.n1 A9.t18 30.2434
R1974 A9.n3 A9.t15 23.7255
R1975 A9.n4 A9.t13 23.7255
R1976 A9.n7 A9.t5 23.7255
R1977 A9.n8 A9.t0 23.7255
R1978 A9.n2 A9.n0 22.6927
R1979 A9.n5 A9.t1 20.1446
R1980 A9.n9 A9.t9 20.1446
R1981 A9.n6 A9.n5 12.5069
R1982 A9.n10 A9.n9 12.5069
R1983 A9.n2 A9.n1 12.5005
R1984 A9.n6 A9.n2 12.0884
R1985 A9 A9.n10 1.87925
R1986 A9.n10 A9.n6 1.54014
R1987 a_70458_18464.n0 a_70458_18464.t3 89.0244
R1988 a_70458_18464.n0 a_70458_18464.t2 63.6549
R1989 a_70458_18464.n1 a_70458_18464.n0 45.5127
R1990 a_70458_18464.n1 a_70458_18464.t1 11.6374
R1991 a_70458_18464.t0 a_70458_18464.n1 8.42385
R1992 a_64632_14904.n3 a_64632_14904.t5 85.5148
R1993 a_64632_14904.n1 a_64632_14904.t1 53.9588
R1994 a_64632_14904.n0 a_64632_14904.t3 49.438
R1995 a_64632_14904.n0 a_64632_14904.t4 46.6672
R1996 a_64632_14904.n4 a_64632_14904.n3 44.8105
R1997 a_64632_14904.n1 a_64632_14904.t2 42.1463
R1998 a_64632_14904.n3 a_64632_14904.t6 35.3273
R1999 a_64632_14904.t0 a_64632_14904.n4 29.2915
R2000 a_64632_14904.n2 a_64632_14904.n0 12.1623
R2001 a_64632_14904.n2 a_64632_14904.n1 5.72343
R2002 a_64632_14904.n4 a_64632_14904.n2 3.59812
R2003 a_75139_18700.n5 a_75139_18700.n4 144.379
R2004 a_75139_18700.n9 a_75139_18700.n8 144.379
R2005 a_75139_18700.n4 a_75139_18700.t4 114.743
R2006 a_75139_18700.n8 a_75139_18700.t8 114.743
R2007 a_75139_18700.t14 a_75139_18700.n5 96.8993
R2008 a_75139_18700.t19 a_75139_18700.n9 96.8993
R2009 a_75139_18700.n2 a_75139_18700.t17 77.6934
R2010 a_75139_18700.n1 a_75139_18700.t18 73.6523
R2011 a_75139_18700.n1 a_75139_18700.t20 56.3148
R2012 a_75139_18700.t4 a_75139_18700.t12 55.2719
R2013 a_75139_18700.t10 a_75139_18700.t21 55.2719
R2014 a_75139_18700.t22 a_75139_18700.t9 55.2719
R2015 a_75139_18700.t8 a_75139_18700.t5 55.2719
R2016 a_75139_18700.t16 a_75139_18700.t11 55.2719
R2017 a_75139_18700.t7 a_75139_18700.t23 55.2719
R2018 a_75139_18700.n2 a_75139_18700.t13 47.5809
R2019 a_75139_18700.n6 a_75139_18700.t6 31.048
R2020 a_75139_18700.n10 a_75139_18700.t15 31.048
R2021 a_75139_18700.n6 a_75139_18700.t14 20.8801
R2022 a_75139_18700.n10 a_75139_18700.t19 20.8801
R2023 a_75139_18700.n4 a_75139_18700.t10 19.0326
R2024 a_75139_18700.n5 a_75139_18700.t22 19.0326
R2025 a_75139_18700.n8 a_75139_18700.t16 19.0326
R2026 a_75139_18700.n9 a_75139_18700.t7 19.0326
R2027 a_75139_18700.n3 a_75139_18700.n2 17.9031
R2028 a_75139_18700.n3 a_75139_18700.n1 17.2914
R2029 a_75139_18700.n7 a_75139_18700.n6 12.5069
R2030 a_75139_18700.n11 a_75139_18700.n10 12.5069
R2031 a_75139_18700.n13 a_75139_18700.n12 6.77428
R2032 a_75139_18700.n7 a_75139_18700.n3 6.27002
R2033 a_75139_18700.n12 a_75139_18700.n11 5.45675
R2034 a_75139_18700.n12 a_75139_18700.n0 3.47716
R2035 a_75139_18700.n13 a_75139_18700.t1 2.2755
R2036 a_75139_18700.t0 a_75139_18700.n13 2.2755
R2037 a_75139_18700.n11 a_75139_18700.n7 1.54014
R2038 a_75139_18700.n0 a_75139_18700.t3 1.26439
R2039 a_75139_18700.n0 a_75139_18700.t2 1.26439
R2040 B11.n1 B11.t0 25.964
R2041 B11.n0 B11.t2 25.2616
R2042 B11.n0 B11.t1 24.4794
R2043 B11.n1 B11.t3 24.3998
R2044 B11.n2 B11.n1 9.39912
R2045 B11.n2 B11.n0 8.0005
R2046 B11 B11.n2 5.18032
R2047 B12.n1 B12.t2 25.964
R2048 B12.n0 B12.t0 25.2616
R2049 B12.n0 B12.t3 24.4794
R2050 B12.n1 B12.t1 24.3998
R2051 B12.n2 B12.n1 9.39912
R2052 B12.n2 B12.n0 8.0005
R2053 B12 B12.n2 5.1755
R2054 a_77611_18700.n5 a_77611_18700.n4 144.379
R2055 a_77611_18700.n9 a_77611_18700.n8 144.379
R2056 a_77611_18700.n4 a_77611_18700.t11 114.743
R2057 a_77611_18700.n8 a_77611_18700.t17 114.743
R2058 a_77611_18700.t7 a_77611_18700.n5 96.8993
R2059 a_77611_18700.t10 a_77611_18700.n9 96.8993
R2060 a_77611_18700.n2 a_77611_18700.t22 77.6934
R2061 a_77611_18700.n1 a_77611_18700.t5 73.6523
R2062 a_77611_18700.n1 a_77611_18700.t6 56.3148
R2063 a_77611_18700.t11 a_77611_18700.t20 55.2719
R2064 a_77611_18700.t21 a_77611_18700.t13 55.2719
R2065 a_77611_18700.t14 a_77611_18700.t4 55.2719
R2066 a_77611_18700.t17 a_77611_18700.t12 55.2719
R2067 a_77611_18700.t9 a_77611_18700.t23 55.2719
R2068 a_77611_18700.t19 a_77611_18700.t15 55.2719
R2069 a_77611_18700.n2 a_77611_18700.t18 47.5809
R2070 a_77611_18700.n6 a_77611_18700.t16 31.048
R2071 a_77611_18700.n10 a_77611_18700.t8 31.048
R2072 a_77611_18700.n6 a_77611_18700.t7 20.8801
R2073 a_77611_18700.n10 a_77611_18700.t10 20.8801
R2074 a_77611_18700.n4 a_77611_18700.t21 19.0326
R2075 a_77611_18700.n5 a_77611_18700.t14 19.0326
R2076 a_77611_18700.n8 a_77611_18700.t9 19.0326
R2077 a_77611_18700.n9 a_77611_18700.t19 19.0326
R2078 a_77611_18700.n3 a_77611_18700.n2 17.9057
R2079 a_77611_18700.n3 a_77611_18700.n1 17.2888
R2080 a_77611_18700.n7 a_77611_18700.n6 12.5069
R2081 a_77611_18700.n11 a_77611_18700.n10 12.5069
R2082 a_77611_18700.n12 a_77611_18700.n0 6.77428
R2083 a_77611_18700.n7 a_77611_18700.n3 6.26871
R2084 a_77611_18700.n12 a_77611_18700.n11 5.45675
R2085 a_77611_18700.n13 a_77611_18700.n12 3.47716
R2086 a_77611_18700.n0 a_77611_18700.t3 2.2755
R2087 a_77611_18700.n0 a_77611_18700.t1 2.2755
R2088 a_77611_18700.n11 a_77611_18700.n7 1.54014
R2089 a_77611_18700.t0 a_77611_18700.n13 1.26439
R2090 a_77611_18700.n13 a_77611_18700.t2 1.26439
R2091 a_62791_16527.n5 a_62791_16527.t11 63.412
R2092 a_62791_16527.n7 a_62791_16527.t4 63.412
R2093 a_62791_16527.n3 a_62791_16527.t7 63.412
R2094 a_62791_16527.n1 a_62791_16527.t6 63.412
R2095 a_62791_16527.n8 a_62791_16527.n7 31.9193
R2096 a_62791_16527.n0 a_62791_16527.t3 31.8559
R2097 a_62791_16527.n0 a_62791_16527.t8 29.9533
R2098 a_62791_16527.n5 a_62791_16527.t5 27.8969
R2099 a_62791_16527.n7 a_62791_16527.t10 27.8969
R2100 a_62791_16527.n3 a_62791_16527.t2 27.8969
R2101 a_62791_16527.n1 a_62791_16527.t9 27.8969
R2102 a_62791_16527.n6 a_62791_16527.n5 20.5415
R2103 a_62791_16527.n4 a_62791_16527.n3 20.5415
R2104 a_62791_16527.n2 a_62791_16527.n1 20.5415
R2105 a_62791_16527.n2 a_62791_16527.n0 13.4025
R2106 a_62791_16527.n9 a_62791_16527.t1 11.2468
R2107 a_62791_16527.n9 a_62791_16527.n8 9.5855
R2108 a_62791_16527.t0 a_62791_16527.n9 4.61924
R2109 a_62791_16527.n4 a_62791_16527.n2 3.97336
R2110 a_62791_16527.n6 a_62791_16527.n4 3.97336
R2111 a_62791_16527.n8 a_62791_16527.n6 1.328
R2112 a_80083_18700.n5 a_80083_18700.n4 144.379
R2113 a_80083_18700.n9 a_80083_18700.n8 144.379
R2114 a_80083_18700.n4 a_80083_18700.t23 114.743
R2115 a_80083_18700.n8 a_80083_18700.t12 114.743
R2116 a_80083_18700.t8 a_80083_18700.n5 96.8993
R2117 a_80083_18700.t15 a_80083_18700.n9 96.8993
R2118 a_80083_18700.n2 a_80083_18700.t19 77.6934
R2119 a_80083_18700.n1 a_80083_18700.t22 73.6523
R2120 a_80083_18700.n1 a_80083_18700.t6 56.3148
R2121 a_80083_18700.t23 a_80083_18700.t16 55.2719
R2122 a_80083_18700.t20 a_80083_18700.t11 55.2719
R2123 a_80083_18700.t7 a_80083_18700.t17 55.2719
R2124 a_80083_18700.t12 a_80083_18700.t5 55.2719
R2125 a_80083_18700.t4 a_80083_18700.t21 55.2719
R2126 a_80083_18700.t14 a_80083_18700.t9 55.2719
R2127 a_80083_18700.n2 a_80083_18700.t13 47.5809
R2128 a_80083_18700.n6 a_80083_18700.t18 31.048
R2129 a_80083_18700.n10 a_80083_18700.t10 31.048
R2130 a_80083_18700.n6 a_80083_18700.t8 20.8801
R2131 a_80083_18700.n10 a_80083_18700.t15 20.8801
R2132 a_80083_18700.n4 a_80083_18700.t20 19.0326
R2133 a_80083_18700.n5 a_80083_18700.t7 19.0326
R2134 a_80083_18700.n8 a_80083_18700.t4 19.0326
R2135 a_80083_18700.n9 a_80083_18700.t14 19.0326
R2136 a_80083_18700.n3 a_80083_18700.n2 17.9122
R2137 a_80083_18700.n3 a_80083_18700.n1 17.2822
R2138 a_80083_18700.n7 a_80083_18700.n6 12.5069
R2139 a_80083_18700.n11 a_80083_18700.n10 12.5069
R2140 a_80083_18700.n12 a_80083_18700.n0 6.77428
R2141 a_80083_18700.n7 a_80083_18700.n3 6.26761
R2142 a_80083_18700.n12 a_80083_18700.n11 5.45675
R2143 a_80083_18700.n13 a_80083_18700.n12 3.47716
R2144 a_80083_18700.n0 a_80083_18700.t2 2.2755
R2145 a_80083_18700.n0 a_80083_18700.t3 2.2755
R2146 a_80083_18700.n11 a_80083_18700.n7 1.54014
R2147 a_80083_18700.t0 a_80083_18700.n13 1.26439
R2148 a_80083_18700.n13 a_80083_18700.t1 1.26439
R2149 a_65251_18700.n5 a_65251_18700.n4 144.379
R2150 a_65251_18700.n9 a_65251_18700.n8 144.379
R2151 a_65251_18700.n4 a_65251_18700.t15 114.743
R2152 a_65251_18700.n8 a_65251_18700.t22 114.743
R2153 a_65251_18700.t10 a_65251_18700.n5 96.8993
R2154 a_65251_18700.t18 a_65251_18700.n9 96.8993
R2155 a_65251_18700.n2 a_65251_18700.t12 77.6934
R2156 a_65251_18700.n1 a_65251_18700.t14 73.6523
R2157 a_65251_18700.n1 a_65251_18700.t17 56.3148
R2158 a_65251_18700.t15 a_65251_18700.t5 55.2719
R2159 a_65251_18700.t8 a_65251_18700.t19 55.2719
R2160 a_65251_18700.t20 a_65251_18700.t6 55.2719
R2161 a_65251_18700.t22 a_65251_18700.t16 55.2719
R2162 a_65251_18700.t13 a_65251_18700.t9 55.2719
R2163 a_65251_18700.t4 a_65251_18700.t21 55.2719
R2164 a_65251_18700.n2 a_65251_18700.t7 47.5809
R2165 a_65251_18700.n6 a_65251_18700.t23 31.048
R2166 a_65251_18700.n10 a_65251_18700.t11 31.048
R2167 a_65251_18700.n6 a_65251_18700.t10 20.8801
R2168 a_65251_18700.n10 a_65251_18700.t18 20.8801
R2169 a_65251_18700.n4 a_65251_18700.t8 19.0326
R2170 a_65251_18700.n5 a_65251_18700.t20 19.0326
R2171 a_65251_18700.n8 a_65251_18700.t13 19.0326
R2172 a_65251_18700.n9 a_65251_18700.t4 19.0326
R2173 a_65251_18700.n3 a_65251_18700.n2 17.9083
R2174 a_65251_18700.n3 a_65251_18700.n1 17.2862
R2175 a_65251_18700.n7 a_65251_18700.n6 12.5069
R2176 a_65251_18700.n11 a_65251_18700.n10 12.5069
R2177 a_65251_18700.n12 a_65251_18700.n0 6.77428
R2178 a_65251_18700.n7 a_65251_18700.n3 6.26761
R2179 a_65251_18700.n12 a_65251_18700.n11 5.45675
R2180 a_65251_18700.n13 a_65251_18700.n12 3.47716
R2181 a_65251_18700.n0 a_65251_18700.t1 2.2755
R2182 a_65251_18700.n0 a_65251_18700.t3 2.2755
R2183 a_65251_18700.n11 a_65251_18700.n7 1.54014
R2184 a_65251_18700.t0 a_65251_18700.n13 1.26439
R2185 a_65251_18700.n13 a_65251_18700.t2 1.26439
R2186 A14.n3 A14.t11 130.792
R2187 A14.n7 A14.t2 130.792
R2188 A14.t3 A14.n4 109.704
R2189 A14.t14 A14.n8 109.704
R2190 A14.n1 A14.t4 95.0309
R2191 A14.n0 A14.t6 90.0773
R2192 A14.n4 A14.n3 79.4894
R2193 A14.n8 A14.n7 79.4894
R2194 A14.t11 A14.t1 55.2719
R2195 A14.t17 A14.t9 55.2719
R2196 A14.t5 A14.t15 55.2719
R2197 A14.t2 A14.t8 55.2719
R2198 A14.t10 A14.t12 55.2719
R2199 A14.t16 A14.t0 55.2719
R2200 A14.n0 A14.t7 39.8898
R2201 A14.n5 A14.t3 30.3125
R2202 A14.n9 A14.t14 30.3125
R2203 A14.n1 A14.t18 30.2434
R2204 A14.n3 A14.t17 23.7255
R2205 A14.n4 A14.t5 23.7255
R2206 A14.n7 A14.t10 23.7255
R2207 A14.n8 A14.t16 23.7255
R2208 A14.n2 A14.n0 22.6927
R2209 A14.n5 A14.t13 20.1446
R2210 A14.n9 A14.t19 20.1446
R2211 A14.n6 A14.n5 12.5069
R2212 A14.n10 A14.n9 12.5069
R2213 A14.n2 A14.n1 12.5005
R2214 A14.n6 A14.n2 12.0872
R2215 A14 A14.n10 1.87604
R2216 A14.n10 A14.n6 1.54014
R2217 a_45475_19620.n5 a_45475_19620.n4 144.379
R2218 a_45475_19620.n4 a_45475_19620.t14 114.743
R2219 a_45475_19620.t12 a_45475_19620.n5 96.8993
R2220 a_45475_19620.n2 a_45475_19620.t5 77.6934
R2221 a_45475_19620.n1 a_45475_19620.t15 73.6523
R2222 a_45475_19620.n1 a_45475_19620.t6 56.3148
R2223 a_45475_19620.t14 a_45475_19620.t11 55.2719
R2224 a_45475_19620.t9 a_45475_19620.t4 55.2719
R2225 a_45475_19620.t13 a_45475_19620.t10 55.2719
R2226 a_45475_19620.n2 a_45475_19620.t7 47.5809
R2227 a_45475_19620.n6 a_45475_19620.t8 31.048
R2228 a_45475_19620.n6 a_45475_19620.t12 20.8801
R2229 a_45475_19620.n4 a_45475_19620.t9 19.0326
R2230 a_45475_19620.n5 a_45475_19620.t13 19.0326
R2231 a_45475_19620.n3 a_45475_19620.n2 17.8431
R2232 a_45475_19620.n3 a_45475_19620.n1 17.3514
R2233 a_45475_19620.n7 a_45475_19620.n6 12.5069
R2234 a_45475_19620.n7 a_45475_19620.n3 7.84572
R2235 a_45475_19620.n9 a_45475_19620.n8 6.77428
R2236 a_45475_19620.n8 a_45475_19620.n7 5.45675
R2237 a_45475_19620.n8 a_45475_19620.n0 3.47716
R2238 a_45475_19620.n9 a_45475_19620.t2 2.2755
R2239 a_45475_19620.t0 a_45475_19620.n9 2.2755
R2240 a_45475_19620.n0 a_45475_19620.t1 1.26439
R2241 a_45475_19620.n0 a_45475_19620.t3 1.26439
R2242 B9.n1 B9.t3 25.964
R2243 B9.n0 B9.t1 25.2616
R2244 B9.n0 B9.t0 24.4794
R2245 B9.n1 B9.t2 24.3998
R2246 B9.n2 B9.n1 9.39912
R2247 B9.n2 B9.n0 8.0005
R2248 B9 B9.n2 5.17871
R2249 B15.n1 B15.t1 25.964
R2250 B15.n0 B15.t3 25.2616
R2251 B15.n0 B15.t2 24.4794
R2252 B15.n1 B15.t0 24.3998
R2253 B15.n2 B15.n1 9.39912
R2254 B15.n2 B15.n0 8.0005
R2255 B15 B15.n2 5.15943
R2256 a_70195_18700.n5 a_70195_18700.n4 144.379
R2257 a_70195_18700.n9 a_70195_18700.n8 144.379
R2258 a_70195_18700.n4 a_70195_18700.t19 114.743
R2259 a_70195_18700.n8 a_70195_18700.t7 114.743
R2260 a_70195_18700.t16 a_70195_18700.n5 96.8993
R2261 a_70195_18700.t5 a_70195_18700.n9 96.8993
R2262 a_70195_18700.n2 a_70195_18700.t12 77.6934
R2263 a_70195_18700.n1 a_70195_18700.t22 73.6523
R2264 a_70195_18700.n1 a_70195_18700.t23 56.3148
R2265 a_70195_18700.t19 a_70195_18700.t11 55.2719
R2266 a_70195_18700.t13 a_70195_18700.t6 55.2719
R2267 a_70195_18700.t15 a_70195_18700.t8 55.2719
R2268 a_70195_18700.t7 a_70195_18700.t21 55.2719
R2269 a_70195_18700.t20 a_70195_18700.t14 55.2719
R2270 a_70195_18700.t4 a_70195_18700.t17 55.2719
R2271 a_70195_18700.n2 a_70195_18700.t10 47.5809
R2272 a_70195_18700.n6 a_70195_18700.t9 31.048
R2273 a_70195_18700.n10 a_70195_18700.t18 31.048
R2274 a_70195_18700.n6 a_70195_18700.t16 20.8801
R2275 a_70195_18700.n10 a_70195_18700.t5 20.8801
R2276 a_70195_18700.n4 a_70195_18700.t13 19.0326
R2277 a_70195_18700.n5 a_70195_18700.t15 19.0326
R2278 a_70195_18700.n8 a_70195_18700.t20 19.0326
R2279 a_70195_18700.n9 a_70195_18700.t4 19.0326
R2280 a_70195_18700.n3 a_70195_18700.n2 17.9057
R2281 a_70195_18700.n3 a_70195_18700.n1 17.2888
R2282 a_70195_18700.n7 a_70195_18700.n6 12.5069
R2283 a_70195_18700.n11 a_70195_18700.n10 12.5069
R2284 a_70195_18700.n13 a_70195_18700.n12 6.77428
R2285 a_70195_18700.n7 a_70195_18700.n3 6.26306
R2286 a_70195_18700.n12 a_70195_18700.n11 5.45675
R2287 a_70195_18700.n12 a_70195_18700.n0 3.47716
R2288 a_70195_18700.n13 a_70195_18700.t3 2.2755
R2289 a_70195_18700.t0 a_70195_18700.n13 2.2755
R2290 a_70195_18700.n11 a_70195_18700.n7 1.54014
R2291 a_70195_18700.n0 a_70195_18700.t1 1.26439
R2292 a_70195_18700.n0 a_70195_18700.t2 1.26439
R2293 a_67723_18700.n5 a_67723_18700.n4 144.379
R2294 a_67723_18700.n9 a_67723_18700.n8 144.379
R2295 a_67723_18700.n4 a_67723_18700.t6 114.743
R2296 a_67723_18700.n8 a_67723_18700.t12 114.743
R2297 a_67723_18700.t21 a_67723_18700.n5 96.8993
R2298 a_67723_18700.t5 a_67723_18700.n9 96.8993
R2299 a_67723_18700.n2 a_67723_18700.t16 77.6934
R2300 a_67723_18700.n1 a_67723_18700.t20 73.6523
R2301 a_67723_18700.n1 a_67723_18700.t23 56.3148
R2302 a_67723_18700.t6 a_67723_18700.t17 55.2719
R2303 a_67723_18700.t13 a_67723_18700.t4 55.2719
R2304 a_67723_18700.t8 a_67723_18700.t18 55.2719
R2305 a_67723_18700.t12 a_67723_18700.t7 55.2719
R2306 a_67723_18700.t19 a_67723_18700.t15 55.2719
R2307 a_67723_18700.t14 a_67723_18700.t9 55.2719
R2308 a_67723_18700.n2 a_67723_18700.t10 47.5809
R2309 a_67723_18700.n6 a_67723_18700.t11 31.048
R2310 a_67723_18700.n10 a_67723_18700.t22 31.048
R2311 a_67723_18700.n6 a_67723_18700.t21 20.8801
R2312 a_67723_18700.n10 a_67723_18700.t5 20.8801
R2313 a_67723_18700.n4 a_67723_18700.t13 19.0326
R2314 a_67723_18700.n5 a_67723_18700.t8 19.0326
R2315 a_67723_18700.n8 a_67723_18700.t19 19.0326
R2316 a_67723_18700.n9 a_67723_18700.t14 19.0326
R2317 a_67723_18700.n3 a_67723_18700.n2 17.9057
R2318 a_67723_18700.n3 a_67723_18700.n1 17.2888
R2319 a_67723_18700.n7 a_67723_18700.n6 12.5069
R2320 a_67723_18700.n11 a_67723_18700.n10 12.5069
R2321 a_67723_18700.n12 a_67723_18700.n0 6.77428
R2322 a_67723_18700.n7 a_67723_18700.n3 6.26761
R2323 a_67723_18700.n12 a_67723_18700.n11 5.45675
R2324 a_67723_18700.n13 a_67723_18700.n12 3.47716
R2325 a_67723_18700.n0 a_67723_18700.t1 2.2755
R2326 a_67723_18700.n0 a_67723_18700.t3 2.2755
R2327 a_67723_18700.n11 a_67723_18700.n7 1.54014
R2328 a_67723_18700.t0 a_67723_18700.n13 1.26439
R2329 a_67723_18700.n13 a_67723_18700.t2 1.26439
R2330 a_77873_18463.n0 a_77873_18463.t3 103.624
R2331 a_77873_18463.n0 a_77873_18463.t2 49.0549
R2332 a_77873_18463.n1 a_77873_18463.n0 45.2394
R2333 a_77873_18463.n1 a_77873_18463.t1 11.6374
R2334 a_77873_18463.t0 a_77873_18463.n1 8.42385
R2335 a_50419_19620.n5 a_50419_19620.n4 144.379
R2336 a_50419_19620.n4 a_50419_19620.t6 114.743
R2337 a_50419_19620.t11 a_50419_19620.n5 96.8993
R2338 a_50419_19620.n2 a_50419_19620.t9 77.6934
R2339 a_50419_19620.n1 a_50419_19620.t13 73.6523
R2340 a_50419_19620.n1 a_50419_19620.t4 56.3148
R2341 a_50419_19620.t6 a_50419_19620.t15 55.2719
R2342 a_50419_19620.t10 a_50419_19620.t7 55.2719
R2343 a_50419_19620.t5 a_50419_19620.t14 55.2719
R2344 a_50419_19620.n2 a_50419_19620.t12 47.5809
R2345 a_50419_19620.n6 a_50419_19620.t8 31.048
R2346 a_50419_19620.n6 a_50419_19620.t11 20.8801
R2347 a_50419_19620.n4 a_50419_19620.t10 19.0326
R2348 a_50419_19620.n5 a_50419_19620.t5 19.0326
R2349 a_50419_19620.n3 a_50419_19620.n2 17.8483
R2350 a_50419_19620.n3 a_50419_19620.n1 17.3462
R2351 a_50419_19620.n7 a_50419_19620.n6 12.5069
R2352 a_50419_19620.n7 a_50419_19620.n3 7.84353
R2353 a_50419_19620.n9 a_50419_19620.n8 6.77428
R2354 a_50419_19620.n8 a_50419_19620.n7 5.45675
R2355 a_50419_19620.n8 a_50419_19620.n0 3.47716
R2356 a_50419_19620.t0 a_50419_19620.n9 2.2755
R2357 a_50419_19620.n9 a_50419_19620.t2 2.2755
R2358 a_50419_19620.n0 a_50419_19620.t3 1.26439
R2359 a_50419_19620.n0 a_50419_19620.t1 1.26439
R2360 A0.n3 A0.t10 130.792
R2361 A0.t6 A0.n4 109.704
R2362 A0.n0 A0.t1 95.0309
R2363 A0.n4 A0.n3 79.4894
R2364 A0.n2 A0.n1 68.9702
R2365 A0.t10 A0.t0 55.2719
R2366 A0.t11 A0.t3 55.2719
R2367 A0.t5 A0.t7 55.2719
R2368 A0.n1 A0.t9 39.8898
R2369 A0.n1 A0.n0 35.1927
R2370 A0.n5 A0.t6 30.3125
R2371 A0.n0 A0.t2 30.2434
R2372 A0.n3 A0.t11 23.7255
R2373 A0.n4 A0.t5 23.7255
R2374 A0.n5 A0.t8 20.1446
R2375 A0.n6 A0.n2 18.5543
R2376 A0.n2 A0.t4 15.4416
R2377 A0.n6 A0.n5 12.5069
R2378 A0 A0.n6 1.86639
R2379 SEL0.n1 SEL0.t4 62.619
R2380 SEL0.n0 SEL0.t7 62.619
R2381 SEL0.n1 SEL0.t6 60.5333
R2382 SEL0.n0 SEL0.t5 60.5333
R2383 SEL0.n3 SEL0.t1 20.933
R2384 SEL0.n6 SEL0.t2 20.7357
R2385 SEL0.n2 SEL0.n0 17.7205
R2386 SEL0.n2 SEL0.n1 17.0005
R2387 SEL0.n5 SEL0.n4 15.0081
R2388 SEL0.n4 SEL0.t3 5.05606
R2389 SEL0.n4 SEL0.t0 5.05606
R2390 SEL0 SEL0.n6 0.522239
R2391 SEL0.n5 SEL0.n3 0.446587
R2392 SEL0.n6 SEL0.n5 0.44137
R2393 SEL0.n3 SEL0.n2 0.275717
R2394 a_40610_17389.n0 a_40610_17389.t4 94.0272
R2395 a_40610_17389.n1 a_40610_17389.t6 92.7549
R2396 a_40610_17389.n2 a_40610_17389.t3 77.219
R2397 a_40610_17389.n2 a_40610_17389.t5 45.9333
R2398 a_40610_17389.n0 a_40610_17389.t1 19.6988
R2399 a_40610_17389.n3 a_40610_17389.n2 17.0005
R2400 a_40610_17389.t0 a_40610_17389.n4 11.6782
R2401 a_40610_17389.n4 a_40610_17389.n3 9.50137
R2402 a_40610_17389.n4 a_40610_17389.t2 8.22873
R2403 a_40610_17389.n3 a_40610_17389.n1 0.509196
R2404 a_40610_17389.n1 a_40610_17389.n0 0.203978
R2405 a_52803_16571.n0 a_52803_16571.t5 132.954
R2406 a_52803_16571.n2 a_52803_16571.n0 25.4316
R2407 a_52803_16571.n0 a_52803_16571.t4 19.7245
R2408 a_52803_16571.n3 a_52803_16571.n2 17.8503
R2409 a_52803_16571.n2 a_52803_16571.n1 17.1065
R2410 a_52803_16571.n1 a_52803_16571.t3 12.856
R2411 a_52803_16571.n1 a_52803_16571.t2 11.4227
R2412 a_52803_16571.n3 a_52803_16571.t1 11.0614
R2413 a_52803_16571.t0 a_52803_16571.n3 8.99985
R2414 a_41233_17389.n0 a_41233_17389.t12 32.0712
R2415 a_41233_17389.n14 a_41233_17389.t4 28.0984
R2416 a_41233_17389.n13 a_41233_17389.t9 28.0984
R2417 a_41233_17389.n12 a_41233_17389.t16 28.0984
R2418 a_41233_17389.n11 a_41233_17389.t15 28.0984
R2419 a_41233_17389.n10 a_41233_17389.t8 28.0984
R2420 a_41233_17389.n9 a_41233_17389.t13 28.0984
R2421 a_41233_17389.n8 a_41233_17389.t3 28.0984
R2422 a_41233_17389.n7 a_41233_17389.t17 28.0984
R2423 a_41233_17389.n6 a_41233_17389.t11 28.0984
R2424 a_41233_17389.n5 a_41233_17389.t14 28.0984
R2425 a_41233_17389.n4 a_41233_17389.t7 28.0984
R2426 a_41233_17389.n3 a_41233_17389.t5 28.0984
R2427 a_41233_17389.n2 a_41233_17389.t6 28.0984
R2428 a_41233_17389.n1 a_41233_17389.t18 28.0984
R2429 a_41233_17389.n0 a_41233_17389.t10 28.0984
R2430 a_41233_17389.n15 a_41233_17389.n14 24.1883
R2431 a_41233_17389.n15 a_41233_17389.t2 11.4387
R2432 a_41233_17389.n16 a_41233_17389.n15 6.60989
R2433 a_41233_17389.t0 a_41233_17389.n16 4.638
R2434 a_41233_17389.n16 a_41233_17389.t1 4.638
R2435 a_41233_17389.n1 a_41233_17389.n0 3.97336
R2436 a_41233_17389.n2 a_41233_17389.n1 3.97336
R2437 a_41233_17389.n3 a_41233_17389.n2 3.97336
R2438 a_41233_17389.n4 a_41233_17389.n3 3.97336
R2439 a_41233_17389.n5 a_41233_17389.n4 3.97336
R2440 a_41233_17389.n6 a_41233_17389.n5 3.97336
R2441 a_41233_17389.n7 a_41233_17389.n6 3.97336
R2442 a_41233_17389.n8 a_41233_17389.n7 3.97336
R2443 a_41233_17389.n9 a_41233_17389.n8 3.97336
R2444 a_41233_17389.n10 a_41233_17389.n9 3.97336
R2445 a_41233_17389.n11 a_41233_17389.n10 3.97336
R2446 a_41233_17389.n12 a_41233_17389.n11 3.97336
R2447 a_41233_17389.n13 a_41233_17389.n12 3.97336
R2448 a_41233_17389.n14 a_41233_17389.n13 3.97336
R2449 CIN.n59 CIN.t50 34.6755
R2450 CIN.n55 CIN.t19 34.6755
R2451 CIN.n51 CIN.t35 34.6755
R2452 CIN.n47 CIN.t18 34.6755
R2453 CIN.n43 CIN.t60 34.6755
R2454 CIN.n39 CIN.t12 34.6755
R2455 CIN.n35 CIN.t47 34.6755
R2456 CIN.n31 CIN.t51 34.6755
R2457 CIN.n27 CIN.t2 34.6755
R2458 CIN.n23 CIN.t21 34.6755
R2459 CIN.n19 CIN.t56 34.6755
R2460 CIN.n15 CIN.t61 34.6755
R2461 CIN.n11 CIN.t6 34.6755
R2462 CIN.n7 CIN.t30 34.6755
R2463 CIN.n3 CIN.t69 34.6755
R2464 CIN.n0 CIN.t3 34.6755
R2465 CIN.n66 CIN.t16 30.2434
R2466 CIN.n64 CIN.t48 30.2434
R2467 CIN.n63 CIN.t45 29.1505
R2468 CIN.n60 CIN.t41 26.1878
R2469 CIN.n56 CIN.t63 26.1878
R2470 CIN.n52 CIN.t28 26.1878
R2471 CIN.n48 CIN.t17 26.1878
R2472 CIN.n44 CIN.t52 26.1878
R2473 CIN.n40 CIN.t4 26.1878
R2474 CIN.n36 CIN.t39 26.1878
R2475 CIN.n32 CIN.t42 26.1878
R2476 CIN.n28 CIN.t36 26.1878
R2477 CIN.n24 CIN.t14 26.1878
R2478 CIN.n20 CIN.t49 26.1878
R2479 CIN.n16 CIN.t53 26.1878
R2480 CIN.n12 CIN.t5 26.1878
R2481 CIN.n8 CIN.t23 26.1878
R2482 CIN.n4 CIN.t68 26.1878
R2483 CIN.n1 CIN.t37 26.1878
R2484 CIN.n60 CIN.t33 24.6235
R2485 CIN.n56 CIN.t54 24.6235
R2486 CIN.n52 CIN.t22 24.6235
R2487 CIN.n48 CIN.t9 24.6235
R2488 CIN.n44 CIN.t43 24.6235
R2489 CIN.n40 CIN.t64 24.6235
R2490 CIN.n36 CIN.t31 24.6235
R2491 CIN.n32 CIN.t34 24.6235
R2492 CIN.n28 CIN.t27 24.6235
R2493 CIN.n24 CIN.t7 24.6235
R2494 CIN.n20 CIN.t40 24.6235
R2495 CIN.n16 CIN.t44 24.6235
R2496 CIN.n12 CIN.t65 24.6235
R2497 CIN.n8 CIN.t15 24.6235
R2498 CIN.n4 CIN.t57 24.6235
R2499 CIN.n1 CIN.t29 24.6235
R2500 CIN.n66 CIN.t32 22.9434
R2501 CIN.n64 CIN.t66 22.9434
R2502 CIN.n63 CIN.t62 21.8505
R2503 CIN.n59 CIN.t58 14.3398
R2504 CIN.n55 CIN.t25 14.3398
R2505 CIN.n51 CIN.t46 14.3398
R2506 CIN.n47 CIN.t24 14.3398
R2507 CIN.n43 CIN.t0 14.3398
R2508 CIN.n39 CIN.t20 14.3398
R2509 CIN.n35 CIN.t55 14.3398
R2510 CIN.n31 CIN.t59 14.3398
R2511 CIN.n27 CIN.t10 14.3398
R2512 CIN.n23 CIN.t26 14.3398
R2513 CIN.n19 CIN.t67 14.3398
R2514 CIN.n15 CIN.t1 14.3398
R2515 CIN.n11 CIN.t13 14.3398
R2516 CIN.n7 CIN.t38 14.3398
R2517 CIN.n3 CIN.t8 14.3398
R2518 CIN.n0 CIN.t11 14.3398
R2519 CIN.n6 CIN.n2 12.9734
R2520 CIN CIN.n67 10.9773
R2521 CIN.n65 CIN.n63 9.14115
R2522 CIN.n62 CIN.n61 9.0005
R2523 CIN.n58 CIN.n57 9.0005
R2524 CIN.n54 CIN.n53 9.0005
R2525 CIN.n50 CIN.n49 9.0005
R2526 CIN.n46 CIN.n45 9.0005
R2527 CIN.n42 CIN.n41 9.0005
R2528 CIN.n38 CIN.n37 9.0005
R2529 CIN.n34 CIN.n33 9.0005
R2530 CIN.n30 CIN.n29 9.0005
R2531 CIN.n26 CIN.n25 9.0005
R2532 CIN.n22 CIN.n21 9.0005
R2533 CIN.n18 CIN.n17 9.0005
R2534 CIN.n14 CIN.n13 9.0005
R2535 CIN.n10 CIN.n9 9.0005
R2536 CIN.n6 CIN.n5 9.0005
R2537 CIN.n61 CIN.n59 8.64267
R2538 CIN.n57 CIN.n55 8.64267
R2539 CIN.n53 CIN.n51 8.64267
R2540 CIN.n49 CIN.n47 8.64267
R2541 CIN.n45 CIN.n43 8.64267
R2542 CIN.n41 CIN.n39 8.64267
R2543 CIN.n37 CIN.n35 8.64267
R2544 CIN.n33 CIN.n31 8.64267
R2545 CIN.n29 CIN.n27 8.64267
R2546 CIN.n25 CIN.n23 8.64267
R2547 CIN.n21 CIN.n19 8.64267
R2548 CIN.n17 CIN.n15 8.64267
R2549 CIN.n13 CIN.n11 8.64267
R2550 CIN.n9 CIN.n7 8.64267
R2551 CIN.n5 CIN.n3 8.64267
R2552 CIN.n2 CIN.n0 8.64267
R2553 CIN.n67 CIN.n66 8.02943
R2554 CIN.n61 CIN.n60 8.0005
R2555 CIN.n57 CIN.n56 8.0005
R2556 CIN.n53 CIN.n52 8.0005
R2557 CIN.n49 CIN.n48 8.0005
R2558 CIN.n45 CIN.n44 8.0005
R2559 CIN.n41 CIN.n40 8.0005
R2560 CIN.n37 CIN.n36 8.0005
R2561 CIN.n33 CIN.n32 8.0005
R2562 CIN.n29 CIN.n28 8.0005
R2563 CIN.n25 CIN.n24 8.0005
R2564 CIN.n21 CIN.n20 8.0005
R2565 CIN.n17 CIN.n16 8.0005
R2566 CIN.n13 CIN.n12 8.0005
R2567 CIN.n9 CIN.n8 8.0005
R2568 CIN.n5 CIN.n4 8.0005
R2569 CIN.n2 CIN.n1 8.0005
R2570 CIN.n65 CIN.n64 8.0005
R2571 CIN.n10 CIN.n6 3.97336
R2572 CIN.n14 CIN.n10 3.97336
R2573 CIN.n18 CIN.n14 3.97336
R2574 CIN.n22 CIN.n18 3.97336
R2575 CIN.n26 CIN.n22 3.97336
R2576 CIN.n30 CIN.n26 3.97336
R2577 CIN.n34 CIN.n30 3.97336
R2578 CIN.n38 CIN.n34 3.97336
R2579 CIN.n42 CIN.n38 3.97336
R2580 CIN.n46 CIN.n42 3.97336
R2581 CIN.n50 CIN.n46 3.97336
R2582 CIN.n54 CIN.n50 3.97336
R2583 CIN.n58 CIN.n54 3.97336
R2584 CIN.n62 CIN.n58 3.97336
R2585 CIN CIN.n62 2.37907
R2586 CIN.n67 CIN.n65 1.18364
R2587 a_57835_18700.n5 a_57835_18700.n4 144.379
R2588 a_57835_18700.n9 a_57835_18700.n8 144.379
R2589 a_57835_18700.n4 a_57835_18700.t5 114.743
R2590 a_57835_18700.n8 a_57835_18700.t10 114.743
R2591 a_57835_18700.t14 a_57835_18700.n5 96.8993
R2592 a_57835_18700.t20 a_57835_18700.n9 96.8993
R2593 a_57835_18700.n2 a_57835_18700.t12 77.6934
R2594 a_57835_18700.n1 a_57835_18700.t18 73.6523
R2595 a_57835_18700.n1 a_57835_18700.t19 56.3148
R2596 a_57835_18700.t5 a_57835_18700.t15 55.2719
R2597 a_57835_18700.t11 a_57835_18700.t21 55.2719
R2598 a_57835_18700.t22 a_57835_18700.t9 55.2719
R2599 a_57835_18700.t10 a_57835_18700.t6 55.2719
R2600 a_57835_18700.t17 a_57835_18700.t13 55.2719
R2601 a_57835_18700.t7 a_57835_18700.t23 55.2719
R2602 a_57835_18700.n2 a_57835_18700.t8 47.5809
R2603 a_57835_18700.n6 a_57835_18700.t4 31.048
R2604 a_57835_18700.n10 a_57835_18700.t16 31.048
R2605 a_57835_18700.n6 a_57835_18700.t14 20.8801
R2606 a_57835_18700.n10 a_57835_18700.t20 20.8801
R2607 a_57835_18700.n4 a_57835_18700.t11 19.0326
R2608 a_57835_18700.n5 a_57835_18700.t22 19.0326
R2609 a_57835_18700.n8 a_57835_18700.t17 19.0326
R2610 a_57835_18700.n9 a_57835_18700.t7 19.0326
R2611 a_57835_18700.n3 a_57835_18700.n2 17.9083
R2612 a_57835_18700.n3 a_57835_18700.n1 17.2862
R2613 a_57835_18700.n7 a_57835_18700.n6 12.5069
R2614 a_57835_18700.n11 a_57835_18700.n10 12.5069
R2615 a_57835_18700.n13 a_57835_18700.n12 6.77428
R2616 a_57835_18700.n7 a_57835_18700.n3 6.26761
R2617 a_57835_18700.n12 a_57835_18700.n11 5.45675
R2618 a_57835_18700.n12 a_57835_18700.n0 3.47716
R2619 a_57835_18700.n13 a_57835_18700.t3 2.2755
R2620 a_57835_18700.t0 a_57835_18700.n13 2.2755
R2621 a_57835_18700.n11 a_57835_18700.n7 1.54014
R2622 a_57835_18700.n0 a_57835_18700.t1 1.26439
R2623 a_57835_18700.n0 a_57835_18700.t2 1.26439
R2624 A3.n3 A3.t6 130.792
R2625 A3.t11 A3.n4 109.704
R2626 A3.n0 A3.t8 95.0309
R2627 A3.n4 A3.n3 79.4894
R2628 A3.n2 A3.n1 61.9312
R2629 A3.t6 A3.t7 55.2719
R2630 A3.t0 A3.t4 55.2719
R2631 A3.t1 A3.t5 55.2719
R2632 A3.n1 A3.t3 39.8898
R2633 A3.n1 A3.n0 35.1927
R2634 A3.n5 A3.t11 30.3125
R2635 A3.n0 A3.t9 30.2434
R2636 A3.n3 A3.t0 23.7255
R2637 A3.n4 A3.t1 23.7255
R2638 A3.n2 A3.t10 22.4811
R2639 A3.n5 A3.t2 20.1446
R2640 A3.n6 A3.n2 18.6445
R2641 A3.n6 A3.n5 12.5069
R2642 A3 A3.n6 1.87121
R2643 A11.n3 A11.t0 130.792
R2644 A11.n7 A11.t14 130.792
R2645 A11.t18 A11.n4 109.704
R2646 A11.t9 A11.n8 109.704
R2647 A11.n1 A11.t16 95.0309
R2648 A11.n0 A11.t3 90.0773
R2649 A11.n4 A11.n3 79.4894
R2650 A11.n8 A11.n7 79.4894
R2651 A11.t0 A11.t12 55.2719
R2652 A11.t11 A11.t1 55.2719
R2653 A11.t17 A11.t5 55.2719
R2654 A11.t14 A11.t19 55.2719
R2655 A11.t2 A11.t6 55.2719
R2656 A11.t7 A11.t13 55.2719
R2657 A11.n0 A11.t4 39.8898
R2658 A11.n5 A11.t18 30.3125
R2659 A11.n9 A11.t9 30.3125
R2660 A11.n1 A11.t10 30.2434
R2661 A11.n3 A11.t11 23.7255
R2662 A11.n4 A11.t17 23.7255
R2663 A11.n7 A11.t2 23.7255
R2664 A11.n8 A11.t7 23.7255
R2665 A11.n2 A11.n0 22.6927
R2666 A11.n5 A11.t8 20.1446
R2667 A11.n9 A11.t15 20.1446
R2668 A11.n6 A11.n5 12.5069
R2669 A11.n10 A11.n9 12.5069
R2670 A11.n2 A11.n1 12.5005
R2671 A11.n6 A11.n2 12.0868
R2672 A11 A11.n10 1.88086
R2673 A11.n10 A11.n6 1.54014
R2674 a_42244_17389.n0 a_42244_17389.t17 32.0712
R2675 a_42244_17389.n14 a_42244_17389.t11 28.0984
R2676 a_42244_17389.n13 a_42244_17389.t3 28.0984
R2677 a_42244_17389.n12 a_42244_17389.t9 28.0984
R2678 a_42244_17389.n11 a_42244_17389.t7 28.0984
R2679 a_42244_17389.n10 a_42244_17389.t16 28.0984
R2680 a_42244_17389.n9 a_42244_17389.t5 28.0984
R2681 a_42244_17389.n8 a_42244_17389.t13 28.0984
R2682 a_42244_17389.n7 a_42244_17389.t12 28.0984
R2683 a_42244_17389.n6 a_42244_17389.t4 28.0984
R2684 a_42244_17389.n5 a_42244_17389.t8 28.0984
R2685 a_42244_17389.n4 a_42244_17389.t15 28.0984
R2686 a_42244_17389.n3 a_42244_17389.t14 28.0984
R2687 a_42244_17389.n2 a_42244_17389.t6 28.0984
R2688 a_42244_17389.n1 a_42244_17389.t10 28.0984
R2689 a_42244_17389.n0 a_42244_17389.t18 28.0984
R2690 a_42244_17389.n15 a_42244_17389.t2 15.1614
R2691 a_42244_17389.n15 a_42244_17389.n14 13.0124
R2692 a_42244_17389.t0 a_42244_17389.n16 8.838
R2693 a_42244_17389.n16 a_42244_17389.t1 8.838
R2694 a_42244_17389.n16 a_42244_17389.n15 7.41136
R2695 a_42244_17389.n1 a_42244_17389.n0 3.97336
R2696 a_42244_17389.n2 a_42244_17389.n1 3.97336
R2697 a_42244_17389.n3 a_42244_17389.n2 3.97336
R2698 a_42244_17389.n4 a_42244_17389.n3 3.97336
R2699 a_42244_17389.n5 a_42244_17389.n4 3.97336
R2700 a_42244_17389.n6 a_42244_17389.n5 3.97336
R2701 a_42244_17389.n7 a_42244_17389.n6 3.97336
R2702 a_42244_17389.n8 a_42244_17389.n7 3.97336
R2703 a_42244_17389.n9 a_42244_17389.n8 3.97336
R2704 a_42244_17389.n10 a_42244_17389.n9 3.97336
R2705 a_42244_17389.n11 a_42244_17389.n10 3.97336
R2706 a_42244_17389.n12 a_42244_17389.n11 3.97336
R2707 a_42244_17389.n13 a_42244_17389.n12 3.97336
R2708 a_42244_17389.n14 a_42244_17389.n13 3.97336
R2709 A5.n3 A5.t13 130.792
R2710 A5.n7 A5.t6 130.792
R2711 A5.t9 A5.n4 109.704
R2712 A5.t19 A5.n8 109.704
R2713 A5.n1 A5.t1 95.0309
R2714 A5.n0 A5.t4 90.0773
R2715 A5.n4 A5.n3 79.4894
R2716 A5.n8 A5.n7 79.4894
R2717 A5.t13 A5.t5 55.2719
R2718 A5.t0 A5.t11 55.2719
R2719 A5.t8 A5.t15 55.2719
R2720 A5.t6 A5.t10 55.2719
R2721 A5.t12 A5.t14 55.2719
R2722 A5.t17 A5.t2 55.2719
R2723 A5.n0 A5.t7 39.8898
R2724 A5.n5 A5.t9 30.3125
R2725 A5.n9 A5.t19 30.3125
R2726 A5.n1 A5.t16 30.2434
R2727 A5.n3 A5.t0 23.7255
R2728 A5.n4 A5.t8 23.7255
R2729 A5.n7 A5.t12 23.7255
R2730 A5.n8 A5.t17 23.7255
R2731 A5.n2 A5.n0 22.6927
R2732 A5.n5 A5.t18 20.1446
R2733 A5.n9 A5.t3 20.1446
R2734 A5.n6 A5.n5 12.5069
R2735 A5.n10 A5.n9 12.5069
R2736 A5.n2 A5.n1 12.5005
R2737 A5.n6 A5.n2 12.091
R2738 A5 A5.n10 1.87604
R2739 A5.n10 A5.n6 1.54014
R2740 A12.n1 A12.t0 95.0309
R2741 A12.n0 A12.t1 90.0773
R2742 A12.n0 A12.t2 39.8898
R2743 A12.n1 A12.t3 30.2434
R2744 A12.n2 A12.n0 22.6927
R2745 A12 A12.n2 15.0252
R2746 A12.n2 A12.n1 12.5005
R2747 a_62783_16853.n1 a_62783_16853.t4 71.6245
R2748 a_62783_16853.n6 a_62783_16853.t10 36.3352
R2749 a_62783_16853.n8 a_62783_16853.t6 36.3352
R2750 a_62783_16853.n4 a_62783_16853.t8 36.3352
R2751 a_62783_16853.n2 a_62783_16853.t7 36.3352
R2752 a_62783_16853.n10 a_62783_16853.t13 35.4953
R2753 a_62783_16853.n6 a_62783_16853.t9 28.0755
R2754 a_62783_16853.n8 a_62783_16853.t14 28.0755
R2755 a_62783_16853.n4 a_62783_16853.t5 28.0755
R2756 a_62783_16853.n2 a_62783_16853.t12 28.0755
R2757 a_62783_16853.n9 a_62783_16853.n8 23.9219
R2758 a_62783_16853.n3 a_62783_16853.n1 21.2048
R2759 a_62783_16853.n10 a_62783_16853.t15 15.9418
R2760 a_62783_16853.n1 a_62783_16853.t11 15.1219
R2761 a_62783_16853.n7 a_62783_16853.n6 12.4992
R2762 a_62783_16853.n5 a_62783_16853.n4 12.4992
R2763 a_62783_16853.n3 a_62783_16853.n2 12.4992
R2764 a_62783_16853.n11 a_62783_16853.n9 10.4759
R2765 a_62783_16853.n11 a_62783_16853.n10 8.0005
R2766 a_62783_16853.n12 a_62783_16853.n0 6.98137
R2767 a_62783_16853.n5 a_62783_16853.n3 3.97336
R2768 a_62783_16853.n7 a_62783_16853.n5 3.97336
R2769 a_62783_16853.n0 a_62783_16853.t3 3.3605
R2770 a_62783_16853.n0 a_62783_16853.t1 3.3605
R2771 a_62783_16853.n13 a_62783_16853.n12 3.3518
R2772 a_62783_16853.n13 a_62783_16853.t2 1.86717
R2773 a_62783_16853.t0 a_62783_16853.n13 1.86717
R2774 a_62783_16853.n12 a_62783_16853.n11 1.26183
R2775 a_62783_16853.n9 a_62783_16853.n7 0.91175
R2776 a_72579_16571.n0 a_72579_16571.t4 132.954
R2777 a_72579_16571.n1 a_72579_16571.n0 43.6211
R2778 a_72579_16571.n3 a_72579_16571.n2 20.315
R2779 a_72579_16571.n0 a_72579_16571.t5 19.7245
R2780 a_72579_16571.n2 a_72579_16571.t3 12.856
R2781 a_72579_16571.n2 a_72579_16571.t2 11.4227
R2782 a_72579_16571.n1 a_72579_16571.t1 11.0614
R2783 a_72579_16571.t0 a_72579_16571.n3 8.42385
R2784 a_72579_16571.n3 a_72579_16571.n1 0.5765
R2785 a_67986_18464.n0 a_67986_18464.t3 103.624
R2786 a_67986_18464.n0 a_67986_18464.t2 49.0549
R2787 a_67986_18464.n1 a_67986_18464.n0 45.2322
R2788 a_67986_18464.n1 a_67986_18464.t1 11.6374
R2789 a_67986_18464.t0 a_67986_18464.n1 8.42385
R2790 a_52895_16853.n0 a_52895_16853.t10 71.6245
R2791 a_52895_16853.n7 a_52895_16853.t7 36.3352
R2792 a_52895_16853.n5 a_52895_16853.t9 36.3352
R2793 a_52895_16853.n3 a_52895_16853.t4 36.3352
R2794 a_52895_16853.n1 a_52895_16853.t3 36.3352
R2795 a_52895_16853.n7 a_52895_16853.t2 28.0755
R2796 a_52895_16853.n5 a_52895_16853.t5 28.0755
R2797 a_52895_16853.n3 a_52895_16853.t8 28.0755
R2798 a_52895_16853.n1 a_52895_16853.t11 28.0755
R2799 a_52895_16853.n2 a_52895_16853.n0 21.2048
R2800 a_52895_16853.t0 a_52895_16853.n9 16.0512
R2801 a_52895_16853.n0 a_52895_16853.t6 15.1219
R2802 a_52895_16853.n8 a_52895_16853.n7 12.7372
R2803 a_52895_16853.n6 a_52895_16853.n5 12.4992
R2804 a_52895_16853.n4 a_52895_16853.n3 12.4992
R2805 a_52895_16853.n2 a_52895_16853.n1 12.4992
R2806 a_52895_16853.n9 a_52895_16853.t1 11.1579
R2807 a_52895_16853.n9 a_52895_16853.n8 9.50514
R2808 a_52895_16853.n4 a_52895_16853.n2 3.97336
R2809 a_52895_16853.n6 a_52895_16853.n4 3.97336
R2810 a_52895_16853.n8 a_52895_16853.n6 3.65836
R2811 a_60307_18700.n5 a_60307_18700.n4 144.379
R2812 a_60307_18700.n9 a_60307_18700.n8 144.379
R2813 a_60307_18700.n4 a_60307_18700.t4 114.743
R2814 a_60307_18700.n8 a_60307_18700.t8 114.743
R2815 a_60307_18700.t13 a_60307_18700.n5 96.8993
R2816 a_60307_18700.t19 a_60307_18700.n9 96.8993
R2817 a_60307_18700.n2 a_60307_18700.t9 77.6934
R2818 a_60307_18700.n1 a_60307_18700.t16 73.6523
R2819 a_60307_18700.n1 a_60307_18700.t18 56.3148
R2820 a_60307_18700.t4 a_60307_18700.t14 55.2719
R2821 a_60307_18700.t11 a_60307_18700.t20 55.2719
R2822 a_60307_18700.t21 a_60307_18700.t10 55.2719
R2823 a_60307_18700.t8 a_60307_18700.t5 55.2719
R2824 a_60307_18700.t17 a_60307_18700.t12 55.2719
R2825 a_60307_18700.t7 a_60307_18700.t23 55.2719
R2826 a_60307_18700.n2 a_60307_18700.t6 47.5809
R2827 a_60307_18700.n6 a_60307_18700.t22 31.048
R2828 a_60307_18700.n10 a_60307_18700.t15 31.048
R2829 a_60307_18700.n6 a_60307_18700.t13 20.8801
R2830 a_60307_18700.n10 a_60307_18700.t19 20.8801
R2831 a_60307_18700.n4 a_60307_18700.t11 19.0326
R2832 a_60307_18700.n5 a_60307_18700.t21 19.0326
R2833 a_60307_18700.n8 a_60307_18700.t17 19.0326
R2834 a_60307_18700.n9 a_60307_18700.t7 19.0326
R2835 a_60307_18700.n3 a_60307_18700.n2 17.9018
R2836 a_60307_18700.n3 a_60307_18700.n1 17.2927
R2837 a_60307_18700.n7 a_60307_18700.n6 12.5069
R2838 a_60307_18700.n11 a_60307_18700.n10 12.5069
R2839 a_60307_18700.n13 a_60307_18700.n12 6.77428
R2840 a_60307_18700.n7 a_60307_18700.n3 6.26922
R2841 a_60307_18700.n12 a_60307_18700.n11 5.45675
R2842 a_60307_18700.n12 a_60307_18700.n0 3.47716
R2843 a_60307_18700.n13 a_60307_18700.t3 2.2755
R2844 a_60307_18700.t0 a_60307_18700.n13 2.2755
R2845 a_60307_18700.n11 a_60307_18700.n7 1.54014
R2846 a_60307_18700.n0 a_60307_18700.t1 1.26439
R2847 a_60307_18700.n0 a_60307_18700.t2 1.26439
R2848 a_43003_19620.n5 a_43003_19620.n4 144.379
R2849 a_43003_19620.n4 a_43003_19620.t8 114.743
R2850 a_43003_19620.t7 a_43003_19620.n5 96.8993
R2851 a_43003_19620.n2 a_43003_19620.t11 77.6934
R2852 a_43003_19620.n1 a_43003_19620.t4 73.6523
R2853 a_43003_19620.n1 a_43003_19620.t9 56.3148
R2854 a_43003_19620.t8 a_43003_19620.t5 55.2719
R2855 a_43003_19620.t12 a_43003_19620.t10 55.2719
R2856 a_43003_19620.t6 a_43003_19620.t14 55.2719
R2857 a_43003_19620.n2 a_43003_19620.t13 47.5809
R2858 a_43003_19620.n6 a_43003_19620.t15 31.048
R2859 a_43003_19620.n6 a_43003_19620.t7 20.8801
R2860 a_43003_19620.n4 a_43003_19620.t12 19.0326
R2861 a_43003_19620.n5 a_43003_19620.t6 19.0326
R2862 a_43003_19620.n3 a_43003_19620.n2 17.8366
R2863 a_43003_19620.n3 a_43003_19620.n1 17.3579
R2864 a_43003_19620.n7 a_43003_19620.n6 12.5069
R2865 a_43003_19620.n7 a_43003_19620.n3 7.84507
R2866 a_43003_19620.n9 a_43003_19620.n8 6.77428
R2867 a_43003_19620.n8 a_43003_19620.n7 5.45675
R2868 a_43003_19620.n8 a_43003_19620.n0 3.47716
R2869 a_43003_19620.n9 a_43003_19620.t2 2.2755
R2870 a_43003_19620.t0 a_43003_19620.n9 2.2755
R2871 a_43003_19620.n0 a_43003_19620.t1 1.26439
R2872 a_43003_19620.n0 a_43003_19620.t3 1.26439
R2873 B10.n1 B10.t0 25.964
R2874 B10.n0 B10.t2 25.2616
R2875 B10.n0 B10.t1 24.4794
R2876 B10.n1 B10.t3 24.3998
R2877 B10.n2 B10.n1 9.39912
R2878 B10.n2 B10.n0 8.0005
R2879 B10 B10.n2 5.17068
R2880 A1.n3 A1.t1 130.792
R2881 A1.t4 A1.n4 109.704
R2882 A1.n0 A1.t6 95.0309
R2883 A1.n4 A1.n3 79.4894
R2884 A1.n2 A1.n1 66.6241
R2885 A1.t1 A1.t3 55.2719
R2886 A1.t5 A1.t9 55.2719
R2887 A1.t10 A1.t0 55.2719
R2888 A1.n1 A1.t2 39.8898
R2889 A1.n1 A1.n0 35.1927
R2890 A1.n5 A1.t4 30.3125
R2891 A1.n0 A1.t7 30.2434
R2892 A1.n3 A1.t5 23.7255
R2893 A1.n4 A1.t10 23.7255
R2894 A1.n5 A1.t8 20.1446
R2895 A1.n6 A1.n2 18.5794
R2896 A1.n2 A1.t11 17.7883
R2897 A1.n6 A1.n5 12.5069
R2898 A1 A1.n6 1.87604
R2899 B3.n1 B3.t3 25.964
R2900 B3.n0 B3.t1 25.2616
R2901 B3.n0 B3.t0 24.4794
R2902 B3.n1 B3.t2 24.3998
R2903 B3.n2 B3.n1 9.39912
R2904 B3.n2 B3.n0 8.0005
R2905 B3 B3.n2 5.16907
R2906 B14.n1 B14.t1 25.964
R2907 B14.n0 B14.t3 25.2616
R2908 B14.n0 B14.t2 24.4794
R2909 B14.n1 B14.t0 24.3998
R2910 B14.n2 B14.n1 9.39912
R2911 B14.n2 B14.n0 8.0005
R2912 B14 B14.n2 5.16746
R2913 a_40765_17389.n1 a_40765_17389.t8 32.0712
R2914 a_40765_17389.n15 a_40765_17389.t16 28.0984
R2915 a_40765_17389.n14 a_40765_17389.t12 28.0984
R2916 a_40765_17389.n13 a_40765_17389.t5 28.0984
R2917 a_40765_17389.n12 a_40765_17389.t11 28.0984
R2918 a_40765_17389.n11 a_40765_17389.t3 28.0984
R2919 a_40765_17389.n10 a_40765_17389.t13 28.0984
R2920 a_40765_17389.n9 a_40765_17389.t9 28.0984
R2921 a_40765_17389.n8 a_40765_17389.t17 28.0984
R2922 a_40765_17389.n7 a_40765_17389.t7 28.0984
R2923 a_40765_17389.n6 a_40765_17389.t15 28.0984
R2924 a_40765_17389.n5 a_40765_17389.t6 28.0984
R2925 a_40765_17389.n4 a_40765_17389.t4 28.0984
R2926 a_40765_17389.n3 a_40765_17389.t14 28.0984
R2927 a_40765_17389.n2 a_40765_17389.t18 28.0984
R2928 a_40765_17389.n1 a_40765_17389.t10 28.0984
R2929 a_40765_17389.n16 a_40765_17389.n15 25.1275
R2930 a_40765_17389.t0 a_40765_17389.n16 11.766
R2931 a_40765_17389.n16 a_40765_17389.n0 6.42946
R2932 a_40765_17389.n0 a_40765_17389.t1 4.5505
R2933 a_40765_17389.n0 a_40765_17389.t2 4.5505
R2934 a_40765_17389.n2 a_40765_17389.n1 3.97336
R2935 a_40765_17389.n3 a_40765_17389.n2 3.97336
R2936 a_40765_17389.n4 a_40765_17389.n3 3.97336
R2937 a_40765_17389.n5 a_40765_17389.n4 3.97336
R2938 a_40765_17389.n6 a_40765_17389.n5 3.97336
R2939 a_40765_17389.n7 a_40765_17389.n6 3.97336
R2940 a_40765_17389.n8 a_40765_17389.n7 3.97336
R2941 a_40765_17389.n9 a_40765_17389.n8 3.97336
R2942 a_40765_17389.n10 a_40765_17389.n9 3.97336
R2943 a_40765_17389.n11 a_40765_17389.n10 3.97336
R2944 a_40765_17389.n12 a_40765_17389.n11 3.97336
R2945 a_40765_17389.n13 a_40765_17389.n12 3.97336
R2946 a_40765_17389.n14 a_40765_17389.n13 3.97336
R2947 a_40765_17389.n15 a_40765_17389.n14 3.97336
R2948 A6.n3 A6.t7 130.792
R2949 A6.n7 A6.t19 130.792
R2950 A6.t14 A6.n4 109.704
R2951 A6.t2 A6.n8 109.704
R2952 A6.n1 A6.t15 95.0309
R2953 A6.n0 A6.t8 90.0773
R2954 A6.n4 A6.n3 79.4894
R2955 A6.n8 A6.n7 79.4894
R2956 A6.t7 A6.t18 55.2719
R2957 A6.t16 A6.t3 55.2719
R2958 A6.t17 A6.t4 55.2719
R2959 A6.t19 A6.t0 55.2719
R2960 A6.t5 A6.t12 55.2719
R2961 A6.t6 A6.t13 55.2719
R2962 A6.n0 A6.t9 39.8898
R2963 A6.n5 A6.t14 30.3125
R2964 A6.n9 A6.t2 30.3125
R2965 A6.n1 A6.t10 30.2434
R2966 A6.n3 A6.t16 23.7255
R2967 A6.n4 A6.t17 23.7255
R2968 A6.n7 A6.t5 23.7255
R2969 A6.n8 A6.t6 23.7255
R2970 A6.n2 A6.n0 22.6927
R2971 A6.n5 A6.t1 20.1446
R2972 A6.n9 A6.t11 20.1446
R2973 A6.n6 A6.n5 12.5069
R2974 A6.n10 A6.n9 12.5069
R2975 A6.n2 A6.n1 12.5005
R2976 A6.n6 A6.n2 12.1682
R2977 A6 A6.n10 1.88407
R2978 A6.n10 A6.n6 1.54014
R2979 a_45737_18467.n0 a_45737_18467.t2 118.355
R2980 a_45737_18467.n1 a_45737_18467.n0 44.468
R2981 a_45737_18467.n0 a_45737_18467.t3 34.3245
R2982 a_45737_18467.n1 a_45737_18467.t1 11.6374
R2983 a_45737_18467.t0 a_45737_18467.n1 8.42385
R2984 a_55363_18700.n5 a_55363_18700.n4 144.379
R2985 a_55363_18700.n9 a_55363_18700.n8 144.379
R2986 a_55363_18700.n4 a_55363_18700.t11 114.743
R2987 a_55363_18700.n8 a_55363_18700.t19 114.743
R2988 a_55363_18700.t6 a_55363_18700.n5 96.8993
R2989 a_55363_18700.t10 a_55363_18700.n9 96.8993
R2990 a_55363_18700.n2 a_55363_18700.t13 77.6934
R2991 a_55363_18700.n1 a_55363_18700.t14 73.6523
R2992 a_55363_18700.n1 a_55363_18700.t18 56.3148
R2993 a_55363_18700.t11 a_55363_18700.t23 55.2719
R2994 a_55363_18700.t20 a_55363_18700.t9 55.2719
R2995 a_55363_18700.t15 a_55363_18700.t4 55.2719
R2996 a_55363_18700.t19 a_55363_18700.t12 55.2719
R2997 a_55363_18700.t5 a_55363_18700.t22 55.2719
R2998 a_55363_18700.t21 a_55363_18700.t16 55.2719
R2999 a_55363_18700.n2 a_55363_18700.t8 47.5809
R3000 a_55363_18700.n6 a_55363_18700.t17 31.048
R3001 a_55363_18700.n10 a_55363_18700.t7 31.048
R3002 a_55363_18700.n6 a_55363_18700.t6 20.8801
R3003 a_55363_18700.n10 a_55363_18700.t10 20.8801
R3004 a_55363_18700.n4 a_55363_18700.t20 19.0326
R3005 a_55363_18700.n5 a_55363_18700.t15 19.0326
R3006 a_55363_18700.n8 a_55363_18700.t5 19.0326
R3007 a_55363_18700.n9 a_55363_18700.t21 19.0326
R3008 a_55363_18700.n3 a_55363_18700.n2 17.9162
R3009 a_55363_18700.n3 a_55363_18700.n1 17.2783
R3010 a_55363_18700.n7 a_55363_18700.n6 12.5069
R3011 a_55363_18700.n11 a_55363_18700.n10 12.5069
R3012 a_55363_18700.n12 a_55363_18700.n0 6.77428
R3013 a_55363_18700.n7 a_55363_18700.n3 6.2731
R3014 a_55363_18700.n12 a_55363_18700.n11 5.45675
R3015 a_55363_18700.n13 a_55363_18700.n12 3.47716
R3016 a_55363_18700.n0 a_55363_18700.t3 2.2755
R3017 a_55363_18700.n0 a_55363_18700.t1 2.2755
R3018 a_55363_18700.n11 a_55363_18700.n7 1.54014
R3019 a_55363_18700.t0 a_55363_18700.n13 1.26439
R3020 a_55363_18700.n13 a_55363_18700.t2 1.26439
R3021 a_58097_18463.n0 a_58097_18463.t3 103.624
R3022 a_58097_18463.n0 a_58097_18463.t2 49.0549
R3023 a_58097_18463.n1 a_58097_18463.n0 45.2335
R3024 a_58097_18463.n1 a_58097_18463.t1 11.6374
R3025 a_58097_18463.t0 a_58097_18463.n1 8.42385
R3026 a_54744_14904.n0 a_54744_14904.t5 70.9148
R3027 a_54744_14904.n1 a_54744_14904.n0 60.141
R3028 a_54744_14904.n2 a_54744_14904.t3 53.9588
R3029 a_54744_14904.n0 a_54744_14904.t6 49.9273
R3030 a_54744_14904.n4 a_54744_14904.t4 49.438
R3031 a_54744_14904.t0 a_54744_14904.n4 46.6672
R3032 a_54744_14904.n2 a_54744_14904.t1 42.1463
R3033 a_54744_14904.n1 a_54744_14904.t2 29.3715
R3034 a_54744_14904.n4 a_54744_14904.n3 12.1623
R3035 a_54744_14904.n3 a_54744_14904.n2 5.72343
R3036 a_54744_14904.n3 a_54744_14904.n1 3.51812
R3037 B7.n1 B7.t3 25.964
R3038 B7.n0 B7.t1 25.2616
R3039 B7.n0 B7.t0 24.4794
R3040 B7.n1 B7.t2 24.3998
R3041 B7.n2 B7.n1 9.39912
R3042 B7.n2 B7.n0 8.0005
R3043 B7 B7.n2 5.16586
R3044 A13.n3 A13.t19 130.792
R3045 A13.n7 A13.t12 130.792
R3046 A13.t14 A13.n4 109.704
R3047 A13.t3 A13.n8 109.704
R3048 A13.n1 A13.t18 95.0309
R3049 A13.n0 A13.t6 90.0773
R3050 A13.n4 A13.n3 79.4894
R3051 A13.n8 A13.n7 79.4894
R3052 A13.t19 A13.t10 55.2719
R3053 A13.t15 A13.t4 55.2719
R3054 A13.t13 A13.t0 55.2719
R3055 A13.t12 A13.t17 55.2719
R3056 A13.t5 A13.t11 55.2719
R3057 A13.t1 A13.t7 55.2719
R3058 A13.n0 A13.t8 39.8898
R3059 A13.n5 A13.t14 30.3125
R3060 A13.n9 A13.t3 30.3125
R3061 A13.n1 A13.t16 30.2434
R3062 A13.n3 A13.t15 23.7255
R3063 A13.n4 A13.t13 23.7255
R3064 A13.n7 A13.t5 23.7255
R3065 A13.n8 A13.t1 23.7255
R3066 A13.n2 A13.n0 22.6927
R3067 A13.n5 A13.t2 20.1446
R3068 A13.n9 A13.t9 20.1446
R3069 A13.n6 A13.n5 12.5069
R3070 A13.n10 A13.n9 12.5069
R3071 A13.n2 A13.n1 12.5005
R3072 A13.n6 A13.n2 12.0868
R3073 A13 A13.n10 1.86157
R3074 A13.n10 A13.n6 1.54014
R3075 B8.n1 B8.t1 25.964
R3076 B8.n0 B8.t3 25.2616
R3077 B8.n0 B8.t2 24.4794
R3078 B8.n1 B8.t0 24.3998
R3079 B8.n2 B8.n1 9.39912
R3080 B8.n2 B8.n0 8.0005
R3081 B8 B8.n2 5.17711
R3082 a_72679_16527.n9 a_72679_16527.t9 63.412
R3083 a_72679_16527.n7 a_72679_16527.t12 36.3352
R3084 a_72679_16527.n5 a_72679_16527.t6 36.3352
R3085 a_72679_16527.n3 a_72679_16527.t2 36.3352
R3086 a_72679_16527.n10 a_72679_16527.n9 32.5783
R3087 a_72679_16527.n0 a_72679_16527.t5 31.8559
R3088 a_72679_16527.n1 a_72679_16527.t11 31.8559
R3089 a_72679_16527.n0 a_72679_16527.t8 29.9533
R3090 a_72679_16527.n1 a_72679_16527.t4 29.8229
R3091 a_72679_16527.n7 a_72679_16527.t7 28.0755
R3092 a_72679_16527.n5 a_72679_16527.t3 28.0755
R3093 a_72679_16527.n3 a_72679_16527.t10 28.0755
R3094 a_72679_16527.n9 a_72679_16527.t13 27.8969
R3095 a_72679_16527.n2 a_72679_16527.n1 19.9098
R3096 a_72679_16527.n8 a_72679_16527.n7 12.692
R3097 a_72679_16527.n6 a_72679_16527.n5 12.692
R3098 a_72679_16527.n4 a_72679_16527.n3 12.692
R3099 a_72679_16527.n11 a_72679_16527.t1 11.2468
R3100 a_72679_16527.n11 a_72679_16527.n10 9.56139
R3101 a_72679_16527.n2 a_72679_16527.n0 9.37014
R3102 a_72679_16527.t0 a_72679_16527.n11 4.61824
R3103 a_72679_16527.n6 a_72679_16527.n4 3.97336
R3104 a_72679_16527.n8 a_72679_16527.n6 3.97336
R3105 a_72679_16527.n4 a_72679_16527.n2 3.85282
R3106 a_72679_16527.n10 a_72679_16527.n8 1.53211
R3107 a_75403_18463.n0 a_75403_18463.t2 118.355
R3108 a_75403_18463.n1 a_75403_18463.n0 44.7128
R3109 a_75403_18463.n0 a_75403_18463.t3 34.3245
R3110 a_75403_18463.n1 a_75403_18463.t1 11.6374
R3111 a_75403_18463.t0 a_75403_18463.n1 8.42385
R3112 a_80345_18463.n0 a_80345_18463.t3 89.0244
R3113 a_80345_18463.n0 a_80345_18463.t2 63.6549
R3114 a_80345_18463.n1 a_80345_18463.n0 45.7649
R3115 a_80345_18463.n1 a_80345_18463.t1 11.6374
R3116 a_80345_18463.t0 a_80345_18463.n1 8.42385
R3117 a_74520_14904.n0 a_74520_14904.t5 100.076
R3118 a_74520_14904.n2 a_74520_14904.t3 53.9588
R3119 a_74520_14904.n4 a_74520_14904.t1 49.438
R3120 a_74520_14904.t0 a_74520_14904.n4 46.6672
R3121 a_74520_14904.n2 a_74520_14904.t2 42.1463
R3122 a_74520_14904.n1 a_74520_14904.n0 29.4944
R3123 a_74520_14904.n1 a_74520_14904.t4 29.2115
R3124 a_74520_14904.n0 a_74520_14904.t6 20.7664
R3125 a_74520_14904.n4 a_74520_14904.n3 12.1623
R3126 a_74520_14904.n3 a_74520_14904.n2 5.72343
R3127 a_74520_14904.n3 a_74520_14904.n1 3.67812
R3128 Y5.n0 Y5.t1 11.2005
R3129 Y5.n0 Y5.t0 8.87826
R3130 Y5 Y5.n0 4.70943
R3131 Y12.n0 Y12.t1 11.2005
R3132 Y12.n0 Y12.t0 8.87826
R3133 Y12 Y12.n0 4.70461
R3134 a_62691_16571.n0 a_62691_16571.t5 132.954
R3135 a_62691_16571.n1 a_62691_16571.n0 43.6211
R3136 a_62691_16571.n3 a_62691_16571.n2 20.1765
R3137 a_62691_16571.n0 a_62691_16571.t4 19.7245
R3138 a_62691_16571.t0 a_62691_16571.n3 12.856
R3139 a_62691_16571.n3 a_62691_16571.t3 11.4227
R3140 a_62691_16571.n1 a_62691_16571.t2 11.0614
R3141 a_62691_16571.n2 a_62691_16571.t1 8.34285
R3142 a_62691_16571.n2 a_62691_16571.n1 0.6575
R3143 a_50681_18467.n0 a_50681_18467.t2 89.0244
R3144 a_50681_18467.n0 a_50681_18467.t3 63.6549
R3145 a_50681_18467.n1 a_50681_18467.n0 45.5174
R3146 a_50681_18467.n1 a_50681_18467.t1 11.6374
R3147 a_50681_18467.t0 a_50681_18467.n1 8.42385
R3148 A15.n3 A15.t1 130.792
R3149 A15.n7 A15.t15 130.792
R3150 A15.t17 A15.n4 109.704
R3151 A15.t7 A15.n8 109.704
R3152 A15.n1 A15.t16 95.0309
R3153 A15.n0 A15.t4 90.0773
R3154 A15.n4 A15.n3 79.4894
R3155 A15.n8 A15.n7 79.4894
R3156 A15.t1 A15.t13 55.2719
R3157 A15.t11 A15.t2 55.2719
R3158 A15.t0 A15.t12 55.2719
R3159 A15.t15 A15.t19 55.2719
R3160 A15.t3 A15.t8 55.2719
R3161 A15.t14 A15.t18 55.2719
R3162 A15.n0 A15.t5 39.8898
R3163 A15.n5 A15.t17 30.3125
R3164 A15.n9 A15.t7 30.3125
R3165 A15.n1 A15.t9 30.2434
R3166 A15.n3 A15.t11 23.7255
R3167 A15.n4 A15.t0 23.7255
R3168 A15.n7 A15.t3 23.7255
R3169 A15.n8 A15.t14 23.7255
R3170 A15.n2 A15.n0 22.6927
R3171 A15.n5 A15.t6 20.1446
R3172 A15.n9 A15.t10 20.1446
R3173 A15.n6 A15.n5 12.5069
R3174 A15.n10 A15.n9 12.5069
R3175 A15.n2 A15.n1 12.5005
R3176 A15.n6 A15.n2 12.0872
R3177 A15 A15.n10 1.87282
R3178 A15.n10 A15.n6 1.54014
R3179 A7.n3 A7.t19 130.792
R3180 A7.n7 A7.t10 130.792
R3181 A7.t13 A7.n4 109.704
R3182 A7.t4 A7.n8 109.704
R3183 A7.n1 A7.t11 95.0309
R3184 A7.n0 A7.t15 90.0773
R3185 A7.n4 A7.n3 79.4894
R3186 A7.n8 A7.n7 79.4894
R3187 A7.t19 A7.t9 55.2719
R3188 A7.t6 A7.t16 55.2719
R3189 A7.t12 A7.t0 55.2719
R3190 A7.t10 A7.t14 55.2719
R3191 A7.t17 A7.t1 55.2719
R3192 A7.t2 A7.t7 55.2719
R3193 A7.n0 A7.t18 39.8898
R3194 A7.n5 A7.t13 30.3125
R3195 A7.n9 A7.t4 30.3125
R3196 A7.n1 A7.t5 30.2434
R3197 A7.n3 A7.t6 23.7255
R3198 A7.n4 A7.t12 23.7255
R3199 A7.n7 A7.t17 23.7255
R3200 A7.n8 A7.t2 23.7255
R3201 A7.n2 A7.n0 22.6927
R3202 A7.n5 A7.t3 20.1446
R3203 A7.n9 A7.t8 20.1446
R3204 A7.n6 A7.n5 12.5069
R3205 A7.n10 A7.n9 12.5069
R3206 A7.n2 A7.n1 12.5005
R3207 A7.n6 A7.n2 12.1682
R3208 A7 A7.n10 1.88246
R3209 A7.n10 A7.n6 1.54014
R3210 Y9.n0 Y9.t1 11.2005
R3211 Y9.n0 Y9.t0 8.87826
R3212 Y9 Y9.n0 4.70621
R3213 a_65513_18464.n0 a_65513_18464.t3 118.355
R3214 a_65513_18464.n1 a_65513_18464.n0 44.7096
R3215 a_65513_18464.n0 a_65513_18464.t2 34.3245
R3216 a_65513_18464.n1 a_65513_18464.t1 11.6374
R3217 a_65513_18464.t0 a_65513_18464.n1 8.42385
R3218 a_44856_14904.n1 a_44856_14904.n0 75.3628
R3219 a_44856_14904.n0 a_44856_14904.t6 64.5273
R3220 a_44856_14904.n0 a_44856_14904.t5 56.3148
R3221 a_44856_14904.n2 a_44856_14904.t2 53.9588
R3222 a_44856_14904.t0 a_44856_14904.n4 49.438
R3223 a_44856_14904.n4 a_44856_14904.t1 46.6672
R3224 a_44856_14904.n2 a_44856_14904.t4 42.1463
R3225 a_44856_14904.n1 a_44856_14904.t3 29.4108
R3226 a_44856_14904.n4 a_44856_14904.n3 12.1623
R3227 a_44856_14904.n3 a_44856_14904.n2 5.72343
R3228 a_44856_14904.n3 a_44856_14904.n1 3.47883
R3229 a_52371_19664.n5 a_52371_19664.t11 63.412
R3230 a_52371_19664.n3 a_52371_19664.t6 63.412
R3231 a_52371_19664.n1 a_52371_19664.t5 63.412
R3232 a_52371_19664.n7 a_52371_19664.t8 63.412
R3233 a_52371_19664.n8 a_52371_19664.t3 38.4559
R3234 a_52371_19664.n0 a_52371_19664.t12 31.8559
R3235 a_52371_19664.n0 a_52371_19664.t2 29.9533
R3236 a_52371_19664.n5 a_52371_19664.t4 27.8969
R3237 a_52371_19664.n3 a_52371_19664.t7 27.8969
R3238 a_52371_19664.n1 a_52371_19664.t9 27.8969
R3239 a_52371_19664.n7 a_52371_19664.t13 27.8969
R3240 a_52371_19664.n8 a_52371_19664.t10 27.2451
R3241 a_52371_19664.n6 a_52371_19664.n5 20.5415
R3242 a_52371_19664.n4 a_52371_19664.n3 20.5415
R3243 a_52371_19664.n2 a_52371_19664.n1 20.5415
R3244 a_52371_19664.n9 a_52371_19664.n7 16.3357
R3245 a_52371_19664.n10 a_52371_19664.n9 15.7987
R3246 a_52371_19664.n2 a_52371_19664.n0 13.4025
R3247 a_52371_19664.n9 a_52371_19664.n8 12.5005
R3248 a_52371_19664.n10 a_52371_19664.t1 11.1543
R3249 a_52371_19664.n9 a_52371_19664.n6 8.70479
R3250 a_52371_19664.t0 a_52371_19664.n10 8.13971
R3251 a_52371_19664.n4 a_52371_19664.n2 3.97336
R3252 a_52371_19664.n6 a_52371_19664.n4 3.97336
R3253 a_55620_18463.n0 a_55620_18463.t2 118.355
R3254 a_55620_18463.n1 a_55620_18463.n0 44.7161
R3255 a_55620_18463.n0 a_55620_18463.t3 34.3245
R3256 a_55620_18463.n1 a_55620_18463.t1 11.6374
R3257 a_55620_18463.t0 a_55620_18463.n1 8.42385
R3258 SEL1.n1 SEL1.t1 79.3048
R3259 SEL1.n4 SEL1.t2 73.0174
R3260 SEL1.n3 SEL1.t4 60.8476
R3261 SEL1.n0 SEL1.t3 59.2531
R3262 SEL1.n1 SEL1.t5 43.8476
R3263 SEL1.n4 SEL1.t6 42.2531
R3264 SEL1.n0 SEL1.t0 20.5077
R3265 SEL1.n5 SEL1.n4 17.0005
R3266 SEL1.n2 SEL1.n1 17.0005
R3267 SEL1.n2 SEL1.n0 1.02311
R3268 SEL1.n5 SEL1.n3 0.488326
R3269 SEL1.n3 SEL1.n2 0.419196
R3270 SEL1 SEL1.n5 0.1805
R3271 Y4.n0 Y4.t1 11.2005
R3272 Y4.n0 Y4.t0 8.87826
R3273 Y4 Y4.n0 4.71104
R3274 B0.n1 B0.t3 25.964
R3275 B0.n0 B0.t1 25.2616
R3276 B0.n0 B0.t0 24.4794
R3277 B0.n1 B0.t2 24.3998
R3278 B0.n2 B0.n1 9.39912
R3279 B0.n2 B0.n0 8.0005
R3280 B0 B0.n2 5.17389
R3281 Y3.n0 Y3.t1 11.2005
R3282 Y3.n0 Y3.t0 8.87826
R3283 Y3 Y3.n0 4.703
R3284 A4.n0 A4.t1 95.0309
R3285 A4.n1 A4.t3 90.0773
R3286 A4.n1 A4.t0 39.8898
R3287 A4.n0 A4.t2 30.2434
R3288 A4 A4.n2 20.6086
R3289 A4.n2 A4.n0 18.1927
R3290 A4.n2 A4.n1 17.0005
R3291 B13.n1 B13.t3 25.964
R3292 B13.n0 B13.t1 25.2616
R3293 B13.n0 B13.t0 24.4794
R3294 B13.n1 B13.t2 24.3998
R3295 B13.n2 B13.n1 9.39912
R3296 B13.n2 B13.n0 8.0005
R3297 B13 B13.n2 5.16264
R3298 Y2.n0 Y2.t1 11.2005
R3299 Y2.n0 Y2.t0 8.87826
R3300 Y2 Y2.n0 4.70782
R3301 a_43265_18467.n0 a_43265_18467.t3 132.954
R3302 a_43265_18467.n1 a_43265_18467.n0 43.9424
R3303 a_43265_18467.n0 a_43265_18467.t2 19.7245
R3304 a_43265_18467.n1 a_43265_18467.t1 11.6374
R3305 a_43265_18467.t0 a_43265_18467.n1 8.42385
R3306 Y14.n0 Y14.t1 11.2005
R3307 Y14.n0 Y14.t0 8.87826
R3308 Y14 Y14.n0 4.70621
R3309 Y13.n0 Y13.t1 11.2005
R3310 Y13.n0 Y13.t0 8.87826
R3311 Y13 Y13.n0 4.70461
R3312 a_60569_18463.n0 a_60569_18463.t2 89.0244
R3313 a_60569_18463.n0 a_60569_18463.t3 63.6549
R3314 a_60569_18463.n1 a_60569_18463.n0 45.5142
R3315 a_60569_18463.n1 a_60569_18463.t1 11.6374
R3316 a_60569_18463.t0 a_60569_18463.n1 8.42385
R3317 Z.n0 Z.t1 17.238
R3318 Z.n0 Z.t2 16.538
R3319 Z.n1 Z.t0 16.1005
R3320 Z.n1 Z.t4 10.413
R3321 Z.n2 Z.n0 7.75314
R3322 Z.n2 Z.n1 6.9294
R3323 Z Z.t3 4.18319
R3324 Z Z.n2 0.318772
R3325 Y1.n0 Y1.t1 11.2005
R3326 Y1.n0 Y1.t0 8.87826
R3327 Y1 Y1.n0 4.70943
R3328 Y8.n0 Y8.t1 11.2005
R3329 Y8.n0 Y8.t0 8.87826
R3330 Y8 Y8.n0 4.703
R3331 Y7.n0 Y7.t1 11.2005
R3332 Y7.n0 Y7.t0 8.87826
R3333 Y7 Y7.n0 4.69979
R3334 F.n4 F.t5 25.964
R3335 F.n3 F.t7 25.2616
R3336 F.n3 F.t6 24.4794
R3337 F.n4 F.t4 24.3998
R3338 F.n5 F.n4 9.39912
R3339 F.n2 F.n0 8.54153
R3340 F.n5 F.n3 8.0005
R3341 F F.n5 5.28639
R3342 F F.n2 5.11121
R3343 F.n2 F.n1 2.74451
R3344 F.n0 F.t1 2.2755
R3345 F.n0 F.t3 2.2755
R3346 F.n1 F.t0 1.26439
R3347 F.n1 F.t2 1.26439
R3348 B1.n1 B1.t1 25.964
R3349 B1.n0 B1.t3 25.2616
R3350 B1.n0 B1.t2 24.4794
R3351 B1.n1 B1.t0 24.3998
R3352 B1.n2 B1.n1 9.39912
R3353 B1.n2 B1.n0 8.0005
R3354 B1 B1.n2 5.16746
R3355 B2.n1 B2.t3 25.964
R3356 B2.n0 B2.t1 25.2616
R3357 B2.n0 B2.t0 24.4794
R3358 B2.n1 B2.t2 24.3998
R3359 B2.n2 B2.n1 9.39912
R3360 B2.n2 B2.n0 8.0005
R3361 B2 B2.n2 5.16264
R3362 Y15.n0 Y15.t2 34.6755
R3363 Y15.n1 Y15.t5 26.1878
R3364 Y15.n1 Y15.t4 24.6235
R3365 Y15.n4 Y15.n2 15.7216
R3366 Y15.n0 Y15.t3 14.3398
R3367 Y15.n3 Y15.t1 11.2005
R3368 Y15.n3 Y15.t0 8.87826
R3369 Y15.n2 Y15.n0 8.64267
R3370 Y15.n2 Y15.n1 8.0005
R3371 Y15.n4 Y15.n3 4.5005
R3372 Y15 Y15.n4 0.209429
R3373 N.n2 N.n1 6.77428
R3374 N N.n2 4.85407
R3375 N.n2 N.n0 3.47716
R3376 N.n1 N.t2 2.2755
R3377 N.n1 N.t0 2.2755
R3378 N.n0 N.t1 1.26439
R3379 N.n0 N.t3 1.26439
R3380 Y6.n0 Y6.t1 11.2005
R3381 Y6.n0 Y6.t0 8.87826
R3382 Y6 Y6.n0 4.69657
R3383 a_48209_18467.n0 a_48209_18467.t2 103.624
R3384 a_48209_18467.n0 a_48209_18467.t3 49.0549
R3385 a_48209_18467.n1 a_48209_18467.n0 44.9919
R3386 a_48209_18467.n1 a_48209_18467.t1 11.6374
R3387 a_48209_18467.t0 a_48209_18467.n1 8.42385
R3388 Y0.n0 Y0.t1 11.2005
R3389 Y0.n0 Y0.t0 8.87826
R3390 Y0 Y0.n0 4.70782
R3391 Y11.n0 Y11.t1 11.2005
R3392 Y11.n0 Y11.t0 8.87826
R3393 Y11 Y11.n0 4.70461
R3394 B6.n1 B6.t3 25.964
R3395 B6.n0 B6.t1 25.2616
R3396 B6.n0 B6.t0 24.4794
R3397 B6.n1 B6.t2 24.3998
R3398 B6.n2 B6.n1 9.39912
R3399 B6.n2 B6.n0 8.0005
R3400 B6 B6.n2 5.18032
R3401 Y10.n0 Y10.t1 11.2005
R3402 Y10.n0 Y10.t0 8.87826
R3403 Y10 Y10.n0 4.70461
C0 a_65611_19848# a_67203_19664# 0.1105f
C1 a_79563_18828# a_80347_18828# 0.41193f
C2 a_65610_17312# a_65908_17312# 1.31452f
C3 a_65963_16575# A9 0.43104f
C4 a_48511_17382# VDD 0.63029f
C5 a_45835_19848# a_45899_19664# 0.41628f
C6 a_69675_18828# a_71243_18828# 0.42094f
C7 a_80442_17311# a_80740_17311# 1.31425f
C8 a_60871_17378# VDD 0.62195f
C9 a_73778_17859# B12 0.44473f
C10 Y15 N 0.1355f
C11 a_75499_19104# a_77091_18828# 0.11759f
C12 a_77970_17311# VDD 0.70711f
C13 a_79995_16571# a_79563_18828# 0.21124f
C14 a_82973_18758# a_83272_18186# 0.27012f
C15 a_55431_16571# VDD 1.23757f
C16 a_75705_17378# A13 1.03722f
C17 VDD A2 1.7314f
C18 CIN A0 0.50148f
C19 a_77971_19848# A14 0.37597f
C20 a_73232_17378# a_72939_16571# 0.24633f
C21 a_59787_18828# VDD 0.44809f
C22 a_70555_19104# VDD 0.48761f
C23 a_83513_16859# F 0.13053f
C24 a_65908_17312# A9 0.43863f
C25 SEL1 SEL0 1.62576f
C26 a_54009_17863# VDD 0.73308f
C27 a_48659_16575# VDD 0.65532f
C28 a_77091_19664# a_78659_20124# 0.42094f
C29 a_69675_18828# a_70619_18828# 0.41865f
C30 a_61019_16575# VDD 0.63481f
C31 a_74195_20792# B12 0.12451f
C32 a_70555_19848# A11 0.37597f
C33 a_75705_17378# VDD 0.62867f
C34 a_82973_18758# a_83173_18758# 0.49569f
C35 a_52959_16571# VDD 1.23757f
C36 a_43363_19848# CIN 1.39817f
C37 a_55922_17378# A5 1.03692f
C38 a_75851_16575# A13 0.43097f
C39 a_77091_19664# A14 0.37602f
C40 a_58195_19104# VDD 0.486f
C41 a_73232_17378# a_72720_17312# 0.31223f
C42 a_69675_18828# VDD 0.44779f
C43 CIN A4 0.18728f
C44 VDD A12 0.75593f
C45 a_63344_17378# a_65611_19848# 1.38706f
C46 a_82467_19228# VDD 0.31651f
C47 a_65611_19848# A9 0.37597f
C48 a_65610_17312# A9 0.12171f
C49 a_54419_20792# VDD 0.48725f
C50 a_48604_17315# VDD 0.54465f
C51 a_77091_19664# a_78035_20124# 0.41865f
C52 a_60964_17311# VDD 0.54532f
C53 a_69675_19664# A11 0.37605f
C54 a_73232_17378# a_75499_19104# 1.44417f
C55 a_75851_16575# VDD 0.64083f
C56 a_72147_19664# VDD 0.74796f
C57 a_83049_16859# VDD 0.21767f
C58 a_56075_16575# A5 0.42698f
C59 a_75798_17311# A13 0.43856f
C60 a_56411_19664# VDD 0.23699f
C61 a_43715_16575# a_43567_17382# 0.37208f
C62 VDD B5 0.40182f
C63 CIN B3 0.67118f
C64 a_58195_19848# A6 0.37598f
C65 a_57315_18828# VDD 0.44779f
C66 a_53463_17382# a_52951_17316# 0.30307f
C67 a_68083_19104# VDD 0.486f
C68 a_82973_18758# VDD 0.27721f
C69 a_63344_17378# A9 0.37659f
C70 a_48306_17315# VDD 0.70087f
C71 VDD Y11 0.12877f
C72 a_77091_19664# a_77523_16571# 0.33618f
C73 a_60666_17311# VDD 0.70485f
C74 a_48211_19664# VDD 1.76201f
C75 a_75798_17311# VDD 0.54538f
C76 a_50779_19848# A3 0.38545f
C77 a_80963_16575# VDD 0.25453f
C78 a_56015_17311# A5 0.43796f
C79 a_75500_17311# A13 0.12171f
C80 a_55787_19664# VDD 0.18022f
C81 a_43660_17315# a_43567_17382# 0.33251f
C82 a_57315_19664# A6 0.37609f
C83 a_55723_19104# VDD 0.48604f
C84 a_67203_18828# VDD 0.44809f
C85 VDD A5 2.88417f
C86 B1 A1 0.15876f
C87 CIN A2 0.124f
C88 a_69251_20792# B10 0.12451f
C89 a_57315_18828# a_58883_18828# 0.42094f
C90 a_82035_18828# VDD 0.48483f
C91 a_57315_19664# a_58883_20124# 0.42094f
C92 a_46039_17382# VDD 0.63029f
C93 a_45835_19848# A1 0.38594f
C94 a_53556_17315# A4 0.22881f
C95 a_58399_17378# VDD 0.62884f
C96 a_65611_19848# a_66299_19664# 0.46435f
C97 a_75500_17311# VDD 0.70718f
C98 a_54009_17863# CIN 0.15686f
C99 a_49899_19664# A3 0.37478f
C100 a_78491_16575# VDD 0.24817f
C101 a_55717_17311# A5 0.12119f
C102 a_57747_16571# a_58099_18828# 1.02578f
C103 a_43362_17315# a_43567_17382# 0.25646f
C104 a_43660_17315# a_43715_16575# 0.31728f
C105 a_52854_18468# VDD 1.00299f
C106 a_65611_19104# VDD 0.486f
C107 a_57315_18828# a_58259_18828# 0.41865f
C108 a_80443_19104# VDD 0.48762f
C109 a_57315_19664# a_58259_20124# 0.41865f
C110 a_51947_20792# VDD 0.49477f
C111 a_46187_16575# VDD 0.65519f
C112 a_44955_19664# A1 0.3749f
C113 CIN A12 0.15248f
C114 VDD Y15 0.42262f
C115 a_58547_16575# VDD 0.64147f
C116 a_65611_19848# a_65675_19664# 0.41628f
C117 a_73325_17311# VDD 0.5372f
C118 a_76019_16575# VDD 0.248f
C119 a_43362_17315# a_43715_16575# 1.26717f
C120 a_63890_17859# B8 0.44473f
C121 a_72147_19664# CIN 0.1206f
C122 a_62735_18464# VDD 0.87917f
C123 CIN B5 0.67118f
C124 VDD B7 0.40188f
C125 a_59787_19664# a_60667_19848# 1.38653f
C126 a_77971_19104# VDD 0.486f
C127 a_57315_19664# a_57747_16571# 0.33618f
C128 a_46132_17315# VDD 0.54511f
C129 a_43363_19848# a_44051_19664# 0.46435f
C130 a_58492_17311# VDD 0.54496f
C131 a_72939_16571# VDD 0.90125f
C132 VDD Y13 0.12879f
C133 a_70107_16571# VDD 0.60567f
C134 a_73547_16575# VDD 0.24808f
C135 a_43362_17315# a_43660_17315# 1.31882f
C136 a_64307_20792# B8 0.12451f
C137 a_54009_17863# a_53556_17315# 0.11972f
C138 a_83173_19616# VDD 0.5013f
C139 a_79995_16571# a_80347_18828# 1.02578f
C140 a_63344_17378# a_63437_17311# 0.33305f
C141 a_77091_18828# VDD 0.44779f
C142 a_45834_17315# VDD 0.70087f
C143 a_75499_19104# A13 0.3823f
C144 a_43363_19848# a_43427_19664# 0.41628f
C145 CIN A5 0.10259f
C146 VDD A7 2.87744f
C147 B2 A2 0.15873f
C148 a_67203_18828# a_68771_18828# 0.42094f
C149 a_58194_17311# VDD 0.70706f
C150 a_72720_17312# VDD 0.90617f
C151 a_71075_16575# VDD 0.2481f
C152 a_80443_19104# A15 0.38214f
C153 a_51467_19664# VDD 0.23699f
C154 a_54009_17863# a_53163_16571# 0.22644f
C155 a_82467_19616# VDD 0.34165f
C156 a_58195_19848# a_59787_19664# 0.1105f
C157 a_63344_17378# a_63051_16571# 0.24596f
C158 a_75499_19104# VDD 0.48599f
C159 a_49475_20792# VDD 0.48725f
C160 a_53163_16571# a_52959_16571# 0.8564f
C161 a_43567_17382# VDD 0.63091f
C162 a_73232_17378# A13 0.38436f
C163 a_67203_18828# a_68147_18828# 0.41865f
C164 a_62832_17312# A8 0.45048f
C165 B4 A4 0.15949f
C166 VDD Y1 0.12331f
C167 a_68603_16575# VDD 0.2481f
C168 a_50843_19664# VDD 0.18022f
C169 a_73232_17378# VDD 1.00371f
C170 a_43715_16575# VDD 0.65307f
C171 a_44067_20792# B0 0.22775f
C172 a_72623_18464# a_76187_20124# 0.42099f
C173 CIN B7 0.67118f
C174 VDD B9 0.40243f
C175 a_59363_20792# B6 0.12451f
C176 a_45739_19664# VDD 1.76482f
C177 a_66131_16575# VDD 0.24818f
C178 a_65163_16571# a_62735_18464# 0.13113f
C179 a_81131_19664# VDD 0.23699f
C180 a_57315_19664# a_58195_19848# 1.38653f
C181 a_80347_18828# a_80151_16571# 0.80172f
C182 a_43660_17315# VDD 0.54509f
C183 a_52951_17316# A4 0.33933f
C184 a_72623_18464# a_75563_20124# 0.41903f
C185 a_63659_16575# VDD 0.24808f
C186 VDD A10 2.88291f
C187 B3 A3 0.15873f
C188 CIN A7 0.10259f
C189 a_80507_19664# VDD 0.18022f
C190 a_63890_17859# a_63437_17311# 0.11367f
C191 a_56075_16575# a_55922_17378# 0.35887f
C192 a_70459_18828# a_70263_16571# 0.80172f
C193 a_52854_18468# a_56411_18828# 0.42094f
C194 a_54009_17863# B4 0.44466f
C195 a_47003_20792# VDD 0.48725f
C196 a_43362_17315# VDD 0.69782f
C197 a_72623_18464# a_75051_16571# 0.40701f
C198 a_48211_19664# A1 0.10022f
C199 a_60667_19848# a_61355_19664# 0.46435f
C200 a_52854_18468# a_53163_16571# 0.34485f
C201 a_46355_16575# Y1 0.14493f
C202 a_73778_17859# A12 1.72926f
C203 a_61187_16575# VDD 0.2482f
C204 a_46539_20792# B1 0.22775f
C205 a_64307_20792# a_63890_17859# 0.18943f
C206 a_63890_17859# a_63051_16571# 0.21755f
C207 a_56015_17311# a_55922_17378# 0.33254f
C208 a_55723_19848# a_57315_19664# 0.1105f
C209 a_52854_18468# a_55787_18828# 0.41865f
C210 a_60667_19104# a_61355_19216# 0.46435f
C211 a_63051_16571# a_63437_17311# 1.43026f
C212 a_46039_17382# A1 1.02327f
C213 a_54419_20792# B4 0.12451f
C214 a_53463_17382# a_56411_20124# 0.42094f
C215 a_83272_18186# VDD 0.47368f
C216 a_55922_17378# VDD 0.62954f
C217 a_60667_19848# a_60731_19664# 0.41628f
C218 a_67635_16571# VDD 0.60848f
C219 a_58715_16575# VDD 0.24817f
C220 CIN B9 0.67118f
C221 VDD B11 0.40182f
C222 a_48995_19664# VDD 0.23699f
C223 a_54009_17863# a_52951_17316# 1.32048f
C224 a_60571_18828# a_60375_16571# 0.80172f
C225 a_51483_20792# B3 0.22775f
C226 a_56015_17311# a_56075_16575# 0.31627f
C227 a_55717_17311# a_55922_17378# 0.25639f
C228 a_60667_19104# a_60731_19216# 0.41628f
C229 a_46187_16575# A1 0.37126f
C230 a_53463_17382# a_55787_20124# 0.41865f
C231 a_56075_16575# VDD 0.64186f
C232 a_77091_18828# a_78659_18828# 0.42094f
C233 a_56243_16575# VDD 0.24835f
C234 a_72623_18464# A12 0.17877f
C235 a_48371_19664# VDD 0.18022f
C236 CIN A10 0.10259f
C237 VDD A13 2.88314f
C238 a_55717_17311# a_56075_16575# 1.26555f
C239 a_53463_17382# a_55723_19848# 1.3865f
C240 a_46132_17315# A1 0.27643f
C241 a_53463_17382# a_55275_16571# 0.2856f
C242 a_44531_20792# VDD 0.49477f
C243 a_56427_20792# B5 0.22775f
C244 a_62735_18464# a_66299_18828# 0.42094f
C245 a_56015_17311# VDD 0.54593f
C246 a_77091_18828# a_78035_18828# 0.41865f
C247 a_53771_16575# VDD 0.24759f
C248 a_49475_20792# B2 0.12451f
C249 a_78659_19664# VDD 0.23699f
C250 a_72147_19664# a_73285_19138# 0.12184f
C251 a_55717_17311# a_56015_17311# 1.31458f
C252 a_83049_16859# F 0.23287f
C253 a_59787_18828# a_60571_18828# 0.40709f
C254 a_73778_17859# a_73325_17311# 0.11326f
C255 a_53771_16575# Y4 0.14493f
C256 a_62735_18464# A8 0.2184f
C257 B13 A13 0.1583f
C258 VDD Y4 0.1287f
C259 a_70555_19848# a_72147_19664# 0.11174f
C260 a_62735_18464# a_65675_18828# 0.41865f
C261 a_70555_19104# a_71243_19216# 0.46435f
C262 a_55717_17311# VDD 0.70822f
C263 a_43267_19664# VDD 1.69876f
C264 a_61371_20792# B7 0.22775f
C265 a_79563_19664# a_82467_19616# 0.14643f
C266 a_51299_16575# VDD 0.24805f
C267 a_78035_19664# VDD 0.18022f
C268 VDD B13 0.40188f
C269 CIN B11 0.67118f
C270 a_73778_17859# a_72939_16571# 0.21857f
C271 a_81147_20792# VDD 0.21882f
C272 a_81611_20792# VDD 0.49421f
C273 a_70555_19104# a_70619_19216# 0.41628f
C274 a_58195_19104# A6 0.38254f
C275 a_58715_16575# Y6 0.14493f
C276 a_52854_18468# a_52951_17316# 0.37641f
C277 a_80443_19848# a_81131_19664# 0.46435f
C278 a_48827_16575# VDD 0.24486f
C279 a_55275_16571# a_55627_18828# 1.02578f
C280 a_44051_20124# CIN 0.42478f
C281 a_66315_20792# B9 0.22775f
C282 a_73778_17859# a_72720_17312# 1.29808f
C283 a_63344_17378# a_62832_17312# 0.31283f
C284 a_77875_18828# a_77679_16571# 0.80172f
C285 a_78675_20792# VDD 0.2187f
C286 CIN A13 0.10259f
C287 VDD A15 2.88849f
C288 a_57315_18828# A6 0.38587f
C289 a_80443_19848# a_80507_19664# 0.41628f
C290 a_46355_16575# VDD 0.24486f
C291 a_63659_16575# Y8 0.14493f
C292 a_46523_19664# VDD 0.23699f
C293 a_82708_14862# VDD 0.10379f
C294 F Y15 0.64649f
C295 a_43427_20124# CIN 0.42404f
C296 a_67987_18828# a_67791_16571# 0.80172f
C297 VDD CIN 5.47307f
C298 a_49899_19664# a_50779_19848# 1.38653f
C299 a_79563_18828# a_80443_19104# 1.45834f
C300 a_71259_20792# B11 0.22775f
C301 a_72623_18464# a_72939_16571# 0.29583f
C302 a_76203_20792# VDD 0.22088f
C303 a_69675_19664# a_71243_20124# 0.42094f
C304 a_69675_18828# a_70459_18828# 0.40709f
C305 a_58195_19848# a_58883_19664# 0.46435f
C306 B14 A14 0.1583f
C307 VDD Y6 0.12853f
C308 a_65163_16571# VDD 0.59574f
C309 a_82973_18758# a_83173_19138# 0.11907f
C310 a_43883_16575# VDD 0.24486f
C311 a_45899_19664# VDD 0.18022f
C312 a_43267_19664# CIN 0.29354f
C313 a_58399_17378# A6 1.03578f
C314 a_68603_16575# Y10 0.14493f
C315 a_79563_18828# a_77971_19104# 0.1206f
C316 a_82035_19664# a_82973_18758# 0.20593f
C317 a_77523_16571# a_77875_18828# 1.02578f
C318 a_73731_20792# VDD 0.22074f
C319 a_72623_18464# a_72720_17312# 0.35681f
C320 CIN B13 0.67118f
C321 VDD B15 0.37886f
C322 a_69675_19664# a_70619_20124# 0.41865f
C323 a_79139_20792# VDD 0.48725f
C324 a_58195_19848# a_58259_19664# 0.41628f
C325 a_76203_20792# B13 0.22775f
C326 a_81147_20792# CIN 0.39689f
C327 a_83513_17431# VDD 0.21564f
C328 a_79563_18828# a_83173_19616# 0.12743f
C329 a_76187_19664# VDD 0.23699f
C330 a_58099_18828# a_57903_16571# 0.80172f
C331 a_58547_16575# A6 0.42554f
C332 a_48307_19848# a_49899_19664# 0.1105f
C333 a_58195_19104# a_58883_19216# 0.46435f
C334 a_82035_19664# a_82035_18828# 0.14029f
C335 a_71259_20792# VDD 0.2187f
C336 a_69675_19664# a_70107_16571# 0.33618f
C337 a_73547_16575# Y12 0.14493f
C338 a_63051_16571# a_62847_16571# 0.85663f
C339 a_53556_17315# VDD 0.54477f
C340 a_68288_17379# A10 1.03714f
C341 a_70760_17379# VDD 0.62198f
C342 a_78675_20792# CIN 0.39689f
C343 VDD SEL0 0.62069f
C344 a_73232_17378# a_76187_18828# 0.42094f
C345 a_81147_20792# B15 0.22775f
C346 a_72623_18464# a_73232_17378# 1.27942f
C347 a_75563_19664# VDD 0.18022f
C348 a_58492_17311# A6 0.4349f
C349 a_81611_20792# B15 0.12451f
C350 a_63890_17859# a_62832_17312# 1.30235f
C351 a_58195_19104# a_58259_19216# 0.41628f
C352 a_62832_17312# a_63437_17311# 0.33254f
C353 a_49899_19664# a_51467_20124# 0.42094f
C354 a_68787_20792# VDD 0.22088f
C355 VDD B2 0.40165f
C356 a_53163_16571# VDD 0.88713f
C357 a_68435_16575# A10 0.4304f
C358 a_80443_19848# VDD 0.49229f
C359 a_70907_16575# VDD 0.63453f
C360 a_76203_20792# CIN 0.39689f
C361 a_55275_16571# A4 1.00993f
C362 a_62259_19664# VDD 0.68831f
C363 a_73232_17378# a_75563_18828# 0.41865f
C364 a_78491_16575# Y14 0.14493f
C365 a_82973_19616# a_83173_19616# 0.11907f
C366 B15 A15 0.1583f
C367 VDD Y8 0.12855f
C368 a_58194_17311# A6 0.11857f
C369 a_78175_17378# A14 1.03738f
C370 a_47427_19664# a_48307_19848# 1.38653f
C371 a_70555_19104# A11 0.38223f
C372 a_62832_17312# a_63051_16571# 1.44209f
C373 a_49899_19664# a_50843_20124# 0.41865f
C374 a_66315_20792# VDD 0.21882f
C375 F N 0.44449f
C376 a_76667_20792# VDD 0.48725f
C377 a_68381_17312# A10 0.43814f
C378 a_53463_17382# A4 1.43694f
C379 a_79563_19664# VDD 0.83405f
C380 a_70853_17312# VDD 0.54554f
C381 a_73731_20792# CIN 0.39689f
C382 a_80443_19104# a_81131_19216# 0.46435f
C383 B0 A0 0.15876f
C384 VDD A1 1.73395f
C385 CIN B15 0.66901f
C386 a_44051_19664# VDD 0.23699f
C387 a_65611_19104# A9 0.38219f
C388 a_78323_16575# A14 0.43092f
C389 a_70107_16571# a_70459_18828# 1.02578f
C390 a_57315_18828# a_58099_18828# 0.40709f
C391 a_69675_18828# A11 0.38493f
C392 a_49899_19664# a_50683_19664# 0.33717f
C393 a_63843_20792# VDD 0.22062f
C394 a_68083_19104# a_68771_19216# 0.46435f
C395 a_68083_17312# A10 0.12129f
C396 a_77971_19848# VDD 0.49025f
C397 a_70555_17312# VDD 0.70523f
C398 a_71259_20792# CIN 0.39689f
C399 a_77971_19848# a_78659_19664# 0.46435f
C400 a_80443_19104# a_80507_19216# 0.41628f
C401 a_76667_20792# B13 0.12451f
C402 a_63344_17378# a_62735_18464# 1.62311f
C403 a_43427_19664# VDD 0.18022f
C404 a_62735_18464# A9 0.38517f
C405 VDD A8 0.73495f
C406 a_78268_17311# A14 0.43896f
C407 a_80443_19848# A15 0.37597f
C408 a_45835_19848# a_47427_19664# 0.1105f
C409 a_75403_18828# a_75207_16571# 0.80172f
C410 a_83137_17311# a_83272_18186# 1.12733f
C411 a_61371_20792# VDD 0.22088f
C412 a_73778_17859# VDD 0.65843f
C413 a_68083_19104# a_68147_19216# 0.41628f
C414 a_77091_19664# VDD 0.42071f
C415 a_68288_17379# VDD 0.62893f
C416 a_68787_20792# CIN 0.39689f
C417 a_77971_19848# a_78035_19664# 0.41628f
C418 VDD B4 0.40433f
C419 CIN B2 0.67118f
C420 a_75499_19848# A13 0.37597f
C421 a_83272_18186# F 0.21443f
C422 a_71243_19664# VDD 0.23699f
C423 a_62259_19664# CIN 0.11994f
C424 a_77970_17311# A14 0.12265f
C425 a_54009_17863# a_53463_17382# 0.10695f
C426 a_63397_19138# VDD 0.5013f
C427 a_65515_18828# a_65319_16571# 0.80172f
C428 a_79563_19664# A15 0.42478f
C429 a_83272_18186# a_83049_17431# 0.44473f
C430 B12 A12 0.15966f
C431 VDD Y10 0.12856f
C432 a_58899_20792# VDD 0.21882f
C433 a_74195_20792# VDD 0.49477f
C434 a_68083_19848# A10 0.37597f
C435 a_55723_19848# a_56411_19664# 0.46435f
C436 a_75499_19848# VDD 0.49025f
C437 a_68435_16575# VDD 0.6413f
C438 a_66315_20792# CIN 0.39689f
C439 a_60219_16571# VDD 0.60828f
C440 a_72623_18464# A13 0.3763f
C441 a_79563_19664# CIN 0.20976f
C442 a_70619_19664# VDD 0.18022f
C443 CIN A1 0.12503f
C444 VDD A3 1.73808f
C445 a_60667_19848# A7 0.37598f
C446 a_44955_19664# a_45835_19848# 1.38653f
C447 a_56427_20792# VDD 0.2187f
C448 a_71723_20792# B11 0.12451f
C449 a_67203_19664# a_68771_20124# 0.42094f
C450 a_67203_18828# a_67987_18828# 0.40709f
C451 a_52951_17316# VDD 0.92546f
C452 a_67203_19664# A10 0.37605f
C453 a_55723_19848# a_55787_19664# 0.41628f
C454 a_72623_18464# VDD 0.80653f
C455 a_68381_17312# VDD 0.54518f
C456 a_63843_20792# CIN 0.39689f
C457 a_83137_17311# VDD 0.69682f
C458 a_55723_19848# A5 0.37597f
C459 a_55627_18828# a_55431_16571# 0.80172f
C460 a_61355_19216# VDD 0.23699f
C461 a_53163_16571# a_53556_17315# 1.42941f
C462 a_59787_19664# A7 0.37608f
C463 a_73285_19138# VDD 0.5013f
C464 B9 A9 0.1583f
C465 CIN A8 0.15195f
C466 VDD F 0.50324f
C467 a_53955_20792# VDD 0.22274f
C468 a_70907_16575# a_70760_17379# 0.35842f
C469 a_67203_19664# a_68147_20124# 0.41865f
C470 a_50983_17382# VDD 0.62885f
C471 a_48307_19848# A2 0.38524f
C472 a_70555_19848# VDD 0.49288f
C473 a_68083_17312# VDD 0.70762f
C474 a_61371_20792# CIN 0.39689f
C475 a_63890_17859# a_62735_18464# 0.50431f
C476 a_83049_17431# VDD 0.26162f
C477 a_73778_17859# CIN 0.15855f
C478 a_79563_18828# VDD 1.18496f
C479 a_53463_17382# A5 0.37553f
C480 a_60731_19216# VDD 0.18087f
C481 CIN B4 0.67118f
C482 VDD B6 0.40243f
C483 a_43363_19848# a_44955_19664# 0.1105f
C484 a_62259_18828# a_62691_19228# 0.14043f
C485 a_55723_19104# a_56411_19216# 0.46435f
C486 a_43363_19848# A0 0.38634f
C487 a_51483_20792# VDD 0.21882f
C488 a_70853_17312# a_70760_17379# 0.33244f
C489 a_67203_19664# a_67635_16571# 0.33618f
C490 a_71723_20792# VDD 0.48725f
C491 a_78323_16575# a_78175_17378# 0.35882f
C492 a_51131_16575# VDD 0.64903f
C493 a_47427_19664# A2 0.37477f
C494 VDD Y12 0.12856f
C495 a_69675_19664# VDD 0.42071f
C496 a_65815_17379# VDD 0.62915f
C497 a_58899_20792# CIN 0.39689f
C498 a_53463_17382# a_52854_18468# 1.42878f
C499 a_80647_17378# VDD 0.63507f
C500 a_62735_18464# a_63051_16571# 0.30005f
C501 a_60571_18828# VDD 0.24822f
C502 a_66779_20792# B9 0.12451f
C503 a_55723_19104# a_55787_19216# 0.41628f
C504 a_71243_19216# VDD 0.23699f
C505 a_47427_19664# a_48995_20124# 0.42094f
C506 a_79563_19664# a_80443_19848# 1.44243f
C507 a_49011_20792# VDD 0.2187f
C508 a_79563_18828# a_81131_18828# 0.42094f
C509 a_70555_17312# a_70760_17379# 0.25634f
C510 a_70853_17312# a_70907_16575# 0.31568f
C511 VDD A6 2.88258f
C512 CIN A3 0.12419f
C513 a_51076_17315# VDD 0.54511f
C514 a_78268_17311# a_78175_17378# 0.33245f
C515 a_68083_19848# VDD 0.49025f
C516 a_65963_16575# VDD 0.64129f
C517 a_56427_20792# CIN 0.39689f
C518 a_77971_19104# a_78659_19216# 0.46435f
C519 a_80795_16575# VDD 0.64366f
C520 a_82973_19616# VDD 0.27163f
C521 a_68771_19664# VDD 0.23699f
C522 a_70619_19216# VDD 0.18087f
C523 a_47427_19664# a_48371_20124# 0.41865f
C524 a_46539_20792# VDD 0.22088f
C525 a_79563_18828# a_80507_18828# 0.41865f
C526 a_70555_17312# a_70907_16575# 1.26473f
C527 a_83173_19138# VDD 0.5013f
C528 a_79563_18828# A15 0.43912f
C529 a_78268_17311# a_78323_16575# 0.31582f
C530 a_50778_17315# VDD 0.70108f
C531 a_77970_17311# a_78175_17378# 0.25632f
C532 a_67203_19664# VDD 0.42139f
C533 a_65908_17312# VDD 0.54577f
C534 VDD Y0 0.12311f
C535 B10 A10 0.1583f
C536 a_53955_20792# CIN 0.39689f
C537 a_77971_19104# A14 0.3821f
C538 a_75499_19848# a_76187_19664# 0.46435f
C539 a_77971_19104# a_78035_19216# 0.41628f
C540 a_80740_17311# VDD 0.54542f
C541 a_82035_19664# VDD 0.69955f
C542 a_62259_19664# A8 0.18501f
C543 a_68147_19664# VDD 0.18022f
C544 a_83513_16859# N 0.18932f
C545 a_52854_18468# a_55627_18828# 0.37698f
C546 a_75051_16571# a_75403_18828# 1.02578f
C547 a_60667_19104# a_62259_18828# 0.12461f
C548 a_70459_18828# VDD 0.2484f
C549 a_80647_17378# A15 1.03727f
C550 a_77971_19848# a_79563_19664# 0.11668f
C551 a_47427_19664# a_48211_19664# 0.33717f
C552 a_44067_20792# VDD 0.21722f
C553 a_70555_17312# a_70853_17312# 1.3145f
C554 VDD B8 0.40428f
C555 CIN B6 0.67118f
C556 a_69251_20792# VDD 0.48725f
C557 a_65611_19104# a_66299_19216# 0.46435f
C558 a_72147_18828# a_72579_19228# 0.14043f
C559 a_77970_17311# a_78323_16575# 1.26465f
C560 a_65611_19848# VDD 0.49025f
C561 a_65610_17312# VDD 0.70782f
C562 a_51483_20792# CIN 0.39689f
C563 a_77091_18828# A14 0.38457f
C564 a_75499_19848# a_75563_19664# 0.41628f
C565 a_57747_16571# VDD 0.60945f
C566 a_80442_17311# VDD 0.70735f
C567 a_61835_20792# B7 0.12451f
C568 VDD Y14 0.12853f
C569 a_62259_19664# a_63397_19138# 0.11894f
C570 a_52951_17316# a_53556_17315# 0.33452f
C571 a_83513_17431# F 0.22418f
C572 a_80795_16575# A15 0.43032f
C573 a_81131_19216# VDD 0.23699f
C574 a_54009_17863# A4 1.59247f
C575 a_65611_19104# a_65675_19216# 0.41628f
C576 a_77970_17311# a_78268_17311# 1.31422f
C577 a_50779_19848# a_51467_19664# 0.46435f
C578 a_63344_17378# VDD 1.12939f
C579 a_72939_16571# a_72735_16571# 0.85663f
C580 a_49011_20792# CIN 0.39689f
C581 CIN A6 0.10259f
C582 VDD A9 2.88301f
C583 a_77091_18828# a_77875_18828# 0.40667f
C584 a_58883_19216# VDD 0.23699f
C585 a_52951_17316# a_53163_16571# 1.47127f
C586 a_59787_18828# a_60667_19104# 1.44423f
C587 a_80740_17311# A15 0.43862f
C588 a_77091_19664# a_77971_19848# 1.38653f
C589 a_80507_19216# VDD 0.18087f
C590 a_48511_17382# A2 1.02513f
C591 a_70555_19104# a_72147_18828# 0.12461f
C592 a_50779_19848# a_50843_19664# 0.41628f
C593 a_60667_19848# VDD 0.49288f
C594 a_46539_20792# CIN 0.39689f
C595 VDD Y2 0.12311f
C596 B11 A11 0.1583f
C597 a_48659_16575# a_48511_17382# 0.35879f
C598 a_58259_19216# VDD 0.18087f
C599 a_61019_16575# a_60871_17378# 0.35842f
C600 a_80442_17311# A15 0.12223f
C601 a_80347_18828# VDD 0.24838f
C602 a_63344_17378# a_66299_20124# 0.42101f
C603 a_62735_18464# a_65515_18828# 0.37714f
C604 a_48659_16575# A2 0.36842f
C605 a_66779_20792# VDD 0.49477f
C606 a_56891_20792# B5 0.12451f
C607 a_43883_16575# Y0 0.14493f
C608 a_59787_19664# VDD 0.42139f
C609 a_44067_20792# CIN 0.39772f
C610 CIN B8 0.67118f
C611 VDD B10 0.40188f
C612 a_79995_16571# VDD 0.57899f
C613 a_66299_19664# VDD 0.23699f
C614 a_48604_17315# a_48511_17382# 0.33262f
C615 a_74195_20792# a_73778_17859# 0.18943f
C616 a_67635_16571# a_67987_18828# 1.02578f
C617 a_58099_18828# VDD 0.24815f
C618 VDD Z 0.39535f
C619 a_58195_19104# a_59787_18828# 0.11759f
C620 a_60964_17311# a_60871_17378# 0.33245f
C621 a_68771_19216# VDD 0.23699f
C622 a_75499_19848# a_77091_19664# 0.1105f
C623 a_68435_16575# a_68288_17379# 0.35882f
C624 a_63344_17378# a_65675_20124# 0.41891f
C625 a_69675_18828# a_70555_19104# 1.44423f
C626 a_48604_17315# A2 0.28264f
C627 a_79563_19664# a_79563_18828# 0.7306f
C628 a_58195_19848# VDD 0.49025f
C629 a_48827_16575# Y2 0.14493f
C630 a_83513_16859# VDD 0.4851f
C631 a_63344_17378# CIN 0.11658f
C632 a_54419_20792# a_54009_17863# 0.18943f
C633 a_49011_20792# B2 0.22775f
C634 a_48604_17315# a_48659_16575# 0.31584f
C635 a_65675_19664# VDD 0.18022f
C636 a_48306_17315# a_48511_17382# 0.2566f
C637 CIN A9 0.10259f
C638 VDD A11 2.87759f
C639 a_52854_18468# A4 0.44948f
C640 a_73778_17859# a_72623_18464# 0.46871f
C641 a_60666_17311# a_60871_17378# 0.25632f
C642 a_68147_19216# VDD 0.18087f
C643 a_60964_17311# a_61019_16575# 0.31555f
C644 a_68381_17312# a_68288_17379# 0.33244f
C645 a_63344_17378# a_65163_16571# 0.35625f
C646 a_63890_17859# VDD 0.65821f
C647 a_75851_16575# a_75705_17378# 0.35882f
C648 a_57315_19664# VDD 0.42071f
C649 a_63437_17311# VDD 0.53715f
C650 a_48306_17315# a_48659_16575# 1.26669f
C651 a_72147_19664# A12 0.18494f
C652 a_51947_20792# B3 0.12451f
C653 a_57315_18828# a_58195_19104# 1.44423f
C654 a_67987_18828# VDD 0.24831f
C655 a_60666_17311# a_61019_16575# 1.26666f
C656 VDD Y3 0.12876f
C657 a_53955_20792# B4 0.22775f
C658 a_44955_19664# a_46523_20124# 0.42094f
C659 a_72623_18464# a_75499_19848# 1.38684f
C660 a_68083_17312# a_68288_17379# 0.25634f
C661 a_68381_17312# a_68435_16575# 0.31594f
C662 a_68083_19104# a_69675_18828# 0.11759f
C663 a_64307_20792# VDD 0.48725f
C664 a_75798_17311# a_75705_17378# 0.33245f
C665 a_80443_19848# a_82035_19664# 0.11799f
C666 a_55723_19848# VDD 0.49025f
C667 a_63051_16571# VDD 0.89895f
C668 a_70555_19848# a_71243_19664# 0.46435f
C669 a_55275_16571# VDD 0.57296f
C670 a_75499_19104# a_76187_19216# 0.46435f
C671 a_62735_18464# a_62832_17312# 0.36233f
C672 a_80151_16571# VDD 1.23757f
C673 a_48306_17315# a_48604_17315# 1.31882f
C674 CIN B10 0.67118f
C675 VDD B12 0.40489f
C676 a_51299_16575# Y3 0.14493f
C677 a_43567_17382# A0 1.02319f
C678 a_60666_17311# a_60964_17311# 1.31457f
C679 a_44955_19664# a_45899_20124# 0.41865f
C680 a_68083_17312# a_68435_16575# 1.26536f
C681 a_78659_19216# VDD 0.23699f
C682 a_75798_17311# a_75851_16575# 0.31577f
C683 a_75500_17311# a_75705_17378# 0.25635f
C684 a_54009_17863# a_52854_18468# 0.54103f
C685 a_58899_20792# B6 0.22775f
C686 a_79563_19664# a_82035_19664# 0.19254f
C687 a_53463_17382# VDD 1.18891f
C688 a_50983_17382# A3 1.02497f
C689 a_70555_19848# a_70619_19664# 0.41628f
C690 a_75499_19104# a_75563_19216# 0.41628f
C691 a_82035_18828# a_82467_19228# 0.13976f
C692 a_77679_16571# VDD 1.23757f
C693 a_56411_19216# VDD 0.23699f
C694 a_43715_16575# A0 0.36841f
C695 a_55723_19104# a_57315_18828# 0.11759f
C696 a_83137_17311# F 0.34454f
C697 VDD A14 2.88293f
C698 B5 A5 0.1583f
C699 CIN A11 0.10259f
C700 a_44955_19664# a_45739_19664# 0.33717f
C701 a_78035_19216# VDD 0.18087f
C702 a_68083_17312# a_68381_17312# 1.31455f
C703 a_45739_19664# A0 0.10199f
C704 a_56243_16575# Y5 0.14493f
C705 a_63344_17378# a_62259_19664# 0.31821f
C706 a_67203_18828# a_68083_19104# 1.44423f
C707 a_75500_17311# a_75851_16575# 1.2651f
C708 a_44531_20792# B0 0.12451f
C709 a_48307_19848# a_48995_19664# 0.46435f
C710 a_50779_19848# VDD 0.48981f
C711 a_51131_16575# A3 0.37531f
C712 a_60667_19104# A7 0.38244f
C713 a_83137_17311# a_83049_17431# 0.25356f
C714 a_63890_17859# CIN 0.15803f
C715 a_75207_16571# VDD 1.23757f
C716 a_47003_20792# B1 0.12451f
C717 a_63843_20792# B8 0.22775f
C718 a_60219_16571# a_60571_18828# 1.02578f
C719 a_73325_17311# A12 0.46974f
C720 a_61355_19664# VDD 0.23699f
C721 VDD B0 0.40202f
C722 a_55787_19216# VDD 0.18109f
C723 a_43660_17315# A0 0.27284f
C724 a_60871_17378# A7 1.03577f
C725 a_77875_18828# VDD 0.2482f
C726 a_55723_19104# A5 0.38186f
C727 a_83049_16859# Y15 0.415f
C728 a_60667_19848# a_62259_19664# 0.11131f
C729 a_61835_20792# VDD 0.48725f
C730 a_75500_17311# a_75798_17311# 1.31436f
C731 VDD Y5 0.1286f
C732 B8 A8 0.15965f
C733 a_79563_19664# a_81131_20124# 0.42697f
C734 a_48307_19848# a_48371_19664# 0.41628f
C735 a_49899_19664# VDD 0.41093f
C736 a_51076_17315# A3 0.28132f
C737 a_59787_18828# A7 0.38551f
C738 a_73232_17378# a_75403_18828# 0.37503f
C739 a_61187_16575# Y7 0.14493f
C740 a_77523_16571# VDD 0.6051f
C741 a_72735_16571# VDD 1.23757f
C742 a_72939_16571# A12 0.14377f
C743 a_60731_19664# VDD 0.18022f
C744 a_55627_18828# VDD 0.25914f
C745 a_51131_16575# a_50983_17382# 0.35878f
C746 a_61019_16575# A7 0.42553f
C747 a_68787_20792# B10 0.22775f
C748 a_52854_18468# a_55723_19104# 1.44417f
C749 a_66299_19216# VDD 0.23699f
C750 a_69675_19664# a_70555_19848# 1.38653f
C751 VDD B14 0.40182f
C752 CIN B12 0.67118f
C753 a_52854_18468# A5 0.38506f
C754 a_80963_16575# Y15 0.14545f
C755 a_65611_19104# a_67203_18828# 0.11759f
C756 a_79563_19664# a_80507_20124# 0.42478f
C757 a_48307_19848# VDD 0.48671f
C758 a_80443_19104# a_82035_18828# 0.12456f
C759 a_70760_17379# A11 1.03731f
C760 a_63344_17378# A8 1.39891f
C761 a_82973_19616# a_83137_17311# 0.2755f
C762 a_70263_16571# VDD 1.23757f
C763 a_53463_17382# CIN 0.14302f
C764 a_46187_16575# a_46039_17382# 0.35879f
C765 a_72720_17312# A12 0.44998f
C766 a_66131_16575# Y9 0.14493f
C767 a_51076_17315# a_50983_17382# 0.33261f
C768 a_60964_17311# A7 0.43488f
C769 a_58547_16575# a_58399_17378# 0.35882f
C770 a_65675_19216# VDD 0.18106f
C771 a_73731_20792# B12 0.22775f
C772 a_79563_19664# a_79995_16571# 0.38576f
C773 a_47427_19664# VDD 0.41093f
C774 B6 A6 0.1583f
C775 CIN A14 0.10259f
C776 VDD SEL1 0.56786f
C777 a_70907_16575# A11 0.4312f
C778 a_82973_19616# a_79563_18828# 0.20837f
C779 a_67791_16571# VDD 1.23757f
C780 a_46132_17315# a_46039_17382# 0.33262f
C781 a_50778_17315# a_50983_17382# 0.25659f
C782 a_51076_17315# a_51131_16575# 0.31611f
C783 a_60666_17311# A7 0.11856f
C784 a_65515_18828# VDD 0.26247f
C785 a_58492_17311# a_58399_17378# 0.33245f
C786 a_68083_19848# a_69675_19664# 0.1105f
C787 a_65963_16575# a_65815_17379# 0.35883f
C788 a_71075_16575# Y11 0.14493f
C789 VDD B1 0.40171f
C790 B0 CIN 0.67165f
C791 a_59787_19664# a_61355_20124# 0.42094f
C792 a_59363_20792# VDD 0.49477f
C793 a_62735_18464# a_65611_19104# 1.44417f
C794 a_45835_19848# VDD 0.48671f
C795 a_73232_17378# A12 1.30376f
C796 a_80795_16575# a_80647_17378# 0.35882f
C797 a_70853_17312# A11 0.43861f
C798 a_78675_20792# B14 0.22775f
C799 a_82035_19664# a_79563_18828# 0.56629f
C800 a_82973_19616# a_83173_20131# 0.49641f
C801 a_65319_16571# VDD 1.23757f
C802 VDD Y7 0.12874f
C803 a_45834_17315# a_46039_17382# 0.2566f
C804 a_46132_17315# a_46187_16575# 0.3163f
C805 a_62691_19228# VDD 0.31651f
C806 a_50778_17315# a_51131_16575# 1.26712f
C807 a_53463_17382# a_53556_17315# 0.32516f
C808 a_58492_17311# a_58547_16575# 0.31582f
C809 a_58194_17311# a_58399_17378# 0.25632f
C810 a_59787_18828# a_61355_18828# 0.42094f
C811 a_65908_17312# a_65815_17379# 0.33245f
C812 a_76187_19216# VDD 0.23699f
C813 a_59787_19664# a_60731_20124# 0.41865f
C814 a_72939_16571# a_73325_17311# 1.43026f
C815 a_44955_19664# VDD 0.4116f
C816 a_80740_17311# a_80647_17378# 0.33245f
C817 CIN B14 0.67118f
C818 VDD A0 1.73124f
C819 a_76019_16575# Y13 0.14493f
C820 a_68083_19848# a_68771_19664# 0.46435f
C821 a_50683_19664# VDD 1.7661f
C822 a_70555_17312# A11 0.12186f
C823 a_78175_17378# VDD 0.62869f
C824 a_62847_16571# VDD 1.23757f
C825 a_45834_17315# a_46187_16575# 1.26669f
C826 a_58883_19664# VDD 0.23699f
C827 a_50778_17315# a_51076_17315# 1.31882f
C828 a_53463_17382# a_53163_16571# 0.24158f
C829 a_58194_17311# a_58547_16575# 1.26693f
C830 a_67203_19664# a_68083_19848# 1.38653f
C831 a_59787_18828# a_60731_18828# 0.41865f
C832 a_65908_17312# a_65963_16575# 0.31603f
C833 a_75563_19216# VDD 0.18106f
C834 a_65610_17312# a_65815_17379# 0.25633f
C835 a_59787_19664# a_60219_16571# 0.33618f
C836 a_72720_17312# a_73325_17311# 0.33146f
C837 a_43363_19848# VDD 0.48671f
C838 a_80740_17311# a_80795_16575# 0.31582f
C839 a_80442_17311# a_80647_17378# 0.25632f
C840 a_63890_17859# A8 1.73191f
C841 a_68083_19848# a_68147_19664# 0.41628f
C842 a_77091_18828# a_77971_19104# 1.44423f
C843 a_78323_16575# VDD 0.64095f
C844 a_63437_17311# A8 0.47145f
C845 a_60375_16571# VDD 1.23757f
C846 B7 A7 0.1583f
C847 VDD A4 0.69916f
C848 a_79139_20792# B14 0.12451f
C849 a_45834_17315# a_46132_17315# 1.31882f
C850 a_58259_19664# VDD 0.18022f
C851 a_62259_18828# VDD 0.52104f
C852 a_68083_19104# A10 0.3823f
C853 a_58194_17311# a_58492_17311# 1.31457f
C854 a_72579_19228# VDD 0.31651f
C855 a_82035_19664# a_83173_19138# 0.12721f
C856 a_75403_18828# VDD 0.26155f
C857 a_65610_17312# a_65963_16575# 1.26513f
C858 a_65815_17379# A9 1.03728f
C859 a_56891_20792# VDD 0.48725f
C860 a_72720_17312# a_72939_16571# 1.43898f
C861 a_45835_19848# a_46523_19664# 0.46435f
C862 a_62832_17312# VDD 0.90736f
C863 a_80442_17311# a_80795_16575# 1.26489f
C864 CIN B1 0.67118f
C865 VDD B3 0.40226f
C866 a_78268_17311# VDD 0.54496f
C867 a_63051_16571# A8 0.14478f
C868 a_75051_16571# VDD 0.60384f
C869 a_57903_16571# VDD 1.23757f
C870 a_65163_16571# a_65515_18828# 1.02578f
C871 a_60667_19104# VDD 0.48762f
C872 a_73232_17378# a_73325_17311# 0.33427f
C873 a_67203_18828# A10 0.38503f
C874 VDD Y9 0.12874f
C875 a_72147_18828# VDD 0.52102f
C876 Z VSS 0.51577f
C877 N VSS 0.40797f
C878 Y14 VSS 0.28597f
C879 Y13 VSS 0.28609f
C880 Y12 VSS 0.28916f
C881 Y11 VSS 0.27926f
C882 Y10 VSS 0.28588f
C883 Y9 VSS 0.28583f
C884 Y8 VSS 0.28845f
C885 Y7 VSS 0.27929f
C886 Y6 VSS 0.28583f
C887 Y5 VSS 0.2856f
C888 Y4 VSS 0.28014f
C889 Y3 VSS 0.27929f
C890 Y2 VSS 0.32501f
C891 Y1 VSS 0.32501f
C892 Y0 VSS 0.32519f
C893 Y15 VSS 0.85153f
C894 F VSS 0.9437f
C895 A12 VSS 1.3537f
C896 A8 VSS 1.3419f
C897 A4 VSS 1.32669f
C898 SEL0 VSS 1.46525f
C899 SEL1 VSS 2.15277f
C900 A15 VSS 2.94017f
C901 A14 VSS 2.93239f
C902 A13 VSS 2.9386f
C903 A11 VSS 2.9364f
C904 A10 VSS 2.89731f
C905 A9 VSS 2.93715f
C906 A7 VSS 2.93699f
C907 A6 VSS 2.9347f
C908 A5 VSS 2.93745f
C909 A3 VSS 2.50326f
C910 A2 VSS 2.51276f
C911 A1 VSS 2.4958f
C912 A0 VSS 2.51461f
C913 B15 VSS 0.43259f
C914 B14 VSS 0.40752f
C915 B13 VSS 0.40754f
C916 B12 VSS 0.41654f
C917 B11 VSS 0.40752f
C918 B10 VSS 0.40754f
C919 B9 VSS 0.40768f
C920 B8 VSS 0.41639f
C921 B7 VSS 0.40754f
C922 B6 VSS 0.40768f
C923 B5 VSS 0.40752f
C924 B4 VSS 0.41648f
C925 B3 VSS 0.4078f
C926 B2 VSS 0.40764f
C927 B1 VSS 0.40766f
C928 CIN VSS 15.01009f
C929 B0 VSS 0.40803f
C930 VDD VSS 0.374p
C931 a_78586_16039# VSS 0.1649f
C932 a_76553_16039# VSS 0.1649f
C933 a_74520_16039# VSS 0.16532f
C934 a_68698_16039# VSS 0.1649f
C935 a_66665_16039# VSS 0.1649f
C936 a_64632_16039# VSS 0.16532f
C937 a_58810_16039# VSS 0.1649f
C938 a_56777_16039# VSS 0.1649f
C939 a_54744_16039# VSS 0.16532f
C940 a_48922_16039# VSS 0.1649f
C941 a_46889_16039# VSS 0.1649f
C942 a_44856_16039# VSS 0.16532f
C943 a_80151_16571# VSS 0.61439f
C944 a_77679_16571# VSS 0.61439f
C945 a_75207_16571# VSS 0.61439f
C946 a_72735_16571# VSS 0.61439f
C947 a_70263_16571# VSS 0.61439f
C948 a_67791_16571# VSS 0.61439f
C949 a_65319_16571# VSS 0.61439f
C950 a_62847_16571# VSS 0.61439f
C951 a_60375_16571# VSS 0.61439f
C952 a_57903_16571# VSS 0.61439f
C953 a_55431_16571# VSS 0.61439f
C954 a_52959_16571# VSS 0.61439f
C955 a_83049_16859# VSS 0.58491f
C956 a_80963_16575# VSS 1.11574f
C957 a_78491_16575# VSS 1.11251f
C958 a_76019_16575# VSS 1.11249f
C959 a_73547_16575# VSS 1.11264f
C960 a_71075_16575# VSS 1.1125f
C961 a_68603_16575# VSS 1.1125f
C962 a_66131_16575# VSS 1.11251f
C963 a_63659_16575# VSS 1.11264f
C964 a_61187_16575# VSS 1.11251f
C965 a_58715_16575# VSS 1.11251f
C966 a_56243_16575# VSS 1.11258f
C967 a_53771_16575# VSS 1.11247f
C968 a_51299_16575# VSS 1.11215f
C969 a_48827_16575# VSS 1.12569f
C970 a_46355_16575# VSS 1.12572f
C971 a_43883_16575# VSS 1.12573f
C972 a_83049_17431# VSS 0.92127f
C973 a_80647_17378# VSS 0.65598f
C974 a_80795_16575# VSS 0.93147f
C975 a_80740_17311# VSS 0.98094f
C976 a_80442_17311# VSS 0.95644f
C977 a_78175_17378# VSS 0.61851f
C978 a_78323_16575# VSS 0.91934f
C979 a_78268_17311# VSS 0.97058f
C980 a_77970_17311# VSS 0.94903f
C981 a_75705_17378# VSS 0.61847f
C982 a_75851_16575# VSS 0.91901f
C983 a_75798_17311# VSS 0.97355f
C984 a_75500_17311# VSS 0.94946f
C985 a_73325_17311# VSS 0.98892f
C986 a_72939_16571# VSS 1.02725f
C987 a_72720_17312# VSS 1.46373f
C988 a_70760_17379# VSS 0.61878f
C989 a_70907_16575# VSS 0.90701f
C990 a_70853_17312# VSS 0.97135f
C991 a_70555_17312# VSS 0.94687f
C992 a_68288_17379# VSS 0.61892f
C993 a_68435_16575# VSS 0.91974f
C994 a_68381_17312# VSS 0.97092f
C995 a_68083_17312# VSS 0.94984f
C996 a_65815_17379# VSS 0.61899f
C997 a_65963_16575# VSS 0.91961f
C998 a_65908_17312# VSS 0.97434f
C999 a_65610_17312# VSS 0.95004f
C1000 a_63437_17311# VSS 0.98796f
C1001 a_63051_16571# VSS 1.02549f
C1002 a_62832_17312# VSS 1.47433f
C1003 a_60871_17378# VSS 0.61833f
C1004 a_61019_16575# VSS 0.90657f
C1005 a_60964_17311# VSS 0.97096f
C1006 a_60666_17311# VSS 0.94622f
C1007 a_58399_17378# VSS 0.61854f
C1008 a_58547_16575# VSS 0.91936f
C1009 a_58492_17311# VSS 0.97062f
C1010 a_58194_17311# VSS 0.94982f
C1011 a_55922_17378# VSS 0.61888f
C1012 a_56075_16575# VSS 0.921f
C1013 a_56015_17311# VSS 0.97523f
C1014 a_55717_17311# VSS 0.94961f
C1015 a_53556_17315# VSS 1.01008f
C1016 a_53163_16571# VSS 1.02181f
C1017 a_52951_17316# VSS 1.47259f
C1018 a_50983_17382# VSS 0.63239f
C1019 a_51131_16575# VSS 0.97101f
C1020 a_51076_17315# VSS 0.99802f
C1021 a_50778_17315# VSS 0.97735f
C1022 a_48511_17382# VSS 0.63242f
C1023 a_48659_16575# VSS 0.98065f
C1024 a_48604_17315# VSS 0.99648f
C1025 a_48306_17315# VSS 0.97872f
C1026 a_46039_17382# VSS 0.63465f
C1027 a_46187_16575# VSS 0.98229f
C1028 a_46132_17315# VSS 0.99991f
C1029 a_45834_17315# VSS 0.97884f
C1030 a_43567_17382# VSS 0.63503f
C1031 a_43715_16575# VSS 0.99805f
C1032 a_43660_17315# VSS 1.00588f
C1033 a_43362_17315# VSS 0.99311f
C1034 a_83272_18186# VSS 1.21469f
C1035 a_83173_18758# VSS 0.37218f
C1036 a_82467_18780# VSS 0.35156f
C1037 a_81131_18828# VSS 0.30342f
C1038 a_80507_18828# VSS 0.28953f
C1039 a_78659_18828# VSS 0.30342f
C1040 a_78035_18828# VSS 0.28953f
C1041 a_76187_18828# VSS 0.30342f
C1042 a_75563_18828# VSS 0.28953f
C1043 a_80347_18828# VSS 0.26155f
C1044 a_77875_18828# VSS 0.26141f
C1045 a_75403_18828# VSS 0.26182f
C1046 a_82973_18758# VSS 0.64618f
C1047 a_82035_18828# VSS 0.50633f
C1048 a_80443_19104# VSS 0.57522f
C1049 a_77971_19104# VSS 0.57497f
C1050 a_77091_18828# VSS 0.83821f
C1051 a_75499_19104# VSS 0.5749f
C1052 a_73232_17378# VSS 1.4935f
C1053 a_73285_18758# VSS 0.37218f
C1054 a_72579_18780# VSS 0.35156f
C1055 a_71243_18828# VSS 0.30412f
C1056 a_70619_18828# VSS 0.29024f
C1057 a_68771_18828# VSS 0.30412f
C1058 a_68147_18828# VSS 0.29024f
C1059 a_66299_18828# VSS 0.30412f
C1060 a_65675_18828# VSS 0.29024f
C1061 a_70459_18828# VSS 0.26196f
C1062 a_67987_18828# VSS 0.26204f
C1063 a_65515_18828# VSS 0.26238f
C1064 a_72147_18828# VSS 0.52355f
C1065 a_70555_19104# VSS 0.57606f
C1066 a_69675_18828# VSS 0.83921f
C1067 a_68083_19104# VSS 0.57581f
C1068 a_67203_18828# VSS 0.83914f
C1069 a_65611_19104# VSS 0.57584f
C1070 a_62735_18464# VSS 1.18092f
C1071 a_63397_18758# VSS 0.37218f
C1072 a_62691_18780# VSS 0.35156f
C1073 a_61355_18828# VSS 0.30342f
C1074 a_60731_18828# VSS 0.28953f
C1075 a_58883_18828# VSS 0.30342f
C1076 a_58259_18828# VSS 0.28953f
C1077 a_56411_18828# VSS 0.30342f
C1078 a_55787_18828# VSS 0.28953f
C1079 a_60571_18828# VSS 0.26141f
C1080 a_58099_18828# VSS 0.26198f
C1081 a_55627_18828# VSS 0.28141f
C1082 a_62259_18828# VSS 0.52314f
C1083 a_60667_19104# VSS 0.57522f
C1084 a_59787_18828# VSS 0.83859f
C1085 a_58195_19104# VSS 0.57497f
C1086 a_57315_18828# VSS 0.83826f
C1087 a_55723_19104# VSS 0.57519f
C1088 a_52854_18468# VSS 1.20322f
C1089 a_83137_17311# VSS 1.55915f
C1090 a_79563_18828# VSS 1.30999f
C1091 a_83173_20131# VSS 0.37218f
C1092 a_82973_19616# VSS 0.66128f
C1093 a_82035_19664# VSS 0.59162f
C1094 a_81131_20124# VSS 0.30342f
C1095 a_80507_20124# VSS 0.28953f
C1096 a_79995_16571# VSS 0.50611f
C1097 a_78659_20124# VSS 0.30342f
C1098 a_78035_20124# VSS 0.28953f
C1099 a_77523_16571# VSS 0.50331f
C1100 a_76187_20124# VSS 0.30342f
C1101 a_75563_20124# VSS 0.28953f
C1102 a_75051_16571# VSS 0.49761f
C1103 a_72147_19664# VSS 0.69649f
C1104 a_71243_20124# VSS 0.30342f
C1105 a_70619_20124# VSS 0.28953f
C1106 a_70107_16571# VSS 0.50355f
C1107 a_68771_20124# VSS 0.30342f
C1108 a_68147_20124# VSS 0.28953f
C1109 a_67635_16571# VSS 0.50353f
C1110 a_66299_20124# VSS 0.30342f
C1111 a_65675_20124# VSS 0.28953f
C1112 a_65163_16571# VSS 0.49955f
C1113 a_62259_19664# VSS 0.69365f
C1114 a_61355_20124# VSS 0.30342f
C1115 a_60731_20124# VSS 0.28953f
C1116 a_60219_16571# VSS 0.50346f
C1117 a_58883_20124# VSS 0.30342f
C1118 a_58259_20124# VSS 0.28953f
C1119 a_57747_16571# VSS 0.50647f
C1120 a_56411_20124# VSS 0.30342f
C1121 a_55787_20124# VSS 0.28953f
C1122 a_55275_16571# VSS 0.47627f
C1123 a_51467_20124# VSS 0.30342f
C1124 a_50843_20124# VSS 0.28953f
C1125 a_50683_19664# VSS 0.97241f
C1126 a_48995_20124# VSS 0.30342f
C1127 a_48371_20124# VSS 0.28953f
C1128 a_48211_19664# VSS 0.96692f
C1129 a_46523_20124# VSS 0.30342f
C1130 a_45899_20124# VSS 0.28953f
C1131 a_45739_19664# VSS 0.97006f
C1132 a_44051_20124# VSS 0.30342f
C1133 a_43427_20124# VSS 0.28953f
C1134 a_43267_19664# VSS 1.22258f
C1135 a_82467_20154# VSS 0.35156f
C1136 a_80443_19848# VSS 0.57844f
C1137 a_79563_19664# VSS 1.39445f
C1138 a_77971_19848# VSS 0.57819f
C1139 a_77091_19664# VSS 0.91376f
C1140 a_75499_19848# VSS 0.57819f
C1141 a_72623_18464# VSS 1.24783f
C1142 a_70555_19848# VSS 0.58599f
C1143 a_69675_19664# VSS 0.91376f
C1144 a_68083_19848# VSS 0.57819f
C1145 a_67203_19664# VSS 0.91401f
C1146 a_65611_19848# VSS 0.57819f
C1147 a_63344_17378# VSS 1.60382f
C1148 a_60667_19848# VSS 0.58599f
C1149 a_59787_19664# VSS 0.91401f
C1150 a_58195_19848# VSS 0.57819f
C1151 a_57315_19664# VSS 0.91376f
C1152 a_55723_19848# VSS 0.57819f
C1153 a_53463_17382# VSS 1.58909f
C1154 a_50779_19848# VSS 0.59327f
C1155 a_49899_19664# VSS 0.98033f
C1156 a_48307_19848# VSS 0.58546f
C1157 a_47427_19664# VSS 0.98024f
C1158 a_45835_19848# VSS 0.58545f
C1159 a_44955_19664# VSS 0.98028f
C1160 a_43363_19848# VSS 0.58545f
C1161 a_73778_17859# VSS 1.57693f
C1162 a_63890_17859# VSS 1.57997f
C1163 a_54009_17863# VSS 1.62969f
C1164 a_81147_20792# VSS 0.60904f
C1165 a_78675_20792# VSS 0.60904f
C1166 a_76203_20792# VSS 0.60682f
C1167 a_73731_20792# VSS 0.61804f
C1168 a_71259_20792# VSS 0.60904f
C1169 a_68787_20792# VSS 0.60682f
C1170 a_66315_20792# VSS 0.60904f
C1171 a_63843_20792# VSS 0.61804f
C1172 a_61371_20792# VSS 0.60682f
C1173 a_58899_20792# VSS 0.60904f
C1174 a_56427_20792# VSS 0.60904f
C1175 a_53955_20792# VSS 0.61588f
C1176 a_51483_20792# VSS 0.60904f
C1177 a_49011_20792# VSS 0.60904f
C1178 a_46539_20792# VSS 0.60682f
C1179 a_44067_20792# VSS 0.61064f
C1180 a_48209_18467.t2 VSS 0.20834f
C1181 a_48209_18467.n0 VSS 3.97999f
C1182 a_48209_18467.n1 VSS 4.49947f
C1183 a_60569_18463.t2 VSS 0.18423f
C1184 a_60569_18463.n0 VSS 4.02595f
C1185 a_60569_18463.n1 VSS 4.45119f
C1186 a_43265_18467.t3 VSS 0.12945f
C1187 a_43265_18467.n0 VSS 2.01437f
C1188 a_43265_18467.n1 VSS 2.27485f
C1189 a_55620_18463.t2 VSS 0.23235f
C1190 a_55620_18463.n0 VSS 3.96695f
C1191 a_55620_18463.n1 VSS 4.51475f
C1192 a_52371_19664.n0 VSS 0.37017f
C1193 a_52371_19664.n1 VSS 0.36512f
C1194 a_52371_19664.n2 VSS 1.76463f
C1195 a_52371_19664.n3 VSS 0.36512f
C1196 a_52371_19664.n4 VSS 1.3929f
C1197 a_52371_19664.n5 VSS 0.36512f
C1198 a_52371_19664.n6 VSS 1.6552f
C1199 a_52371_19664.n7 VSS 0.23572f
C1200 a_52371_19664.n8 VSS 0.11065f
C1201 a_52371_19664.n9 VSS 1.53139f
C1202 a_52371_19664.n10 VSS 0.32323f
C1203 a_44856_14904.t1 VSS 0.6604f
C1204 a_44856_14904.t3 VSS 2.15641f
C1205 a_44856_14904.t5 VSS 0.21773f
C1206 a_44856_14904.n0 VSS 8.92685f
C1207 a_44856_14904.n1 VSS 18.0915f
C1208 a_44856_14904.t2 VSS 0.76359f
C1209 a_44856_14904.t4 VSS 0.59642f
C1210 a_44856_14904.n2 VSS 1.40153f
C1211 a_44856_14904.n3 VSS 3.19289f
C1212 a_44856_14904.n4 VSS 2.34638f
C1213 a_44856_14904.t0 VSS 0.69961f
C1214 a_65513_18464.t3 VSS 0.23242f
C1215 a_65513_18464.n0 VSS 3.96709f
C1216 a_65513_18464.n1 VSS 4.51447f
C1217 A7.t15 VSS 0.11303f
C1218 A7.n0 VSS 0.42314f
C1219 A7.t11 VSS 0.10768f
C1220 A7.n1 VSS 0.19236f
C1221 A7.n2 VSS 1.2819f
C1222 A7.t19 VSS 0.17716f
C1223 A7.t6 VSS 0.10106f
C1224 A7.n3 VSS 0.15185f
C1225 A7.t12 VSS 0.10106f
C1226 A7.n4 VSS 0.14153f
C1227 A7.t13 VSS 0.13396f
C1228 A7.n5 VSS 0.11288f
C1229 A7.n6 VSS 0.48868f
C1230 A7.t10 VSS 0.17716f
C1231 A7.t17 VSS 0.10106f
C1232 A7.n7 VSS 0.15185f
C1233 A7.t2 VSS 0.10106f
C1234 A7.n8 VSS 0.14153f
C1235 A7.t4 VSS 0.13396f
C1236 A7.n9 VSS 0.11288f
C1237 A7.n10 VSS 0.37725f
C1238 A15.t4 VSS 0.1132f
C1239 A15.n0 VSS 0.4238f
C1240 A15.t16 VSS 0.10785f
C1241 A15.n1 VSS 0.19266f
C1242 A15.n2 VSS 1.27982f
C1243 A15.t1 VSS 0.17744f
C1244 A15.t11 VSS 0.10122f
C1245 A15.n3 VSS 0.15209f
C1246 A15.t0 VSS 0.10122f
C1247 A15.n4 VSS 0.14175f
C1248 A15.t17 VSS 0.13417f
C1249 A15.n5 VSS 0.11306f
C1250 A15.n6 VSS 0.4848f
C1251 A15.t15 VSS 0.17744f
C1252 A15.t3 VSS 0.10122f
C1253 A15.n7 VSS 0.15209f
C1254 A15.t14 VSS 0.10122f
C1255 A15.n8 VSS 0.14175f
C1256 A15.t7 VSS 0.13417f
C1257 A15.n9 VSS 0.11306f
C1258 A15.n10 VSS 0.37684f
C1259 a_50681_18467.t2 VSS 0.18835f
C1260 a_50681_18467.n0 VSS 4.11668f
C1261 a_50681_18467.n1 VSS 4.551f
C1262 a_50681_18467.t0 VSS 0.10068f
C1263 a_62691_16571.t5 VSS 0.11624f
C1264 a_62691_16571.n0 VSS 1.77815f
C1265 a_62691_16571.n1 VSS 1.77428f
C1266 a_62691_16571.n2 VSS 0.44519f
C1267 a_62691_16571.n3 VSS 0.2812f
C1268 a_74520_14904.t1 VSS 0.40437f
C1269 a_74520_14904.t4 VSS 1.23421f
C1270 a_74520_14904.t5 VSS 0.17764f
C1271 a_74520_14904.n0 VSS 4.16444f
C1272 a_74520_14904.n1 VSS 11.422f
C1273 a_74520_14904.t3 VSS 0.44135f
C1274 a_74520_14904.t2 VSS 0.34473f
C1275 a_74520_14904.n2 VSS 0.81008f
C1276 a_74520_14904.n3 VSS 1.8877f
C1277 a_74520_14904.n4 VSS 1.3562f
C1278 a_74520_14904.t0 VSS 0.38171f
C1279 a_80345_18463.t3 VSS 0.18606f
C1280 a_80345_18463.n0 VSS 4.08037f
C1281 a_80345_18463.n1 VSS 4.49256f
C1282 a_75403_18463.t2 VSS 0.23243f
C1283 a_75403_18463.n0 VSS 3.96697f
C1284 a_75403_18463.n1 VSS 4.51458f
C1285 a_72679_16527.n0 VSS 0.1915f
C1286 a_72679_16527.n1 VSS 0.37375f
C1287 a_72679_16527.n2 VSS 0.77393f
C1288 a_72679_16527.n3 VSS 0.56815f
C1289 a_72679_16527.n4 VSS 1.10905f
C1290 a_72679_16527.n5 VSS 0.56815f
C1291 a_72679_16527.n6 VSS 1.12058f
C1292 a_72679_16527.n7 VSS 0.56815f
C1293 a_72679_16527.n8 VSS 0.88722f
C1294 a_72679_16527.n9 VSS 0.79826f
C1295 a_72679_16527.n10 VSS 1.31449f
C1296 a_72679_16527.n11 VSS 0.30604f
C1297 a_72679_16527.t0 VSS 0.17144f
C1298 A13.t6 VSS 0.11315f
C1299 A13.n0 VSS 0.42362f
C1300 A13.t18 VSS 0.10781f
C1301 A13.n1 VSS 0.19257f
C1302 A13.n2 VSS 1.28148f
C1303 A13.t19 VSS 0.17736f
C1304 A13.t15 VSS 0.10118f
C1305 A13.n3 VSS 0.15202f
C1306 A13.t13 VSS 0.10118f
C1307 A13.n4 VSS 0.14169f
C1308 A13.t14 VSS 0.13411f
C1309 A13.n5 VSS 0.11301f
C1310 A13.n6 VSS 0.48476f
C1311 A13.t12 VSS 0.17736f
C1312 A13.t5 VSS 0.10118f
C1313 A13.n7 VSS 0.15202f
C1314 A13.t1 VSS 0.10118f
C1315 A13.n8 VSS 0.14169f
C1316 A13.t3 VSS 0.13411f
C1317 A13.n9 VSS 0.11301f
C1318 A13.n10 VSS 0.37551f
C1319 a_54744_14904.t4 VSS 0.68172f
C1320 a_54744_14904.t2 VSS 2.09705f
C1321 a_54744_14904.t5 VSS 0.24126f
C1322 a_54744_14904.n0 VSS 7.04564f
C1323 a_54744_14904.n1 VSS 19.2726f
C1324 a_54744_14904.t3 VSS 0.74406f
C1325 a_54744_14904.t1 VSS 0.58117f
C1326 a_54744_14904.n2 VSS 1.36568f
C1327 a_54744_14904.n3 VSS 3.12443f
C1328 a_54744_14904.n4 VSS 2.28637f
C1329 a_54744_14904.t0 VSS 0.64351f
C1330 a_58097_18463.t3 VSS 0.20834f
C1331 a_58097_18463.n0 VSS 3.98442f
C1332 a_58097_18463.n1 VSS 4.49504f
C1333 a_55363_18700.n1 VSS 0.10221f
C1334 a_55363_18700.n2 VSS 0.11731f
C1335 a_55363_18700.n3 VSS 0.4791f
C1336 a_55363_18700.n7 VSS 0.25995f
C1337 a_55363_18700.n11 VSS 0.17864f
C1338 a_55363_18700.n12 VSS 0.12743f
C1339 a_45737_18467.t2 VSS 0.23242f
C1340 a_45737_18467.n0 VSS 3.96586f
C1341 a_45737_18467.n1 VSS 4.5157f
C1342 A6.t8 VSS 0.11295f
C1343 A6.n0 VSS 0.42286f
C1344 A6.t15 VSS 0.10761f
C1345 A6.n1 VSS 0.19223f
C1346 A6.n2 VSS 1.28446f
C1347 A6.t7 VSS 0.17705f
C1348 A6.t16 VSS 0.101f
C1349 A6.n3 VSS 0.15175f
C1350 A6.t17 VSS 0.101f
C1351 A6.n4 VSS 0.14144f
C1352 A6.t14 VSS 0.13387f
C1353 A6.n5 VSS 0.11281f
C1354 A6.n6 VSS 0.48863f
C1355 A6.t19 VSS 0.17705f
C1356 A6.t5 VSS 0.101f
C1357 A6.n7 VSS 0.15175f
C1358 A6.t6 VSS 0.101f
C1359 A6.n8 VSS 0.14144f
C1360 A6.t2 VSS 0.13387f
C1361 A6.n9 VSS 0.11281f
C1362 A6.n10 VSS 0.37717f
C1363 a_40765_17389.t8 VSS 0.22441f
C1364 a_40765_17389.t10 VSS 0.10669f
C1365 a_40765_17389.n1 VSS 2.5354f
C1366 a_40765_17389.t18 VSS 0.10669f
C1367 a_40765_17389.n2 VSS 1.70284f
C1368 a_40765_17389.t14 VSS 0.10669f
C1369 a_40765_17389.n3 VSS 1.70284f
C1370 a_40765_17389.t4 VSS 0.10669f
C1371 a_40765_17389.n4 VSS 1.70284f
C1372 a_40765_17389.t6 VSS 0.10669f
C1373 a_40765_17389.n5 VSS 1.70284f
C1374 a_40765_17389.t15 VSS 0.10669f
C1375 a_40765_17389.n6 VSS 1.70284f
C1376 a_40765_17389.t7 VSS 0.10669f
C1377 a_40765_17389.n7 VSS 1.70284f
C1378 a_40765_17389.t17 VSS 0.10669f
C1379 a_40765_17389.n8 VSS 1.70284f
C1380 a_40765_17389.t9 VSS 0.10669f
C1381 a_40765_17389.n9 VSS 1.70284f
C1382 a_40765_17389.t13 VSS 0.10669f
C1383 a_40765_17389.n10 VSS 1.70284f
C1384 a_40765_17389.t3 VSS 0.10669f
C1385 a_40765_17389.n11 VSS 1.70284f
C1386 a_40765_17389.t11 VSS 0.10669f
C1387 a_40765_17389.n12 VSS 1.70284f
C1388 a_40765_17389.t5 VSS 0.10669f
C1389 a_40765_17389.n13 VSS 1.70284f
C1390 a_40765_17389.t12 VSS 0.10669f
C1391 a_40765_17389.n14 VSS 1.70284f
C1392 a_40765_17389.t16 VSS 0.10669f
C1393 a_40765_17389.n15 VSS 3.51795f
C1394 a_40765_17389.n16 VSS 2.42412f
C1395 a_40765_17389.t0 VSS 0.17564f
C1396 A1.n0 VSS 0.40054f
C1397 A1.n1 VSS 0.38326f
C1398 A1.n2 VSS 0.29527f
C1399 A1.t1 VSS 0.10019f
C1400 A1.n6 VSS 0.41692f
C1401 a_43003_19620.n1 VSS 0.12141f
C1402 a_43003_19620.n2 VSS 0.13687f
C1403 a_43003_19620.n3 VSS 0.62367f
C1404 a_43003_19620.n7 VSS 0.43992f
C1405 a_43003_19620.n8 VSS 0.15065f
C1406 a_60307_18700.n1 VSS 0.10231f
C1407 a_60307_18700.n2 VSS 0.11704f
C1408 a_60307_18700.n3 VSS 0.47938f
C1409 a_60307_18700.n7 VSS 0.25963f
C1410 a_60307_18700.n11 VSS 0.17866f
C1411 a_60307_18700.n12 VSS 0.12745f
C1412 a_52895_16853.t1 VSS 0.12855f
C1413 a_52895_16853.t10 VSS 0.11007f
C1414 a_52895_16853.n0 VSS 0.2239f
C1415 a_52895_16853.n1 VSS 0.63216f
C1416 a_52895_16853.n2 VSS 1.69896f
C1417 a_52895_16853.n3 VSS 0.63216f
C1418 a_52895_16853.n4 VSS 1.26653f
C1419 a_52895_16853.n5 VSS 0.63216f
C1420 a_52895_16853.n6 VSS 1.23191f
C1421 a_52895_16853.n7 VSS 0.74184f
C1422 a_52895_16853.n8 VSS 1.0804f
C1423 a_52895_16853.n9 VSS 0.38579f
C1424 a_67986_18464.t3 VSS 0.20834f
C1425 a_67986_18464.n0 VSS 3.98436f
C1426 a_67986_18464.n1 VSS 4.4951f
C1427 a_72579_16571.t4 VSS 0.11575f
C1428 a_72579_16571.n0 VSS 1.77061f
C1429 a_72579_16571.n1 VSS 1.75882f
C1430 a_72579_16571.n2 VSS 0.28836f
C1431 a_72579_16571.n3 VSS 0.4606f
C1432 a_62783_16853.n1 VSS 0.18894f
C1433 a_62783_16853.n2 VSS 0.53345f
C1434 a_62783_16853.n3 VSS 1.43368f
C1435 a_62783_16853.n4 VSS 0.53345f
C1436 a_62783_16853.n5 VSS 1.06878f
C1437 a_62783_16853.n6 VSS 0.53345f
C1438 a_62783_16853.n7 VSS 0.78481f
C1439 a_62783_16853.n8 VSS 0.9737f
C1440 a_62783_16853.n9 VSS 1.18948f
C1441 a_62783_16853.n11 VSS 0.14378f
C1442 a_62783_16853.n12 VSS 0.28753f
C1443 a_62783_16853.n13 VSS 0.12012f
C1444 A5.t4 VSS 0.11317f
C1445 A5.n0 VSS 0.42366f
C1446 A5.t1 VSS 0.10782f
C1447 A5.n1 VSS 0.19259f
C1448 A5.n2 VSS 1.28071f
C1449 A5.t13 VSS 0.17738f
C1450 A5.t0 VSS 0.10119f
C1451 A5.n3 VSS 0.15204f
C1452 A5.t8 VSS 0.10119f
C1453 A5.n4 VSS 0.14171f
C1454 A5.t9 VSS 0.13412f
C1455 A5.n5 VSS 0.11302f
C1456 A5.n6 VSS 0.48515f
C1457 A5.t6 VSS 0.17738f
C1458 A5.t12 VSS 0.10119f
C1459 A5.n7 VSS 0.15204f
C1460 A5.t17 VSS 0.10119f
C1461 A5.n8 VSS 0.14171f
C1462 A5.t19 VSS 0.13412f
C1463 A5.n9 VSS 0.11302f
C1464 A5.n10 VSS 0.37705f
C1465 a_42244_17389.t2 VSS 0.14394f
C1466 a_42244_17389.t17 VSS 0.25613f
C1467 a_42244_17389.t18 VSS 0.12177f
C1468 a_42244_17389.n0 VSS 2.89385f
C1469 a_42244_17389.t10 VSS 0.12177f
C1470 a_42244_17389.n1 VSS 1.94359f
C1471 a_42244_17389.t6 VSS 0.12177f
C1472 a_42244_17389.n2 VSS 1.94359f
C1473 a_42244_17389.t14 VSS 0.12177f
C1474 a_42244_17389.n3 VSS 1.94359f
C1475 a_42244_17389.t15 VSS 0.12177f
C1476 a_42244_17389.n4 VSS 1.94359f
C1477 a_42244_17389.t8 VSS 0.12177f
C1478 a_42244_17389.n5 VSS 1.94359f
C1479 a_42244_17389.t4 VSS 0.12177f
C1480 a_42244_17389.n6 VSS 1.94359f
C1481 a_42244_17389.t12 VSS 0.12177f
C1482 a_42244_17389.n7 VSS 1.94359f
C1483 a_42244_17389.t13 VSS 0.12177f
C1484 a_42244_17389.n8 VSS 1.94359f
C1485 a_42244_17389.t5 VSS 0.12177f
C1486 a_42244_17389.n9 VSS 1.94359f
C1487 a_42244_17389.t16 VSS 0.12177f
C1488 a_42244_17389.n10 VSS 1.94359f
C1489 a_42244_17389.t7 VSS 0.12177f
C1490 a_42244_17389.n11 VSS 1.94359f
C1491 a_42244_17389.t9 VSS 0.12177f
C1492 a_42244_17389.n12 VSS 1.94359f
C1493 a_42244_17389.t3 VSS 0.12177f
C1494 a_42244_17389.n13 VSS 1.94359f
C1495 a_42244_17389.t11 VSS 0.12177f
C1496 a_42244_17389.n14 VSS 1.69656f
C1497 a_42244_17389.n15 VSS 0.16727f
C1498 a_42244_17389.n16 VSS 0.15598f
C1499 A11.t3 VSS 0.11317f
C1500 A11.n0 VSS 0.42367f
C1501 A11.t16 VSS 0.10782f
C1502 A11.n1 VSS 0.1926f
C1503 A11.n2 VSS 1.28101f
C1504 A11.t0 VSS 0.17738f
C1505 A11.t11 VSS 0.10119f
C1506 A11.n3 VSS 0.15204f
C1507 A11.t17 VSS 0.10119f
C1508 A11.n4 VSS 0.14171f
C1509 A11.t18 VSS 0.13413f
C1510 A11.n5 VSS 0.11303f
C1511 A11.n6 VSS 0.48477f
C1512 A11.t14 VSS 0.17738f
C1513 A11.t2 VSS 0.10119f
C1514 A11.n7 VSS 0.15204f
C1515 A11.t7 VSS 0.10119f
C1516 A11.n8 VSS 0.14171f
C1517 A11.t9 VSS 0.13413f
C1518 A11.n9 VSS 0.11303f
C1519 A11.n10 VSS 0.37756f
C1520 A3.n0 VSS 0.41458f
C1521 A3.n1 VSS 0.39319f
C1522 A3.n2 VSS 0.31279f
C1523 A3.t6 VSS 0.1037f
C1524 A3.n6 VSS 0.44013f
C1525 a_57835_18700.n1 VSS 0.10225f
C1526 a_57835_18700.n2 VSS 0.11715f
C1527 a_57835_18700.n3 VSS 0.47923f
C1528 a_57835_18700.n7 VSS 0.25993f
C1529 a_57835_18700.n11 VSS 0.17864f
C1530 a_57835_18700.n12 VSS 0.12743f
C1531 CIN.n6 VSS 0.31554f
C1532 CIN.n10 VSS 0.19469f
C1533 CIN.n14 VSS 0.19469f
C1534 CIN.n18 VSS 0.19469f
C1535 CIN.n22 VSS 0.19469f
C1536 CIN.n26 VSS 0.19469f
C1537 CIN.n30 VSS 0.19469f
C1538 CIN.n34 VSS 0.19469f
C1539 CIN.n38 VSS 0.19469f
C1540 CIN.n42 VSS 0.19469f
C1541 CIN.n46 VSS 0.19469f
C1542 CIN.n50 VSS 0.19469f
C1543 CIN.n54 VSS 0.19469f
C1544 CIN.n58 VSS 0.19469f
C1545 CIN.n62 VSS 0.1566f
C1546 a_41233_17389.t12 VSS 0.13734f
C1547 a_41233_17389.n0 VSS 1.55173f
C1548 a_41233_17389.n1 VSS 1.04218f
C1549 a_41233_17389.n2 VSS 1.04218f
C1550 a_41233_17389.n3 VSS 1.04218f
C1551 a_41233_17389.n4 VSS 1.04218f
C1552 a_41233_17389.n5 VSS 1.04218f
C1553 a_41233_17389.n6 VSS 1.04218f
C1554 a_41233_17389.n7 VSS 1.04218f
C1555 a_41233_17389.n8 VSS 1.04218f
C1556 a_41233_17389.n9 VSS 1.04218f
C1557 a_41233_17389.n10 VSS 1.04218f
C1558 a_41233_17389.n11 VSS 1.04218f
C1559 a_41233_17389.n12 VSS 1.04218f
C1560 a_41233_17389.n13 VSS 1.04218f
C1561 a_41233_17389.n14 VSS 2.03652f
C1562 a_41233_17389.n15 VSS 1.50219f
C1563 a_52803_16571.t5 VSS 0.11565f
C1564 a_52803_16571.n0 VSS 0.8058f
C1565 a_52803_16571.n1 VSS 0.33241f
C1566 a_52803_16571.n2 VSS 2.60732f
C1567 a_52803_16571.n3 VSS 0.51988f
C1568 a_40610_17389.n0 VSS 0.61025f
C1569 a_40610_17389.n1 VSS 0.20022f
C1570 a_40610_17389.n2 VSS 0.14922f
C1571 a_40610_17389.n3 VSS 0.29803f
C1572 a_40610_17389.n4 VSS 0.32165f
C1573 SEL0.n0 VSS 0.16671f
C1574 SEL0.n1 VSS 0.15452f
C1575 SEL0.n2 VSS 0.43774f
C1576 SEL0.t1 VSS 0.10413f
C1577 SEL0.n3 VSS 0.20904f
C1578 SEL0.n4 VSS 0.13776f
C1579 SEL0.n5 VSS 0.1905f
C1580 SEL0.t2 VSS 0.10114f
C1581 SEL0.n6 VSS 0.22501f
C1582 A0.n0 VSS 0.4167f
C1583 A0.n1 VSS 0.40048f
C1584 A0.n2 VSS 0.30969f
C1585 A0.t10 VSS 0.10423f
C1586 A0.n6 VSS 0.43368f
C1587 a_50419_19620.n1 VSS 0.12124f
C1588 a_50419_19620.n2 VSS 0.13705f
C1589 a_50419_19620.n3 VSS 0.62344f
C1590 a_50419_19620.n7 VSS 0.44086f
C1591 a_50419_19620.n8 VSS 0.15056f
C1592 a_77873_18463.t3 VSS 0.20835f
C1593 a_77873_18463.n0 VSS 3.98451f
C1594 a_77873_18463.n1 VSS 4.49492f
C1595 a_67723_18700.n1 VSS 0.10229f
C1596 a_67723_18700.n2 VSS 0.11712f
C1597 a_67723_18700.n3 VSS 0.47931f
C1598 a_67723_18700.n7 VSS 0.25953f
C1599 a_67723_18700.n11 VSS 0.17867f
C1600 a_67723_18700.n12 VSS 0.12746f
C1601 a_70195_18700.n1 VSS 0.10217f
C1602 a_70195_18700.n2 VSS 0.11699f
C1603 a_70195_18700.n3 VSS 0.47959f
C1604 a_70195_18700.n7 VSS 0.2615f
C1605 a_70195_18700.n11 VSS 0.17846f
C1606 a_70195_18700.n12 VSS 0.12731f
C1607 a_45475_19620.n1 VSS 0.11658f
C1608 a_45475_19620.n2 VSS 0.13163f
C1609 a_45475_19620.n3 VSS 0.59859f
C1610 a_45475_19620.n7 VSS 0.42139f
C1611 a_45475_19620.n8 VSS 0.14472f
C1612 A14.t6 VSS 0.11323f
C1613 A14.n0 VSS 0.4239f
C1614 A14.t4 VSS 0.10788f
C1615 A14.n1 VSS 0.1927f
C1616 A14.n2 VSS 1.27897f
C1617 A14.t11 VSS 0.17748f
C1618 A14.t17 VSS 0.10124f
C1619 A14.n3 VSS 0.15212f
C1620 A14.t5 VSS 0.10124f
C1621 A14.n4 VSS 0.14179f
C1622 A14.t3 VSS 0.1342f
C1623 A14.n5 VSS 0.11309f
C1624 A14.n6 VSS 0.48474f
C1625 A14.t2 VSS 0.17748f
C1626 A14.t10 VSS 0.10124f
C1627 A14.n7 VSS 0.15212f
C1628 A14.t16 VSS 0.10124f
C1629 A14.n8 VSS 0.14179f
C1630 A14.t14 VSS 0.1342f
C1631 A14.n9 VSS 0.11309f
C1632 A14.n10 VSS 0.37726f
C1633 a_65251_18700.n1 VSS 0.10225f
C1634 a_65251_18700.n2 VSS 0.11715f
C1635 a_65251_18700.n3 VSS 0.47923f
C1636 a_65251_18700.n7 VSS 0.25993f
C1637 a_65251_18700.n11 VSS 0.17864f
C1638 a_65251_18700.n12 VSS 0.12743f
C1639 a_80083_18700.n1 VSS 0.10223f
C1640 a_80083_18700.n2 VSS 0.11723f
C1641 a_80083_18700.n3 VSS 0.47917f
C1642 a_80083_18700.n7 VSS 0.25993f
C1643 a_80083_18700.n11 VSS 0.17864f
C1644 a_80083_18700.n12 VSS 0.12743f
C1645 a_62791_16527.n0 VSS 0.34456f
C1646 a_62791_16527.n1 VSS 0.33986f
C1647 a_62791_16527.n2 VSS 1.64257f
C1648 a_62791_16527.n3 VSS 0.33986f
C1649 a_62791_16527.n4 VSS 1.29655f
C1650 a_62791_16527.n5 VSS 0.33986f
C1651 a_62791_16527.n6 VSS 1.03485f
C1652 a_62791_16527.n7 VSS 0.8328f
C1653 a_62791_16527.n8 VSS 1.33767f
C1654 a_62791_16527.n9 VSS 0.31705f
C1655 a_62791_16527.t0 VSS 0.17745f
C1656 a_77611_18700.n1 VSS 0.10227f
C1657 a_77611_18700.n2 VSS 0.1171f
C1658 a_77611_18700.n3 VSS 0.47926f
C1659 a_77611_18700.n7 VSS 0.25993f
C1660 a_77611_18700.n11 VSS 0.17864f
C1661 a_77611_18700.n12 VSS 0.12743f
C1662 a_75139_18700.n1 VSS 0.10229f
C1663 a_75139_18700.n2 VSS 0.11705f
C1664 a_75139_18700.n3 VSS 0.47934f
C1665 a_75139_18700.n7 VSS 0.25988f
C1666 a_75139_18700.n11 VSS 0.17864f
C1667 a_75139_18700.n12 VSS 0.12743f
C1668 a_64632_14904.t3 VSS 0.67814f
C1669 a_64632_14904.t4 VSS 0.64013f
C1670 a_64632_14904.n0 VSS 2.27437f
C1671 a_64632_14904.t1 VSS 0.74015f
C1672 a_64632_14904.t2 VSS 0.57812f
C1673 a_64632_14904.n1 VSS 1.35852f
C1674 a_64632_14904.n2 VSS 3.13606f
C1675 a_64632_14904.t5 VSS 0.26897f
C1676 a_64632_14904.n3 VSS 6.09354f
C1677 a_64632_14904.n4 VSS 20.0667f
C1678 a_64632_14904.t0 VSS 2.07776f
C1679 a_70458_18464.t3 VSS 0.18442f
C1680 a_70458_18464.n0 VSS 4.02685f
C1681 a_70458_18464.n1 VSS 4.44985f
C1682 A9.t6 VSS 0.11315f
C1683 A9.n0 VSS 0.42362f
C1684 A9.t3 VSS 0.10781f
C1685 A9.n1 VSS 0.19257f
C1686 A9.n2 VSS 1.28142f
C1687 A9.t17 VSS 0.17736f
C1688 A9.t15 VSS 0.10118f
C1689 A9.n3 VSS 0.15202f
C1690 A9.t13 VSS 0.10118f
C1691 A9.n4 VSS 0.14169f
C1692 A9.t14 VSS 0.13411f
C1693 A9.n5 VSS 0.11301f
C1694 A9.n6 VSS 0.48482f
C1695 A9.t12 VSS 0.17736f
C1696 A9.t5 VSS 0.10118f
C1697 A9.n7 VSS 0.15202f
C1698 A9.t0 VSS 0.10118f
C1699 A9.n8 VSS 0.14169f
C1700 A9.t2 VSS 0.13411f
C1701 A9.n9 VSS 0.11301f
C1702 A9.n10 VSS 0.37735f
C1703 A10.n0 VSS 0.34789f
C1704 A10.n1 VSS 0.15815f
C1705 A10.n2 VSS 1.05331f
C1706 A10.t7 VSS 0.14566f
C1707 A10.n3 VSS 0.12485f
C1708 A10.n4 VSS 0.11636f
C1709 A10.t0 VSS 0.11014f
C1710 A10.n6 VSS 0.39829f
C1711 A10.t19 VSS 0.14566f
C1712 A10.n7 VSS 0.12485f
C1713 A10.n8 VSS 0.11636f
C1714 A10.t9 VSS 0.11014f
C1715 A10.n10 VSS 0.30948f
C1716 a_47947_19620.n1 VSS 0.12144f
C1717 a_47947_19620.n2 VSS 0.13711f
C1718 a_47947_19620.n3 VSS 0.62353f
C1719 a_47947_19620.n7 VSS 0.43895f
C1720 a_47947_19620.n8 VSS 0.15076f
C1721 a_41692_17389.t13 VSS 0.13379f
C1722 a_41692_17389.n1 VSS 1.51165f
C1723 a_41692_17389.n2 VSS 1.01526f
C1724 a_41692_17389.n3 VSS 1.01526f
C1725 a_41692_17389.n4 VSS 1.01526f
C1726 a_41692_17389.n5 VSS 1.01526f
C1727 a_41692_17389.n6 VSS 1.01526f
C1728 a_41692_17389.n7 VSS 1.01526f
C1729 a_41692_17389.n8 VSS 1.01526f
C1730 a_41692_17389.n9 VSS 1.01526f
C1731 a_41692_17389.n10 VSS 1.01526f
C1732 a_41692_17389.n11 VSS 1.01526f
C1733 a_41692_17389.n12 VSS 1.01526f
C1734 a_41692_17389.n13 VSS 1.01526f
C1735 a_41692_17389.n14 VSS 1.01526f
C1736 a_41692_17389.n15 VSS 1.96051f
C1737 a_41692_17389.n16 VSS 1.44231f
C1738 VDD.n3 VSS 0.14738f
C1739 VDD.t306 VSS 0.36504f
C1740 VDD.t547 VSS 0.14315f
C1741 VDD.t312 VSS 0.14315f
C1742 VDD.t582 VSS 0.14315f
C1743 VDD.t307 VSS 0.42498f
C1744 VDD.t360 VSS 0.16067f
C1745 VDD.n15 VSS 0.43744f
C1746 VDD.t198 VSS 0.16111f
C1747 VDD.t320 VSS 0.16502f
C1748 VDD.t272 VSS 0.12672f
C1749 VDD.t190 VSS 0.12672f
C1750 VDD.t760 VSS 0.127f
C1751 VDD.t523 VSS 0.1812f
C1752 VDD.t442 VSS 0.18844f
C1753 VDD.t446 VSS 0.14296f
C1754 VDD.t514 VSS 0.17674f
C1755 VDD.n16 VSS 0.18284f
C1756 VDD.t161 VSS 0.13678f
C1757 VDD.t594 VSS 0.14473f
C1758 VDD.t50 VSS 0.12576f
C1759 VDD.t223 VSS 0.12672f
C1760 VDD.t153 VSS 0.12672f
C1761 VDD.t606 VSS 0.127f
C1762 VDD.t24 VSS 0.1812f
C1763 VDD.t287 VSS 0.18844f
C1764 VDD.t451 VSS 0.14296f
C1765 VDD.t515 VSS 0.26944f
C1766 VDD.t574 VSS 0.22948f
C1767 VDD.t80 VSS 0.14421f
C1768 VDD.t504 VSS 0.126f
C1769 VDD.t424 VSS 0.12672f
C1770 VDD.t663 VSS 0.12672f
C1771 VDD.t428 VSS 0.127f
C1772 VDD.t804 VSS 0.18063f
C1773 VDD.t429 VSS 0.18929f
C1774 VDD.t448 VSS 0.14332f
C1775 VDD.t535 VSS 0.26932f
C1776 VDD.t42 VSS 0.22948f
C1777 VDD.t364 VSS 0.14447f
C1778 VDD.t141 VSS 0.12588f
C1779 VDD.t244 VSS 0.12672f
C1780 VDD.t44 VSS 0.12672f
C1781 VDD.t366 VSS 0.127f
C1782 VDD.t682 VSS 0.20307f
C1783 VDD.t536 VSS 0.14861f
C1784 VDD.t447 VSS 0.1097f
C1785 VDD.n18 VSS 0.18261f
C1786 VDD.t688 VSS 0.13692f
C1787 VDD.t752 VSS 0.14462f
C1788 VDD.t354 VSS 0.12588f
C1789 VDD.t732 VSS 0.12672f
C1790 VDD.t694 VSS 0.12672f
C1791 VDD.t749 VSS 0.127f
C1792 VDD.t8 VSS 0.18095f
C1793 VDD.t2 VSS 0.18907f
C1794 VDD.t373 VSS 0.14352f
C1795 VDD.t685 VSS 0.27012f
C1796 VDD.t334 VSS 0.22971f
C1797 VDD.t584 VSS 0.14462f
C1798 VDD.t78 VSS 0.12588f
C1799 VDD.t637 VSS 0.12672f
C1800 VDD.t350 VSS 0.12672f
C1801 VDD.t618 VSS 0.127f
C1802 VDD.t236 VSS 0.18095f
C1803 VDD.t125 VSS 0.18907f
C1804 VDD.t188 VSS 0.14329f
C1805 VDD.t326 VSS 0.27026f
C1806 VDD.t570 VSS 0.22971f
C1807 VDD.t127 VSS 0.14488f
C1808 VDD.t270 VSS 0.12576f
C1809 VDD.t248 VSS 0.12672f
C1810 VDD.t564 VSS 0.12672f
C1811 VDD.t179 VSS 0.127f
C1812 VDD.t202 VSS 0.20333f
C1813 VDD.t189 VSS 0.14892f
C1814 VDD.n22 VSS 0.10803f
C1815 VDD.t327 VSS 0.10588f
C1816 VDD.n23 VSS 0.18243f
C1817 VDD.t102 VSS 0.16438f
C1818 VDD.t463 VSS 0.14447f
C1819 VDD.t623 VSS 0.12588f
C1820 VDD.t133 VSS 0.12672f
C1821 VDD.t104 VSS 0.12672f
C1822 VDD.t462 VSS 0.127f
C1823 VDD.t92 VSS 0.18091f
C1824 VDD.t527 VSS 0.18886f
C1825 VDD.t374 VSS 0.12648f
C1826 VDD.t684 VSS 0.20311f
C1827 VDD.t210 VSS 0.22948f
C1828 VDD.t171 VSS 0.14473f
C1829 VDD.t246 VSS 0.12576f
C1830 VDD.t545 VSS 0.12672f
C1831 VDD.t16 VSS 0.12672f
C1832 VDD.t675 VSS 0.127f
C1833 VDD.t165 VSS 0.1812f
C1834 VDD.t260 VSS 0.18844f
C1835 VDD.t467 VSS 0.14296f
C1836 VDD.t671 VSS 0.27027f
C1837 VDD.t46 VSS 0.22948f
C1838 VDD.t108 VSS 0.14473f
C1839 VDD.t702 VSS 0.12576f
C1840 VDD.t775 VSS 0.12672f
C1841 VDD.t793 VSS 0.12672f
C1842 VDD.t110 VSS 0.127f
C1843 VDD.t700 VSS 0.1812f
C1844 VDD.t52 VSS 0.18844f
C1845 VDD.t548 VSS 0.14194f
C1846 VDD.t672 VSS 0.16207f
C1847 VDD.n27 VSS 0.1849f
C1848 VDD.t420 VSS 0.14997f
C1849 VDD.t800 VSS 0.14601f
C1850 VDD.t708 VSS 0.12518f
C1851 VDD.t533 VSS 0.12672f
C1852 VDD.t394 VSS 0.12672f
C1853 VDD.t439 VSS 0.127f
C1854 VDD.t175 VSS 0.20334f
C1855 VDD.t557 VSS 0.14676f
C1856 VDD.n31 VSS 0.10991f
C1857 VDD.t319 VSS 0.2275f
C1858 VDD.t456 VSS 0.2304f
C1859 VDD.t516 VSS 0.14319f
C1860 VDD.t216 VSS 0.1268f
C1861 VDD.t383 VSS 0.12672f
C1862 VDD.t454 VSS 0.12672f
C1863 VDD.t518 VSS 0.127f
C1864 VDD.t531 VSS 0.17913f
C1865 VDD.t74 VSS 0.1926f
C1866 VDD.t276 VSS 0.12699f
C1867 VDD.t318 VSS 0.20682f
C1868 VDD.t779 VSS 0.2304f
C1869 VDD.t741 VSS 0.14532f
C1870 VDD.t724 VSS 0.12577f
C1871 VDD.t785 VSS 0.12672f
C1872 VDD.t293 VSS 0.12672f
C1873 VDD.t736 VSS 0.127f
C1874 VDD.t252 VSS 0.16501f
C1875 VDD.t40 VSS 0.22948f
C1876 VDD.n32 VSS 0.21673f
C1877 VDD.t266 VSS 0.1237f
C1878 VDD.t375 VSS 0.1237f
C1879 VDD.t60 VSS 0.1237f
C1880 VDD.t225 VSS 0.11377f
C1881 VDD.t155 VSS 0.12507f
C1882 VDD.t117 VSS 0.12672f
C1883 VDD.t716 VSS 0.12672f
C1884 VDD.t227 VSS 0.127f
C1885 VDD.t633 VSS 0.16501f
C1886 VDD.t221 VSS 0.3022f
C1887 VDD.t539 VSS 0.23141f
C1888 VDD.t4 VSS 0.11377f
C1889 VDD.t34 VSS 0.12507f
C1890 VDD.t106 VSS 0.12672f
C1891 VDD.t596 VSS 0.12672f
C1892 VDD.t305 VSS 0.127f
C1893 VDD.t452 VSS 0.16501f
C1894 VDD.t767 VSS 0.3022f
C1895 VDD.t308 VSS 0.23141f
C1896 VDD.t773 VSS 0.11377f
C1897 VDD.t558 VSS 0.12507f
C1898 VDD.t274 VSS 0.12672f
C1899 VDD.t356 VSS 0.12672f
C1900 VDD.t387 VSS 0.127f
C1901 VDD.t572 VSS 0.16501f
C1902 VDD.t232 VSS 0.23671f
C1903 VDD.t798 VSS 0.21527f
C1904 VDD.t220 VSS 0.14499f
C1905 VDD.t797 VSS 0.14405f
C1906 VDD.t468 VSS 0.23528f
C1907 VDD.t469 VSS 0.26949f
C1908 VDD.n39 VSS 0.26861f
C1909 VDD.n40 VSS 0.23743f
C1910 A2.n0 VSS 0.41367f
C1911 A2.n1 VSS 0.39077f
C1912 A2.n2 VSS 0.31209f
C1913 A2.t8 VSS 0.10347f
C1914 A2.n6 VSS 0.44416f
C1915 a_72671_16853.n1 VSS 0.11149f
C1916 a_72671_16853.n2 VSS 0.26148f
C1917 a_72671_16853.n3 VSS 0.96546f
C1918 a_72671_16853.n4 VSS 0.32072f
C1919 a_72671_16853.n5 VSS 1.20613f
C1920 a_72671_16853.n6 VSS 0.32072f
C1921 a_72671_16853.n7 VSS 1.24477f
C1922 a_72671_16853.n8 VSS 0.32072f
C1923 a_72671_16853.n9 VSS 0.93799f
C1924 a_72671_16853.n10 VSS 0.97526f
C1925 a_72671_16853.n11 VSS 1.18521f
C1926 a_72671_16853.n13 VSS 0.14671f
C1927 a_72671_16853.n14 VSS 0.29337f
C1928 a_72671_16853.n15 VSS 0.12256f
.ends
