** TEST SUMMARY
** 00: 0x1234 + 0x4321
** 01: 0xFFFF + 0x0001
** 02: 0x7FFF + 0x0001
** 03: 0x4321 - 0x1234
** 04: 0x0000 - 0x0001
** 05: 0x8000 - 0x0001
** 06: 0x1234 - 0x1234
** 07: 0x1234 - 0x4321
** 08: 0x1234 & 0x00FF
** 09: 0xAAAA | 0x5555
** 10: 0xF0F0 ^ 0x0F0F

.control
save all

** Define input signals

** A BUS
alter @VA15[PWL] = [ 0n 0.0 5n 0.0 5n 3.3 10n 3.3 10n 0.0 15n 0.0 15n 0.0 20n 0.0 20n 0.0 25n 0.0 25n 3.3 30n 3.3 30n 0.0 35n 0.0 35n 0.0 40n 0.0 40n 0.0 45n 0.0 45n 3.3 50n 3.3 50n 3.3 55n 3.3 ]
alter @VA14[PWL] = [ 0n 0.0 5n 0.0 5n 3.3 10n 3.3 10n 3.3 15n 3.3 15n 3.3 20n 3.3 20n 0.0 25n 0.0 25n 0.0 30n 0.0 30n 0.0 35n 0.0 35n 0.0 40n 0.0 40n 0.0 45n 0.0 45n 0.0 50n 0.0 50n 3.3 55n 3.3 ]
alter @VA13[PWL] = [ 0n 0.0 5n 0.0 5n 3.3 10n 3.3 10n 3.3 15n 3.3 15n 0.0 20n 0.0 20n 0.0 25n 0.0 25n 0.0 30n 0.0 30n 0.0 35n 0.0 35n 0.0 40n 0.0 40n 0.0 45n 0.0 45n 3.3 50n 3.3 50n 3.3 55n 3.3 ]
alter @VA12[PWL] = [ 0n 3.3 5n 3.3 5n 3.3 10n 3.3 10n 3.3 15n 3.3 15n 0.0 20n 0.0 20n 0.0 25n 0.0 25n 0.0 30n 0.0 30n 3.3 35n 3.3 35n 3.3 40n 3.3 40n 3.3 45n 3.3 45n 0.0 50n 0.0 50n 3.3 55n 3.3 ]
alter @VA11[PWL] = [ 0n 0.0 5n 0.0 5n 3.3 10n 3.3 10n 3.3 15n 3.3 15n 0.0 20n 0.0 20n 0.0 25n 0.0 25n 0.0 30n 0.0 30n 0.0 35n 0.0 35n 0.0 40n 0.0 40n 0.0 45n 0.0 45n 3.3 50n 3.3 50n 0.0 55n 0.0 ]
alter @VA10[PWL] = [ 0n 0.0 5n 0.0 5n 3.3 10n 3.3 10n 3.3 15n 3.3 15n 0.0 20n 0.0 20n 0.0 25n 0.0 25n 0.0 30n 0.0 30n 0.0 35n 0.0 35n 0.0 40n 0.0 40n 0.0 45n 0.0 45n 0.0 50n 0.0 50n 0.0 55n 0.0 ]
alter @VA9[PWL] = [ 0n 3.3 5n 3.3 5n 3.3 10n 3.3 10n 3.3 15n 3.3 15n 3.3 20n 3.3 20n 0.0 25n 0.0 25n 0.0 30n 0.0 30n 3.3 35n 3.3 35n 3.3 40n 3.3 40n 3.3 45n 3.3 45n 3.3 50n 3.3 50n 0.0 55n 0.0 ]
alter @VA8[PWL] = [ 0n 0.0 5n 0.0 5n 3.3 10n 3.3 10n 3.3 15n 3.3 15n 3.3 20n 3.3 20n 0.0 25n 0.0 25n 0.0 30n 0.0 30n 0.0 35n 0.0 35n 0.0 40n 0.0 40n 0.0 45n 0.0 45n 0.0 50n 0.0 50n 0.0 55n 0.0 ]
alter @VA7[PWL] = [ 0n 0.0 5n 0.0 5n 3.3 10n 3.3 10n 3.3 15n 3.3 15n 0.0 20n 0.0 20n 0.0 25n 0.0 25n 0.0 30n 0.0 30n 0.0 35n 0.0 35n 0.0 40n 0.0 40n 0.0 45n 0.0 45n 3.3 50n 3.3 50n 3.3 55n 3.3 ]
alter @VA6[PWL] = [ 0n 0.0 5n 0.0 5n 3.3 10n 3.3 10n 3.3 15n 3.3 15n 0.0 20n 0.0 20n 0.0 25n 0.0 25n 0.0 30n 0.0 30n 0.0 35n 0.0 35n 0.0 40n 0.0 40n 0.0 45n 0.0 45n 0.0 50n 0.0 50n 3.3 55n 3.3 ]
alter @VA5[PWL] = [ 0n 3.3 5n 3.3 5n 3.3 10n 3.3 10n 3.3 15n 3.3 15n 3.3 20n 3.3 20n 0.0 25n 0.0 25n 0.0 30n 0.0 30n 3.3 35n 3.3 35n 3.3 40n 3.3 40n 3.3 45n 3.3 45n 3.3 50n 3.3 50n 3.3 55n 3.3 ]
alter @VA4[PWL] = [ 0n 3.3 5n 3.3 5n 3.3 10n 3.3 10n 3.3 15n 3.3 15n 0.0 20n 0.0 20n 0.0 25n 0.0 25n 0.0 30n 0.0 30n 3.3 35n 3.3 35n 3.3 40n 3.3 40n 3.3 45n 3.3 45n 0.0 50n 0.0 50n 3.3 55n 3.3 ]
alter @VA3[PWL] = [ 0n 0.0 5n 0.0 5n 3.3 10n 3.3 10n 3.3 15n 3.3 15n 0.0 20n 0.0 20n 0.0 25n 0.0 25n 0.0 30n 0.0 30n 0.0 35n 0.0 35n 0.0 40n 0.0 40n 0.0 45n 0.0 45n 3.3 50n 3.3 50n 0.0 55n 0.0 ]
alter @VA2[PWL] = [ 0n 3.3 5n 3.3 5n 3.3 10n 3.3 10n 3.3 15n 3.3 15n 0.0 20n 0.0 20n 0.0 25n 0.0 25n 0.0 30n 0.0 30n 3.3 35n 3.3 35n 3.3 40n 3.3 40n 3.3 45n 3.3 45n 0.0 50n 0.0 50n 0.0 55n 0.0 ]
alter @VA1[PWL] = [ 0n 0.0 5n 0.0 5n 3.3 10n 3.3 10n 3.3 15n 3.3 15n 0.0 20n 0.0 20n 0.0 25n 0.0 25n 0.0 30n 0.0 30n 0.0 35n 0.0 35n 0.0 40n 0.0 40n 0.0 45n 0.0 45n 3.3 50n 3.3 50n 0.0 55n 0.0 ]
alter @VA0[PWL] = [ 0n 0.0 5n 0.0 5n 3.3 10n 3.3 10n 3.3 15n 3.3 15n 3.3 20n 3.3 20n 0.0 25n 0.0 25n 0.0 30n 0.0 30n 0.0 35n 0.0 35n 0.0 40n 0.0 40n 0.0 45n 0.0 45n 0.0 50n 0.0 50n 0.0 55n 0.0 ]

** B BUS
alter @VB15[PWL] = [ 0n 0.0 5n 0.0 5n 0.0 10n 0.0 10n 0.0 15n 0.0 15n 0.0 20n 0.0 20n 0.0 25n 0.0 25n 0.0 30n 0.0 30n 0.0 35n 0.0 35n 0.0 40n 0.0 40n 0.0 45n 0.0 45n 0.0 50n 0.0 50n 0.0 55n 0.0 ]
alter @VB14[PWL] = [ 0n 3.3 5n 3.3 5n 0.0 10n 0.0 10n 0.0 15n 0.0 15n 0.0 20n 0.0 20n 0.0 25n 0.0 25n 0.0 30n 0.0 30n 0.0 35n 0.0 35n 3.3 40n 3.3 40n 0.0 45n 0.0 45n 3.3 50n 3.3 50n 0.0 55n 0.0 ]
alter @VB13[PWL] = [ 0n 0.0 5n 0.0 5n 0.0 10n 0.0 10n 0.0 15n 0.0 15n 0.0 20n 0.0 20n 0.0 25n 0.0 25n 0.0 30n 0.0 30n 0.0 35n 0.0 35n 0.0 40n 0.0 40n 0.0 45n 0.0 45n 0.0 50n 0.0 50n 0.0 55n 0.0 ]
alter @VB12[PWL] = [ 0n 0.0 5n 0.0 5n 0.0 10n 0.0 10n 0.0 15n 0.0 15n 3.3 20n 3.3 20n 0.0 25n 0.0 25n 0.0 30n 0.0 30n 3.3 35n 3.3 35n 0.0 40n 0.0 40n 0.0 45n 0.0 45n 3.3 50n 3.3 50n 0.0 55n 0.0 ]
alter @VB11[PWL] = [ 0n 0.0 5n 0.0 5n 0.0 10n 0.0 10n 0.0 15n 0.0 15n 0.0 20n 0.0 20n 0.0 25n 0.0 25n 0.0 30n 0.0 30n 0.0 35n 0.0 35n 0.0 40n 0.0 40n 0.0 45n 0.0 45n 0.0 50n 0.0 50n 3.3 55n 3.3 ]
alter @VB10[PWL] = [ 0n 0.0 5n 0.0 5n 0.0 10n 0.0 10n 0.0 15n 0.0 15n 0.0 20n 0.0 20n 0.0 25n 0.0 25n 0.0 30n 0.0 30n 0.0 35n 0.0 35n 0.0 40n 0.0 40n 0.0 45n 0.0 45n 3.3 50n 3.3 50n 3.3 55n 3.3 ]
alter @VB9[PWL] = [ 0n 3.3 5n 3.3 5n 0.0 10n 0.0 10n 0.0 15n 0.0 15n 3.3 20n 3.3 20n 0.0 25n 0.0 25n 0.0 30n 0.0 30n 3.3 35n 3.3 35n 3.3 40n 3.3 40n 0.0 45n 0.0 45n 0.0 50n 0.0 50n 3.3 55n 3.3 ]
alter @VB8[PWL] = [ 0n 3.3 5n 3.3 5n 0.0 10n 0.0 10n 0.0 15n 0.0 15n 0.0 20n 0.0 20n 0.0 25n 0.0 25n 0.0 30n 0.0 30n 0.0 35n 0.0 35n 3.3 40n 3.3 40n 0.0 45n 0.0 45n 3.3 50n 3.3 50n 3.3 55n 3.3 ]
alter @VB7[PWL] = [ 0n 0.0 5n 0.0 5n 0.0 10n 0.0 10n 0.0 15n 0.0 15n 0.0 20n 0.0 20n 0.0 25n 0.0 25n 0.0 30n 0.0 30n 0.0 35n 0.0 35n 0.0 40n 0.0 40n 3.3 45n 3.3 45n 0.0 50n 0.0 50n 0.0 55n 0.0 ]
alter @VB6[PWL] = [ 0n 0.0 5n 0.0 5n 0.0 10n 0.0 10n 0.0 15n 0.0 15n 0.0 20n 0.0 20n 0.0 25n 0.0 25n 0.0 30n 0.0 30n 0.0 35n 0.0 35n 0.0 40n 0.0 40n 3.3 45n 3.3 45n 3.3 50n 3.3 50n 0.0 55n 0.0 ]
alter @VB5[PWL] = [ 0n 3.3 5n 3.3 5n 0.0 10n 0.0 10n 0.0 15n 0.0 15n 3.3 20n 3.3 20n 0.0 25n 0.0 25n 0.0 30n 0.0 30n 3.3 35n 3.3 35n 3.3 40n 3.3 40n 3.3 45n 3.3 45n 0.0 50n 0.0 50n 0.0 55n 0.0 ]
alter @VB4[PWL] = [ 0n 0.0 5n 0.0 5n 0.0 10n 0.0 10n 0.0 15n 0.0 15n 3.3 20n 3.3 20n 0.0 25n 0.0 25n 0.0 30n 0.0 30n 3.3 35n 3.3 35n 0.0 40n 0.0 40n 3.3 45n 3.3 45n 3.3 50n 3.3 50n 0.0 55n 0.0 ]
alter @VB3[PWL] = [ 0n 0.0 5n 0.0 5n 0.0 10n 0.0 10n 0.0 15n 0.0 15n 0.0 20n 0.0 20n 0.0 25n 0.0 25n 0.0 30n 0.0 30n 0.0 35n 0.0 35n 0.0 40n 0.0 40n 3.3 45n 3.3 45n 0.0 50n 0.0 50n 3.3 55n 3.3 ]
alter @VB2[PWL] = [ 0n 0.0 5n 0.0 5n 0.0 10n 0.0 10n 0.0 15n 0.0 15n 3.3 20n 3.3 20n 0.0 25n 0.0 25n 0.0 30n 0.0 30n 3.3 35n 3.3 35n 0.0 40n 0.0 40n 3.3 45n 3.3 45n 3.3 50n 3.3 50n 3.3 55n 3.3 ]
alter @VB1[PWL] = [ 0n 0.0 5n 0.0 5n 0.0 10n 0.0 10n 0.0 15n 0.0 15n 0.0 20n 0.0 20n 0.0 25n 0.0 25n 0.0 30n 0.0 30n 0.0 35n 0.0 35n 0.0 40n 0.0 40n 3.3 45n 3.3 45n 0.0 50n 0.0 50n 3.3 55n 3.3 ]
alter @VB0[PWL] = [ 0n 3.3 5n 3.3 5n 3.3 10n 3.3 10n 3.3 15n 3.3 15n 0.0 20n 0.0 20n 3.3 25n 3.3 25n 3.3 30n 3.3 30n 0.0 35n 0.0 35n 3.3 40n 3.3 40n 3.3 45n 3.3 45n 3.3 50n 3.3 50n 3.3 55n 3.3 ]

** CONTROL
alter @VSEL1[PWL] = [ 0n 0.0 5n 0.0 5n 0.0 10n 0.0 10n 0.0 15n 0.0 15n 0.0 20n 0.0 20n 0.0 25n 0.0 25n 0.0 30n 0.0 30n 0.0 35n 0.0 35n 0.0 40n 0.0 40n 0.0 45n 0.0 45n 3.3 50n 3.3 50n 3.3 55n 3.3 ]
alter @VSEL0[PWL] = [ 0n 0.0 5n 0.0 5n 0.0 10n 0.0 10n 0.0 15n 0.0 15n 0.0 20n 0.0 20n 0.0 25n 0.0 25n 0.0 30n 0.0 30n 0.0 35n 0.0 35n 0.0 40n 0.0 40n 3.3 45n 3.3 45n 0.0 50n 0.0 50n 3.3 55n 3.3 ]
alter @VCIN[PWL]  = [ 0n 0.0 5n 0.0 5n 0.0 10n 0.0 10n 0.0 15n 0.0 15n 3.3 20n 3.3 20n 3.3 25n 3.3 25n 3.3 30n 3.3 30n 3.3 35n 3.3 35n 3.3 40n 3.3 40n 0.0 45n 0.0 45n 0.0 50n 0.0 50n 0.0 55n 0.0 ]

tran 0.005n 55n

write alu_tb.raw

.endc
