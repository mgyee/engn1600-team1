** sch_path: /foss/designs/engn1600-team1/CAD4/xor2.sch
.subckt xor2 VDD OUT IN0 IN1 VSS
*.PININFO VSS:B VDD:B IN0:I IN1:I OUT:O
M1 net3 IN1 VDD VDD pfet_03v3 L=0.28u W=1.44u nf=1 m=1
M2 net2 IN0 net3 VDD pfet_03v3 L=0.28u W=1.44u nf=1 m=1
M3 net2 IN0 VSS VSS nfet_03v3 L=0.28u W=0.72u nf=1 m=1
M5 OUT net2 VSS VSS nfet_03v3 L=0.28u W=0.72u nf=1 m=1
M6 net2 IN1 VSS VSS nfet_03v3 L=0.28u W=0.72u nf=1 m=1
M7 OUT IN0 net1 VDD pfet_03v3 L=0.28u W=1.44u nf=1 m=1
M8 OUT IN1 net1 VDD pfet_03v3 L=0.28u W=1.44u nf=1 m=1
M9 net1 net2 VDD VDD pfet_03v3 L=0.28u W=1.44u nf=1 m=1
M10 OUT IN1 net4 VSS nfet_03v3 L=0.28u W=0.72u nf=1 m=1
M11 net4 IN0 VSS VSS nfet_03v3 L=0.28u W=0.72u nf=1 m=1
.ends
