** sch_path: /foss/designs/engn1600-team1/CAD4/alu_2x1_mux_cmos.sch
.subckt 2x1_mux_cmos A SEL SELb Y VDD VSS B Yb
*.PININFO A:I B:I SEL:I Y:O VDD:B VSS:B SELb:I Yb:O
M1 VSS B net1 VSS nfet_03v3 L=0.28u W='2.5*0.36u' nf=1 m=1
M2 net1 SEL Yb VSS nfet_03v3 L=0.28u W='1.875*0.36u' nf=1 m=1
M3 Yb SELb net2 VSS nfet_03v3 L=0.28u W='1.875*0.36u' nf=1 m=1
M4 net2 A VSS VSS nfet_03v3 L=0.28u W='2.5*0.36u' nf=1 m=1
M5 net3 SELb Yb VDD pfet_03v3 L=0.28u W='1.875*0.72u' nf=1 m=1
M6 VDD B net3 VDD pfet_03v3 L=0.28u W='2.5*0.72u' nf=1 m=1
M7 net4 A VDD VDD pfet_03v3 L=0.28u W='2.5*0.72u' nf=1 m=1
M8 Yb SEL net4 VDD pfet_03v3 L=0.28u W='1.875*0.72u' nf=1 m=1
M9 VSS Yb Y VSS nfet_03v3 L=0.28u W='0.775/0.36*0.36u' nf=1 m=1
M10 VDD Yb Y VDD pfet_03v3 L=0.28u W='0.775/0.36*0.72u' nf=1 m=1
**** begin user architecture code

.param kI=2.5
.param kYb=1.875
.param kY=0.775/0.36

**** end user architecture code
.ends
