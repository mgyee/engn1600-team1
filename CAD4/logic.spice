** sch_path: /foss/designs/engn1600-team1/CAD4/logic.sch
.subckt logic NOR VDD VSS XNOR A B NAND XOR
*.PININFO VSS:B VDD:B A:I B:I NAND:O NOR:O XNOR:O XOR:O
x1 VDD NAND A B VSS nand2
x3 VDD NOR net1 VSS inv
x2 VDD NOR A B VSS nor2
x4 VDD XNOR NAND net1 VSS nand2
x6 VDD XNOR XOR VSS inv
.ends

* expanding   symbol:  engn1600-team1/CAD4/nand2.sym # of pins=5
** sym_path: /foss/designs/engn1600-team1/CAD4/nand2.sym
** sch_path: /foss/designs/engn1600-team1/CAD4/nand2.sch
.subckt nand2 VDD OUT IN0 IN1 VSS
*.PININFO VSS:B VDD:B IN0:I IN1:I OUT:O
M1 net1 IN1 VSS VSS nfet_03v3 L=0.28u W=0.72u nf=1 m=1
M2 OUT IN0 net1 VSS nfet_03v3 L=0.28u W=0.72u nf=1 m=1
M3 OUT IN1 VDD VDD pfet_03v3 L=0.28u W=0.72u nf=1 m=1
M4 OUT IN0 VDD VDD pfet_03v3 L=0.28u W=0.72u nf=1 m=1
.ends

* expanding   symbol:  engn1600-team1/CAD4/inv.sym # of pins=4
** sym_path: /foss/designs/engn1600-team1/CAD4/inv.sym
** sch_path: /foss/designs/engn1600-team1/CAD4/inv.sch
.subckt inv VDD IN OUT VSS
*.PININFO IN:I OUT:O VDD:B VSS:B
M1 OUT IN VDD VDD pfet_03v3 L=0.28u W=0.72u nf=1 m=1
M2 OUT IN VSS VSS nfet_03v3 L=0.28u W=0.36u nf=1 m=1
.ends

* expanding   symbol:  engn1600-team1/CAD4/nor2.sym # of pins=5
** sym_path: /foss/designs/engn1600-team1/CAD4/nor2.sym
** sch_path: /foss/designs/engn1600-team1/CAD4/nor2.sch
.subckt nor2 VDD OUT IN0 IN1 VSS
*.PININFO VSS:B VDD:B IN0:I IN1:I OUT:O
M1 OUT IN0 VSS VSS nfet_03v3 L=0.28u W=0.36u nf=1 m=1
M2 OUT IN1 VSS VSS nfet_03v3 L=0.28u W=0.36u nf=1 m=1
M3 net1 IN1 VDD VDD pfet_03v3 L=0.28u W=1.44u nf=1 m=1
M4 OUT IN0 net1 VDD pfet_03v3 L=0.28u W=1.44u nf=1 m=1
.ends
