** sch_path: /foss/designs/CAD2/DFF.sch
.subckt DFF RSTn VDD Q D VSS CLK Qb
*.PININFO D:I RSTn:I Q:O Qb:O CLK:B VDD:B VSS:B
x1 VDD c net6 D cbar VSS TRI_STATE_INV
x2 c VDD VSS net1 net6 cbar TGATE
x3 VDD net6 net2 VSS INV
x4 VDD net2 net1 RSTn VSS NAND2
x5 c VDD VSS net2 net4 cbar TGATE
x6 VDD net4 net3 RSTn VSS NAND2
x7 VDD c net4 net3 cbar VSS TRI_STATE_INV
x8 VDD net3 Q VSS INV
x9 VDD net3 net5 VSS INV
x10 VDD net5 Qb VSS INV
x11 VDD CLK cbar VSS INV
x12 VDD cbar c VSS INV
.ends

* expanding   symbol:  CAD2/TRI_STATE_INV.sym # of pins=6
** sym_path: /foss/designs/CAD2/TRI_STATE_INV.sym
** sch_path: /foss/designs/CAD2/TRI_STATE_INV.sch
.subckt TRI_STATE_INV VDD CLK OUT IN CLKN VSS
*.PININFO VSS:B VDD:B CLK:B CLKN:B IN:I OUT:O
M1 net1 CLK VDD VDD pfet_03v3 L=0.28u W=4u nf=1 m=1
M2 OUT IN net1 VDD pfet_03v3 L=0.28u W=4u nf=1 m=1
M3 OUT IN net2 VSS nfet_03v3 L=0.28u W=2u nf=1 m=1
M4 net2 CLKN VSS VSS nfet_03v3 L=0.28u W=2u nf=1 m=1
.ends

* expanding   symbol:  CAD2/TGATE.sym # of pins=6
** sym_path: /foss/designs/CAD2/TGATE.sym
** sch_path: /foss/designs/CAD2/TGATE.sch
.subckt TGATE CLK VDD VSS IN OUT CLKN
*.PININFO IN:I OUT:O CLKN:B CLK:B VDD:B VSS:B
M1 IN CLK OUT VSS nfet_03v3 L=0.28u W=1u nf=1 m=1
M2 IN CLKN OUT VDD pfet_03v3 L=0.28u W=2u nf=1 m=1
.ends

* expanding   symbol:  CAD2/INV.sym # of pins=4
** sym_path: /foss/designs/CAD2/INV.sym
** sch_path: /foss/designs/CAD2/INV.sch
.subckt INV vdd IN OUT vss
*.PININFO IN:I OUT:O vss:B vdd:B
M1 OUT IN vss vss nfet_03v3 L=0.28u W=1u nf=1 m=1
M2 OUT IN vdd vdd pfet_03v3 L=0.28u W=2u nf=1 m=1
.ends

* expanding   symbol:  CAD2/NAND2.sym # of pins=5
** sym_path: /foss/designs/CAD2/NAND2.sym
** sch_path: /foss/designs/CAD2/NAND2.sch
.subckt NAND2 vdd INO OUT IN1 vss
*.PININFO INO:I IN1:I vdd:B vss:B OUT:O
M1 OUT INO net1 vss nfet_03v3 L=0.28u W=2u nf=1 m=1
M2 net1 IN1 vss vss nfet_03v3 L=0.28u W=2u nf=1 m=1
M3 OUT INO vdd vdd pfet_03v3 L=0.28u W=2u nf=1 m=1
M4 OUT IN1 vdd vdd pfet_03v3 L=0.28u W=2u nf=1 m=1
.ends
