** sch_path: /foss/designs/CAD2/TGATE.sch
.subckt TGATE CLK VDD VSS IN OUT CLKN
*.PININFO IN:I OUT:O CLKN:B CLK:B VDD:B VSS:B
M1 IN CLKN OUT VSS nfet_03v3 L=0.28u W=1u nf=1 m=1
M2 IN CLK OUT VDD pfet_03v3 L=0.28u W=2u nf=1 m=1
.ends
