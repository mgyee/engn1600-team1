** sch_path: /foss/designs/CAD2/DFF_Loop_PostPex_Testbench.sch
**.subckt DFF_Loop_PostPex_Testbench
V1 VDD GND 3.3
V2 VSS GND 0
V3 CLK GND 3
V4 D GND 3
V5 RSTn GND 3.3
C1 Qb GND 10f m=1
C2 Q GND 10f m=1
**** begin user architecture code

.include /foss/pdks/gf180mcuD/libs.tech/ngspice/design.ngspice
.lib /foss/pdks/gf180mcuD/libs.tech/ngspice/sm141064.ngspice typical

.subckt DFF_flat RSTn Q CLK D Qb VSS VDD
X0 a_1071_1500# a_n907_1431# VDD.t27 VDD.t26 pfet_03v3 ad=1.04p pd=4.52u as=2.6p ps=9.3u w=4u l=0.28u
X1 a_3022_1567# a_2285_219# VDD.t1 VDD.t0 pfet_03v3 ad=0.52p pd=2.52u as=1.3p ps=5.3u w=2u l=0.28u
X2 a_n907_1431# a_n2195_1438.t2 VSS.t10 VSS.t9 nfet_03v3 ad=0.61p pd=3.22u as=0.61p ps=3.22u w=1u l=0.28u
X3 Q.t0 a_6555_1638# VSS.t19 VSS.t18 nfet_03v3 ad=0.61p pd=3.22u as=0.61p ps=3.22u w=1u l=0.28u
X4 a_7454_2228# a_n2195_1438.t3 VSS.t8 VSS.t7 nfet_03v3 ad=0.52p pd=2.52u as=1.22p ps=5.22u w=2u l=0.28u
X5 a_8183_2228# a_n907_1431# VDD.t25 VDD.t24 pfet_03v3 ad=1.04p pd=4.52u as=2.6p ps=9.3u w=4u l=0.28u
X6 VDD.t15 RSTn.t0 a_3022_1567# VDD.t14 pfet_03v3 ad=1.3p pd=5.3u as=0.52p ps=2.52u w=2u l=0.28u
X7 a_2285_219# a_1231_771# VSS.t23 VSS.t22 nfet_03v3 ad=0.61p pd=3.22u as=0.61p ps=3.22u w=1u l=0.28u
X8 VDD.t8 a_5268_1150# a_6555_1638# VDD.t7 pfet_03v3 ad=1.3p pd=5.3u as=0.52p ps=2.52u w=2u l=0.28u
X9 a_6555_912# RSTn.t1 VSS.t4 VSS.t3 nfet_03v3 ad=0.52p pd=2.52u as=1.22p ps=5.22u w=2u l=0.28u
X10 VSS.t1 RSTn.t2 a_3975_879# VSS.t0 nfet_03v3 ad=1.22p pd=5.22u as=0.52p ps=2.52u w=2u l=0.28u
X11 Qb.t0 a_9035_317# VSS.t13 VSS.t12 nfet_03v3 ad=0.61p pd=3.22u as=0.61p ps=3.22u w=1u l=0.28u
X12 a_3022_1567# a_n907_1431# a_1231_771# VSS.t25 nfet_03v3 ad=0.61p pd=3.22u as=0.61p ps=3.22u w=1u l=0.28u
X13 a_9035_317# a_6555_1638# VSS.t17 VSS.t16 nfet_03v3 ad=0.61p pd=3.22u as=0.61p ps=3.22u w=1u l=0.28u
X14 a_3975_879# a_2285_219# a_3022_1567# VSS.t2 nfet_03v3 ad=0.52p pd=2.52u as=1.22p ps=5.22u w=2u l=0.28u
X15 a_n2195_1438.t1 CLK.t0 VSS.t21 VSS.t20 nfet_03v3 ad=0.61p pd=3.22u as=0.61p ps=3.22u w=1u l=0.28u
X16 Q.t1 a_6555_1638# VDD.t13 VDD.t12 pfet_03v3 ad=1.3p pd=5.3u as=1.3p ps=5.3u w=2u l=0.28u
X17 a_1071_771# a_n2195_1438.t4 VSS.t6 VSS.t5 nfet_03v3 ad=0.52p pd=2.52u as=1.22p ps=5.22u w=2u l=0.28u
X18 a_5268_1150# a_n907_1431# a_2285_219# VSS.t24 nfet_03v3 ad=0.61p pd=3.22u as=0.61p ps=3.22u w=1u l=0.28u
X19 a_n907_1431# a_n2195_1438.t5 VDD.t22 VDD.t21 pfet_03v3 ad=1.3p pd=5.3u as=1.3p ps=5.3u w=2u l=0.28u
X20 a_3022_1567# a_n2195_1438.t6 a_1231_771# VDD.t16 pfet_03v3 ad=1.3p pd=5.3u as=1.3p ps=5.3u w=2u l=0.28u
X21 a_6555_1638# RSTn.t3 VDD.t4 VDD.t3 pfet_03v3 ad=0.52p pd=2.52u as=1.3p ps=5.3u w=2u l=0.28u
X22 a_5268_1150# a_n2195_1438.t7 a_2285_219# VDD.t2 pfet_03v3 ad=1.3p pd=5.3u as=1.3p ps=5.3u w=2u l=0.28u
X23 a_2285_219# a_1231_771# VDD.t20 VDD.t19 pfet_03v3 ad=1.3p pd=5.3u as=1.3p ps=5.3u w=2u l=0.28u
X24 a_1231_771# D.t0 a_1071_771# VSS.t11 nfet_03v3 ad=1.22p pd=5.22u as=0.52p ps=2.52u w=2u l=0.28u
X25 a_n2195_1438.t0 CLK.t1 VDD.t18 VDD.t17 pfet_03v3 ad=1.3p pd=5.3u as=1.3p ps=5.3u w=2u l=0.28u
X26 Qb.t1 a_9035_317# VDD.t6 VDD.t5 pfet_03v3 ad=1.3p pd=5.3u as=1.3p ps=5.3u w=2u l=0.28u
X27 a_5268_1150# a_6555_1638# a_7454_2228# VSS.t15 nfet_03v3 ad=1.22p pd=5.22u as=0.52p ps=2.52u w=2u l=0.28u
X28 a_6555_1638# a_5268_1150# a_6555_912# VSS.t14 nfet_03v3 ad=1.22p pd=5.22u as=0.52p ps=2.52u w=2u l=0.28u
X29 a_9035_317# a_6555_1638# VDD.t11 VDD.t10 pfet_03v3 ad=1.3p pd=5.3u as=1.3p ps=5.3u w=2u l=0.28u
X30 a_5268_1150# a_6555_1638# a_8183_2228# VDD.t9 pfet_03v3 ad=2.6p pd=9.3u as=1.04p ps=4.52u w=4u l=0.28u
X31 a_1231_771# D.t1 a_1071_1500# VDD.t23 pfet_03v3 ad=2.6p pd=9.3u as=1.04p ps=4.52u w=4u l=0.28u
R0 VDD.n11 VDD.t2 395.863
R1 VDD.n15 VDD.t16 395.464
R2 VDD.n17 VDD.t17 386.182
R3 VDD.n18 VDD.t21 386.182
R4 VDD.n2 VDD.t12 386.182
R5 VDD.n12 VDD.t14 386.026
R6 VDD.n8 VDD.t3 386.026
R7 VDD.n5 VDD.t5 385.858
R8 VDD.n3 VDD.t10 385.858
R9 VDD.n0 VDD.t19 385.858
R10 VDD.n20 VDD.t26 241.577
R11 VDD.n1 VDD.t24 241.577
R12 VDD.t14 VDD.t0 236.686
R13 VDD.t3 VDD.t7 236.686
R14 VDD.t26 VDD.t23 148.7
R15 VDD.t24 VDD.t9 148.7
R16 VDD.n16 VDD.n0 11.2146
R17 VDD.n21 VDD.n19 10.9694
R18 VDD.n10 VDD.n7 10.694
R19 VDD.n21 VDD.n20 9.9254
R20 VDD.n14 VDD.n13 9.9074
R21 VDD.n10 VDD.n9 9.62838
R22 VDD.n13 VDD.t1 4.20008
R23 VDD.n9 VDD.t8 4.16561
R24 VDD.n5 VDD.t6 3.52831
R25 VDD.n3 VDD.t11 3.52831
R26 VDD.n0 VDD.t20 3.52831
R27 VDD.n12 VDD.t15 3.20383
R28 VDD.n17 VDD.t18 3.20383
R29 VDD.n18 VDD.t22 3.20383
R30 VDD.n8 VDD.t4 3.20383
R31 VDD.n2 VDD.t13 3.20383
R32 VDD.n19 VDD.n17 2.19361
R33 VDD.n4 VDD.n2 1.66763
R34 VDD.n20 VDD.t27 1.61523
R35 VDD.n1 VDD.t25 1.61523
R36 VDD.n6 VDD.n5 1.24609
R37 VDD.n7 VDD.n6 0.626994
R38 VDD.n7 VDD.n1 0.597342
R39 VDD.n6 VDD.n4 0.5165
R40 VDD.n19 VDD.n18 0.483789
R41 VDD.n4 VDD.n3 0.430289
R42 VDD.n13 VDD.n12 0.372822
R43 VDD.n9 VDD.n8 0.367349
R44 VDD.n15 VDD.n14 0.345345
R45 VDD.n14 VDD.n11 0.299878
R46 VDD VDD.n16 0.232029
R47 VDD.n11 VDD.n10 0.212909
R48 VDD.n16 VDD.n15 0.173039
R49 VDD VDD.n21 0.0531943
R50 a_n2195_1438.n0 a_n2195_1438.t3 87.7196
R51 a_n2195_1438.n4 a_n2195_1438.t5 51.0281
R52 a_n2195_1438.n1 a_n2195_1438.t6 50.6747
R53 a_n2195_1438.n0 a_n2195_1438.t7 50.2216
R54 a_n2195_1438.n2 a_n2195_1438.t4 46.3543
R55 a_n2195_1438.n4 a_n2195_1438.t2 24.5076
R56 a_n2195_1438.n2 a_n2195_1438.n1 10.22
R57 a_n2195_1438.n3 a_n2195_1438.t1 9.16629
R58 a_n2195_1438.n5 a_n2195_1438.n4 9.1542
R59 a_n2195_1438.t0 a_n2195_1438.n5 4.15419
R60 a_n2195_1438.n3 a_n2195_1438.n2 2.78897
R61 a_n2195_1438.n1 a_n2195_1438.n0 2.00183
R62 a_n2195_1438.n5 a_n2195_1438.n3 0.161929
R63 VSS.n14 VSS.t12 226642
R64 VSS.n18 VSS.n14 184560
R65 VSS.n44 VSS.n43 133540
R66 VSS.n39 VSS.n2 17254.7
R67 VSS.t15 VSS.n11 14122.1
R68 VSS.n44 VSS.n39 11797.5
R69 VSS.t7 VSS.n29 9648.44
R70 VSS.n39 VSS.n3 8020.78
R71 VSS.n16 VSS.n15 7126.25
R72 VSS.n15 VSS.n11 6081.19
R73 VSS.n15 VSS.n12 5511.42
R74 VSS.n30 VSS.t15 5510.19
R75 VSS.n30 VSS.n8 5387.1
R76 VSS.n32 VSS.n31 5356.33
R77 VSS.n5 VSS.n2 4515.96
R78 VSS.n31 VSS.n3 4279.67
R79 VSS.n31 VSS.n30 3896.87
R80 VSS.n29 VSS.n26 3021.58
R81 VSS.n39 VSS.n38 2668.72
R82 VSS.n9 VSS.n3 2106.65
R83 VSS.t7 VSS.n12 1568.53
R84 VSS.n16 VSS.t18 1415.5
R85 VSS.n18 VSS.t16 1388.38
R86 VSS.n44 VSS.t9 1384.01
R87 VSS.n43 VSS.n41 1373.43
R88 VSS.n45 VSS.n44 1305.79
R89 VSS.n17 VSS.n16 1071.84
R90 VSS.n19 VSS.n18 1060.83
R91 VSS.n38 VSS.t22 1027.96
R92 VSS.t24 VSS.n32 881.659
R93 VSS.t22 VSS.n5 865.283
R94 VSS.t2 VSS.n9 798.481
R95 VSS.n26 VSS.t18 795.788
R96 VSS.n19 VSS.t12 789.602
R97 VSS.t16 VSS.n17 783.51
R98 VSS.n28 VSS.n8 700.11
R99 VSS.n33 VSS.n8 699.832
R100 VSS.n32 VSS.n10 699.032
R101 VSS.n9 VSS.t25 691.242
R102 VSS.n2 VSS.t11 568.894
R103 VSS.n29 VSS.t14 525.971
R104 VSS.t15 VSS.t7 489.642
R105 VSS.n45 VSS.t5 480.486
R106 VSS.n10 VSS.t0 452.394
R107 VSS.n14 VSS.n11 450.853
R108 VSS.n33 VSS.t24 446.183
R109 VSS.t3 VSS.n28 444.233
R110 VSS.t20 VSS.n42 388.132
R111 VSS.n41 VSS.t9 377.731
R112 VSS.n37 VSS.t25 363.048
R113 VSS.t11 VSS.t5 307.51
R114 VSS.t0 VSS.t2 289.533
R115 VSS.t14 VSS.t3 284.308
R116 VSS.n38 VSS.n37 275.916
R117 VSS.n43 VSS.t20 194.91
R118 VSS.n37 VSS.n36 21.3351
R119 VSS.n34 VSS.n33 20.975
R120 VSS.n23 VSS.n22 11.1066
R121 VSS.n26 VSS.n25 10.4858
R122 VSS.n41 VSS.n40 10.4005
R123 VSS.n5 VSS.n4 10.4005
R124 VSS.n20 VSS.n19 10.4005
R125 VSS.n17 VSS.n13 10.4005
R126 VSS.n42 VSS.n1 10.3684
R127 VSS.n35 VSS.n6 10.1004
R128 VSS.n47 VSS.n46 10.1003
R129 VSS.n27 VSS.n7 10.0608
R130 VSS.n40 VSS.n1 9.5066
R131 VSS.n25 VSS.n24 9.40565
R132 VSS.n24 VSS.n21 9.3605
R133 VSS.n4 VSS.n0 9.36007
R134 VSS.n40 VSS.t10 8.98866
R135 VSS.n42 VSS.t21 8.98866
R136 VSS.n4 VSS.t23 8.98866
R137 VSS.n13 VSS.t17 8.94247
R138 VSS.n20 VSS.t13 8.94247
R139 VSS.n25 VSS.t19 8.90339
R140 VSS.n46 VSS.t6 3.5074
R141 VSS.n22 VSS.t8 3.5074
R142 VSS.n6 VSS.t1 3.5041
R143 VSS.n27 VSS.t4 3.5041
R144 VSS.n46 VSS.n45 3.46717
R145 VSS.n10 VSS.n6 3.46717
R146 VSS.n22 VSS.n12 3.46717
R147 VSS.n28 VSS.n27 3.46717
R148 VSS.n47 VSS.n1 2.24722
R149 VSS.n21 VSS.n20 1.29511
R150 VSS.n36 VSS.n35 0.414593
R151 VSS VSS.n0 0.279127
R152 VSS.n23 VSS.n7 0.240655
R153 VSS.n21 VSS.n13 0.238942
R154 VSS.n35 VSS.n34 0.225966
R155 VSS.n36 VSS.n0 0.173272
R156 VSS.n24 VSS.n23 0.151122
R157 VSS.n34 VSS.n7 0.146459
R158 VSS VSS.n47 0.00399741
R159 Q Q.t0 9.28486
R160 Q Q.t1 4.29561
R161 RSTn.n1 RSTn.t0 50.7239
R162 RSTn.n0 RSTn.t1 50.7239
R163 RSTn.n1 RSTn.t2 37.5434
R164 RSTn.n0 RSTn.t3 37.5434
R165 RSTn RSTn.n0 12.0066
R166 RSTn RSTn.n1 8.00751
R167 Qb Qb.t0 9.32629
R168 Qb Qb.t1 4.25419
R169 CLK.n0 CLK.t1 51.0281
R170 CLK.n0 CLK.t0 24.5076
R171 CLK CLK.n0 8.47482
R172 D.n0 D.t1 77.0995
R173 D.n0 D.t0 37.5434
R174 D D.n0 8.00642
C0 D VDD 0.13303f
C1 Q VDD 0.27479f
C2 a_6555_1638# a_n907_1431# 0.31084f
C3 a_5268_1150# RSTn 0.26779f
C4 VDD a_8183_2228# 0.31677f
C5 a_1231_771# a_3022_1567# 0.24466f
C6 a_5268_1150# a_2285_219# 0.24106f
C7 RSTn a_2285_219# 0.26464f
C8 a_6555_1638# a_6555_912# 0.13246f
C9 VDD a_3022_1567# 0.70996f
C10 a_3975_879# a_3022_1567# 0.13226f
C11 VDD a_6555_1638# 1.43768f
C12 a_1071_1500# a_1231_771# 0.28032f
C13 Q a_6555_1638# 0.2423f
C14 a_9035_317# VDD 0.53205f
C15 a_1071_1500# VDD 0.29881f
C16 a_2285_219# a_n907_1431# 0.35134f
C17 CLK VDD 0.25038f
C18 a_1231_771# a_1071_771# 0.11961f
C19 a_5268_1150# VDD 0.88681f
C20 RSTn VDD 1.22466f
C21 m1_2226_1141# a_2285_219# 0.13517f
C22 Qb VDD 0.1711f
C23 VDD a_2285_219# 0.3928f
C24 a_1231_771# a_n907_1431# 0.20468f
C25 a_5268_1150# a_8183_2228# 0.28027f
C26 VDD a_n907_1431# 1.52577f
C27 a_5268_1150# a_6555_1638# 0.23736f
C28 VDD a_1231_771# 0.89549f
C29 Q a_n907_1431# 0.12174f
C30 a_2285_219# a_3022_1567# 0.20168f
C31 a_5268_1150# a_7454_2228# 0.12027f
C32 Qb VSS 0.42789f
C33 Q VSS 0.25938f
C34 RSTn VSS 1.85481f
C35 D VSS 0.26137f
C36 CLK VSS 0.50463f
C37 VDD VSS 28.63657f
C38 a_9035_317# VSS 0.89696f
C39 a_6555_912# VSS 0.13827f
C40 a_3975_879# VSS 0.13382f
C41 a_1071_771# VSS 0.13922f
C42 a_7454_2228# VSS 0.12773f
C43 a_6555_1638# VSS 3.50714f
C44 a_2285_219# VSS 2.34894f
C45 a_3022_1567# VSS 0.73695f
C46 a_n907_1431# VSS 5.87311f
C47 a_1231_771# VSS 1.78471f
C48 a_5268_1150# VSS 2.50453f
C49 a_n2195_1438.n0 VSS 0.57441f
C50 a_n2195_1438.n1 VSS 0.61259f
C51 a_n2195_1438.n2 VSS 0.45497f
C52 a_n2195_1438.n3 VSS 0.20435f
C53 a_n2195_1438.n5 VSS 0.20515f
C54 VDD.n10 VSS 0.28207f
C55 VDD.n11 VSS 0.13236f
C56 VDD.n14 VSS 0.10725f
C57 VDD.n15 VSS 0.12595f
.ends

X0 RSTn Q CLK D Qb VSS VDD DFF_flat

.control
save all

** Define input signals
let fclock = 10e6
let clockper = 1/fclock
let inputper = clockper*2
let resetper = clockper*8
let clocktfr = 0.01*clockper
let clockton = 0.5*clockper - 2*clocktfr
let resettfr = 0.01*resetper
let reseton = 0.5*resetper - 2*resettfr
let inputtfr = 0.01*inputper
let inputton = 0.5*inputper - 2*inputtfr

** Define transient params
let tstop = 10*clockper
let tstep = 0.001*clockper

** Set source
alter @v3[DC] = 0.0
alter @v3[PULSE] = [ 0 3.3 150n  $&clocktfr $&clocktfr $&clockton $&clockper 0 ]
alter @v4[PULSE] = [ 0 3.3 0 $&inputtfr $&inputtfr $&inputton $&inputper 0]
alter @v5[PULSE] = [ 3.3 0 0 $&resettfr $&resettfr $&reseton $&resetper 0]

**Set sweep parameters
let setuptimestart = 200p
let setuptimeend = 0p
let deltatime = 100p
let setuptime = setuptimestart

** Sweep Simulations
while setuptime ge setuptimeend
    reset
    alter @v3[PULSE] = [ 0 3.3 $&(200n-setuptime)  $&clocktfr $&clocktfr $&clockton $&clockper 0 ]
    tran $&tstep $&tstop
    setplot tran1
    meas tran TRIG v(clk) VAL=0.1 RISE=6 TARG v(q) VAL=0.1 FALL=2
    let setuptime = setuptime - deltatime
end

** Save waveform
write DFF_Post_Pex_Testbench.raw
.endc

**** end user architecture code
**.ends
.GLOBAL GND
.end
