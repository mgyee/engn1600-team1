** TEST SUMMARY
** 00: INCR
** 01: RESET
** 02: INCR
** 03: BR by 16
** 04: INCR
** 05: BR by -16
** 06: INCR
** 07: JMP to 0x1234
** 08: INCR
** 09: JMP to 0x3579
** 10: SI bit 0
** 11: SI bit 0
** 12: SI bit 0
** 13: SI bit 0
** 14: SI bit 0
** 15: SI bit 0
** 16: SI bit 0
** 17: SI bit 0
** 18: SI bit 0
** 19: SI bit 0
** 20: SI bit 0
** 21: SI bit 0
** 22: SI bit 0
** 23: SI bit 0
** 24: SI bit 0
** 25: SI bit 0
** 26: SI bit 0
** 27: SI bit 1
** 28: SI bit 0
** 29: SI bit 1
** 30: SI bit 0
** 31: SI bit 1
** 32: SI bit 0
** 33: SI bit 1
** 34: SI bit 0
** 35: SI bit 1
** 36: SI bit 0
** 37: SI bit 1
** 38: SI bit 0
** 39: SI bit 1
** 40: SI bit 0
** 41: SI bit 1

.control
save all

** Define input signals

** DEST BUS
alter @VDEST15[PWL] = [ 0n 0.0 10n 0.0 10n 0.0 20n 0.0 20n 0.0 30n 0.0 30n 0.0 40n 0.0 40n 0.0 50n 0.0 50n 0.0 60n 0.0 60n 0.0 70n 0.0 70n 0.0 80n 0.0 80n 0.0 90n 0.0 90n 0.0 100n 0.0 100n 3.3 110n 3.3 110n 3.3 120n 3.3 120n 3.3 130n 3.3 130n 3.3 140n 3.3 140n 3.3 150n 3.3 150n 3.3 160n 3.3 160n 3.3 170n 3.3 170n 3.3 180n 3.3 180n 3.3 190n 3.3 190n 3.3 200n 3.3 200n 3.3 210n 3.3 210n 3.3 220n 3.3 220n 3.3 230n 3.3 230n 3.3 240n 3.3 240n 3.3 250n 3.3 250n 3.3 260n 3.3 260n 3.3 270n 3.3 270n 3.3 280n 3.3 280n 3.3 290n 3.3 290n 3.3 300n 3.3 300n 3.3 310n 3.3 310n 3.3 320n 3.3 320n 3.3 330n 3.3 330n 3.3 340n 3.3 340n 3.3 350n 3.3 350n 3.3 360n 3.3 360n 3.3 370n 3.3 370n 3.3 380n 3.3 380n 3.3 390n 3.3 390n 3.3 400n 3.3 400n 3.3 410n 3.3 410n 3.3 420n 3.3 ]
alter @VDEST14[PWL] = [ 0n 0.0 10n 0.0 10n 0.0 20n 0.0 20n 0.0 30n 0.0 30n 0.0 40n 0.0 40n 0.0 50n 0.0 50n 0.0 60n 0.0 60n 0.0 70n 0.0 70n 0.0 80n 0.0 80n 0.0 90n 0.0 90n 0.0 100n 0.0 100n 3.3 110n 3.3 110n 3.3 120n 3.3 120n 3.3 130n 3.3 130n 3.3 140n 3.3 140n 3.3 150n 3.3 150n 3.3 160n 3.3 160n 3.3 170n 3.3 170n 3.3 180n 3.3 180n 3.3 190n 3.3 190n 3.3 200n 3.3 200n 3.3 210n 3.3 210n 3.3 220n 3.3 220n 3.3 230n 3.3 230n 3.3 240n 3.3 240n 3.3 250n 3.3 250n 3.3 260n 3.3 260n 3.3 270n 3.3 270n 3.3 280n 3.3 280n 3.3 290n 3.3 290n 3.3 300n 3.3 300n 3.3 310n 3.3 310n 3.3 320n 3.3 320n 3.3 330n 3.3 330n 3.3 340n 3.3 340n 3.3 350n 3.3 350n 3.3 360n 3.3 360n 3.3 370n 3.3 370n 3.3 380n 3.3 380n 3.3 390n 3.3 390n 3.3 400n 3.3 400n 3.3 410n 3.3 410n 3.3 420n 3.3 ]
alter @VDEST13[PWL] = [ 0n 0.0 10n 0.0 10n 0.0 20n 0.0 20n 0.0 30n 0.0 30n 0.0 40n 0.0 40n 0.0 50n 0.0 50n 0.0 60n 0.0 60n 0.0 70n 0.0 70n 0.0 80n 0.0 80n 0.0 90n 0.0 90n 3.3 100n 3.3 100n 3.3 110n 3.3 110n 3.3 120n 3.3 120n 3.3 130n 3.3 130n 3.3 140n 3.3 140n 3.3 150n 3.3 150n 3.3 160n 3.3 160n 3.3 170n 3.3 170n 3.3 180n 3.3 180n 3.3 190n 3.3 190n 3.3 200n 3.3 200n 3.3 210n 3.3 210n 3.3 220n 3.3 220n 3.3 230n 3.3 230n 3.3 240n 3.3 240n 3.3 250n 3.3 250n 3.3 260n 3.3 260n 3.3 270n 3.3 270n 3.3 280n 3.3 280n 3.3 290n 3.3 290n 3.3 300n 3.3 300n 3.3 310n 3.3 310n 3.3 320n 3.3 320n 3.3 330n 3.3 330n 3.3 340n 3.3 340n 3.3 350n 3.3 350n 3.3 360n 3.3 360n 3.3 370n 3.3 370n 3.3 380n 3.3 380n 3.3 390n 3.3 390n 3.3 400n 3.3 400n 3.3 410n 3.3 410n 3.3 420n 3.3 ]
alter @VDEST12[PWL] = [ 0n 0.0 10n 0.0 10n 0.0 20n 0.0 20n 0.0 30n 0.0 30n 0.0 40n 0.0 40n 0.0 50n 0.0 50n 0.0 60n 0.0 60n 0.0 70n 0.0 70n 3.3 80n 3.3 80n 0.0 90n 0.0 90n 3.3 100n 3.3 100n 3.3 110n 3.3 110n 3.3 120n 3.3 120n 3.3 130n 3.3 130n 3.3 140n 3.3 140n 3.3 150n 3.3 150n 3.3 160n 3.3 160n 3.3 170n 3.3 170n 3.3 180n 3.3 180n 3.3 190n 3.3 190n 3.3 200n 3.3 200n 3.3 210n 3.3 210n 3.3 220n 3.3 220n 3.3 230n 3.3 230n 3.3 240n 3.3 240n 3.3 250n 3.3 250n 3.3 260n 3.3 260n 3.3 270n 3.3 270n 3.3 280n 3.3 280n 3.3 290n 3.3 290n 3.3 300n 3.3 300n 3.3 310n 3.3 310n 3.3 320n 3.3 320n 3.3 330n 3.3 330n 3.3 340n 3.3 340n 3.3 350n 3.3 350n 3.3 360n 3.3 360n 3.3 370n 3.3 370n 3.3 380n 3.3 380n 3.3 390n 3.3 390n 3.3 400n 3.3 400n 3.3 410n 3.3 410n 3.3 420n 3.3 ]
alter @VDEST11[PWL] = [ 0n 0.0 10n 0.0 10n 0.0 20n 0.0 20n 0.0 30n 0.0 30n 0.0 40n 0.0 40n 0.0 50n 0.0 50n 0.0 60n 0.0 60n 0.0 70n 0.0 70n 0.0 80n 0.0 80n 0.0 90n 0.0 90n 0.0 100n 0.0 100n 3.3 110n 3.3 110n 3.3 120n 3.3 120n 3.3 130n 3.3 130n 3.3 140n 3.3 140n 3.3 150n 3.3 150n 3.3 160n 3.3 160n 3.3 170n 3.3 170n 3.3 180n 3.3 180n 3.3 190n 3.3 190n 3.3 200n 3.3 200n 3.3 210n 3.3 210n 3.3 220n 3.3 220n 3.3 230n 3.3 230n 3.3 240n 3.3 240n 3.3 250n 3.3 250n 3.3 260n 3.3 260n 3.3 270n 3.3 270n 3.3 280n 3.3 280n 3.3 290n 3.3 290n 3.3 300n 3.3 300n 3.3 310n 3.3 310n 3.3 320n 3.3 320n 3.3 330n 3.3 330n 3.3 340n 3.3 340n 3.3 350n 3.3 350n 3.3 360n 3.3 360n 3.3 370n 3.3 370n 3.3 380n 3.3 380n 3.3 390n 3.3 390n 3.3 400n 3.3 400n 3.3 410n 3.3 410n 3.3 420n 3.3 ]
alter @VDEST10[PWL] = [ 0n 0.0 10n 0.0 10n 0.0 20n 0.0 20n 0.0 30n 0.0 30n 0.0 40n 0.0 40n 0.0 50n 0.0 50n 0.0 60n 0.0 60n 0.0 70n 0.0 70n 0.0 80n 0.0 80n 0.0 90n 0.0 90n 3.3 100n 3.3 100n 3.3 110n 3.3 110n 3.3 120n 3.3 120n 3.3 130n 3.3 130n 3.3 140n 3.3 140n 3.3 150n 3.3 150n 3.3 160n 3.3 160n 3.3 170n 3.3 170n 3.3 180n 3.3 180n 3.3 190n 3.3 190n 3.3 200n 3.3 200n 3.3 210n 3.3 210n 3.3 220n 3.3 220n 3.3 230n 3.3 230n 3.3 240n 3.3 240n 3.3 250n 3.3 250n 3.3 260n 3.3 260n 3.3 270n 3.3 270n 3.3 280n 3.3 280n 3.3 290n 3.3 290n 3.3 300n 3.3 300n 3.3 310n 3.3 310n 3.3 320n 3.3 320n 3.3 330n 3.3 330n 3.3 340n 3.3 340n 3.3 350n 3.3 350n 3.3 360n 3.3 360n 3.3 370n 3.3 370n 3.3 380n 3.3 380n 3.3 390n 3.3 390n 3.3 400n 3.3 400n 3.3 410n 3.3 410n 3.3 420n 3.3 ]
alter @VDEST9[PWL] = [ 0n 0.0 10n 0.0 10n 0.0 20n 0.0 20n 0.0 30n 0.0 30n 0.0 40n 0.0 40n 0.0 50n 0.0 50n 0.0 60n 0.0 60n 0.0 70n 0.0 70n 3.3 80n 3.3 80n 0.0 90n 0.0 90n 0.0 100n 0.0 100n 3.3 110n 3.3 110n 3.3 120n 3.3 120n 3.3 130n 3.3 130n 3.3 140n 3.3 140n 3.3 150n 3.3 150n 3.3 160n 3.3 160n 3.3 170n 3.3 170n 3.3 180n 3.3 180n 3.3 190n 3.3 190n 3.3 200n 3.3 200n 3.3 210n 3.3 210n 3.3 220n 3.3 220n 3.3 230n 3.3 230n 3.3 240n 3.3 240n 3.3 250n 3.3 250n 3.3 260n 3.3 260n 3.3 270n 3.3 270n 3.3 280n 3.3 280n 3.3 290n 3.3 290n 3.3 300n 3.3 300n 3.3 310n 3.3 310n 3.3 320n 3.3 320n 3.3 330n 3.3 330n 3.3 340n 3.3 340n 3.3 350n 3.3 350n 3.3 360n 3.3 360n 3.3 370n 3.3 370n 3.3 380n 3.3 380n 3.3 390n 3.3 390n 3.3 400n 3.3 400n 3.3 410n 3.3 410n 3.3 420n 3.3 ]
alter @VDEST8[PWL] = [ 0n 0.0 10n 0.0 10n 0.0 20n 0.0 20n 0.0 30n 0.0 30n 0.0 40n 0.0 40n 0.0 50n 0.0 50n 0.0 60n 0.0 60n 0.0 70n 0.0 70n 0.0 80n 0.0 80n 0.0 90n 0.0 90n 3.3 100n 3.3 100n 3.3 110n 3.3 110n 3.3 120n 3.3 120n 3.3 130n 3.3 130n 3.3 140n 3.3 140n 3.3 150n 3.3 150n 3.3 160n 3.3 160n 3.3 170n 3.3 170n 3.3 180n 3.3 180n 3.3 190n 3.3 190n 3.3 200n 3.3 200n 3.3 210n 3.3 210n 3.3 220n 3.3 220n 3.3 230n 3.3 230n 3.3 240n 3.3 240n 3.3 250n 3.3 250n 3.3 260n 3.3 260n 3.3 270n 3.3 270n 3.3 280n 3.3 280n 3.3 290n 3.3 290n 3.3 300n 3.3 300n 3.3 310n 3.3 310n 3.3 320n 3.3 320n 3.3 330n 3.3 330n 3.3 340n 3.3 340n 3.3 350n 3.3 350n 3.3 360n 3.3 360n 3.3 370n 3.3 370n 3.3 380n 3.3 380n 3.3 390n 3.3 390n 3.3 400n 3.3 400n 3.3 410n 3.3 410n 3.3 420n 3.3 ]
alter @VDEST7[PWL] = [ 0n 0.0 10n 0.0 10n 0.0 20n 0.0 20n 0.0 30n 0.0 30n 0.0 40n 0.0 40n 0.0 50n 0.0 50n 0.0 60n 0.0 60n 0.0 70n 0.0 70n 0.0 80n 0.0 80n 0.0 90n 0.0 90n 0.0 100n 0.0 100n 3.3 110n 3.3 110n 3.3 120n 3.3 120n 3.3 130n 3.3 130n 3.3 140n 3.3 140n 3.3 150n 3.3 150n 3.3 160n 3.3 160n 3.3 170n 3.3 170n 3.3 180n 3.3 180n 3.3 190n 3.3 190n 3.3 200n 3.3 200n 3.3 210n 3.3 210n 3.3 220n 3.3 220n 3.3 230n 3.3 230n 3.3 240n 3.3 240n 3.3 250n 3.3 250n 3.3 260n 3.3 260n 3.3 270n 3.3 270n 3.3 280n 3.3 280n 3.3 290n 3.3 290n 3.3 300n 3.3 300n 3.3 310n 3.3 310n 3.3 320n 3.3 320n 3.3 330n 3.3 330n 3.3 340n 3.3 340n 3.3 350n 3.3 350n 3.3 360n 3.3 360n 3.3 370n 3.3 370n 3.3 380n 3.3 380n 3.3 390n 3.3 390n 3.3 400n 3.3 400n 3.3 410n 3.3 410n 3.3 420n 3.3 ]
alter @VDEST6[PWL] = [ 0n 0.0 10n 0.0 10n 0.0 20n 0.0 20n 0.0 30n 0.0 30n 0.0 40n 0.0 40n 0.0 50n 0.0 50n 0.0 60n 0.0 60n 0.0 70n 0.0 70n 0.0 80n 0.0 80n 0.0 90n 0.0 90n 3.3 100n 3.3 100n 3.3 110n 3.3 110n 3.3 120n 3.3 120n 3.3 130n 3.3 130n 3.3 140n 3.3 140n 3.3 150n 3.3 150n 3.3 160n 3.3 160n 3.3 170n 3.3 170n 3.3 180n 3.3 180n 3.3 190n 3.3 190n 3.3 200n 3.3 200n 3.3 210n 3.3 210n 3.3 220n 3.3 220n 3.3 230n 3.3 230n 3.3 240n 3.3 240n 3.3 250n 3.3 250n 3.3 260n 3.3 260n 3.3 270n 3.3 270n 3.3 280n 3.3 280n 3.3 290n 3.3 290n 3.3 300n 3.3 300n 3.3 310n 3.3 310n 3.3 320n 3.3 320n 3.3 330n 3.3 330n 3.3 340n 3.3 340n 3.3 350n 3.3 350n 3.3 360n 3.3 360n 3.3 370n 3.3 370n 3.3 380n 3.3 380n 3.3 390n 3.3 390n 3.3 400n 3.3 400n 3.3 410n 3.3 410n 3.3 420n 3.3 ]
alter @VDEST5[PWL] = [ 0n 0.0 10n 0.0 10n 0.0 20n 0.0 20n 0.0 30n 0.0 30n 0.0 40n 0.0 40n 0.0 50n 0.0 50n 0.0 60n 0.0 60n 0.0 70n 0.0 70n 3.3 80n 3.3 80n 0.0 90n 0.0 90n 3.3 100n 3.3 100n 3.3 110n 3.3 110n 3.3 120n 3.3 120n 3.3 130n 3.3 130n 3.3 140n 3.3 140n 3.3 150n 3.3 150n 3.3 160n 3.3 160n 3.3 170n 3.3 170n 3.3 180n 3.3 180n 3.3 190n 3.3 190n 3.3 200n 3.3 200n 3.3 210n 3.3 210n 3.3 220n 3.3 220n 3.3 230n 3.3 230n 3.3 240n 3.3 240n 3.3 250n 3.3 250n 3.3 260n 3.3 260n 3.3 270n 3.3 270n 3.3 280n 3.3 280n 3.3 290n 3.3 290n 3.3 300n 3.3 300n 3.3 310n 3.3 310n 3.3 320n 3.3 320n 3.3 330n 3.3 330n 3.3 340n 3.3 340n 3.3 350n 3.3 350n 3.3 360n 3.3 360n 3.3 370n 3.3 370n 3.3 380n 3.3 380n 3.3 390n 3.3 390n 3.3 400n 3.3 400n 3.3 410n 3.3 410n 3.3 420n 3.3 ]
alter @VDEST4[PWL] = [ 0n 0.0 10n 0.0 10n 0.0 20n 0.0 20n 0.0 30n 0.0 30n 0.0 40n 0.0 40n 0.0 50n 0.0 50n 0.0 60n 0.0 60n 0.0 70n 0.0 70n 3.3 80n 3.3 80n 0.0 90n 0.0 90n 3.3 100n 3.3 100n 3.3 110n 3.3 110n 3.3 120n 3.3 120n 3.3 130n 3.3 130n 3.3 140n 3.3 140n 3.3 150n 3.3 150n 3.3 160n 3.3 160n 3.3 170n 3.3 170n 3.3 180n 3.3 180n 3.3 190n 3.3 190n 3.3 200n 3.3 200n 3.3 210n 3.3 210n 3.3 220n 3.3 220n 3.3 230n 3.3 230n 3.3 240n 3.3 240n 3.3 250n 3.3 250n 3.3 260n 3.3 260n 3.3 270n 3.3 270n 3.3 280n 3.3 280n 3.3 290n 3.3 290n 3.3 300n 3.3 300n 3.3 310n 3.3 310n 3.3 320n 3.3 320n 3.3 330n 3.3 330n 3.3 340n 3.3 340n 3.3 350n 3.3 350n 3.3 360n 3.3 360n 3.3 370n 3.3 370n 3.3 380n 3.3 380n 3.3 390n 3.3 390n 3.3 400n 3.3 400n 3.3 410n 3.3 410n 3.3 420n 3.3 ]
alter @VDEST3[PWL] = [ 0n 0.0 10n 0.0 10n 0.0 20n 0.0 20n 0.0 30n 0.0 30n 0.0 40n 0.0 40n 0.0 50n 0.0 50n 0.0 60n 0.0 60n 0.0 70n 0.0 70n 0.0 80n 0.0 80n 0.0 90n 0.0 90n 3.3 100n 3.3 100n 3.3 110n 3.3 110n 3.3 120n 3.3 120n 3.3 130n 3.3 130n 3.3 140n 3.3 140n 3.3 150n 3.3 150n 3.3 160n 3.3 160n 3.3 170n 3.3 170n 3.3 180n 3.3 180n 3.3 190n 3.3 190n 3.3 200n 3.3 200n 3.3 210n 3.3 210n 3.3 220n 3.3 220n 3.3 230n 3.3 230n 3.3 240n 3.3 240n 3.3 250n 3.3 250n 3.3 260n 3.3 260n 3.3 270n 3.3 270n 3.3 280n 3.3 280n 3.3 290n 3.3 290n 3.3 300n 3.3 300n 3.3 310n 3.3 310n 3.3 320n 3.3 320n 3.3 330n 3.3 330n 3.3 340n 3.3 340n 3.3 350n 3.3 350n 3.3 360n 3.3 360n 3.3 370n 3.3 370n 3.3 380n 3.3 380n 3.3 390n 3.3 390n 3.3 400n 3.3 400n 3.3 410n 3.3 410n 3.3 420n 3.3 ]
alter @VDEST2[PWL] = [ 0n 0.0 10n 0.0 10n 0.0 20n 0.0 20n 0.0 30n 0.0 30n 0.0 40n 0.0 40n 0.0 50n 0.0 50n 0.0 60n 0.0 60n 0.0 70n 0.0 70n 3.3 80n 3.3 80n 0.0 90n 0.0 90n 0.0 100n 0.0 100n 3.3 110n 3.3 110n 3.3 120n 3.3 120n 3.3 130n 3.3 130n 3.3 140n 3.3 140n 3.3 150n 3.3 150n 3.3 160n 3.3 160n 3.3 170n 3.3 170n 3.3 180n 3.3 180n 3.3 190n 3.3 190n 3.3 200n 3.3 200n 3.3 210n 3.3 210n 3.3 220n 3.3 220n 3.3 230n 3.3 230n 3.3 240n 3.3 240n 3.3 250n 3.3 250n 3.3 260n 3.3 260n 3.3 270n 3.3 270n 3.3 280n 3.3 280n 3.3 290n 3.3 290n 3.3 300n 3.3 300n 3.3 310n 3.3 310n 3.3 320n 3.3 320n 3.3 330n 3.3 330n 3.3 340n 3.3 340n 3.3 350n 3.3 350n 3.3 360n 3.3 360n 3.3 370n 3.3 370n 3.3 380n 3.3 380n 3.3 390n 3.3 390n 3.3 400n 3.3 400n 3.3 410n 3.3 410n 3.3 420n 3.3 ]
alter @VDEST1[PWL] = [ 0n 0.0 10n 0.0 10n 0.0 20n 0.0 20n 0.0 30n 0.0 30n 0.0 40n 0.0 40n 0.0 50n 0.0 50n 0.0 60n 0.0 60n 0.0 70n 0.0 70n 0.0 80n 0.0 80n 0.0 90n 0.0 90n 0.0 100n 0.0 100n 3.3 110n 3.3 110n 3.3 120n 3.3 120n 3.3 130n 3.3 130n 3.3 140n 3.3 140n 3.3 150n 3.3 150n 3.3 160n 3.3 160n 3.3 170n 3.3 170n 3.3 180n 3.3 180n 3.3 190n 3.3 190n 3.3 200n 3.3 200n 3.3 210n 3.3 210n 3.3 220n 3.3 220n 3.3 230n 3.3 230n 3.3 240n 3.3 240n 3.3 250n 3.3 250n 3.3 260n 3.3 260n 3.3 270n 3.3 270n 3.3 280n 3.3 280n 3.3 290n 3.3 290n 3.3 300n 3.3 300n 3.3 310n 3.3 310n 3.3 320n 3.3 320n 3.3 330n 3.3 330n 3.3 340n 3.3 340n 3.3 350n 3.3 350n 3.3 360n 3.3 360n 3.3 370n 3.3 370n 3.3 380n 3.3 380n 3.3 390n 3.3 390n 3.3 400n 3.3 400n 3.3 410n 3.3 410n 3.3 420n 3.3 ]
alter @VDEST0[PWL] = [ 0n 0.0 10n 0.0 10n 0.0 20n 0.0 20n 0.0 30n 0.0 30n 0.0 40n 0.0 40n 0.0 50n 0.0 50n 0.0 60n 0.0 60n 0.0 70n 0.0 70n 0.0 80n 0.0 80n 0.0 90n 0.0 90n 3.3 100n 3.3 100n 3.3 110n 3.3 110n 3.3 120n 3.3 120n 3.3 130n 3.3 130n 3.3 140n 3.3 140n 3.3 150n 3.3 150n 3.3 160n 3.3 160n 3.3 170n 3.3 170n 3.3 180n 3.3 180n 3.3 190n 3.3 190n 3.3 200n 3.3 200n 3.3 210n 3.3 210n 3.3 220n 3.3 220n 3.3 230n 3.3 230n 3.3 240n 3.3 240n 3.3 250n 3.3 250n 3.3 260n 3.3 260n 3.3 270n 3.3 270n 3.3 280n 3.3 280n 3.3 290n 3.3 290n 3.3 300n 3.3 300n 3.3 310n 3.3 310n 3.3 320n 3.3 320n 3.3 330n 3.3 330n 3.3 340n 3.3 340n 3.3 350n 3.3 350n 3.3 360n 3.3 360n 3.3 370n 3.3 370n 3.3 380n 3.3 380n 3.3 390n 3.3 390n 3.3 400n 3.3 400n 3.3 410n 3.3 410n 3.3 420n 3.3 ]

** DISP BUS
alter @VDISP7[PWL] = [ 0n 0.0 10n 0.0 10n 0.0 20n 0.0 20n 0.0 30n 0.0 30n 0.0 40n 0.0 40n 0.0 50n 0.0 50n 3.3 60n 3.3 60n 0.0 70n 0.0 70n 0.0 80n 0.0 80n 0.0 90n 0.0 90n 0.0 100n 0.0 100n 0.0 110n 0.0 110n 0.0 120n 0.0 120n 0.0 130n 0.0 130n 0.0 140n 0.0 140n 0.0 150n 0.0 150n 0.0 160n 0.0 160n 0.0 170n 0.0 170n 0.0 180n 0.0 180n 0.0 190n 0.0 190n 0.0 200n 0.0 200n 0.0 210n 0.0 210n 0.0 220n 0.0 220n 0.0 230n 0.0 230n 0.0 240n 0.0 240n 0.0 250n 0.0 250n 0.0 260n 0.0 260n 0.0 270n 0.0 270n 0.0 280n 0.0 280n 0.0 290n 0.0 290n 0.0 300n 0.0 300n 0.0 310n 0.0 310n 0.0 320n 0.0 320n 0.0 330n 0.0 330n 0.0 340n 0.0 340n 0.0 350n 0.0 350n 0.0 360n 0.0 360n 0.0 370n 0.0 370n 0.0 380n 0.0 380n 0.0 390n 0.0 390n 0.0 400n 0.0 400n 0.0 410n 0.0 410n 0.0 420n 0.0 ]
alter @VDISP6[PWL] = [ 0n 0.0 10n 0.0 10n 0.0 20n 0.0 20n 0.0 30n 0.0 30n 0.0 40n 0.0 40n 0.0 50n 0.0 50n 3.3 60n 3.3 60n 0.0 70n 0.0 70n 0.0 80n 0.0 80n 0.0 90n 0.0 90n 0.0 100n 0.0 100n 0.0 110n 0.0 110n 0.0 120n 0.0 120n 0.0 130n 0.0 130n 0.0 140n 0.0 140n 0.0 150n 0.0 150n 0.0 160n 0.0 160n 0.0 170n 0.0 170n 0.0 180n 0.0 180n 0.0 190n 0.0 190n 0.0 200n 0.0 200n 0.0 210n 0.0 210n 0.0 220n 0.0 220n 0.0 230n 0.0 230n 0.0 240n 0.0 240n 0.0 250n 0.0 250n 0.0 260n 0.0 260n 0.0 270n 0.0 270n 0.0 280n 0.0 280n 0.0 290n 0.0 290n 0.0 300n 0.0 300n 0.0 310n 0.0 310n 0.0 320n 0.0 320n 0.0 330n 0.0 330n 0.0 340n 0.0 340n 0.0 350n 0.0 350n 0.0 360n 0.0 360n 0.0 370n 0.0 370n 0.0 380n 0.0 380n 0.0 390n 0.0 390n 0.0 400n 0.0 400n 0.0 410n 0.0 410n 0.0 420n 0.0 ]
alter @VDISP5[PWL] = [ 0n 0.0 10n 0.0 10n 0.0 20n 0.0 20n 0.0 30n 0.0 30n 0.0 40n 0.0 40n 0.0 50n 0.0 50n 3.3 60n 3.3 60n 0.0 70n 0.0 70n 0.0 80n 0.0 80n 0.0 90n 0.0 90n 3.3 100n 3.3 100n 3.3 110n 3.3 110n 3.3 120n 3.3 120n 3.3 130n 3.3 130n 3.3 140n 3.3 140n 3.3 150n 3.3 150n 3.3 160n 3.3 160n 3.3 170n 3.3 170n 3.3 180n 3.3 180n 3.3 190n 3.3 190n 3.3 200n 3.3 200n 3.3 210n 3.3 210n 3.3 220n 3.3 220n 3.3 230n 3.3 230n 3.3 240n 3.3 240n 3.3 250n 3.3 250n 3.3 260n 3.3 260n 3.3 270n 3.3 270n 3.3 280n 3.3 280n 3.3 290n 3.3 290n 3.3 300n 3.3 300n 3.3 310n 3.3 310n 3.3 320n 3.3 320n 3.3 330n 3.3 330n 3.3 340n 3.3 340n 3.3 350n 3.3 350n 3.3 360n 3.3 360n 3.3 370n 3.3 370n 3.3 380n 3.3 380n 3.3 390n 3.3 390n 3.3 400n 3.3 400n 3.3 410n 3.3 410n 3.3 420n 3.3 ]
alter @VDISP4[PWL] = [ 0n 0.0 10n 0.0 10n 0.0 20n 0.0 20n 0.0 30n 0.0 30n 3.3 40n 3.3 40n 0.0 50n 0.0 50n 3.3 60n 3.3 60n 0.0 70n 0.0 70n 0.0 80n 0.0 80n 0.0 90n 0.0 90n 0.0 100n 0.0 100n 0.0 110n 0.0 110n 0.0 120n 0.0 120n 0.0 130n 0.0 130n 0.0 140n 0.0 140n 0.0 150n 0.0 150n 0.0 160n 0.0 160n 0.0 170n 0.0 170n 0.0 180n 0.0 180n 0.0 190n 0.0 190n 0.0 200n 0.0 200n 0.0 210n 0.0 210n 0.0 220n 0.0 220n 0.0 230n 0.0 230n 0.0 240n 0.0 240n 0.0 250n 0.0 250n 0.0 260n 0.0 260n 0.0 270n 0.0 270n 0.0 280n 0.0 280n 0.0 290n 0.0 290n 0.0 300n 0.0 300n 0.0 310n 0.0 310n 0.0 320n 0.0 320n 0.0 330n 0.0 330n 0.0 340n 0.0 340n 0.0 350n 0.0 350n 0.0 360n 0.0 360n 0.0 370n 0.0 370n 0.0 380n 0.0 380n 0.0 390n 0.0 390n 0.0 400n 0.0 400n 0.0 410n 0.0 410n 0.0 420n 0.0 ]
alter @VDISP3[PWL] = [ 0n 0.0 10n 0.0 10n 0.0 20n 0.0 20n 0.0 30n 0.0 30n 0.0 40n 0.0 40n 0.0 50n 0.0 50n 0.0 60n 0.0 60n 0.0 70n 0.0 70n 0.0 80n 0.0 80n 0.0 90n 0.0 90n 0.0 100n 0.0 100n 0.0 110n 0.0 110n 0.0 120n 0.0 120n 0.0 130n 0.0 130n 0.0 140n 0.0 140n 0.0 150n 0.0 150n 0.0 160n 0.0 160n 0.0 170n 0.0 170n 0.0 180n 0.0 180n 0.0 190n 0.0 190n 0.0 200n 0.0 200n 0.0 210n 0.0 210n 0.0 220n 0.0 220n 0.0 230n 0.0 230n 0.0 240n 0.0 240n 0.0 250n 0.0 250n 0.0 260n 0.0 260n 0.0 270n 0.0 270n 0.0 280n 0.0 280n 0.0 290n 0.0 290n 0.0 300n 0.0 300n 0.0 310n 0.0 310n 0.0 320n 0.0 320n 0.0 330n 0.0 330n 0.0 340n 0.0 340n 0.0 350n 0.0 350n 0.0 360n 0.0 360n 0.0 370n 0.0 370n 0.0 380n 0.0 380n 0.0 390n 0.0 390n 0.0 400n 0.0 400n 0.0 410n 0.0 410n 0.0 420n 0.0 ]
alter @VDISP2[PWL] = [ 0n 0.0 10n 0.0 10n 0.0 20n 0.0 20n 0.0 30n 0.0 30n 0.0 40n 0.0 40n 0.0 50n 0.0 50n 0.0 60n 0.0 60n 0.0 70n 0.0 70n 0.0 80n 0.0 80n 0.0 90n 0.0 90n 0.0 100n 0.0 100n 0.0 110n 0.0 110n 0.0 120n 0.0 120n 0.0 130n 0.0 130n 0.0 140n 0.0 140n 0.0 150n 0.0 150n 0.0 160n 0.0 160n 0.0 170n 0.0 170n 0.0 180n 0.0 180n 0.0 190n 0.0 190n 0.0 200n 0.0 200n 0.0 210n 0.0 210n 0.0 220n 0.0 220n 0.0 230n 0.0 230n 0.0 240n 0.0 240n 0.0 250n 0.0 250n 0.0 260n 0.0 260n 0.0 270n 0.0 270n 0.0 280n 0.0 280n 0.0 290n 0.0 290n 0.0 300n 0.0 300n 0.0 310n 0.0 310n 0.0 320n 0.0 320n 0.0 330n 0.0 330n 0.0 340n 0.0 340n 0.0 350n 0.0 350n 0.0 360n 0.0 360n 0.0 370n 0.0 370n 0.0 380n 0.0 380n 0.0 390n 0.0 390n 0.0 400n 0.0 400n 0.0 410n 0.0 410n 0.0 420n 0.0 ]
alter @VDISP1[PWL] = [ 0n 0.0 10n 0.0 10n 0.0 20n 0.0 20n 0.0 30n 0.0 30n 0.0 40n 0.0 40n 0.0 50n 0.0 50n 0.0 60n 0.0 60n 0.0 70n 0.0 70n 0.0 80n 0.0 80n 0.0 90n 0.0 90n 0.0 100n 0.0 100n 0.0 110n 0.0 110n 0.0 120n 0.0 120n 0.0 130n 0.0 130n 0.0 140n 0.0 140n 0.0 150n 0.0 150n 0.0 160n 0.0 160n 0.0 170n 0.0 170n 0.0 180n 0.0 180n 0.0 190n 0.0 190n 0.0 200n 0.0 200n 0.0 210n 0.0 210n 0.0 220n 0.0 220n 0.0 230n 0.0 230n 0.0 240n 0.0 240n 0.0 250n 0.0 250n 0.0 260n 0.0 260n 0.0 270n 0.0 270n 0.0 280n 0.0 280n 0.0 290n 0.0 290n 0.0 300n 0.0 300n 0.0 310n 0.0 310n 0.0 320n 0.0 320n 0.0 330n 0.0 330n 0.0 340n 0.0 340n 0.0 350n 0.0 350n 0.0 360n 0.0 360n 0.0 370n 0.0 370n 0.0 380n 0.0 380n 0.0 390n 0.0 390n 0.0 400n 0.0 400n 0.0 410n 0.0 410n 0.0 420n 0.0 ]
alter @VDISP0[PWL] = [ 0n 0.0 10n 0.0 10n 0.0 20n 0.0 20n 0.0 30n 0.0 30n 0.0 40n 0.0 40n 0.0 50n 0.0 50n 0.0 60n 0.0 60n 0.0 70n 0.0 70n 0.0 80n 0.0 80n 0.0 90n 0.0 90n 0.0 100n 0.0 100n 0.0 110n 0.0 110n 0.0 120n 0.0 120n 0.0 130n 0.0 130n 0.0 140n 0.0 140n 0.0 150n 0.0 150n 0.0 160n 0.0 160n 0.0 170n 0.0 170n 0.0 180n 0.0 180n 0.0 190n 0.0 190n 0.0 200n 0.0 200n 0.0 210n 0.0 210n 0.0 220n 0.0 220n 0.0 230n 0.0 230n 0.0 240n 0.0 240n 0.0 250n 0.0 250n 0.0 260n 0.0 260n 0.0 270n 0.0 270n 0.0 280n 0.0 280n 0.0 290n 0.0 290n 0.0 300n 0.0 300n 0.0 310n 0.0 310n 0.0 320n 0.0 320n 0.0 330n 0.0 330n 0.0 340n 0.0 340n 0.0 350n 0.0 350n 0.0 360n 0.0 360n 0.0 370n 0.0 370n 0.0 380n 0.0 380n 0.0 390n 0.0 390n 0.0 400n 0.0 400n 0.0 410n 0.0 410n 0.0 420n 0.0 ]

** CONTROL
alter @VRSTn[PWL] = [ 0n 3.3 10n 3.3 10n 0.0 20n 0.0 20n 3.3 30n 3.3 30n 3.3 40n 3.3 40n 3.3 50n 3.3 50n 3.3 60n 3.3 60n 3.3 70n 3.3 70n 3.3 80n 3.3 80n 3.3 90n 3.3 90n 3.3 100n 3.3 100n 3.3 110n 3.3 110n 3.3 120n 3.3 120n 3.3 130n 3.3 130n 3.3 140n 3.3 140n 3.3 150n 3.3 150n 3.3 160n 3.3 160n 3.3 170n 3.3 170n 3.3 180n 3.3 180n 3.3 190n 3.3 190n 3.3 200n 3.3 200n 3.3 210n 3.3 210n 3.3 220n 3.3 220n 3.3 230n 3.3 230n 3.3 240n 3.3 240n 3.3 250n 3.3 250n 3.3 260n 3.3 260n 3.3 270n 3.3 270n 3.3 280n 3.3 280n 3.3 290n 3.3 290n 3.3 300n 3.3 300n 3.3 310n 3.3 310n 3.3 320n 3.3 320n 3.3 330n 3.3 330n 3.3 340n 3.3 340n 3.3 350n 3.3 350n 3.3 360n 3.3 360n 3.3 370n 3.3 370n 3.3 380n 3.3 380n 3.3 390n 3.3 390n 3.3 400n 3.3 400n 3.3 410n 3.3 410n 3.3 420n 3.3 ]
alter @VBR[PWL] = [ 0n 0.0 10n 0.0 10n 0.0 20n 0.0 20n 0.0 30n 0.0 30n 3.3 40n 3.3 40n 0.0 50n 0.0 50n 3.3 60n 3.3 60n 0.0 70n 0.0 70n 0.0 80n 0.0 80n 0.0 90n 0.0 90n 3.3 100n 3.3 100n 3.3 110n 3.3 110n 3.3 120n 3.3 120n 3.3 130n 3.3 130n 3.3 140n 3.3 140n 3.3 150n 3.3 150n 3.3 160n 3.3 160n 3.3 170n 3.3 170n 3.3 180n 3.3 180n 3.3 190n 3.3 190n 3.3 200n 3.3 200n 3.3 210n 3.3 210n 3.3 220n 3.3 220n 3.3 230n 3.3 230n 3.3 240n 3.3 240n 3.3 250n 3.3 250n 3.3 260n 3.3 260n 3.3 270n 3.3 270n 3.3 280n 3.3 280n 3.3 290n 3.3 290n 3.3 300n 3.3 300n 3.3 310n 3.3 310n 3.3 320n 3.3 320n 3.3 330n 3.3 330n 3.3 340n 3.3 340n 3.3 350n 3.3 350n 3.3 360n 3.3 360n 3.3 370n 3.3 370n 3.3 380n 3.3 380n 3.3 390n 3.3 390n 3.3 400n 3.3 400n 3.3 410n 3.3 410n 3.3 420n 3.3 ]
alter @VJMP[PWL] = [ 0n 0.0 10n 0.0 10n 0.0 20n 0.0 20n 0.0 30n 0.0 30n 0.0 40n 0.0 40n 0.0 50n 0.0 50n 0.0 60n 0.0 60n 0.0 70n 0.0 70n 3.3 80n 3.3 80n 0.0 90n 0.0 90n 3.3 100n 3.3 100n 3.3 110n 3.3 110n 3.3 120n 3.3 120n 3.3 130n 3.3 130n 3.3 140n 3.3 140n 3.3 150n 3.3 150n 3.3 160n 3.3 160n 3.3 170n 3.3 170n 3.3 180n 3.3 180n 3.3 190n 3.3 190n 3.3 200n 3.3 200n 3.3 210n 3.3 210n 3.3 220n 3.3 220n 3.3 230n 3.3 230n 3.3 240n 3.3 240n 3.3 250n 3.3 250n 3.3 260n 3.3 260n 3.3 270n 3.3 270n 3.3 280n 3.3 280n 3.3 290n 3.3 290n 3.3 300n 3.3 300n 3.3 310n 3.3 310n 3.3 320n 3.3 320n 3.3 330n 3.3 330n 3.3 340n 3.3 340n 3.3 350n 3.3 350n 3.3 360n 3.3 360n 3.3 370n 3.3 370n 3.3 380n 3.3 380n 3.3 390n 3.3 390n 3.3 400n 3.3 400n 3.3 410n 3.3 410n 3.3 420n 3.3 ]
alter @VSI[PWL] = [ 0n 0.0 10n 0.0 10n 0.0 20n 0.0 20n 0.0 30n 0.0 30n 0.0 40n 0.0 40n 0.0 50n 0.0 50n 0.0 60n 0.0 60n 0.0 70n 0.0 70n 0.0 80n 0.0 80n 0.0 90n 0.0 90n 0.0 100n 0.0 100n 0.0 110n 0.0 110n 0.0 120n 0.0 120n 0.0 130n 0.0 130n 0.0 140n 0.0 140n 0.0 150n 0.0 150n 0.0 160n 0.0 160n 0.0 170n 0.0 170n 0.0 180n 0.0 180n 0.0 190n 0.0 190n 0.0 200n 0.0 200n 0.0 210n 0.0 210n 0.0 220n 0.0 220n 0.0 230n 0.0 230n 0.0 240n 0.0 240n 0.0 250n 0.0 250n 0.0 260n 0.0 260n 0.0 270n 0.0 270n 3.3 280n 3.3 280n 0.0 290n 0.0 290n 3.3 300n 3.3 300n 0.0 310n 0.0 310n 3.3 320n 3.3 320n 0.0 330n 0.0 330n 3.3 340n 3.3 340n 0.0 350n 0.0 350n 3.3 360n 3.3 360n 0.0 370n 0.0 370n 3.3 380n 3.3 380n 0.0 390n 0.0 390n 3.3 400n 3.3 400n 0.0 410n 0.0 410n 3.3 420n 3.3 ]
alter @VSE[PWL] = [ 0n 0.0 10n 0.0 10n 0.0 20n 0.0 20n 0.0 30n 0.0 30n 0.0 40n 0.0 40n 0.0 50n 0.0 50n 0.0 60n 0.0 60n 0.0 70n 0.0 70n 0.0 80n 0.0 80n 0.0 90n 0.0 90n 0.0 100n 0.0 100n 3.3 110n 3.3 110n 3.3 120n 3.3 120n 3.3 130n 3.3 130n 3.3 140n 3.3 140n 3.3 150n 3.3 150n 3.3 160n 3.3 160n 3.3 170n 3.3 170n 3.3 180n 3.3 180n 3.3 190n 3.3 190n 3.3 200n 3.3 200n 3.3 210n 3.3 210n 3.3 220n 3.3 220n 3.3 230n 3.3 230n 3.3 240n 3.3 240n 3.3 250n 3.3 250n 3.3 260n 3.3 260n 3.3 270n 3.3 270n 3.3 280n 3.3 280n 3.3 290n 3.3 290n 3.3 300n 3.3 300n 3.3 310n 3.3 310n 3.3 320n 3.3 320n 3.3 330n 3.3 330n 3.3 340n 3.3 340n 3.3 350n 3.3 350n 3.3 360n 3.3 360n 3.3 370n 3.3 370n 3.3 380n 3.3 380n 3.3 390n 3.3 390n 3.3 400n 3.3 400n 3.3 410n 3.3 410n 3.3 420n 3.3 ]

** CLK
alter @VCLK[PULSE] = [ 0 3.3 7.5n 0 0 5.0n 10n 0 ]

tran 0.01n 420n

write pc_tb.raw

.endc
