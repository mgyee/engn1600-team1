** sch_path: /foss/designs/engn1600-team1/CAD6/dff.sch
.subckt dff D Q RSTn Qb c cbar
*.PININFO D:I Q:O RSTn:I Qb:O c:B cbar:B
M7 net2 c VDD VDD pfet_03v3 L=0.28u W=0.36u nf=1 m=1
M8 net1 D net2 VDD pfet_03v3 L=0.28u W=0.36u nf=1 m=1
M9 net1 D net3 VSS nfet_03v3 L=0.28u W=0.36u nf=1 m=1
M10 net3 cbar VSS VSS nfet_03v3 L=0.28u W=0.36u nf=1 m=1
M13 net4 net1 VDD VDD pfet_03v3 L=0.28u W=0.36u nf=1 m=1
M14 net4 net1 VSS VSS nfet_03v3 L=0.28u W=0.36u nf=1 m=1
M15 net1 cbar net5 VDD pfet_03v3 L=0.28u W=0.36u nf=1 m=1
M16 net1 c net5 VSS nfet_03v3 L=0.28u W=0.36u nf=1 m=1
M25 net5 RSTn VDD VDD pfet_03v3 L=0.28u W=0.36u nf=1 m=1
M26 net5 net4 VDD VDD pfet_03v3 L=0.28u W=0.36u nf=1 m=1
M27 net6 net4 VSS VSS nfet_03v3 L=0.28u W=0.36u nf=1 m=1
M28 net5 RSTn net6 VSS nfet_03v3 L=0.28u W=0.36u nf=1 m=1
M29 net4 cbar net7 VDD pfet_03v3 L=0.28u W=0.36u nf=1 m=1
M30 net4 c net7 VSS nfet_03v3 L=0.28u W=0.36u nf=1 m=1
M31 net8 net7 VDD VDD pfet_03v3 L=0.28u W=0.36u nf=1 m=1
M32 net8 RSTn VDD VDD pfet_03v3 L=0.28u W=0.36u nf=1 m=1
M33 net9 RSTn VSS VSS nfet_03v3 L=0.28u W=0.36u nf=1 m=1
M34 net8 net7 net9 VSS nfet_03v3 L=0.28u W=0.36u nf=1 m=1
M35 net10 c VDD VDD pfet_03v3 L=0.28u W=0.36u nf=1 m=1
M36 net7 net8 net10 VDD pfet_03v3 L=0.28u W=0.36u nf=1 m=1
M37 net7 net8 net12 VSS nfet_03v3 L=0.28u W=0.36u nf=1 m=1
M38 net12 cbar VSS VSS nfet_03v3 L=0.28u W=0.36u nf=1 m=1
M43 Q net8 VDD VDD pfet_03v3 L=0.28u W=0.72u nf=1 m=1
M44 Q net8 VSS VSS nfet_03v3 L=0.28u W=0.36u nf=1 m=1
M3 net11 net8 VDD VDD pfet_03v3 L=0.28u W=0.36u nf=1 m=1
M4 net11 net8 VSS VSS nfet_03v3 L=0.28u W=0.36u nf=1 m=1
M5 Qb net11 VDD VDD pfet_03v3 L=0.28u W=0.72u nf=1 m=1
M6 Qb net11 VSS VSS nfet_03v3 L=0.28u W=0.36u nf=1 m=1
.ends
