* NGSPICE file created from pc_flat.ext - technology: gf180mcuD

.subckt pc_flat VSS PC15 PC14 PC13 PC12 PC11 PC10 PC9 PC8 PC7 PC6 PC5 PC4 PC3 PC2
+ PC1 PC0 VDD JMP BR SE CLK RSTn PC_NEXT15 DISP6 DISP5 DISP4 DISP3 DISP2 DISP1 DISP0
+ DEST6 DEST0 DEST1 DEST2 DEST3 DEST4 DEST5 DEST7 DEST8 DEST9 DEST10 DEST11 DEST12
+ DEST13 DEST14 DEST15 DISP7 SI
X0 a_60660_3404# a_61604_4236# VSS VSS nfet_03v3 ad=0.1332p pd=1.1u as=0.2592p ps=2.16u w=0.36u l=0.28u
X1 a_22923_3632# a_20282_3448# a_23611_3908# VSS nfet_03v3 ad=93.59999f pd=0.88u as=93.59999f ps=0.88u w=0.36u l=0.28u
X2 a_39335_3392# a_37214_3448# a_39655_3448# VDD pfet_03v3 ad=0.1872p pd=1.24u as=86.39999f ps=0.96u w=0.72u l=0.28u
X3 VSS PC12.t4 a_53242_3908# VSS nfet_03v3 ad=93.59999f pd=0.88u as=0.1584p ps=1.6u w=0.36u l=0.28u
X4 a_49633_3908# PC11.t4 a_48321_3632# VSS nfet_03v3 ad=57.59999f pd=0.68u as=93.59999f ps=0.88u w=0.36u l=0.28u
X5 a_1238_3392# VSS a_1558_3908# VSS nfet_03v3 ad=93.59999f pd=0.88u as=43.2f ps=0.6u w=0.36u l=0.28u
X6 a_34390_3118# RSTn.t0 VDD VDD pfet_03v3 ad=0.108p pd=0.96u as=0.108p ps=0.96u w=0.36u l=0.28u
X7 PC9.t0 a_41863_3400# a_42257_2866# VDD pfet_03v3 ad=0.2592p pd=2.16u as=0.1332p ps=1.1u w=0.36u l=0.28u
X8 VDD a_60500_3392# a_59192_4236# VDD pfet_03v3 ad=0.1872p pd=1.24u as=0.3168p ps=2.32u w=0.72u l=0.28u
X9 a_22619_3908# a_22563_3404# VSS VSS nfet_03v3 ad=43.2f pd=0.6u as=93.59999f ps=0.88u w=0.36u l=0.28u
X10 a_52281_2618# CLK.t0 a_51170_2618# VSS nfet_03v3 ad=0.1728p pd=1.68u as=0.1728p ps=1.68u w=0.36u l=0.28u
X11 a_9951_2618# CLK.t1 a_8840_2618# VSS nfet_03v3 ad=0.1728p pd=1.68u as=0.1728p ps=1.68u w=0.36u l=0.28u
X12 DEST15.t0 JMP.t0 a_63425_3400# VSS nfet_03v3 ad=0.18p pd=1.72u as=0.1332p ps=1.1u w=0.36u l=0.28u
X13 PC3.t1 SE.t0 a_16859_2866# VSS nfet_03v3 ad=0.2592p pd=2.16u as=0.1332p ps=1.1u w=0.36u l=0.28u
X14 a_n467_2616# CLK.t2 VSS VSS nfet_03v3 ad=0.2016p pd=1.84u as=0.1584p ps=1.6u w=0.36u l=0.28u
X15 a_10438_2618# RSTn.t1 VSS VSS nfet_03v3 ad=0.108p pd=0.96u as=0.1728p ps=1.68u w=0.36u l=0.28u
X16 a_4303_2618# CLK.t3 a_4759_3118# VSS nfet_03v3 ad=0.1728p pd=1.68u as=0.108p ps=0.96u w=0.36u l=0.28u
X17 a_12232_4236# JMP.t1 VDD.t549 VDD.t548 pfet_03v3 ad=0.4032p pd=2.56u as=0.3168p ps=2.32u w=0.72u l=0.28u
X18 VDD a_25772_2618# a_25924_3118# VDD pfet_03v3 ad=0.108p pd=0.96u as=0.1728p ps=1.68u w=0.36u l=0.28u
X19 a_33397_4236# JMP.t2 VSS VSS nfet_03v3 ad=0.2016p pd=1.84u as=0.1584p ps=1.6u w=0.36u l=0.28u
X20 VDD RSTn.t2 a_48383_3118# VDD pfet_03v3 ad=0.108p pd=0.96u as=0.1728p ps=1.68u w=0.36u l=0.28u
X21 a_2342_4236# BR.t0 VSS VSS nfet_03v3 ad=0.2016p pd=1.84u as=0.1584p ps=1.6u w=0.36u l=0.28u
X22 a_52554_3632# a_49913_3448# a_53242_3448# VDD pfet_03v3 ad=0.1872p pd=1.24u as=0.1872p ps=1.24u w=0.72u l=0.28u
X23 VDD a_8840_2618# a_8992_3118# VDD pfet_03v3 ad=0.108p pd=0.96u as=0.1728p ps=1.68u w=0.36u l=0.28u
X24 VDD a_1398_3404# a_1822_3448# VDD pfet_03v3 ad=0.1872p pd=1.24u as=0.1872p ps=1.24u w=0.72u l=0.28u
X25 VDD a_43728_3404# a_45400_3448# VDD pfet_03v3 ad=0.1872p pd=1.24u as=0.1152p ps=1.04u w=0.72u l=0.28u
X26 a_39582_2618# a_39917_3118# a_40549_2618# VSS nfet_03v3 ad=0.1728p pd=1.68u as=0.108p ps=0.96u w=0.36u l=0.28u
X27 a_5687_3908# a_5631_3404# VSS VSS nfet_03v3 ad=43.2f pd=0.6u as=93.59999f ps=0.88u w=0.36u l=0.28u
X28 a_30869_3392# a_28748_3448# a_31189_3448# VDD pfet_03v3 ad=0.1872p pd=1.24u as=86.39999f ps=0.96u w=0.72u l=0.28u
X29 a_16465_3400# SE.t1 VDD VDD pfet_03v3 ad=0.4032p pd=2.56u as=0.3168p ps=2.32u w=0.72u l=0.28u
X30 VSS a_28748_3448# a_31453_3908# VSS nfet_03v3 ad=0.1584p pd=1.6u as=93.59999f ps=0.88u w=0.36u l=0.28u
X31 a_56851_3448# a_56787_3632# a_56267_3392# VDD pfet_03v3 ad=0.1872p pd=1.24u as=0.1872p ps=1.24u w=0.72u l=0.28u
X32 a_47241_2618# a_46937_2618# VSS VSS nfet_03v3 ad=0.108p pd=0.96u as=0.1728p ps=1.68u w=0.36u l=0.28u
X33 a_17306_2618# a_17002_2618# VSS VSS nfet_03v3 ad=0.1728p pd=1.68u as=0.1728p ps=1.68u w=0.36u l=0.28u
X34 DEST7.t1 a_29164_4236# a_29561_3400# VDD.t276 pfet_03v3 ad=0.18p pd=1.72u as=0.1332p ps=1.1u w=0.36u l=0.28u
X35 a_56514_2618# a_54562_2616# a_55403_2618# VDD pfet_03v3 ad=0.1728p pd=1.68u as=0.1728p ps=1.68u w=0.36u l=0.28u
X36 a_59156_3118# CLK.t4 VDD VDD pfet_03v3 ad=0.108p pd=0.96u as=0.1728p ps=1.68u w=0.36u l=0.28u
X37 a_32083_2618# a_29164_2616# VSS VSS nfet_03v3 ad=0.108p pd=0.96u as=0.1728p ps=1.68u w=0.36u l=0.28u
X38 a_4127_2618# a_3766_2616# VSS VSS nfet_03v3 ad=0.108p pd=0.96u as=0.1728p ps=1.68u w=0.36u l=0.28u
X39 DISP1.t0 a_6575_4236# a_5631_3404# VDD.t354 pfet_03v3 ad=0.3654p pd=2.75u as=0.1332p ps=1.1u w=0.36u l=0.28u
X40 a_59192_3400# JMP.t3 a_59192_4236# VDD.t550 pfet_03v3 ad=0.1332p pd=1.1u as=0.4446p ps=3.19u w=0.36u l=0.28u
X41 a_43568_3392# a_41447_3448# a_43888_3908# VSS nfet_03v3 ad=93.59999f pd=0.88u as=43.2f ps=0.6u w=0.36u l=0.28u
X42 a_57371_4236# BR.t1 VDD.t605 VDD.t604 pfet_03v3 ad=0.4032p pd=2.56u as=0.3168p ps=2.32u w=0.72u l=0.28u
X43 VDD VSS a_1822_3448# VDD pfet_03v3 ad=0.3168p pd=2.32u as=0.1872p ps=1.24u w=0.72u l=0.28u
X44 a_41167_3908# PC9.t4 a_39855_3632# VSS nfet_03v3 ad=57.59999f pd=0.68u as=93.59999f ps=0.88u w=0.36u l=0.28u
X45 a_46096_3400# SE.t2 VDD VDD pfet_03v3 ad=0.4032p pd=2.56u as=0.3168p ps=2.32u w=0.72u l=0.28u
X46 a_374_2618# a_70_2618# VSS VSS nfet_03v3 ad=0.1728p pd=1.68u as=0.1728p ps=1.68u w=0.36u l=0.28u
X47 DEST13.t1 a_54562_4236# a_54959_3400# VDD.t470 pfet_03v3 ad=0.18p pd=1.72u as=0.1332p ps=1.1u w=0.36u l=0.28u
X48 a_27844_3908# a_26796_3404# VSS VSS nfet_03v3 ad=93.59999f pd=0.88u as=93.59999f ps=0.88u w=0.36u l=0.28u
X49 a_46633_2618# CLK.t5 a_47089_3118# VSS nfet_03v3 ad=0.1728p pd=1.68u as=0.108p ps=0.96u w=0.36u l=0.28u
X50 a_35318_3448# a_35262_3404# VDD VDD pfet_03v3 ad=86.39999f pd=0.96u as=0.1872p ps=1.24u w=0.72u l=0.28u
X51 a_32981_3448# a_31389_3632# VDD VDD pfet_03v3 ad=0.3168p pd=2.32u as=0.1872p ps=1.24u w=0.72u l=0.28u
X52 VSS a_43728_3404# a_44152_3908# VSS nfet_03v3 ad=93.59999f pd=0.88u as=93.59999f ps=0.88u w=0.36u l=0.28u
X53 a_48321_3632# a_45680_3448# a_49009_3908# VSS nfet_03v3 ad=93.59999f pd=0.88u as=93.59999f ps=0.88u w=0.36u l=0.28u
X54 a_29956_5022.t26 a_29172_5022# VDD.t660 VDD.t439 pfet_03v3 ad=0.216p pd=1.32u as=0.3456p ps=2.4u w=0.72u l=0.28u
X55 a_22563_3404# a_23507_4236# VSS VSS nfet_03v3 ad=0.1332p pd=1.1u as=0.2592p ps=2.16u w=0.36u l=0.28u
X56 a_22650_2618# a_20698_2616# a_21539_2618# VDD pfet_03v3 ad=0.1728p pd=1.68u as=0.1728p ps=1.68u w=0.36u l=0.28u
X57 a_25328_3400# JMP.t4 a_25328_4236# VDD.t551 pfet_03v3 ad=0.1332p pd=1.1u as=0.4446p ps=3.19u w=0.36u l=0.28u
X58 VSS a_22403_3392# a_21095_4236# VSS nfet_03v3 ad=93.59999f pd=0.88u as=0.1584p ps=1.6u w=0.36u l=0.28u
X59 VDD RSTn.t3 a_39917_3118# VDD pfet_03v3 ad=0.108p pd=0.96u as=0.1728p ps=1.68u w=0.36u l=0.28u
X60 a_23507_4236# BR.t2 VDD.t310 VDD.t309 pfet_03v3 ad=0.4032p pd=2.56u as=0.3168p ps=2.32u w=0.72u l=0.28u
X61 a_48017_3908# a_47961_3404# VSS VSS nfet_03v3 ad=43.2f pd=0.6u as=93.59999f ps=0.88u w=0.36u l=0.28u
X62 DEST5.t0 a_20698_4236# a_21095_3400# VDD.t72 pfet_03v3 ad=0.18p pd=1.72u as=0.1332p ps=1.1u w=0.36u l=0.28u
X63 a_43815_2618# a_44150_3118# a_44782_3118# VDD pfet_03v3 ad=0.1728p pd=1.68u as=0.108p ps=0.96u w=0.36u l=0.28u
X64 a_35836_2618# RSTn.t4 VSS VSS nfet_03v3 ad=0.108p pd=0.96u as=0.1728p ps=1.68u w=0.36u l=0.28u
X65 PC5.t2 a_22985_3118# VDD VDD pfet_03v3 ad=0.3456p pd=2.4u as=0.3456p ps=2.4u w=0.72u l=0.28u
X66 a_37630_4236# JMP.t5 VDD.t359 VDD.t358 pfet_03v3 ad=0.4032p pd=2.56u as=0.3168p ps=2.32u w=0.72u l=0.28u
X67 a_12769_2618# CLK.t6 a_13225_3118# VSS nfet_03v3 ad=0.1728p pd=1.68u as=0.108p ps=0.96u w=0.36u l=0.28u
X68 a_50723_2866# a_50329_3400# a_50726_3400# VSS nfet_03v3 ad=0.1332p pd=1.1u as=0.3654p ps=2.75u w=0.36u l=0.28u
X69 a_29956_5022.t0 a_48905_4236# a_47961_3404# VDD.t51 pfet_03v3 ad=0.3654p pd=2.75u as=0.1332p ps=1.1u w=0.36u l=0.28u
X70 VSS a_9864_3404# a_10288_3908# VSS nfet_03v3 ad=93.59999f pd=0.88u as=93.59999f ps=0.88u w=0.36u l=0.28u
X71 a_14457_3632# a_11816_3448# a_15145_3908# VSS nfet_03v3 ad=93.59999f pd=0.88u as=93.59999f ps=0.88u w=0.36u l=0.28u
X72 VDD a_41447_3448# a_44152_3448# VDD pfet_03v3 ad=0.3168p pd=2.32u as=0.1872p ps=1.24u w=0.72u l=0.28u
X73 a_58795_3400# SE.t3 VSS VSS nfet_03v3 ad=0.2016p pd=1.84u as=0.1584p ps=1.6u w=0.36u l=0.28u
X74 a_5718_2618# a_3766_2616# a_4607_2618# VDD pfet_03v3 ad=0.1728p pd=1.68u as=0.1728p ps=1.68u w=0.36u l=0.28u
X75 a_61234_2618# RSTn.t5 VSS VSS nfet_03v3 ad=0.108p pd=0.96u as=0.1728p ps=1.68u w=0.36u l=0.28u
X76 a_8396_3400# JMP.t6 a_8396_4236# VDD.t360 pfet_03v3 ad=0.1332p pd=1.1u as=0.4446p ps=3.19u w=0.36u l=0.28u
X77 a_33791_2866# SE.t4 a_33794_3400# VDD pfet_03v3 ad=0.1332p pd=1.1u as=0.3654p ps=2.75u w=0.36u l=0.28u
X78 a_31453_3908# PC7.t4 VSS VSS nfet_03v3 ad=93.59999f pd=0.88u as=93.59999f ps=0.88u w=0.36u l=0.28u
X79 a_56267_3392# a_54146_3448# a_56587_3448# VDD pfet_03v3 ad=0.1872p pd=1.24u as=86.39999f ps=0.96u w=0.72u l=0.28u
X80 DEST1.t1 a_3766_4236# a_4163_3400# VDD.t414 pfet_03v3 ad=0.18p pd=1.72u as=0.1332p ps=1.1u w=0.36u l=0.28u
X81 a_18754_3908# a_18690_3632# a_18170_3392# VSS nfet_03v3 ad=93.59999f pd=0.88u as=93.59999f ps=0.88u w=0.36u l=0.28u
X82 a_57481_2618# a_54562_2616# VSS VSS nfet_03v3 ad=0.108p pd=0.96u as=0.1728p ps=1.68u w=0.36u l=0.28u
X83 a_51322_3118# RSTn.t6 VDD VDD pfet_03v3 ad=0.108p pd=0.96u as=0.108p ps=0.96u w=0.36u l=0.28u
X84 a_33397_2616# CLK.t7 VDD VDD pfet_03v3 ad=0.4032p pd=2.56u as=0.3168p ps=2.32u w=0.72u l=0.28u
X85 DISP3.t1 a_15041_4236# a_14097_3404# VDD.t566 pfet_03v3 ad=0.3654p pd=2.75u as=0.1332p ps=1.1u w=0.36u l=0.28u
X86 a_41863_2616# CLK.t8 VSS VSS nfet_03v3 ad=0.2016p pd=1.84u as=0.1584p ps=1.6u w=0.36u l=0.28u
X87 a_24931_3400# SE.t5 VSS VSS nfet_03v3 ad=0.2016p pd=1.84u as=0.1584p ps=1.6u w=0.36u l=0.28u
X88 a_38167_2618# a_38024_2866# a_37991_2618# VSS nfet_03v3 ad=0.1728p pd=1.68u as=0.108p ps=0.96u w=0.36u l=0.28u
X89 a_2446_3448# a_1398_3404# VDD VDD pfet_03v3 ad=0.1872p pd=1.24u as=0.1872p ps=1.24u w=0.72u l=0.28u
X90 VDD a_374_2618# a_526_3118# VDD pfet_03v3 ad=0.108p pd=0.96u as=0.1728p ps=1.68u w=0.36u l=0.28u
X91 a_50329_4236# JMP.t7 VSS VSS nfet_03v3 ad=0.2016p pd=1.84u as=0.1584p ps=1.6u w=0.36u l=0.28u
X92 a_22403_3392# a_20282_3448# a_22723_3448# VDD pfet_03v3 ad=0.1872p pd=1.24u as=86.39999f ps=0.96u w=0.72u l=0.28u
X93 VDD PC6.t4 a_27844_3448# VDD pfet_03v3 ad=0.1872p pd=1.24u as=0.3168p ps=2.32u w=0.72u l=0.28u
X94 a_58379_3448# a_56787_3632# VSS VSS nfet_03v3 ad=0.1584p pd=1.6u as=93.59999f ps=0.88u w=0.36u l=0.28u
X95 a_43728_3404# BR.t3 VSS VDD.t311 pfet_03v3 ad=0.1332p pd=1.1u as=0.2592p ps=2.16u w=0.36u l=0.28u
X96 PC3.t0 a_16465_3400# a_16859_2866# VDD pfet_03v3 ad=0.2592p pd=2.16u as=0.1332p ps=1.1u w=0.36u l=0.28u
X97 VDD a_35102_3392# a_33794_4236# VDD pfet_03v3 ad=0.1872p pd=1.24u as=0.3168p ps=2.32u w=0.72u l=0.28u
X98 PC4.t2 a_18752_3118# VDD VDD pfet_03v3 ad=0.3456p pd=2.4u as=0.3456p ps=2.4u w=0.72u l=0.28u
X99 VDD a_60660_3404# a_62332_3448# VDD pfet_03v3 ad=0.1872p pd=1.24u as=0.1152p ps=1.04u w=0.72u l=0.28u
X100 a_48048_2618# a_46096_2616# a_46937_2618# VDD pfet_03v3 ad=0.1728p pd=1.68u as=0.1728p ps=1.68u w=0.36u l=0.28u
X101 a_23617_2618# a_20698_2616# VSS VSS nfet_03v3 ad=0.108p pd=0.96u as=0.1728p ps=1.68u w=0.36u l=0.28u
X102 DEST9.t0 JMP.t8 a_38027_3400# VSS nfet_03v3 ad=0.18p pd=1.72u as=0.1332p ps=1.1u w=0.36u l=0.28u
X103 a_22723_3448# PC5.t4 a_22619_3448# VDD pfet_03v3 ad=86.39999f pd=0.96u as=86.39999f ps=0.96u w=0.72u l=0.28u
X104 VDD RSTn.t7 a_65315_3118# VDD pfet_03v3 ad=0.108p pd=0.96u as=0.1728p ps=1.68u w=0.36u l=0.28u
X105 a_7999_3400# SE.t6 VSS VSS nfet_03v3 ad=0.2016p pd=1.84u as=0.1584p ps=1.6u w=0.36u l=0.28u
X106 VSS a_47801_3392# a_46493_4236# VSS nfet_03v3 ad=93.59999f pd=0.88u as=0.1584p ps=1.6u w=0.36u l=0.28u
X107 a_42400_2618# a_41863_2616# a_42856_3118# VDD pfet_03v3 ad=0.1728p pd=1.68u as=0.108p ps=0.96u w=0.36u l=0.28u
X108 a_34238_2618# a_33934_2618# VSS VSS nfet_03v3 ad=0.1728p pd=1.68u as=0.1728p ps=1.68u w=0.36u l=0.28u
X109 VDD a_22563_3404# a_22987_3448# VDD pfet_03v3 ad=0.1872p pd=1.24u as=0.1872p ps=1.24u w=0.72u l=0.28u
X110 a_27156_3632# a_24515_3448# a_27844_3448# VDD pfet_03v3 ad=0.1872p pd=1.24u as=0.1872p ps=1.24u w=0.72u l=0.28u
X111 DEST11.t1 a_46096_4236# a_46493_3400# VDD.t250 pfet_03v3 ad=0.18p pd=1.72u as=0.1332p ps=1.1u w=0.36u l=0.28u
X112 a_60500_3392# a_58379_3448# a_60820_3908# VSS nfet_03v3 ad=93.59999f pd=0.88u as=43.2f ps=0.6u w=0.36u l=0.28u
X113 a_10288_3908# a_10224_3632# a_9704_3392# VSS nfet_03v3 ad=93.59999f pd=0.88u as=93.59999f ps=0.88u w=0.36u l=0.28u
X114 a_44152_3448# PC10.t4 VDD VDD pfet_03v3 ad=0.1872p pd=1.24u as=0.1872p ps=1.24u w=0.72u l=0.28u
X115 a_12593_3118# CLK.t9 VDD VDD pfet_03v3 ad=0.108p pd=0.96u as=0.1728p ps=1.68u w=0.36u l=0.28u
X116 VSS a_35262_3404# a_35686_3908# VSS nfet_03v3 ad=93.59999f pd=0.88u as=93.59999f ps=0.88u w=0.36u l=0.28u
X117 a_5791_3448# PC1.t4 a_5687_3448# VDD pfet_03v3 ad=86.39999f pd=0.96u as=86.39999f ps=0.96u w=0.72u l=0.28u
X118 a_63565_2618# CLK.t10 a_64021_3118# VSS nfet_03v3 ad=0.1728p pd=1.68u as=0.108p ps=0.96u w=0.36u l=0.28u
X119 PC10.t2 a_44150_3118# VSS VSS nfet_03v3 ad=0.1728p pd=1.68u as=0.1728p ps=1.68u w=0.36u l=0.28u
X120 a_31973_4236# BR.t4 VSS VSS nfet_03v3 ad=0.2016p pd=1.84u as=0.1584p ps=1.6u w=0.36u l=0.28u
X121 a_18170_3392# a_16049_3448# a_18490_3908# VSS nfet_03v3 ad=93.59999f pd=0.88u as=43.2f ps=0.6u w=0.36u l=0.28u
X122 a_52250_3448# a_52194_3404# VDD VDD pfet_03v3 ad=86.39999f pd=0.96u as=0.1872p ps=1.24u w=0.72u l=0.28u
X123 VSS a_60660_3404# a_61084_3908# VSS nfet_03v3 ad=93.59999f pd=0.88u as=93.59999f ps=0.88u w=0.36u l=0.28u
X124 a_27850_3118# CLK.t11 VDD VDD pfet_03v3 ad=0.108p pd=0.96u as=0.1728p ps=1.68u w=0.36u l=0.28u
X125 a_65253_3632# a_62612_3448# a_65941_3908# VSS nfet_03v3 ad=93.59999f pd=0.88u as=93.59999f ps=0.88u w=0.36u l=0.28u
X126 VDD a_38471_2618# a_38623_3118# VDD pfet_03v3 ad=0.108p pd=0.96u as=0.1728p ps=1.68u w=0.36u l=0.28u
X127 a_39495_3404# a_40439_4236# VSS VSS nfet_03v3 ad=0.1332p pd=1.1u as=0.2592p ps=2.16u w=0.36u l=0.28u
X128 a_40439_4236# BR.t5 VDD.t313 VDD.t312 pfet_03v3 ad=0.4032p pd=2.56u as=0.3168p ps=2.32u w=0.72u l=0.28u
X129 a_n70_3400# JMP.t9 a_n70_4236# VDD.t361 pfet_03v3 ad=0.1332p pd=1.1u as=0.4446p ps=3.19u w=0.36u l=0.28u
X130 a_10288_3448# PC2.t4 VDD VDD pfet_03v3 ad=0.1872p pd=1.24u as=0.1872p ps=1.24u w=0.72u l=0.28u
X131 a_15769_3448# PC3.t4 a_14457_3632# VDD pfet_03v3 ad=0.1152p pd=1.04u as=0.1872p ps=1.24u w=0.72u l=0.28u
X132 a_64949_3908# a_64893_3404# VSS VSS nfet_03v3 ad=43.2f pd=0.6u as=93.59999f ps=0.88u w=0.36u l=0.28u
X133 a_60747_2618# a_61082_3118# a_61714_3118# VDD pfet_03v3 ad=0.1728p pd=1.68u as=0.108p ps=0.96u w=0.36u l=0.28u
X134 a_22985_3118# a_22650_2618# VDD VDD pfet_03v3 ad=0.1728p pd=1.68u as=0.108p ps=0.96u w=0.36u l=0.28u
X135 a_n467_4236# JMP.t10 VDD.t681 VDD.t680 pfet_03v3 ad=0.4032p pd=2.56u as=0.3168p ps=2.32u w=0.72u l=0.28u
X136 VDD PC0.t4 a_2446_3448# VDD pfet_03v3 ad=0.1872p pd=1.24u as=0.3168p ps=2.32u w=0.72u l=0.28u
X137 a_33758_2618# a_33397_2616# VSS VSS nfet_03v3 ad=0.108p pd=0.96u as=0.1728p ps=1.68u w=0.36u l=0.28u
X138 a_30005_2618# a_29701_2618# VSS VSS nfet_03v3 ad=0.1728p pd=1.68u as=0.1728p ps=1.68u w=0.36u l=0.28u
X139 PC2.t2 a_10286_3118# VSS VSS nfet_03v3 ad=0.1728p pd=1.68u as=0.1728p ps=1.68u w=0.36u l=0.28u
X140 a_29956_5022.t15 BR.t6 a_56427_3404# VSS nfet_03v3 ad=0.3654p pd=2.75u as=0.1332p ps=1.1u w=0.36u l=0.28u
X141 VDD a_18330_3404# a_18754_3448# VDD pfet_03v3 ad=0.1872p pd=1.24u as=0.1872p ps=1.24u w=0.72u l=0.28u
X142 a_31389_3632# a_28748_3448# a_32077_3908# VSS nfet_03v3 ad=93.59999f pd=0.88u as=93.59999f ps=0.88u w=0.36u l=0.28u
X143 a_48121_3908# PC11.t5 a_48017_3908# VSS nfet_03v3 ad=43.2f pd=0.6u as=43.2f ps=0.6u w=0.36u l=0.28u
X144 VSS a_22563_3404# a_24235_3908# VSS nfet_03v3 ad=93.59999f pd=0.88u as=57.59999f ps=0.68u w=0.36u l=0.28u
X145 a_50723_2866# SE.t7 a_50726_3400# VDD pfet_03v3 ad=0.1332p pd=1.1u as=0.3654p ps=2.75u w=0.36u l=0.28u
X146 a_18417_2618# a_18752_3118# a_19384_3118# VDD pfet_03v3 ad=0.1728p pd=1.68u as=0.108p ps=0.96u w=0.36u l=0.28u
X147 a_58795_3400# SE.t8 VDD VDD pfet_03v3 ad=0.4032p pd=2.56u as=0.3168p ps=2.32u w=0.72u l=0.28u
X148 a_6053_3118# a_5718_2618# VDD VDD pfet_03v3 ad=0.1728p pd=1.68u as=0.108p ps=0.96u w=0.36u l=0.28u
X149 a_60747_2618# CLK.t12 a_59636_2618# VSS nfet_03v3 ad=0.1728p pd=1.68u as=0.1728p ps=1.68u w=0.36u l=0.28u
X150 a_26796_3404# a_27740_4236# VSS VSS nfet_03v3 ad=0.1332p pd=1.1u as=0.2592p ps=2.16u w=0.36u l=0.28u
X151 a_25325_2866# a_24931_3400# a_25328_3400# VSS nfet_03v3 ad=0.1332p pd=1.1u as=0.3654p ps=2.75u w=0.36u l=0.28u
X152 a_59636_2618# a_59332_2618# VSS VSS nfet_03v3 ad=0.1728p pd=1.68u as=0.1728p ps=1.68u w=0.36u l=0.28u
X153 VDD a_16049_3448# a_18754_3448# VDD pfet_03v3 ad=0.3168p pd=2.32u as=0.1872p ps=1.24u w=0.72u l=0.28u
X154 a_50329_2616# CLK.t13 VDD VDD pfet_03v3 ad=0.4032p pd=2.56u as=0.3168p ps=2.32u w=0.72u l=0.28u
X155 a_44150_3118# a_43815_2618# a_44302_2618# VSS nfet_03v3 ad=0.1728p pd=1.68u as=0.108p ps=0.96u w=0.36u l=0.28u
X156 DISP5.t1 BR.t7 a_22563_3404# VSS nfet_03v3 ad=0.3654p pd=2.75u as=0.1332p ps=1.1u w=0.36u l=0.28u
X157 a_35686_3908# a_35622_3632# a_35102_3392# VSS nfet_03v3 ad=93.59999f pd=0.88u as=93.59999f ps=0.88u w=0.36u l=0.28u
X158 a_37991_3118# CLK.t14 VDD VDD pfet_03v3 ad=0.108p pd=0.96u as=0.1728p ps=1.68u w=0.36u l=0.28u
X159 a_4759_3118# RSTn.t8 a_4911_2618# VSS nfet_03v3 ad=0.108p pd=0.96u as=0.108p ps=0.96u w=0.36u l=0.28u
X160 VSS a_5631_3404# a_7303_3908# VSS nfet_03v3 ad=93.59999f pd=0.88u as=57.59999f ps=0.68u w=0.36u l=0.28u
X161 a_55099_2618# a_54956_2866# a_54923_2618# VSS nfet_03v3 ad=0.1728p pd=1.68u as=0.108p ps=0.96u w=0.36u l=0.28u
X162 a_18417_2618# CLK.t15 a_17306_2618# VSS nfet_03v3 ad=0.1728p pd=1.68u as=0.1728p ps=1.68u w=0.36u l=0.28u
X163 a_29561_3400# a_29164_4236# a_29561_4236# VSS nfet_03v3 ad=0.1332p pd=1.1u as=0.4446p ps=3.19u w=0.36u l=0.28u
X164 a_54956_2866# a_54562_3400# a_54959_3400# VSS nfet_03v3 ad=0.1332p pd=1.1u as=0.3654p ps=2.75u w=0.36u l=0.28u
X165 a_24931_3400# SE.t9 VDD VDD pfet_03v3 ad=0.4032p pd=2.56u as=0.3168p ps=2.32u w=0.72u l=0.28u
X166 VDD PC10.t5 a_44776_3448# VDD pfet_03v3 ad=0.1872p pd=1.24u as=0.3168p ps=2.32u w=0.72u l=0.28u
X167 VDD a_52034_3392# a_50726_4236# VDD pfet_03v3 ad=0.1872p pd=1.24u as=0.3168p ps=2.32u w=0.72u l=0.28u
X168 a_2452_3118# CLK.t16 VDD VDD pfet_03v3 ad=0.108p pd=0.96u as=0.1728p ps=1.68u w=0.36u l=0.28u
X169 a_25924_3118# RSTn.t9 VDD VDD pfet_03v3 ad=0.108p pd=0.96u as=0.108p ps=0.96u w=0.36u l=0.28u
X170 a_60660_3404# BR.t8 VSS VDD.t350 pfet_03v3 ad=0.1332p pd=1.1u as=0.2592p ps=2.16u w=0.36u l=0.28u
X171 a_8393_2866# a_7999_3400# a_8396_3400# VSS nfet_03v3 ad=0.1332p pd=1.1u as=0.3654p ps=2.75u w=0.36u l=0.28u
X172 a_14153_3908# a_14097_3404# VSS VSS nfet_03v3 ad=43.2f pd=0.6u as=93.59999f ps=0.88u w=0.36u l=0.28u
X173 a_61084_3908# a_61020_3632# a_60500_3392# VSS nfet_03v3 ad=93.59999f pd=0.88u as=93.59999f ps=0.88u w=0.36u l=0.28u
X174 PC11.t3 SE.t10 a_50723_2866# VSS nfet_03v3 ad=0.2592p pd=2.16u as=0.1332p ps=1.1u w=0.36u l=0.28u
X175 a_9951_2618# a_10286_3118# a_10918_3118# VDD pfet_03v3 ad=0.1728p pd=1.68u as=0.108p ps=0.96u w=0.36u l=0.28u
X176 a_51474_2618# a_51170_2618# VSS VSS nfet_03v3 ad=0.108p pd=0.96u as=0.1728p ps=1.68u w=0.36u l=0.28u
X177 a_40549_2618# a_37630_2616# VSS VSS nfet_03v3 ad=0.108p pd=0.96u as=0.1728p ps=1.68u w=0.36u l=0.28u
X178 a_16465_2616# CLK.t17 VSS VSS nfet_03v3 ad=0.2016p pd=1.84u as=0.1584p ps=1.6u w=0.36u l=0.28u
X179 VSS a_64733_3392# a_63425_4236# VSS nfet_03v3 ad=93.59999f pd=0.88u as=0.1584p ps=1.6u w=0.36u l=0.28u
X180 a_65837_4236# BR.t9 VDD.t352 VDD.t351 pfet_03v3 ad=0.4032p pd=2.56u as=0.3168p ps=2.32u w=0.72u l=0.28u
X181 a_59332_2618# a_58795_2616# a_59788_3118# VDD pfet_03v3 ad=0.1728p pd=1.68u as=0.108p ps=0.96u w=0.36u l=0.28u
X182 a_35686_3448# PC8.t4 VDD VDD pfet_03v3 ad=0.1872p pd=1.24u as=0.1872p ps=1.24u w=0.72u l=0.28u
X183 a_44088_3632# a_41447_3448# a_44776_3448# VDD pfet_03v3 ad=0.1872p pd=1.24u as=0.1872p ps=1.24u w=0.72u l=0.28u
X184 PC15.t0 a_65315_3118# VDD VDD pfet_03v3 ad=0.3456p pd=2.4u as=0.3456p ps=2.4u w=0.72u l=0.28u
X185 a_48383_3118# a_48048_2618# VDD VDD pfet_03v3 ad=0.1728p pd=1.68u as=0.108p ps=0.96u w=0.36u l=0.28u
X186 a_29172_5022# DISP7.t0 VDD.t473 VDD.t439 pfet_03v3 ad=0.216p pd=1.32u as=0.3456p ps=2.4u w=0.72u l=0.28u
X187 DEST15.t1 a_63028_4236# a_63425_3400# VDD.t231 pfet_03v3 ad=0.18p pd=1.72u as=0.1332p ps=1.1u w=0.36u l=0.28u
X188 a_41447_3448# a_39855_3632# VSS VSS nfet_03v3 ad=0.1584p pd=1.6u as=93.59999f ps=0.88u w=0.36u l=0.28u
X189 a_7999_3400# SE.t11 VDD VDD pfet_03v3 ad=0.4032p pd=2.56u as=0.3168p ps=2.32u w=0.72u l=0.28u
X190 a_59332_2618# a_59189_2866# a_59156_3118# VDD pfet_03v3 ad=0.1728p pd=1.68u as=0.108p ps=0.96u w=0.36u l=0.28u
X191 a_46096_2616# CLK.t18 VSS VSS nfet_03v3 ad=0.2016p pd=1.84u as=0.1584p ps=1.6u w=0.36u l=0.28u
X192 PC8.t2 a_35684_3118# VSS VSS nfet_03v3 ad=0.1728p pd=1.68u as=0.1728p ps=1.68u w=0.36u l=0.28u
X193 a_8992_3118# RSTn.t10 VDD VDD pfet_03v3 ad=0.108p pd=0.96u as=0.108p ps=0.96u w=0.36u l=0.28u
X194 a_32077_3908# a_31029_3404# VSS VSS nfet_03v3 ad=93.59999f pd=0.88u as=93.59999f ps=0.88u w=0.36u l=0.28u
X195 a_61084_3448# PC14.t4 VDD VDD pfet_03v3 ad=0.1872p pd=1.24u as=0.1872p ps=1.24u w=0.72u l=0.28u
X196 a_66565_3448# PC15.t2 a_65253_3632# VDD pfet_03v3 ad=0.1152p pd=1.04u as=0.1872p ps=1.24u w=0.72u l=0.28u
X197 a_56787_3632# a_54146_3448# a_57475_3908# VSS nfet_03v3 ad=93.59999f pd=0.88u as=93.59999f ps=0.88u w=0.36u l=0.28u
X198 a_29956_5022.t25 a_29172_5022# VDD.t659 VDD.t439 pfet_03v3 ad=0.3456p pd=2.4u as=0.216p ps=1.32u w=0.72u l=0.28u
X199 a_47089_3118# RSTn.t11 a_47241_2618# VSS nfet_03v3 ad=0.108p pd=0.96u as=0.108p ps=0.96u w=0.36u l=0.28u
X200 DISP4.t0 BR.t10 a_18330_3404# VSS nfet_03v3 ad=0.3654p pd=2.75u as=0.1332p ps=1.1u w=0.36u l=0.28u
X201 VSS a_47961_3404# a_49633_3908# VSS nfet_03v3 ad=93.59999f pd=0.88u as=57.59999f ps=0.68u w=0.36u l=0.28u
X202 PC14.t3 a_61082_3118# VSS VSS nfet_03v3 ad=0.1728p pd=1.68u as=0.1728p ps=1.68u w=0.36u l=0.28u
X203 a_31116_2618# a_31451_3118# a_32083_2618# VSS nfet_03v3 ad=0.1728p pd=1.68u as=0.108p ps=0.96u w=0.36u l=0.28u
X204 VDD RSTn.t12 a_1820_3118# VDD pfet_03v3 ad=0.108p pd=0.96u as=0.1728p ps=1.68u w=0.36u l=0.28u
X205 a_14519_3118# a_14184_2618# VDD VDD pfet_03v3 ad=0.1728p pd=1.68u as=0.108p ps=0.96u w=0.36u l=0.28u
X206 VSS a_20282_3448# a_22987_3908# VSS nfet_03v3 ad=0.1584p pd=1.6u as=93.59999f ps=0.88u w=0.36u l=0.28u
X207 a_25772_2618# a_25468_2618# VDD VDD pfet_03v3 ad=0.1728p pd=1.68u as=0.1728p ps=1.68u w=0.36u l=0.28u
X208 a_18754_3448# PC4.t4 VDD VDD pfet_03v3 ad=0.1872p pd=1.24u as=0.1872p ps=1.24u w=0.72u l=0.28u
X209 a_41863_4236# JMP.t11 VDD.t683 VDD.t682 pfet_03v3 ad=0.4032p pd=2.56u as=0.3168p ps=2.32u w=0.72u l=0.28u
X210 VSS a_3350_3448# a_6055_3908# VSS nfet_03v3 ad=0.1584p pd=1.6u as=93.59999f ps=0.88u w=0.36u l=0.28u
X211 a_32701_3448# PC7.t5 a_31389_3632# VDD pfet_03v3 ad=0.1152p pd=1.04u as=0.1872p ps=1.24u w=0.72u l=0.28u
X212 PC10.t0 SE.t12 a_46490_2866# VSS nfet_03v3 ad=0.2592p pd=2.16u as=0.1332p ps=1.1u w=0.36u l=0.28u
X213 a_39917_3118# a_39582_2618# VDD VDD pfet_03v3 ad=0.1728p pd=1.68u as=0.108p ps=0.96u w=0.36u l=0.28u
X214 a_4163_3400# a_3766_4236# a_4163_4236# VSS nfet_03v3 ad=0.1332p pd=1.1u as=0.4446p ps=3.19u w=0.36u l=0.28u
X215 a_50690_2618# a_50329_2616# VSS VSS nfet_03v3 ad=0.108p pd=0.96u as=0.1728p ps=1.68u w=0.36u l=0.28u
X216 a_24515_3448# a_22923_3632# VDD VDD pfet_03v3 ad=0.3168p pd=2.32u as=0.1872p ps=1.24u w=0.72u l=0.28u
X217 a_17002_2618# a_16859_2866# a_16826_2618# VSS nfet_03v3 ad=0.1728p pd=1.68u as=0.108p ps=0.96u w=0.36u l=0.28u
X218 VDD a_21539_2618# a_21691_3118# VDD pfet_03v3 ad=0.108p pd=0.96u as=0.1728p ps=1.68u w=0.36u l=0.28u
X219 a_16859_2866# a_16465_3400# a_16862_3400# VSS nfet_03v3 ad=0.1332p pd=1.1u as=0.3654p ps=2.75u w=0.36u l=0.28u
X220 a_39551_3908# a_39495_3404# VSS VSS nfet_03v3 ad=43.2f pd=0.6u as=93.59999f ps=0.88u w=0.36u l=0.28u
X221 a_22563_3404# BR.t11 VSS VDD.t624 pfet_03v3 ad=0.1332p pd=1.1u as=0.2592p ps=2.16u w=0.36u l=0.28u
X222 a_36206_4236# BR.t12 VSS VSS nfet_03v3 ad=0.2016p pd=1.84u as=0.1584p ps=1.6u w=0.36u l=0.28u
X223 VDD a_13937_3392# a_12629_4236# VDD pfet_03v3 ad=0.1872p pd=1.24u as=0.3168p ps=2.32u w=0.72u l=0.28u
X224 a_65947_2618# a_63028_2616# VSS VSS nfet_03v3 ad=0.108p pd=0.96u as=0.1728p ps=1.68u w=0.36u l=0.28u
X225 a_35349_2618# a_35684_3118# a_36316_3118# VDD pfet_03v3 ad=0.1728p pd=1.68u as=0.108p ps=0.96u w=0.36u l=0.28u
X226 a_8536_2618# a_8393_2866# a_8360_3118# VDD pfet_03v3 ad=0.1728p pd=1.68u as=0.108p ps=0.96u w=0.36u l=0.28u
X227 a_54146_3448# a_52554_3632# VDD VDD pfet_03v3 ad=0.3168p pd=2.32u as=0.1872p ps=1.24u w=0.72u l=0.28u
X228 a_65053_3448# PC15.t3 a_64949_3448# VDD pfet_03v3 ad=86.39999f pd=0.96u as=86.39999f ps=0.96u w=0.72u l=0.28u
X229 PC2.t0 SE.t13 a_12626_2866# VSS nfet_03v3 ad=0.2592p pd=2.16u as=0.1332p ps=1.1u w=0.36u l=0.28u
X230 a_44776_3448# a_43728_3404# VDD VDD pfet_03v3 ad=0.1872p pd=1.24u as=0.1872p ps=1.24u w=0.72u l=0.28u
X231 a_7583_3448# a_5991_3632# VDD VDD pfet_03v3 ad=0.3168p pd=2.32u as=0.1872p ps=1.24u w=0.72u l=0.28u
X232 VSS a_39495_3404# a_41167_3908# VSS nfet_03v3 ad=93.59999f pd=0.88u as=57.59999f ps=0.68u w=0.36u l=0.28u
X233 a_61082_3118# a_60747_2618# a_61234_2618# VSS nfet_03v3 ad=0.1728p pd=1.68u as=0.108p ps=0.96u w=0.36u l=0.28u
X234 a_29956_5022.t11 BR.t13 a_39495_3404# VSS nfet_03v3 ad=0.3654p pd=2.75u as=0.1332p ps=1.1u w=0.36u l=0.28u
X235 a_25325_2866# SE.t14 a_25328_3400# VDD pfet_03v3 ad=0.1332p pd=1.1u as=0.3654p ps=2.75u w=0.36u l=0.28u
X236 VDD a_4607_2618# a_4759_3118# VDD pfet_03v3 ad=0.108p pd=0.96u as=0.1728p ps=1.68u w=0.36u l=0.28u
X237 a_52618_3908# a_52554_3632# a_52034_3392# VSS nfet_03v3 ad=93.59999f pd=0.88u as=93.59999f ps=0.88u w=0.36u l=0.28u
X238 a_57475_3908# a_56427_3404# VSS VSS nfet_03v3 ad=93.59999f pd=0.88u as=93.59999f ps=0.88u w=0.36u l=0.28u
X239 a_54923_3118# CLK.t19 VDD VDD pfet_03v3 ad=0.108p pd=0.96u as=0.1728p ps=1.68u w=0.36u l=0.28u
X240 a_47801_3392# a_45680_3448# a_48121_3448# VDD pfet_03v3 ad=0.1872p pd=1.24u as=86.39999f ps=0.96u w=0.72u l=0.28u
X241 a_35349_2618# CLK.t20 a_34238_2618# VSS nfet_03v3 ad=0.1728p pd=1.68u as=0.1728p ps=1.68u w=0.36u l=0.28u
X242 a_46493_3400# a_46096_4236# a_46493_4236# VSS nfet_03v3 ad=0.1332p pd=1.1u as=0.4446p ps=3.19u w=0.36u l=0.28u
X243 VDD a_32981_3448# a_35686_3448# VDD pfet_03v3 ad=0.3168p pd=2.32u as=0.1872p ps=1.24u w=0.72u l=0.28u
X244 VDD PC14.t5 a_61708_3448# VDD pfet_03v3 ad=0.1872p pd=1.24u as=0.3168p ps=2.32u w=0.72u l=0.28u
X245 a_43008_2618# a_42704_2618# VSS VSS nfet_03v3 ad=0.108p pd=0.96u as=0.1728p ps=1.68u w=0.36u l=0.28u
X246 a_10912_3448# a_9864_3404# VDD VDD pfet_03v3 ad=0.1872p pd=1.24u as=0.1872p ps=1.24u w=0.72u l=0.28u
X247 a_526_3118# RSTn.t13 VDD VDD pfet_03v3 ad=0.108p pd=0.96u as=0.108p ps=0.96u w=0.36u l=0.28u
X248 a_56514_2618# a_56849_3118# a_57481_2618# VSS nfet_03v3 ad=0.1728p pd=1.68u as=0.108p ps=0.96u w=0.36u l=0.28u
X249 a_50866_2618# a_50329_2616# a_51322_3118# VDD pfet_03v3 ad=0.1728p pd=1.68u as=0.108p ps=0.96u w=0.36u l=0.28u
X250 a_18752_3118# a_18417_2618# a_18904_2618# VSS nfet_03v3 ad=0.1728p pd=1.68u as=0.108p ps=0.96u w=0.36u l=0.28u
X251 DEST10.t1 JMP.t12 a_42260_3400# VSS nfet_03v3 ad=0.18p pd=1.72u as=0.1332p ps=1.1u w=0.36u l=0.28u
X252 a_54956_2866# SE.t15 a_54959_3400# VDD pfet_03v3 ad=0.1332p pd=1.1u as=0.3654p ps=2.75u w=0.36u l=0.28u
X253 a_58099_3908# PC13.t4 a_56787_3632# VSS nfet_03v3 ad=57.59999f pd=0.68u as=93.59999f ps=0.88u w=0.36u l=0.28u
X254 a_8393_2866# SE.t16 a_8396_3400# VDD pfet_03v3 ad=0.1332p pd=1.1u as=0.3654p ps=2.75u w=0.36u l=0.28u
X255 PC11.t2 a_50329_3400# a_50723_2866# VDD pfet_03v3 ad=0.2592p pd=2.16u as=0.1332p ps=1.1u w=0.36u l=0.28u
X256 a_6055_3908# PC1.t5 VSS VSS nfet_03v3 ad=93.59999f pd=0.88u as=93.59999f ps=0.88u w=0.36u l=0.28u
X257 VDD PC4.t5 a_19378_3448# VDD pfet_03v3 ad=0.1872p pd=1.24u as=0.3168p ps=2.32u w=0.72u l=0.28u
X258 a_52618_3448# PC12.t5 VDD VDD pfet_03v3 ad=0.1872p pd=1.24u as=0.1872p ps=1.24u w=0.72u l=0.28u
X259 a_65315_3118# a_64980_2618# VDD VDD pfet_03v3 ad=0.1728p pd=1.68u as=0.108p ps=0.96u w=0.36u l=0.28u
X260 a_12629_3400# a_12232_4236# a_12629_4236# VSS nfet_03v3 ad=0.1332p pd=1.1u as=0.4446p ps=3.19u w=0.36u l=0.28u
X261 a_49913_3448# a_48321_3632# VDD VDD pfet_03v3 ad=0.3168p pd=2.32u as=0.1872p ps=1.24u w=0.72u l=0.28u
X262 PC12.t1 a_52616_3118# VSS VSS nfet_03v3 ad=0.1728p pd=1.68u as=0.1728p ps=1.68u w=0.36u l=0.28u
X263 a_15151_2618# a_12232_2616# VSS VSS nfet_03v3 ad=0.108p pd=0.96u as=0.1728p ps=1.68u w=0.36u l=0.28u
X264 VSS a_39335_3392# a_38027_4236# VSS nfet_03v3 ad=93.59999f pd=0.88u as=0.1584p ps=1.6u w=0.36u l=0.28u
X265 a_64021_3118# RSTn.t14 a_64173_2618# VSS nfet_03v3 ad=0.108p pd=0.96u as=0.108p ps=0.96u w=0.36u l=0.28u
X266 DEST9.t1 a_37630_4236# a_38027_3400# VDD.t251 pfet_03v3 ad=0.18p pd=1.72u as=0.1332p ps=1.1u w=0.36u l=0.28u
X267 a_14257_3448# PC3.t5 a_14153_3448# VDD pfet_03v3 ad=86.39999f pd=0.96u as=86.39999f ps=0.96u w=0.72u l=0.28u
X268 VSS a_37214_3448# a_39919_3908# VSS nfet_03v3 ad=0.1584p pd=1.6u as=93.59999f ps=0.88u w=0.36u l=0.28u
X269 a_65317_3448# a_65253_3632# a_64733_3392# VDD pfet_03v3 ad=0.1872p pd=1.24u as=0.1872p ps=1.24u w=0.72u l=0.28u
X270 a_42704_2618# a_42400_2618# VDD VDD pfet_03v3 ad=0.1728p pd=1.68u as=0.1728p ps=1.68u w=0.36u l=0.28u
X271 a_12769_2618# a_12626_2866# a_12593_3118# VDD pfet_03v3 ad=0.1728p pd=1.68u as=0.108p ps=0.96u w=0.36u l=0.28u
X272 a_16049_3448# a_14457_3632# VDD VDD pfet_03v3 ad=0.3168p pd=2.32u as=0.1872p ps=1.24u w=0.72u l=0.28u
X273 PC0.t1 a_1820_3118# VDD VDD pfet_03v3 ad=0.3456p pd=2.4u as=0.3456p ps=2.4u w=0.72u l=0.28u
X274 a_29956_5022.t14 BR.t14 a_64893_3404# VSS nfet_03v3 ad=0.3654p pd=2.75u as=0.1332p ps=1.1u w=0.36u l=0.28u
X275 a_26956_3908# PC6.t5 a_26852_3908# VSS nfet_03v3 ad=43.2f pd=0.6u as=43.2f ps=0.6u w=0.36u l=0.28u
X276 a_52034_3392# a_49913_3448# a_52354_3908# VSS nfet_03v3 ad=93.59999f pd=0.88u as=43.2f ps=0.6u w=0.36u l=0.28u
X277 VDD RSTn.t15 a_22985_3118# VDD pfet_03v3 ad=0.108p pd=0.96u as=0.1728p ps=1.68u w=0.36u l=0.28u
X278 a_48385_3908# PC11.t6 VSS VSS nfet_03v3 ad=93.59999f pd=0.88u as=93.59999f ps=0.88u w=0.36u l=0.28u
X279 a_29956_5022.t35 a_29172_5022# VSS.t605 VSS nfet_03v3 ad=0.108p pd=0.96u as=0.108p ps=0.96u w=0.36u l=0.28u
X280 a_26883_2618# a_27218_3118# a_27850_3118# VDD pfet_03v3 ad=0.1728p pd=1.68u as=0.108p ps=0.96u w=0.36u l=0.28u
X281 a_10024_3908# PC2.t5 a_9920_3908# VSS nfet_03v3 ad=43.2f pd=0.6u as=43.2f ps=0.6u w=0.36u l=0.28u
X282 VDD PC2.t6 a_10912_3448# VDD pfet_03v3 ad=0.1872p pd=1.24u as=0.3168p ps=2.32u w=0.72u l=0.28u
X283 VSS PC5.t5 a_23611_3908# VSS nfet_03v3 ad=93.59999f pd=0.88u as=0.1584p ps=1.6u w=0.36u l=0.28u
X284 PC10.t3 a_46096_3400# a_46490_2866# VDD pfet_03v3 ad=0.2592p pd=2.16u as=0.1332p ps=1.1u w=0.36u l=0.28u
X285 a_55099_2618# CLK.t21 a_55555_3118# VSS nfet_03v3 ad=0.1728p pd=1.68u as=0.108p ps=0.96u w=0.36u l=0.28u
X286 a_33934_2618# a_33791_2866# a_33758_2618# VSS nfet_03v3 ad=0.1728p pd=1.68u as=0.108p ps=0.96u w=0.36u l=0.28u
X287 a_14671_2618# RSTn.t16 VSS VSS nfet_03v3 ad=0.108p pd=0.96u as=0.1728p ps=1.68u w=0.36u l=0.28u
X288 a_52281_2618# a_52616_3118# a_53248_3118# VDD pfet_03v3 ad=0.1728p pd=1.68u as=0.108p ps=0.96u w=0.36u l=0.28u
X289 a_16465_4236# JMP.t13 VDD.t685 VDD.t684 pfet_03v3 ad=0.4032p pd=2.56u as=0.3168p ps=2.32u w=0.72u l=0.28u
X290 a_39495_3404# BR.t15 VSS VDD.t320 pfet_03v3 ad=0.1332p pd=1.1u as=0.2592p ps=2.16u w=0.36u l=0.28u
X291 a_53138_4236# BR.t16 VSS VSS nfet_03v3 ad=0.2016p pd=1.84u as=0.1584p ps=1.6u w=0.36u l=0.28u
X292 VDD a_30869_3392# a_29561_4236# VDD pfet_03v3 ad=0.1872p pd=1.24u as=0.3168p ps=2.32u w=0.72u l=0.28u
X293 a_58795_2616# CLK.t22 VSS VSS nfet_03v3 ad=0.2016p pd=1.84u as=0.1584p ps=1.6u w=0.36u l=0.28u
X294 a_31029_3404# a_31973_4236# VSS VSS nfet_03v3 ad=0.1332p pd=1.1u as=0.2592p ps=2.16u w=0.36u l=0.28u
X295 a_16859_2866# SE.t17 a_16862_3400# VDD pfet_03v3 ad=0.1332p pd=1.1u as=0.3654p ps=2.75u w=0.36u l=0.28u
X296 a_63869_2618# a_63565_2618# VSS VSS nfet_03v3 ad=0.1728p pd=1.68u as=0.1728p ps=1.68u w=0.36u l=0.28u
X297 a_25292_2618# a_24931_2616# VSS VSS nfet_03v3 ad=0.108p pd=0.96u as=0.1728p ps=1.68u w=0.36u l=0.28u
X298 a_31116_2618# a_29164_2616# a_30005_2618# VDD pfet_03v3 ad=0.1728p pd=1.68u as=0.1728p ps=1.68u w=0.36u l=0.28u
X299 a_6575_4236# BR.t17 VSS VSS nfet_03v3 ad=0.2016p pd=1.84u as=0.1584p ps=1.6u w=0.36u l=0.28u
X300 VDD a_52194_3404# a_52618_3448# VDD pfet_03v3 ad=0.1872p pd=1.24u as=0.1872p ps=1.24u w=0.72u l=0.28u
X301 a_14521_3908# PC3.t6 VSS VSS nfet_03v3 ad=93.59999f pd=0.88u as=93.59999f ps=0.88u w=0.36u l=0.28u
X302 a_20002_3908# PC4.t6 a_18690_3632# VSS nfet_03v3 ad=57.59999f pd=0.68u as=93.59999f ps=0.88u w=0.36u l=0.28u
X303 VSS PC1.t6 a_6679_3908# VSS nfet_03v3 ad=93.59999f pd=0.88u as=0.1584p ps=1.6u w=0.36u l=0.28u
X304 PC2.t3 a_12232_3400# a_12626_2866# VDD pfet_03v3 ad=0.2592p pd=2.16u as=0.1332p ps=1.1u w=0.36u l=0.28u
X305 a_46096_4236# JMP.t14 VDD.t687 VDD.t686 pfet_03v3 ad=0.4032p pd=2.56u as=0.3168p ps=2.32u w=0.72u l=0.28u
X306 a_n106_3118# CLK.t23 VDD VDD pfet_03v3 ad=0.108p pd=0.96u as=0.1728p ps=1.68u w=0.36u l=0.28u
X307 a_29956_5022.t4 a_57371_4236# a_56427_3404# VDD.t204 pfet_03v3 ad=0.3654p pd=2.75u as=0.1332p ps=1.1u w=0.36u l=0.28u
X308 a_39655_3448# PC9.t5 a_39551_3448# VDD pfet_03v3 ad=86.39999f pd=0.96u as=86.39999f ps=0.96u w=0.72u l=0.28u
X309 a_24931_2616# CLK.t24 VSS VSS nfet_03v3 ad=0.2016p pd=1.84u as=0.1584p ps=1.6u w=0.36u l=0.28u
X310 a_30157_3118# RSTn.t17 VDD VDD pfet_03v3 ad=0.108p pd=0.96u as=0.108p ps=0.96u w=0.36u l=0.28u
X311 VDD a_49913_3448# a_52618_3448# VDD pfet_03v3 ad=0.3168p pd=2.32u as=0.1872p ps=1.24u w=0.72u l=0.28u
X312 a_8360_2618# a_7999_2616# VSS VSS nfet_03v3 ad=0.108p pd=0.96u as=0.1728p ps=1.68u w=0.36u l=0.28u
X313 VDD RSTn.t18 a_18752_3118# VDD pfet_03v3 ad=0.108p pd=0.96u as=0.1728p ps=1.68u w=0.36u l=0.28u
X314 a_5991_3632# a_3350_3448# a_6679_3908# VSS nfet_03v3 ad=93.59999f pd=0.88u as=93.59999f ps=0.88u w=0.36u l=0.28u
X315 a_64733_3392# a_62612_3448# a_65053_3448# VDD pfet_03v3 ad=0.1872p pd=1.24u as=86.39999f ps=0.96u w=0.72u l=0.28u
X316 a_26796_3404# BR.t18 VSS VDD.t355 pfet_03v3 ad=0.1332p pd=1.1u as=0.2592p ps=2.16u w=0.36u l=0.28u
X317 VDD a_14097_3404# a_15769_3448# VDD pfet_03v3 ad=0.1872p pd=1.24u as=0.1152p ps=1.04u w=0.72u l=0.28u
X318 VDD a_18170_3392# a_16862_4236# VDD pfet_03v3 ad=0.1872p pd=1.24u as=0.3168p ps=2.32u w=0.72u l=0.28u
X319 a_27220_3908# a_27156_3632# a_26636_3392# VSS nfet_03v3 ad=93.59999f pd=0.88u as=93.59999f ps=0.88u w=0.36u l=0.28u
X320 VSS a_62612_3448# a_65317_3908# VSS nfet_03v3 ad=0.1584p pd=1.6u as=93.59999f ps=0.88u w=0.36u l=0.28u
X321 a_29525_3118# CLK.t25 VDD VDD pfet_03v3 ad=0.108p pd=0.96u as=0.1728p ps=1.68u w=0.36u l=0.28u
X322 a_1558_3908# PC0.t5 a_1454_3908# VSS nfet_03v3 ad=43.2f pd=0.6u as=43.2f ps=0.6u w=0.36u l=0.28u
X323 a_40543_3908# a_39495_3404# VSS VSS nfet_03v3 ad=93.59999f pd=0.88u as=93.59999f ps=0.88u w=0.36u l=0.28u
X324 a_59788_3118# RSTn.t19 VDD VDD pfet_03v3 ad=0.108p pd=0.96u as=0.108p ps=0.96u w=0.36u l=0.28u
X325 a_17610_2618# a_17306_2618# VSS VSS nfet_03v3 ad=0.108p pd=0.96u as=0.1728p ps=1.68u w=0.36u l=0.28u
X326 DISP5.t0 a_23507_4236# a_22563_3404# VDD.t7 pfet_03v3 ad=0.3654p pd=2.75u as=0.1332p ps=1.1u w=0.36u l=0.28u
X327 VDD PC8.t5 a_36310_3448# VDD pfet_03v3 ad=0.1872p pd=1.24u as=0.3168p ps=2.32u w=0.72u l=0.28u
X328 a_1485_2618# a_1820_3118# a_2452_3118# VDD pfet_03v3 ad=0.1728p pd=1.68u as=0.108p ps=0.96u w=0.36u l=0.28u
X329 a_48905_4236# BR.t19 VSS VSS nfet_03v3 ad=0.2016p pd=1.84u as=0.1584p ps=1.6u w=0.36u l=0.28u
X330 a_33397_3400# SE.t18 VSS VSS nfet_03v3 ad=0.2016p pd=1.84u as=0.1584p ps=1.6u w=0.36u l=0.28u
X331 a_63565_2618# PC_NEXT15.t4 a_63389_3118# VDD pfet_03v3 ad=0.1728p pd=1.68u as=0.108p ps=0.96u w=0.36u l=0.28u
X332 a_25468_2618# a_24931_2616# a_25924_3118# VDD pfet_03v3 ad=0.1728p pd=1.68u as=0.108p ps=0.96u w=0.36u l=0.28u
X333 a_7999_2616# CLK.t26 VSS VSS nfet_03v3 ad=0.2016p pd=1.84u as=0.1584p ps=1.6u w=0.36u l=0.28u
X334 a_29561_3400# JMP.t15 a_29561_4236# VDD.t276 pfet_03v3 ad=0.1332p pd=1.1u as=0.4446p ps=3.19u w=0.36u l=0.28u
X335 a_66845_3448# a_65253_3632# VDD VDD pfet_03v3 ad=0.3168p pd=2.32u as=0.1872p ps=1.24u w=0.72u l=0.28u
X336 a_26883_2618# a_24931_2616# a_25772_2618# VDD pfet_03v3 ad=0.1728p pd=1.68u as=0.1728p ps=1.68u w=0.36u l=0.28u
X337 SI.t0 SE.t19 a_n73_2866# VSS nfet_03v3 ad=0.2592p pd=2.16u as=0.1332p ps=1.1u w=0.36u l=0.28u
X338 VSS a_56267_3392# a_54959_4236# VSS nfet_03v3 ad=93.59999f pd=0.88u as=0.1584p ps=1.6u w=0.36u l=0.28u
X339 a_13073_2618# a_12769_2618# VSS VSS nfet_03v3 ad=0.1728p pd=1.68u as=0.1728p ps=1.68u w=0.36u l=0.28u
X340 VDD.t658 a_29172_5022# a_29956_5022.t24 VDD.t439 pfet_03v3 ad=0.216p pd=1.32u as=0.216p ps=1.32u w=0.72u l=0.28u
X341 a_27220_3448# PC6.t6 VDD VDD pfet_03v3 ad=0.1872p pd=1.24u as=0.1872p ps=1.24u w=0.72u l=0.28u
X342 a_17002_2618# CLK.t27 a_17458_3118# VSS nfet_03v3 ad=0.1728p pd=1.68u as=0.108p ps=0.96u w=0.36u l=0.28u
X343 a_15041_4236# BR.t20 VSS VSS nfet_03v3 ad=0.2016p pd=1.84u as=0.1584p ps=1.6u w=0.36u l=0.28u
X344 a_56427_3404# a_57371_4236# VSS VSS nfet_03v3 ad=0.1332p pd=1.1u as=0.2592p ps=2.16u w=0.36u l=0.28u
X345 VSS a_14097_3404# a_14521_3908# VSS nfet_03v3 ad=93.59999f pd=0.88u as=93.59999f ps=0.88u w=0.36u l=0.28u
X346 a_31189_3448# PC7.t6 a_31085_3448# VDD pfet_03v3 ad=86.39999f pd=0.96u as=86.39999f ps=0.96u w=0.72u l=0.28u
X347 PC6.t1 a_27218_3118# VSS VSS nfet_03v3 ad=0.1728p pd=1.68u as=0.1728p ps=1.68u w=0.36u l=0.28u
X348 a_8536_2618# a_7999_2616# a_8992_3118# VDD pfet_03v3 ad=0.1728p pd=1.68u as=0.108p ps=0.96u w=0.36u l=0.28u
X349 VDD a_45680_3448# a_48385_3448# VDD pfet_03v3 ad=0.3168p pd=2.32u as=0.1872p ps=1.24u w=0.72u l=0.28u
X350 a_23611_3448# a_22563_3404# VDD VDD pfet_03v3 ad=0.1872p pd=1.24u as=0.1872p ps=1.24u w=0.72u l=0.28u
X351 a_31085_3448# a_31029_3404# VDD VDD pfet_03v3 ad=86.39999f pd=0.96u as=0.1872p ps=1.24u w=0.72u l=0.28u
X352 a_43888_3908# PC10.t6 a_43784_3908# VSS nfet_03v3 ad=43.2f pd=0.6u as=43.2f ps=0.6u w=0.36u l=0.28u
X353 a_21059_3118# CLK.t28 VDD VDD pfet_03v3 ad=0.108p pd=0.96u as=0.1728p ps=1.68u w=0.36u l=0.28u
X354 a_55555_3118# RSTn.t20 VDD VDD pfet_03v3 ad=0.108p pd=0.96u as=0.108p ps=0.96u w=0.36u l=0.28u
X355 DISP4.t1 a_19274_4236# a_18330_3404# VDD.t738 pfet_03v3 ad=0.3654p pd=2.75u as=0.1332p ps=1.1u w=0.36u l=0.28u
X356 a_43784_3908# a_43728_3404# VSS VSS nfet_03v3 ad=43.2f pd=0.6u as=93.59999f ps=0.88u w=0.36u l=0.28u
X357 a_16826_2618# a_16465_2616# VSS VSS nfet_03v3 ad=0.108p pd=0.96u as=0.1728p ps=1.68u w=0.36u l=0.28u
X358 VDD a_11816_3448# a_14521_3448# VDD pfet_03v3 ad=0.3168p pd=2.32u as=0.1872p ps=1.24u w=0.72u l=0.28u
X359 a_53242_3448# a_52194_3404# VDD VDD pfet_03v3 ad=0.1872p pd=1.24u as=0.1872p ps=1.24u w=0.72u l=0.28u
X360 a_31603_2618# RSTn.t21 VSS VSS nfet_03v3 ad=0.108p pd=0.96u as=0.1728p ps=1.68u w=0.36u l=0.28u
X361 a_26636_3392# a_24515_3448# a_26956_3908# VSS nfet_03v3 ad=93.59999f pd=0.88u as=43.2f ps=0.6u w=0.36u l=0.28u
X362 a_24235_3448# PC5.t6 a_22923_3632# VDD pfet_03v3 ad=0.1152p pd=1.04u as=0.1872p ps=1.24u w=0.72u l=0.28u
X363 a_36316_3118# CLK.t29 VDD VDD pfet_03v3 ad=0.108p pd=0.96u as=0.1728p ps=1.68u w=0.36u l=0.28u
X364 a_1822_3448# a_1758_3632# a_1238_3392# VDD pfet_03v3 ad=0.1872p pd=1.24u as=0.1872p ps=1.24u w=0.72u l=0.28u
X365 a_6679_3448# a_5631_3404# VDD VDD pfet_03v3 ad=0.1872p pd=1.24u as=0.1872p ps=1.24u w=0.72u l=0.28u
X366 a_42224_2618# a_41863_2616# VSS VSS nfet_03v3 ad=0.108p pd=0.96u as=0.1728p ps=1.68u w=0.36u l=0.28u
X367 a_54562_4236# JMP.t16 VSS VSS nfet_03v3 ad=0.2016p pd=1.84u as=0.1584p ps=1.6u w=0.36u l=0.28u
X368 VSS a_5471_3392# a_4163_4236# VSS nfet_03v3 ad=93.59999f pd=0.88u as=0.1584p ps=1.6u w=0.36u l=0.28u
X369 VSS PC9.t6 a_40543_3908# VSS nfet_03v3 ad=93.59999f pd=0.88u as=0.1584p ps=1.6u w=0.36u l=0.28u
X370 a_50866_2618# a_50723_2866# a_50690_2618# VSS nfet_03v3 ad=0.1728p pd=1.68u as=0.108p ps=0.96u w=0.36u l=0.28u
X371 a_36934_3908# PC8.t6 a_35622_3632# VSS nfet_03v3 ad=57.59999f pd=0.68u as=93.59999f ps=0.88u w=0.36u l=0.28u
X372 a_1485_2618# a_n467_2616# a_374_2618# VDD pfet_03v3 ad=0.1728p pd=1.68u as=0.1728p ps=1.68u w=0.36u l=0.28u
X373 a_4163_3400# JMP.t17 a_4163_4236# VDD.t395 pfet_03v3 ad=0.1332p pd=1.1u as=0.4446p ps=3.19u w=0.36u l=0.28u
X374 a_3042_4236# BR.t21 a_1398_3404# VSS nfet_03v3 ad=0.3654p pd=2.75u as=0.1332p ps=1.1u w=0.36u l=0.28u
X375 VDD a_64893_3404# a_66565_3448# VDD pfet_03v3 ad=0.1872p pd=1.24u as=0.1152p ps=1.04u w=0.72u l=0.28u
X376 a_21691_3118# RSTn.t22 VDD VDD pfet_03v3 ad=0.108p pd=0.96u as=0.108p ps=0.96u w=0.36u l=0.28u
X377 a_1822_3448# PC0.t6 VDD VDD pfet_03v3 ad=0.1872p pd=1.24u as=0.1872p ps=1.24u w=0.72u l=0.28u
X378 a_7303_3448# PC1.t7 a_5991_3632# VDD pfet_03v3 ad=0.1152p pd=1.04u as=0.1872p ps=1.24u w=0.72u l=0.28u
X379 a_38471_2618# a_38167_2618# VSS VSS nfet_03v3 ad=0.1728p pd=1.68u as=0.1728p ps=1.68u w=0.36u l=0.28u
X380 a_27218_3118# a_26883_2618# a_27370_2618# VSS nfet_03v3 ad=0.1728p pd=1.68u as=0.108p ps=0.96u w=0.36u l=0.28u
X381 VDD a_26796_3404# a_27220_3448# VDD pfet_03v3 ad=0.1872p pd=1.24u as=0.1872p ps=1.24u w=0.72u l=0.28u
X382 VDD a_13073_2618# a_13225_3118# VDD pfet_03v3 ad=0.108p pd=0.96u as=0.1728p ps=1.68u w=0.36u l=0.28u
X383 a_20698_4236# JMP.t18 VSS VSS nfet_03v3 ad=0.2016p pd=1.84u as=0.1584p ps=1.6u w=0.36u l=0.28u
X384 a_39855_3632# a_37214_3448# a_40543_3448# VDD pfet_03v3 ad=0.1872p pd=1.24u as=0.1872p ps=1.24u w=0.72u l=0.28u
X385 a_56587_3448# PC13.t5 a_56483_3448# VDD pfet_03v3 ad=86.39999f pd=0.96u as=86.39999f ps=0.96u w=0.72u l=0.28u
X386 VDD a_31029_3404# a_32701_3448# VDD pfet_03v3 ad=0.1872p pd=1.24u as=0.1152p ps=1.04u w=0.72u l=0.28u
X387 a_44152_3908# a_44088_3632# a_43568_3392# VSS nfet_03v3 ad=93.59999f pd=0.88u as=93.59999f ps=0.88u w=0.36u l=0.28u
X388 a_49009_3908# a_47961_3404# VSS VSS nfet_03v3 ad=93.59999f pd=0.88u as=93.59999f ps=0.88u w=0.36u l=0.28u
X389 a_34542_2618# a_34238_2618# VSS VSS nfet_03v3 ad=0.108p pd=0.96u as=0.1728p ps=1.68u w=0.36u l=0.28u
X390 a_29956_5022.t3 a_40439_4236# a_39495_3404# VDD.t203 pfet_03v3 ad=0.3654p pd=2.75u as=0.1332p ps=1.1u w=0.36u l=0.28u
X391 a_56483_3448# a_56427_3404# VDD VDD pfet_03v3 ad=86.39999f pd=0.96u as=0.1872p ps=1.24u w=0.72u l=0.28u
X392 a_50329_3400# SE.t20 VSS VSS nfet_03v3 ad=0.2016p pd=1.84u as=0.1584p ps=1.6u w=0.36u l=0.28u
X393 a_70_2618# a_n467_2616# a_526_3118# VDD pfet_03v3 ad=0.1728p pd=1.68u as=0.108p ps=0.96u w=0.36u l=0.28u
X394 a_48048_2618# a_48383_3118# a_49015_2618# VSS nfet_03v3 ad=0.1728p pd=1.68u as=0.108p ps=0.96u w=0.36u l=0.28u
X395 a_46457_3118# CLK.t30 VDD VDD pfet_03v3 ad=0.108p pd=0.96u as=0.1728p ps=1.68u w=0.36u l=0.28u
X396 a_43815_2618# a_41863_2616# a_42704_2618# VDD pfet_03v3 ad=0.1728p pd=1.68u as=0.1728p ps=1.68u w=0.36u l=0.28u
X397 a_46493_3400# JMP.t19 a_46493_4236# VDD.t396 pfet_03v3 ad=0.1332p pd=1.1u as=0.4446p ps=3.19u w=0.36u l=0.28u
X398 a_3766_4236# JMP.t20 VSS VSS nfet_03v3 ad=0.2016p pd=1.84u as=0.1584p ps=1.6u w=0.36u l=0.28u
X399 a_44672_4236# BR.t22 VDD.t626 VDD.t625 pfet_03v3 ad=0.4032p pd=2.56u as=0.3168p ps=2.32u w=0.72u l=0.28u
X400 a_22923_3632# a_20282_3448# a_23611_3448# VDD pfet_03v3 ad=0.1872p pd=1.24u as=0.1872p ps=1.24u w=0.72u l=0.28u
X401 a_33397_3400# SE.t21 VDD VDD pfet_03v3 ad=0.4032p pd=2.56u as=0.3168p ps=2.32u w=0.72u l=0.28u
X402 VDD PC12.t6 a_53242_3448# VDD pfet_03v3 ad=0.1872p pd=1.24u as=0.3168p ps=2.32u w=0.72u l=0.28u
X403 PC10.t1 a_44150_3118# VDD VDD pfet_03v3 ad=0.3456p pd=2.4u as=0.3456p ps=2.4u w=0.72u l=0.28u
X404 DEST10.t0 a_41863_4236# a_42260_3400# VDD.t34 pfet_03v3 ad=0.18p pd=1.72u as=0.1332p ps=1.1u w=0.36u l=0.28u
X405 SI.t1 a_n467_3400# a_n73_2866# VDD pfet_03v3 ad=0.2592p pd=2.16u as=0.1332p ps=1.1u w=0.36u l=0.28u
X406 a_15145_3908# a_14097_3404# VSS VSS nfet_03v3 ad=93.59999f pd=0.88u as=93.59999f ps=0.88u w=0.36u l=0.28u
X407 a_49633_3448# PC11.t7 a_48321_3632# VDD pfet_03v3 ad=0.1152p pd=1.04u as=0.1872p ps=1.24u w=0.72u l=0.28u
X408 a_57001_2618# RSTn.t23 VSS VSS nfet_03v3 ad=0.108p pd=0.96u as=0.1728p ps=1.68u w=0.36u l=0.28u
X409 a_33934_2618# CLK.t31 a_34390_3118# VSS nfet_03v3 ad=0.1728p pd=1.68u as=0.108p ps=0.96u w=0.36u l=0.28u
X410 a_58795_4236# JMP.t21 VDD.t132 VDD.t131 pfet_03v3 ad=0.4032p pd=2.56u as=0.3168p ps=2.32u w=0.72u l=0.28u
X411 a_1238_3392# VSS a_1558_3448# VDD pfet_03v3 ad=0.1872p pd=1.24u as=86.39999f ps=0.96u w=0.72u l=0.28u
X412 a_20282_3448# a_18690_3632# VSS VSS nfet_03v3 ad=0.1584p pd=1.6u as=93.59999f ps=0.88u w=0.36u l=0.28u
X413 a_22619_3448# a_22563_3404# VDD VDD pfet_03v3 ad=86.39999f pd=0.96u as=0.1872p ps=1.24u w=0.72u l=0.28u
X414 VSS a_31029_3404# a_31453_3908# VSS nfet_03v3 ad=93.59999f pd=0.88u as=93.59999f ps=0.88u w=0.36u l=0.28u
X415 a_35622_3632# a_32981_3448# a_36310_3908# VSS nfet_03v3 ad=93.59999f pd=0.88u as=93.59999f ps=0.88u w=0.36u l=0.28u
X416 a_14184_2618# a_14519_3118# a_15151_2618# VSS nfet_03v3 ad=0.1728p pd=1.68u as=0.108p ps=0.96u w=0.36u l=0.28u
X417 a_12629_3400# JMP.t22 a_12629_4236# VDD.t133 pfet_03v3 ad=0.1332p pd=1.1u as=0.4446p ps=3.19u w=0.36u l=0.28u
X418 a_56849_3118# a_56514_2618# VDD VDD pfet_03v3 ad=0.1728p pd=1.68u as=0.108p ps=0.96u w=0.36u l=0.28u
X419 a_1820_3118# a_1485_2618# a_1972_2618# VSS nfet_03v3 ad=0.1728p pd=1.68u as=0.108p ps=0.96u w=0.36u l=0.28u
X420 a_10808_4236# BR.t23 VDD.t628 VDD.t627 pfet_03v3 ad=0.4032p pd=2.56u as=0.3168p ps=2.32u w=0.72u l=0.28u
X421 a_60820_3908# PC14.t6 a_60716_3908# VSS nfet_03v3 ad=43.2f pd=0.6u as=43.2f ps=0.6u w=0.36u l=0.28u
X422 a_64980_2618# CLK.t32 a_63869_2618# VSS nfet_03v3 ad=0.1728p pd=1.68u as=0.1728p ps=1.68u w=0.36u l=0.28u
X423 PC2.t1 a_10286_3118# VDD VDD pfet_03v3 ad=0.3456p pd=2.4u as=0.3456p ps=2.4u w=0.72u l=0.28u
X424 VSS.t604 a_29172_5022# a_29956_5022.t34 VSS nfet_03v3 ad=0.108p pd=0.96u as=0.108p ps=0.96u w=0.36u l=0.28u
X425 a_24931_4236# JMP.t23 VDD.t135 VDD.t134 pfet_03v3 ad=0.4032p pd=2.56u as=0.3168p ps=2.32u w=0.72u l=0.28u
X426 PC6.t2 SE.t22 a_29558_2866# VSS nfet_03v3 ad=0.2592p pd=2.16u as=0.1332p ps=1.1u w=0.36u l=0.28u
X427 a_54562_2616# CLK.t33 VDD VDD pfet_03v3 ad=0.4032p pd=2.56u as=0.3168p ps=2.32u w=0.72u l=0.28u
X428 a_5687_3448# a_5631_3404# VDD VDD pfet_03v3 ad=86.39999f pd=0.96u as=0.1872p ps=1.24u w=0.72u l=0.28u
X429 VSS a_56427_3404# a_58099_3908# VSS nfet_03v3 ad=93.59999f pd=0.88u as=57.59999f ps=0.68u w=0.36u l=0.28u
X430 VDD a_28748_3448# a_31453_3448# VDD pfet_03v3 ad=0.3168p pd=2.32u as=0.1872p ps=1.24u w=0.72u l=0.28u
X431 a_18490_3908# PC4.t7 a_18386_3908# VSS nfet_03v3 ad=43.2f pd=0.6u as=43.2f ps=0.6u w=0.36u l=0.28u
X432 VDD a_63869_2618# a_64021_3118# VDD pfet_03v3 ad=0.108p pd=0.96u as=0.1728p ps=1.68u w=0.36u l=0.28u
X433 a_53248_3118# CLK.t34 VDD VDD pfet_03v3 ad=0.108p pd=0.96u as=0.1728p ps=1.68u w=0.36u l=0.28u
X434 a_59189_2866# a_58795_3400# a_59192_3400# VSS nfet_03v3 ad=0.1332p pd=1.1u as=0.3654p ps=2.75u w=0.36u l=0.28u
X435 a_43568_3392# a_41447_3448# a_43888_3448# VDD pfet_03v3 ad=0.1872p pd=1.24u as=86.39999f ps=0.96u w=0.72u l=0.28u
X436 a_6685_3118# CLK.t35 VDD VDD pfet_03v3 ad=0.108p pd=0.96u as=0.1728p ps=1.68u w=0.36u l=0.28u
X437 a_29956_5022.t5 a_65837_4236# a_64893_3404# VDD.t221 pfet_03v3 ad=0.3654p pd=2.75u as=0.1332p ps=1.1u w=0.36u l=0.28u
X438 a_41167_3448# PC9.t7 a_39855_3632# VDD pfet_03v3 ad=0.1152p pd=1.04u as=0.1872p ps=1.24u w=0.72u l=0.28u
X439 a_59940_2618# a_59636_2618# VSS VSS nfet_03v3 ad=0.108p pd=0.96u as=0.1728p ps=1.68u w=0.36u l=0.28u
X440 a_7999_4236# JMP.t24 VDD.t137 VDD.t136 pfet_03v3 ad=0.4032p pd=2.56u as=0.3168p ps=2.32u w=0.72u l=0.28u
X441 a_27844_3448# a_26796_3404# VDD VDD pfet_03v3 ad=0.1872p pd=1.24u as=0.1872p ps=1.24u w=0.72u l=0.28u
X442 a_44782_2618# a_41863_2616# VSS VSS nfet_03v3 ad=0.108p pd=0.96u as=0.1728p ps=1.68u w=0.36u l=0.28u
X443 a_20698_2616# CLK.t36 VDD VDD pfet_03v3 ad=0.4032p pd=2.56u as=0.3168p ps=2.32u w=0.72u l=0.28u
X444 a_29164_4236# JMP.t25 VSS VSS nfet_03v3 ad=0.2016p pd=1.84u as=0.1584p ps=1.6u w=0.36u l=0.28u
X445 a_9704_3392# a_7583_3448# a_10024_3908# VSS nfet_03v3 ad=93.59999f pd=0.88u as=43.2f ps=0.6u w=0.36u l=0.28u
X446 VSS PC3.t7 a_15145_3908# VSS nfet_03v3 ad=93.59999f pd=0.88u as=0.1584p ps=1.6u w=0.36u l=0.28u
X447 a_53866_3908# PC12.t7 a_52554_3632# VSS nfet_03v3 ad=57.59999f pd=0.68u as=93.59999f ps=0.88u w=0.36u l=0.28u
X448 a_55403_2618# a_55099_2618# VSS VSS nfet_03v3 ad=0.1728p pd=1.68u as=0.1728p ps=1.68u w=0.36u l=0.28u
X449 a_25468_2618# a_25325_2866# a_25292_2618# VSS nfet_03v3 ad=0.1728p pd=1.68u as=0.108p ps=0.96u w=0.36u l=0.28u
X450 VDD a_43728_3404# a_44152_3448# VDD pfet_03v3 ad=0.1872p pd=1.24u as=0.1872p ps=1.24u w=0.72u l=0.28u
X451 a_48321_3632# a_45680_3448# a_49009_3448# VDD pfet_03v3 ad=0.1872p pd=1.24u as=0.1872p ps=1.24u w=0.72u l=0.28u
X452 VDD a_30005_2618# a_30157_3118# VDD pfet_03v3 ad=0.108p pd=0.96u as=0.1728p ps=1.68u w=0.36u l=0.28u
X453 a_45680_3448# a_44088_3632# VSS VSS nfet_03v3 ad=0.1584p pd=1.6u as=93.59999f ps=0.88u w=0.36u l=0.28u
X454 a_31029_3404# BR.t24 VSS VDD.t629 pfet_03v3 ad=0.1332p pd=1.1u as=0.2592p ps=2.16u w=0.36u l=0.28u
X455 VDD a_22403_3392# a_21095_4236# VDD pfet_03v3 ad=0.1872p pd=1.24u as=0.3168p ps=2.32u w=0.72u l=0.28u
X456 PC4.t1 SE.t23 a_21092_2866# VSS nfet_03v3 ad=0.2592p pd=2.16u as=0.1332p ps=1.1u w=0.36u l=0.28u
X457 a_48017_3448# a_47961_3404# VDD VDD pfet_03v3 ad=86.39999f pd=0.96u as=0.1872p ps=1.24u w=0.72u l=0.28u
X458 VSS a_56427_3404# a_56851_3908# VSS nfet_03v3 ad=93.59999f pd=0.88u as=93.59999f ps=0.88u w=0.36u l=0.28u
X459 a_14184_2618# CLK.t37 a_13073_2618# VSS nfet_03v3 ad=0.1728p pd=1.68u as=0.1728p ps=1.68u w=0.36u l=0.28u
X460 a_65941_3908# a_64893_3404# VSS VSS nfet_03v3 ad=93.59999f pd=0.88u as=93.59999f ps=0.88u w=0.36u l=0.28u
X461 a_3766_2616# CLK.t38 VDD VDD pfet_03v3 ad=0.4032p pd=2.56u as=0.3168p ps=2.32u w=0.72u l=0.28u
X462 a_10918_2618# a_7999_2616# VSS VSS nfet_03v3 ad=0.108p pd=0.96u as=0.1728p ps=1.68u w=0.36u l=0.28u
X463 DEST6.t0 JMP.t26 a_25328_3400# VSS nfet_03v3 ad=0.18p pd=1.72u as=0.1332p ps=1.1u w=0.36u l=0.28u
X464 VDD RSTn.t24 a_52616_3118# VDD pfet_03v3 ad=0.108p pd=0.96u as=0.1728p ps=1.68u w=0.36u l=0.28u
X465 VDD.t657 a_29172_5022# a_29956_5022.t23 VDD.t439 pfet_03v3 ad=0.216p pd=1.32u as=0.216p ps=1.32u w=0.72u l=0.28u
X466 a_5631_3404# a_6575_4236# VDD.t353 VSS nfet_03v3 ad=0.1332p pd=1.1u as=0.2592p ps=2.16u w=0.36u l=0.28u
X467 PC0.t0 SE.t24 a_4160_2866# VSS nfet_03v3 ad=0.2592p pd=2.16u as=0.1332p ps=1.1u w=0.36u l=0.28u
X468 a_29701_2618# a_29164_2616# a_30157_3118# VDD pfet_03v3 ad=0.1728p pd=1.68u as=0.108p ps=0.96u w=0.36u l=0.28u
X469 a_21539_2618# a_21235_2618# VSS VSS nfet_03v3 ad=0.1728p pd=1.68u as=0.1728p ps=1.68u w=0.36u l=0.28u
X470 VDD a_9864_3404# a_10288_3448# VDD pfet_03v3 ad=0.1872p pd=1.24u as=0.1872p ps=1.24u w=0.72u l=0.28u
X471 a_14457_3632# a_11816_3448# a_15145_3448# VDD pfet_03v3 ad=0.1872p pd=1.24u as=0.1872p ps=1.24u w=0.72u l=0.28u
X472 a_63389_3118# CLK.t39 VDD VDD pfet_03v3 ad=0.108p pd=0.96u as=0.1728p ps=1.68u w=0.36u l=0.28u
X473 a_64980_2618# a_65315_3118# a_65947_2618# VSS nfet_03v3 ad=0.1728p pd=1.68u as=0.108p ps=0.96u w=0.36u l=0.28u
X474 a_49015_3118# CLK.t40 VDD VDD pfet_03v3 ad=0.108p pd=0.96u as=0.1728p ps=1.68u w=0.36u l=0.28u
X475 PC8.t1 a_35684_3118# VDD VDD pfet_03v3 ad=0.3456p pd=2.4u as=0.3456p ps=2.4u w=0.72u l=0.28u
X476 a_11816_3448# a_10224_3632# VSS VSS nfet_03v3 ad=0.1584p pd=1.6u as=93.59999f ps=0.88u w=0.36u l=0.28u
X477 VSS a_54146_3448# a_56851_3908# VSS nfet_03v3 ad=0.1584p pd=1.6u as=93.59999f ps=0.88u w=0.36u l=0.28u
X478 a_29701_2618# a_29558_2866# a_29525_3118# VDD pfet_03v3 ad=0.1728p pd=1.68u as=0.108p ps=0.96u w=0.36u l=0.28u
X479 a_61604_4236# BR.t25 VDD.t631 VDD.t630 pfet_03v3 ad=0.4032p pd=2.56u as=0.3168p ps=2.32u w=0.72u l=0.28u
X480 a_54959_3400# a_54562_4236# a_54959_4236# VSS nfet_03v3 ad=0.1332p pd=1.1u as=0.4446p ps=3.19u w=0.36u l=0.28u
X481 a_31453_3448# PC7.t7 VDD VDD pfet_03v3 ad=0.1872p pd=1.24u as=0.1872p ps=1.24u w=0.72u l=0.28u
X482 a_18754_3448# a_18690_3632# a_18170_3392# VDD pfet_03v3 ad=0.1872p pd=1.24u as=0.1872p ps=1.24u w=0.72u l=0.28u
X483 a_50329_3400# SE.t25 VDD VDD pfet_03v3 ad=0.4032p pd=2.56u as=0.3168p ps=2.32u w=0.72u l=0.28u
X484 PC14.t2 a_61082_3118# VDD VDD pfet_03v3 ad=0.3456p pd=2.4u as=0.3456p ps=2.4u w=0.72u l=0.28u
X485 DEST2.t0 JMP.t27 a_8396_3400# VSS nfet_03v3 ad=0.18p pd=1.72u as=0.1332p ps=1.1u w=0.36u l=0.28u
X486 a_17458_3118# RSTn.t25 a_17610_2618# VSS nfet_03v3 ad=0.108p pd=0.96u as=0.108p ps=0.96u w=0.36u l=0.28u
X487 VDD.t656 a_29172_5022# a_29956_5022.t22 VDD.t439 pfet_03v3 ad=0.216p pd=1.32u as=0.216p ps=1.32u w=0.72u l=0.28u
X488 PC7.t1 a_31451_3118# VSS VSS nfet_03v3 ad=0.1728p pd=1.68u as=0.1728p ps=1.68u w=0.36u l=0.28u
X489 a_4607_2618# a_4303_2618# VSS VSS nfet_03v3 ad=0.1728p pd=1.68u as=0.1728p ps=1.68u w=0.36u l=0.28u
X490 a_42856_3118# RSTn.t26 a_43008_2618# VSS nfet_03v3 ad=0.108p pd=0.96u as=0.108p ps=0.96u w=0.36u l=0.28u
X491 a_29172_5022# DISP7.t1 VDD.t526 VDD.t439 pfet_03v3 ad=0.3456p pd=2.4u as=0.216p ps=1.32u w=0.72u l=0.28u
X492 a_19274_4236# BR.t26 VDD.t330 VDD.t329 pfet_03v3 ad=0.4032p pd=2.56u as=0.3168p ps=2.32u w=0.72u l=0.28u
X493 a_21095_3400# a_20698_4236# a_21095_4236# VSS nfet_03v3 ad=0.1332p pd=1.1u as=0.4446p ps=3.19u w=0.36u l=0.28u
X494 a_58379_3448# a_56787_3632# VDD VDD pfet_03v3 ad=0.3168p pd=2.32u as=0.1872p ps=1.24u w=0.72u l=0.28u
X495 a_10286_3118# a_9951_2618# VDD VDD pfet_03v3 ad=0.1728p pd=1.68u as=0.108p ps=0.96u w=0.36u l=0.28u
X496 a_47961_3404# a_48905_4236# VSS VSS nfet_03v3 ad=0.1332p pd=1.1u as=0.2592p ps=2.16u w=0.36u l=0.28u
X497 a_35102_3392# a_32981_3448# a_35422_3908# VSS nfet_03v3 ad=93.59999f pd=0.88u as=43.2f ps=0.6u w=0.36u l=0.28u
X498 VDD a_55403_2618# a_55555_3118# VDD pfet_03v3 ad=0.108p pd=0.96u as=0.1728p ps=1.68u w=0.36u l=0.28u
X499 a_63028_4236# JMP.t28 VSS VSS nfet_03v3 ad=0.2016p pd=1.84u as=0.1584p ps=1.6u w=0.36u l=0.28u
X500 a_21235_2618# a_21092_2866# a_21059_3118# VDD pfet_03v3 ad=0.1728p pd=1.68u as=0.108p ps=0.96u w=0.36u l=0.28u
X501 a_29956_5022.t10 BR.t27 a_43728_3404# VSS nfet_03v3 ad=0.3654p pd=2.75u as=0.1332p ps=1.1u w=0.36u l=0.28u
X502 PC6.t3 a_29164_3400# a_29558_2866# VDD pfet_03v3 ad=0.2592p pd=2.16u as=0.1332p ps=1.1u w=0.36u l=0.28u
X503 VDD a_47801_3392# a_46493_4236# VDD pfet_03v3 ad=0.1872p pd=1.24u as=0.3168p ps=2.32u w=0.72u l=0.28u
X504 a_56427_3404# BR.t28 VSS VDD.t331 pfet_03v3 ad=0.1332p pd=1.1u as=0.2592p ps=2.16u w=0.36u l=0.28u
X505 a_35422_3908# PC8.t7 a_35318_3908# VSS nfet_03v3 ad=43.2f pd=0.6u as=43.2f ps=0.6u w=0.36u l=0.28u
X506 VSS PC15.t4 a_65941_3908# VSS nfet_03v3 ad=93.59999f pd=0.88u as=0.1584p ps=1.6u w=0.36u l=0.28u
X507 a_38167_2618# CLK.t41 a_38623_3118# VSS nfet_03v3 ad=0.1728p pd=1.68u as=0.108p ps=0.96u w=0.36u l=0.28u
X508 a_51170_2618# a_50866_2618# VDD VDD pfet_03v3 ad=0.1728p pd=1.68u as=0.1728p ps=1.68u w=0.36u l=0.28u
X509 a_39582_2618# CLK.t42 a_38471_2618# VSS nfet_03v3 ad=0.1728p pd=1.68u as=0.1728p ps=1.68u w=0.36u l=0.28u
X510 a_8840_2618# a_8536_2618# VDD VDD pfet_03v3 ad=0.1728p pd=1.68u as=0.1728p ps=1.68u w=0.36u l=0.28u
X511 a_60500_3392# a_58379_3448# a_60820_3448# VDD pfet_03v3 ad=0.1872p pd=1.24u as=86.39999f ps=0.96u w=0.72u l=0.28u
X512 a_29164_2616# CLK.t43 VDD VDD pfet_03v3 ad=0.4032p pd=2.56u as=0.3168p ps=2.32u w=0.72u l=0.28u
X513 a_14097_3404# a_15041_4236# VSS VSS nfet_03v3 ad=0.1332p pd=1.1u as=0.2592p ps=2.16u w=0.36u l=0.28u
X514 a_10288_3448# a_10224_3632# a_9704_3392# VDD pfet_03v3 ad=0.1872p pd=1.24u as=0.1872p ps=1.24u w=0.72u l=0.28u
X515 a_59189_2866# SE.t26 a_59192_3400# VDD pfet_03v3 ad=0.1332p pd=1.1u as=0.3654p ps=2.75u w=0.36u l=0.28u
X516 a_46937_2618# a_46633_2618# VSS VSS nfet_03v3 ad=0.1728p pd=1.68u as=0.1728p ps=1.68u w=0.36u l=0.28u
X517 VSS a_9864_3404# a_11536_3908# VSS nfet_03v3 ad=93.59999f pd=0.88u as=57.59999f ps=0.68u w=0.36u l=0.28u
X518 VDD a_35262_3404# a_35686_3448# VDD pfet_03v3 ad=0.1872p pd=1.24u as=0.1872p ps=1.24u w=0.72u l=0.28u
X519 a_4303_2618# a_4160_2866# a_4127_3118# VDD pfet_03v3 ad=0.1728p pd=1.68u as=0.108p ps=0.96u w=0.36u l=0.28u
X520 a_61714_2618# a_58795_2616# VSS VSS nfet_03v3 ad=0.108p pd=0.96u as=0.1728p ps=1.68u w=0.36u l=0.28u
X521 a_1758_3632# VSS a_2446_3908# VSS nfet_03v3 ad=93.59999f pd=0.88u as=93.59999f ps=0.88u w=0.36u l=0.28u
X522 a_56851_3908# PC13.t6 VSS VSS nfet_03v3 ad=93.59999f pd=0.88u as=93.59999f ps=0.88u w=0.36u l=0.28u
X523 a_31451_3118# a_31116_2618# a_31603_2618# VSS nfet_03v3 ad=0.1728p pd=1.68u as=0.108p ps=0.96u w=0.36u l=0.28u
X524 DISP2.t0 BR.t29 a_9864_3404# VSS nfet_03v3 ad=0.3654p pd=2.75u as=0.1332p ps=1.1u w=0.36u l=0.28u
X525 a_22987_3908# a_22923_3632# a_22403_3392# VSS nfet_03v3 ad=93.59999f pd=0.88u as=93.59999f ps=0.88u w=0.36u l=0.28u
X526 a_18170_3392# a_16049_3448# a_18490_3448# VDD pfet_03v3 ad=0.1872p pd=1.24u as=86.39999f ps=0.96u w=0.72u l=0.28u
X527 VSS PC7.t8 a_32077_3908# VSS nfet_03v3 ad=93.59999f pd=0.88u as=0.1584p ps=1.6u w=0.36u l=0.28u
X528 VDD a_60660_3404# a_61084_3448# VDD pfet_03v3 ad=0.1872p pd=1.24u as=0.1872p ps=1.24u w=0.72u l=0.28u
X529 a_65253_3632# a_62612_3448# a_65941_3448# VDD pfet_03v3 ad=0.1872p pd=1.24u as=0.1872p ps=1.24u w=0.72u l=0.28u
X530 a_42400_2618# a_42257_2866# a_42224_2618# VSS nfet_03v3 ad=0.1728p pd=1.68u as=0.108p ps=0.96u w=0.36u l=0.28u
X531 a_42257_2866# a_41863_3400# a_42260_3400# VSS nfet_03v3 ad=0.1332p pd=1.1u as=0.3654p ps=2.75u w=0.36u l=0.28u
X532 a_62612_3448# a_61020_3632# VSS VSS nfet_03v3 ad=0.1584p pd=1.6u as=93.59999f ps=0.88u w=0.36u l=0.28u
X533 a_70_2618# a_n73_2866# a_n106_2618# VSS nfet_03v3 ad=0.1728p pd=1.68u as=0.108p ps=0.96u w=0.36u l=0.28u
X534 a_13225_3118# RSTn.t27 VDD VDD pfet_03v3 ad=0.108p pd=0.96u as=0.108p ps=0.96u w=0.36u l=0.28u
X535 a_n73_2866# a_n467_3400# a_n70_3400# VSS nfet_03v3 ad=0.1332p pd=1.1u as=0.3654p ps=2.75u w=0.36u l=0.28u
X536 a_6055_3908# a_5991_3632# a_5471_3392# VSS nfet_03v3 ad=93.59999f pd=0.88u as=93.59999f ps=0.88u w=0.36u l=0.28u
X537 a_64949_3448# a_64893_3404# VDD VDD pfet_03v3 ad=86.39999f pd=0.96u as=0.1872p ps=1.24u w=0.72u l=0.28u
X538 PC13.t3 a_56849_3118# VSS VSS nfet_03v3 ad=0.1728p pd=1.68u as=0.1728p ps=1.68u w=0.36u l=0.28u
X539 a_19384_2618# a_16465_2616# VSS VSS nfet_03v3 ad=0.108p pd=0.96u as=0.1728p ps=1.68u w=0.36u l=0.28u
X540 a_6205_2618# RSTn.t28 VSS VSS nfet_03v3 ad=0.108p pd=0.96u as=0.1728p ps=1.68u w=0.36u l=0.28u
X541 a_3042_4236# a_2342_4236# a_1398_3404# VDD.t120 pfet_03v3 ad=0.3654p pd=2.75u as=0.1332p ps=1.1u w=0.36u l=0.28u
X542 a_22987_3908# PC5.t7 VSS VSS nfet_03v3 ad=93.59999f pd=0.88u as=93.59999f ps=0.88u w=0.36u l=0.28u
X543 a_28468_3908# PC6.t7 a_27156_3632# VSS nfet_03v3 ad=57.59999f pd=0.68u as=93.59999f ps=0.88u w=0.36u l=0.28u
X544 a_12232_4236# JMP.t29 VSS VSS nfet_03v3 ad=0.2016p pd=1.84u as=0.1584p ps=1.6u w=0.36u l=0.28u
X545 PC4.t0 a_20698_3400# a_21092_2866# VDD pfet_03v3 ad=0.2592p pd=2.16u as=0.1332p ps=1.1u w=0.36u l=0.28u
X546 a_31389_3632# a_28748_3448# a_32077_3448# VDD pfet_03v3 ad=0.1872p pd=1.24u as=0.1872p ps=1.24u w=0.72u l=0.28u
X547 PC12.t0 a_52616_3118# VDD VDD pfet_03v3 ad=0.3456p pd=2.4u as=0.3456p ps=2.4u w=0.72u l=0.28u
X548 a_35684_3118# a_35349_2618# VDD VDD pfet_03v3 ad=0.1728p pd=1.68u as=0.108p ps=0.96u w=0.36u l=0.28u
X549 a_48121_3448# PC11.t8 a_48017_3448# VDD pfet_03v3 ad=86.39999f pd=0.96u as=86.39999f ps=0.96u w=0.72u l=0.28u
X550 PC0.t3 a_3766_3400# a_4160_2866# VDD pfet_03v3 ad=0.2592p pd=2.16u as=0.1332p ps=1.1u w=0.36u l=0.28u
X551 VDD a_22563_3404# a_24235_3448# VDD pfet_03v3 ad=0.1872p pd=1.24u as=0.1152p ps=1.04u w=0.72u l=0.28u
X552 a_46633_2618# a_46490_2866# a_46457_3118# VDD pfet_03v3 ad=0.1728p pd=1.68u as=0.108p ps=0.96u w=0.36u l=0.28u
X553 a_33397_2616# CLK.t44 VSS VSS nfet_03v3 ad=0.2016p pd=1.84u as=0.1584p ps=1.6u w=0.36u l=0.28u
X554 VDD RSTn.t29 a_27218_3118# VDD pfet_03v3 ad=0.108p pd=0.96u as=0.1728p ps=1.68u w=0.36u l=0.28u
X555 a_34390_3118# RSTn.t30 a_34542_2618# VSS nfet_03v3 ad=0.108p pd=0.96u as=0.108p ps=0.96u w=0.36u l=0.28u
X556 a_29956_5022.t33 a_29172_5022# VSS.t603 VSS nfet_03v3 ad=0.108p pd=0.96u as=0.1728p ps=1.68u w=0.36u l=0.28u
X557 VSS a_35262_3404# a_36934_3908# VSS nfet_03v3 ad=93.59999f pd=0.88u as=57.59999f ps=0.68u w=0.36u l=0.28u
X558 VSS a_7583_3448# a_10288_3908# VSS nfet_03v3 ad=0.1584p pd=1.6u as=93.59999f ps=0.88u w=0.36u l=0.28u
X559 a_35686_3448# a_35622_3632# a_35102_3392# VDD pfet_03v3 ad=0.1872p pd=1.24u as=0.1872p ps=1.24u w=0.72u l=0.28u
X560 a_26076_2618# a_25772_2618# VSS VSS nfet_03v3 ad=0.108p pd=0.96u as=0.1728p ps=1.68u w=0.36u l=0.28u
X561 VDD a_5631_3404# a_7303_3448# VDD pfet_03v3 ad=0.1872p pd=1.24u as=0.1152p ps=1.04u w=0.72u l=0.28u
X562 a_63028_2616# CLK.t45 VDD VDD pfet_03v3 ad=0.4032p pd=2.56u as=0.3168p ps=2.32u w=0.72u l=0.28u
X563 a_48535_2618# RSTn.t31 VSS VSS nfet_03v3 ad=0.108p pd=0.96u as=0.1728p ps=1.68u w=0.36u l=0.28u
X564 a_57371_4236# BR.t30 VSS VSS nfet_03v3 ad=0.2016p pd=1.84u as=0.1584p ps=1.6u w=0.36u l=0.28u
X565 a_29956_5022.t16 BR.t31 a_35262_3404# VSS nfet_03v3 ad=0.3654p pd=2.75u as=0.1332p ps=1.1u w=0.36u l=0.28u
X566 a_9144_2618# a_8840_2618# VSS VSS nfet_03v3 ad=0.108p pd=0.96u as=0.1728p ps=1.68u w=0.36u l=0.28u
X567 a_64893_3404# a_65837_4236# VSS VSS nfet_03v3 ad=0.1332p pd=1.1u as=0.2592p ps=2.16u w=0.36u l=0.28u
X568 a_14153_3448# a_14097_3404# VDD VDD pfet_03v3 ad=86.39999f pd=0.96u as=0.1872p ps=1.24u w=0.72u l=0.28u
X569 VSS PC13.t7 a_57475_3908# VSS nfet_03v3 ad=93.59999f pd=0.88u as=0.1584p ps=1.6u w=0.36u l=0.28u
X570 a_61084_3448# a_61020_3632# a_60500_3392# VDD pfet_03v3 ad=0.1872p pd=1.24u as=0.1872p ps=1.24u w=0.72u l=0.28u
X571 a_5471_3392# a_3350_3448# a_5791_3908# VSS nfet_03v3 ad=93.59999f pd=0.88u as=43.2f ps=0.6u w=0.36u l=0.28u
X572 a_29956_5022.t9 BR.t32 a_60660_3404# VSS nfet_03v3 ad=0.3654p pd=2.75u as=0.1332p ps=1.1u w=0.36u l=0.28u
X573 VDD a_64733_3392# a_63425_4236# VDD pfet_03v3 ad=0.1872p pd=1.24u as=0.3168p ps=2.32u w=0.72u l=0.28u
X574 a_38623_3118# RSTn.t32 VDD VDD pfet_03v3 ad=0.108p pd=0.96u as=0.108p ps=0.96u w=0.36u l=0.28u
X575 a_3070_3908# PC0.t7 a_1758_3632# VSS nfet_03v3 ad=57.59999f pd=0.68u as=93.59999f ps=0.88u w=0.36u l=0.28u
X576 a_26852_3908# a_26796_3404# VSS VSS nfet_03v3 ad=43.2f pd=0.6u as=93.59999f ps=0.88u w=0.36u l=0.28u
X577 a_52354_3908# PC12.t8 a_52250_3908# VSS nfet_03v3 ad=43.2f pd=0.6u as=43.2f ps=0.6u w=0.36u l=0.28u
X578 PC14.t0 SE.t27 PC_NEXT15.t0 VSS nfet_03v3 ad=0.2592p pd=2.16u as=0.1332p ps=1.1u w=0.36u l=0.28u
X579 a_56514_2618# CLK.t46 a_55403_2618# VSS nfet_03v3 ad=0.1728p pd=1.68u as=0.1728p ps=1.68u w=0.36u l=0.28u
X580 a_59156_2618# a_58795_2616# VSS VSS nfet_03v3 ad=0.108p pd=0.96u as=0.1728p ps=1.68u w=0.36u l=0.28u
X581 a_23507_4236# BR.t33 VSS VSS nfet_03v3 ad=0.2016p pd=1.84u as=0.1584p ps=1.6u w=0.36u l=0.28u
X582 a_22650_2618# a_22985_3118# a_23617_3118# VDD pfet_03v3 ad=0.1728p pd=1.68u as=0.108p ps=0.96u w=0.36u l=0.28u
X583 a_41447_3448# a_39855_3632# VDD VDD pfet_03v3 ad=0.3168p pd=2.32u as=0.1872p ps=1.24u w=0.72u l=0.28u
X584 a_32077_3448# a_31029_3404# VDD VDD pfet_03v3 ad=0.1872p pd=1.24u as=0.1872p ps=1.24u w=0.72u l=0.28u
X585 a_37630_4236# JMP.t30 VSS VSS nfet_03v3 ad=0.2016p pd=1.84u as=0.1584p ps=1.6u w=0.36u l=0.28u
X586 VSS a_5631_3404# a_6055_3908# VSS nfet_03v3 ad=93.59999f pd=0.88u as=93.59999f ps=0.88u w=0.36u l=0.28u
X587 a_56787_3632# a_54146_3448# a_57475_3448# VDD pfet_03v3 ad=0.1872p pd=1.24u as=0.1872p ps=1.24u w=0.72u l=0.28u
X588 VDD a_47961_3404# a_49633_3448# VDD pfet_03v3 ad=0.1872p pd=1.24u as=0.1152p ps=1.04u w=0.72u l=0.28u
X589 a_9920_3908# a_9864_3404# VSS VSS nfet_03v3 ad=43.2f pd=0.6u as=93.59999f ps=0.88u w=0.36u l=0.28u
X590 a_5718_2618# a_6053_3118# a_6685_3118# VDD pfet_03v3 ad=0.1728p pd=1.68u as=0.108p ps=0.96u w=0.36u l=0.28u
X591 a_22650_2618# CLK.t47 a_21539_2618# VSS nfet_03v3 ad=0.1728p pd=1.68u as=0.1728p ps=1.68u w=0.36u l=0.28u
X592 a_33794_3400# a_33397_4236# a_33794_4236# VSS nfet_03v3 ad=0.1332p pd=1.1u as=0.4446p ps=3.19u w=0.36u l=0.28u
X593 VDD a_20282_3448# a_22987_3448# VDD pfet_03v3 ad=0.3168p pd=2.32u as=0.1872p ps=1.24u w=0.72u l=0.28u
X594 a_40069_2618# RSTn.t33 VSS VSS nfet_03v3 ad=0.108p pd=0.96u as=0.1728p ps=1.68u w=0.36u l=0.28u
X595 a_12232_2616# CLK.t48 VDD VDD pfet_03v3 ad=0.4032p pd=2.56u as=0.3168p ps=2.32u w=0.72u l=0.28u
X596 a_43815_2618# a_44150_3118# a_44782_2618# VSS nfet_03v3 ad=0.1728p pd=1.68u as=0.108p ps=0.96u w=0.36u l=0.28u
X597 VDD a_3350_3448# a_6055_3448# VDD pfet_03v3 ad=0.3168p pd=2.32u as=0.1872p ps=1.24u w=0.72u l=0.28u
X598 a_42257_2866# SE.t28 a_42260_3400# VDD pfet_03v3 ad=0.1332p pd=1.1u as=0.3654p ps=2.75u w=0.36u l=0.28u
X599 a_39919_3908# PC9.t8 VSS VSS nfet_03v3 ad=93.59999f pd=0.88u as=93.59999f ps=0.88u w=0.36u l=0.28u
X600 a_45400_3908# PC10.t7 a_44088_3632# VSS nfet_03v3 ad=57.59999f pd=0.68u as=93.59999f ps=0.88u w=0.36u l=0.28u
X601 a_63425_3400# a_63028_4236# a_63425_4236# VSS nfet_03v3 ad=0.1332p pd=1.1u as=0.4446p ps=3.19u w=0.36u l=0.28u
X602 a_n73_2866# SE.t29 a_n70_3400# VDD pfet_03v3 ad=0.1332p pd=1.1u as=0.3654p ps=2.75u w=0.36u l=0.28u
X603 a_37214_3448# a_35622_3632# VSS VSS nfet_03v3 ad=0.1584p pd=1.6u as=93.59999f ps=0.88u w=0.36u l=0.28u
X604 a_52616_3118# a_52281_2618# VDD VDD pfet_03v3 ad=0.1728p pd=1.68u as=0.108p ps=0.96u w=0.36u l=0.28u
X605 a_5718_2618# CLK.t49 a_4607_2618# VSS nfet_03v3 ad=0.1728p pd=1.68u as=0.1728p ps=1.68u w=0.36u l=0.28u
X606 VSS a_58379_3448# a_61084_3908# VSS nfet_03v3 ad=0.1584p pd=1.6u as=93.59999f ps=0.88u w=0.36u l=0.28u
X607 a_39551_3448# a_39495_3404# VDD VDD pfet_03v3 ad=86.39999f pd=0.96u as=0.1872p ps=1.24u w=0.72u l=0.28u
X608 VSS a_47961_3404# a_48385_3908# VSS nfet_03v3 ad=93.59999f pd=0.88u as=93.59999f ps=0.88u w=0.36u l=0.28u
X609 a_1454_3908# a_1398_3404# VSS VSS nfet_03v3 ad=43.2f pd=0.6u as=93.59999f ps=0.88u w=0.36u l=0.28u
X610 a_50329_2616# CLK.t50 VSS VSS nfet_03v3 ad=0.2016p pd=1.84u as=0.1584p ps=1.6u w=0.36u l=0.28u
X611 PC9.t2 a_39917_3118# VSS VSS nfet_03v3 ad=0.1728p pd=1.68u as=0.1728p ps=1.68u w=0.36u l=0.28u
X612 VSS a_26636_3392# a_25328_4236# VSS nfet_03v3 ad=93.59999f pd=0.88u as=0.1584p ps=1.6u w=0.36u l=0.28u
X613 VDD RSTn.t34 a_44150_3118# VDD pfet_03v3 ad=0.108p pd=0.96u as=0.1728p ps=1.68u w=0.36u l=0.28u
X614 a_27740_4236# BR.t34 VDD.t42 VDD.t41 pfet_03v3 ad=0.4032p pd=2.56u as=0.3168p ps=2.32u w=0.72u l=0.28u
X615 a_51322_3118# RSTn.t35 a_51474_2618# VSS nfet_03v3 ad=0.108p pd=0.96u as=0.108p ps=0.96u w=0.36u l=0.28u
X616 a_21235_2618# a_20698_2616# a_21691_3118# VDD pfet_03v3 ad=0.1728p pd=1.68u as=0.108p ps=0.96u w=0.36u l=0.28u
X617 a_29956_5022.t21 a_29172_5022# VDD.t655 VDD.t439 pfet_03v3 ad=0.216p pd=1.32u as=0.216p ps=1.32u w=0.72u l=0.28u
X618 a_11536_3908# PC2.t7 a_10224_3632# VSS nfet_03v3 ad=57.59999f pd=0.68u as=93.59999f ps=0.88u w=0.36u l=0.28u
X619 PC6.t0 a_27218_3118# VDD VDD pfet_03v3 ad=0.3456p pd=2.4u as=0.3456p ps=2.4u w=0.72u l=0.28u
X620 DEST6.t1 a_24931_4236# a_25328_3400# VDD.t527 pfet_03v3 ad=0.18p pd=1.72u as=0.1332p ps=1.1u w=0.36u l=0.28u
X621 VDD a_39495_3404# a_41167_3448# VDD pfet_03v3 ad=0.1872p pd=1.24u as=0.1152p ps=1.04u w=0.72u l=0.28u
X622 a_5631_3404# BR.t35 VDD.t44 VDD.t43 pfet_03v3 ad=0.1332p pd=1.1u as=0.2592p ps=2.16u w=0.36u l=0.28u
X623 DEST4.t1 JMP.t31 a_16862_3400# VSS nfet_03v3 ad=0.18p pd=1.72u as=0.1332p ps=1.1u w=0.36u l=0.28u
X624 VDD.t440 DISP7.t2 a_29172_5022# VDD.t439 pfet_03v3 ad=0.216p pd=1.32u as=0.216p ps=1.32u w=0.72u l=0.28u
X625 a_52618_3448# a_52554_3632# a_52034_3392# VDD pfet_03v3 ad=0.1872p pd=1.24u as=0.1872p ps=1.24u w=0.72u l=0.28u
X626 a_57475_3448# a_56427_3404# VDD VDD pfet_03v3 ad=0.1872p pd=1.24u as=0.1872p ps=1.24u w=0.72u l=0.28u
X627 a_18690_3632# a_16049_3448# a_19378_3908# VSS nfet_03v3 ad=93.59999f pd=0.88u as=93.59999f ps=0.88u w=0.36u l=0.28u
X628 VSS a_52194_3404# a_53866_3908# VSS nfet_03v3 ad=93.59999f pd=0.88u as=57.59999f ps=0.68u w=0.36u l=0.28u
X629 a_678_2618# a_374_2618# VSS VSS nfet_03v3 ad=0.108p pd=0.96u as=0.1728p ps=1.68u w=0.36u l=0.28u
X630 a_52281_2618# a_50329_2616# a_51170_2618# VDD pfet_03v3 ad=0.1728p pd=1.68u as=0.1728p ps=1.68u w=0.36u l=0.28u
X631 a_9951_2618# a_7999_2616# a_8840_2618# VDD pfet_03v3 ad=0.1728p pd=1.68u as=0.1728p ps=1.68u w=0.36u l=0.28u
X632 a_29956_5022.t20 a_29172_5022# VDD.t654 VDD.t439 pfet_03v3 ad=0.216p pd=1.32u as=0.216p ps=1.32u w=0.72u l=0.28u
X633 a_54959_3400# JMP.t32 a_54959_4236# VDD.t397 pfet_03v3 ad=0.1332p pd=1.1u as=0.4446p ps=3.19u w=0.36u l=0.28u
X634 a_29956_5022.t13 BR.t36 a_52194_3404# VSS nfet_03v3 ad=0.3654p pd=2.75u as=0.1332p ps=1.1u w=0.36u l=0.28u
X635 VSS a_9704_3392# a_8396_4236# VSS nfet_03v3 ad=93.59999f pd=0.88u as=0.1584p ps=1.6u w=0.36u l=0.28u
X636 a_4303_2618# a_3766_2616# a_4759_3118# VDD pfet_03v3 ad=0.1728p pd=1.68u as=0.108p ps=0.96u w=0.36u l=0.28u
X637 VDD RSTn.t36 a_10286_3118# VDD pfet_03v3 ad=0.108p pd=0.96u as=0.1728p ps=1.68u w=0.36u l=0.28u
X638 DEST2.t1 a_7999_4236# a_8396_3400# VDD.t224 pfet_03v3 ad=0.18p pd=1.72u as=0.1332p ps=1.1u w=0.36u l=0.28u
X639 a_65467_2618# RSTn.t37 VSS VSS nfet_03v3 ad=0.108p pd=0.96u as=0.1728p ps=1.68u w=0.36u l=0.28u
X640 a_48048_2618# CLK.t51 a_46937_2618# VSS nfet_03v3 ad=0.1728p pd=1.68u as=0.1728p ps=1.68u w=0.36u l=0.28u
X641 a_58099_3448# PC13.t8 a_56787_3632# VDD pfet_03v3 ad=0.1152p pd=1.04u as=0.1872p ps=1.24u w=0.72u l=0.28u
X642 a_42400_2618# CLK.t52 a_42856_3118# VSS nfet_03v3 ad=0.1728p pd=1.68u as=0.108p ps=0.96u w=0.36u l=0.28u
X643 a_37630_2616# CLK.t53 VDD VDD pfet_03v3 ad=0.4032p pd=2.56u as=0.3168p ps=2.32u w=0.72u l=0.28u
X644 a_6055_3448# PC1.t8 VDD VDD pfet_03v3 ad=0.1872p pd=1.24u as=0.1872p ps=1.24u w=0.72u l=0.28u
X645 a_39582_2618# a_39917_3118# a_40549_3118# VDD pfet_03v3 ad=0.1728p pd=1.68u as=0.108p ps=0.96u w=0.36u l=0.28u
X646 a_40439_4236# BR.t37 VSS VSS nfet_03v3 ad=0.2016p pd=1.84u as=0.1584p ps=1.6u w=0.36u l=0.28u
X647 VSS a_39495_3404# a_39919_3908# VSS nfet_03v3 ad=93.59999f pd=0.88u as=93.59999f ps=0.88u w=0.36u l=0.28u
X648 a_65317_3908# PC15.t5 VSS VSS nfet_03v3 ad=93.59999f pd=0.88u as=93.59999f ps=0.88u w=0.36u l=0.28u
X649 a_21095_3400# JMP.t33 a_21095_4236# VDD.t398 pfet_03v3 ad=0.1332p pd=1.1u as=0.4446p ps=3.19u w=0.36u l=0.28u
X650 VDD a_46937_2618# a_47089_3118# VDD pfet_03v3 ad=0.108p pd=0.96u as=0.1728p ps=1.68u w=0.36u l=0.28u
X651 a_12593_2618# a_12232_2616# VSS VSS nfet_03v3 ad=0.108p pd=0.96u as=0.1728p ps=1.68u w=0.36u l=0.28u
X652 a_17306_2618# a_17002_2618# VDD VDD pfet_03v3 ad=0.1728p pd=1.68u as=0.1728p ps=1.68u w=0.36u l=0.28u
X653 a_n467_4236# JMP.t34 VSS VSS nfet_03v3 ad=0.2016p pd=1.84u as=0.1584p ps=1.6u w=0.36u l=0.28u
X654 PC14.t1 a_63028_3400# PC_NEXT15.t2 VDD pfet_03v3 ad=0.2592p pd=2.16u as=0.1332p ps=1.1u w=0.36u l=0.28u
X655 PC1.t2 a_6053_3118# VSS VSS nfet_03v3 ad=0.1728p pd=1.68u as=0.1728p ps=1.68u w=0.36u l=0.28u
X656 VDD a_39335_3392# a_38027_4236# VDD pfet_03v3 ad=0.1872p pd=1.24u as=0.3168p ps=2.32u w=0.72u l=0.28u
X657 a_4127_3118# CLK.t54 VDD VDD pfet_03v3 ad=0.108p pd=0.96u as=0.1728p ps=1.68u w=0.36u l=0.28u
X658 a_32083_3118# CLK.t55 VDD VDD pfet_03v3 ad=0.108p pd=0.96u as=0.1728p ps=1.68u w=0.36u l=0.28u
X659 a_47961_3404# BR.t38 VSS VDD.t196 pfet_03v3 ad=0.1332p pd=1.1u as=0.2592p ps=2.16u w=0.36u l=0.28u
X660 a_48385_3908# a_48321_3632# a_47801_3392# VSS nfet_03v3 ad=93.59999f pd=0.88u as=93.59999f ps=0.88u w=0.36u l=0.28u
X661 a_33397_4236# JMP.t35 VDD.t400 VDD.t399 pfet_03v3 ad=0.4032p pd=2.56u as=0.3168p ps=2.32u w=0.72u l=0.28u
X662 VSS a_1238_3392# a_n70_4236# VSS nfet_03v3 ad=93.59999f pd=0.88u as=0.1584p ps=1.6u w=0.36u l=0.28u
X663 PC8.t0 SE.t30 a_38024_2866# VSS nfet_03v3 ad=0.2592p pd=2.16u as=0.1332p ps=1.1u w=0.36u l=0.28u
X664 a_27850_2618# a_24931_2616# VSS VSS nfet_03v3 ad=0.108p pd=0.96u as=0.1728p ps=1.68u w=0.36u l=0.28u
X665 a_2342_4236# BR.t39 VDD.t198 VDD.t197 pfet_03v3 ad=0.4032p pd=2.56u as=0.3168p ps=2.32u w=0.72u l=0.28u
X666 a_29956_5022.t8 a_44672_4236# a_43728_3404# VDD.t468 pfet_03v3 ad=0.3654p pd=2.75u as=0.1332p ps=1.1u w=0.36u l=0.28u
X667 a_61708_3908# a_60660_3404# VSS VSS nfet_03v3 ad=93.59999f pd=0.88u as=93.59999f ps=0.88u w=0.36u l=0.28u
X668 a_374_2618# a_70_2618# VDD VDD pfet_03v3 ad=0.1728p pd=1.68u as=0.1728p ps=1.68u w=0.36u l=0.28u
X669 a_38775_2618# a_38471_2618# VSS VSS nfet_03v3 ad=0.108p pd=0.96u as=0.1728p ps=1.68u w=0.36u l=0.28u
X670 a_10224_3632# a_7583_3448# a_10912_3908# VSS nfet_03v3 ad=93.59999f pd=0.88u as=93.59999f ps=0.88u w=0.36u l=0.28u
X671 a_46633_2618# a_46096_2616# a_47089_3118# VDD pfet_03v3 ad=0.1728p pd=1.68u as=0.108p ps=0.96u w=0.36u l=0.28u
X672 VDD a_37214_3448# a_39919_3448# VDD pfet_03v3 ad=0.3168p pd=2.32u as=0.1872p ps=1.24u w=0.72u l=0.28u
X673 a_54562_3400# SE.t31 VSS VSS nfet_03v3 ad=0.2016p pd=1.84u as=0.1584p ps=1.6u w=0.36u l=0.28u
X674 a_22985_3118# a_22650_2618# a_23137_2618# VSS nfet_03v3 ad=0.1728p pd=1.68u as=0.108p ps=0.96u w=0.36u l=0.28u
X675 a_28748_3448# a_27156_3632# VSS VSS nfet_03v3 ad=0.1584p pd=1.6u as=93.59999f ps=0.88u w=0.36u l=0.28u
X676 a_26956_3448# PC6.t8 a_26852_3448# VDD pfet_03v3 ad=86.39999f pd=0.96u as=86.39999f ps=0.96u w=0.72u l=0.28u
X677 a_52034_3392# a_49913_3448# a_52354_3448# VDD pfet_03v3 ad=0.1872p pd=1.24u as=86.39999f ps=0.96u w=0.72u l=0.28u
X678 a_60747_2618# a_61082_3118# a_61714_2618# VSS nfet_03v3 ad=0.1728p pd=1.68u as=0.108p ps=0.96u w=0.36u l=0.28u
X679 a_14097_3404# BR.t40 VSS VDD.t199 pfet_03v3 ad=0.1332p pd=1.1u as=0.2592p ps=2.16u w=0.36u l=0.28u
X680 a_14521_3908# a_14457_3632# a_13937_3392# VSS nfet_03v3 ad=93.59999f pd=0.88u as=93.59999f ps=0.88u w=0.36u l=0.28u
X681 a_19378_3908# a_18330_3404# VSS VSS nfet_03v3 ad=93.59999f pd=0.88u as=93.59999f ps=0.88u w=0.36u l=0.28u
X682 a_48385_3448# PC11.t9 VDD VDD pfet_03v3 ad=0.1872p pd=1.24u as=0.1872p ps=1.24u w=0.72u l=0.28u
X683 a_62332_3908# PC14.t7 a_61020_3632# VSS nfet_03v3 ad=57.59999f pd=0.68u as=93.59999f ps=0.88u w=0.36u l=0.28u
X684 a_29172_5022# DISP7.t3 VSS.t658 VSS nfet_03v3 ad=0.108p pd=0.96u as=0.1728p ps=1.68u w=0.36u l=0.28u
X685 DISP2.t1 a_10808_4236# a_9864_3404# VDD.t679 pfet_03v3 ad=0.3654p pd=2.75u as=0.1332p ps=1.1u w=0.36u l=0.28u
X686 a_10024_3448# PC2.t8 a_9920_3448# VDD pfet_03v3 ad=86.39999f pd=0.96u as=86.39999f ps=0.96u w=0.72u l=0.28u
X687 VDD PC5.t8 a_23611_3448# VDD pfet_03v3 ad=0.1872p pd=1.24u as=0.3168p ps=2.32u w=0.72u l=0.28u
X688 VDD RSTn.t38 a_35684_3118# VDD pfet_03v3 ad=0.108p pd=0.96u as=0.1728p ps=1.68u w=0.36u l=0.28u
X689 a_20698_3400# SE.t32 VSS VSS nfet_03v3 ad=0.2016p pd=1.84u as=0.1584p ps=1.6u w=0.36u l=0.28u
X690 PC11.t1 a_48383_3118# VSS VSS nfet_03v3 ad=0.1728p pd=1.68u as=0.1728p ps=1.68u w=0.36u l=0.28u
X691 a_18417_2618# a_18752_3118# a_19384_2618# VSS nfet_03v3 ad=0.1728p pd=1.68u as=0.108p ps=0.96u w=0.36u l=0.28u
X692 a_12769_2618# a_12232_2616# a_13225_3118# VDD pfet_03v3 ad=0.1728p pd=1.68u as=0.108p ps=0.96u w=0.36u l=0.28u
X693 a_29956_5022.t32 a_29172_5022# VSS.t602 VSS nfet_03v3 ad=0.1728p pd=1.68u as=0.108p ps=0.96u w=0.36u l=0.28u
X694 a_6053_3118# a_5718_2618# a_6205_2618# VSS nfet_03v3 ad=0.1728p pd=1.68u as=0.108p ps=0.96u w=0.36u l=0.28u
X695 VSS a_43568_3392# a_42260_4236# VSS nfet_03v3 ad=93.59999f pd=0.88u as=0.1584p ps=1.6u w=0.36u l=0.28u
X696 VDD RSTn.t39 a_61082_3118# VDD pfet_03v3 ad=0.108p pd=0.96u as=0.1728p ps=1.68u w=0.36u l=0.28u
X697 a_38027_3400# a_37630_4236# a_38027_4236# VSS nfet_03v3 ad=0.1332p pd=1.1u as=0.4446p ps=3.19u w=0.36u l=0.28u
X698 a_14521_3448# PC3.t8 VDD VDD pfet_03v3 ad=0.1872p pd=1.24u as=0.1872p ps=1.24u w=0.72u l=0.28u
X699 a_20002_3448# PC4.t8 a_18690_3632# VDD pfet_03v3 ad=0.1152p pd=1.04u as=0.1872p ps=1.24u w=0.72u l=0.28u
X700 a_65837_4236# BR.t41 VSS VSS nfet_03v3 ad=0.2016p pd=1.84u as=0.1584p ps=1.6u w=0.36u l=0.28u
X701 VSS a_64893_3404# a_65317_3908# VSS nfet_03v3 ad=93.59999f pd=0.88u as=93.59999f ps=0.88u w=0.36u l=0.28u
X702 DEST8.t0 JMP.t36 a_33794_3400# VSS nfet_03v3 ad=0.18p pd=1.72u as=0.1332p ps=1.1u w=0.36u l=0.28u
X703 VDD PC1.t9 a_6679_3448# VDD pfet_03v3 ad=0.1872p pd=1.24u as=0.3168p ps=2.32u w=0.72u l=0.28u
X704 a_37991_2618# a_37630_2616# VSS VSS nfet_03v3 ad=0.108p pd=0.96u as=0.1728p ps=1.68u w=0.36u l=0.28u
X705 PC3.t3 a_14519_3118# VSS VSS nfet_03v3 ad=0.1728p pd=1.68u as=0.1728p ps=1.68u w=0.36u l=0.28u
X706 a_3766_3400# SE.t33 VSS VSS nfet_03v3 ad=0.2016p pd=1.84u as=0.1584p ps=1.6u w=0.36u l=0.28u
X707 a_57481_3118# CLK.t56 VDD VDD pfet_03v3 ad=0.108p pd=0.96u as=0.1728p ps=1.68u w=0.36u l=0.28u
X708 a_25924_3118# RSTn.t40 a_26076_2618# VSS nfet_03v3 ad=0.108p pd=0.96u as=0.108p ps=0.96u w=0.36u l=0.28u
X709 a_2452_2618# a_n467_2616# VSS VSS nfet_03v3 ad=0.108p pd=0.96u as=0.1728p ps=1.68u w=0.36u l=0.28u
X710 a_38167_2618# a_38024_2866# a_37991_3118# VDD pfet_03v3 ad=0.1728p pd=1.68u as=0.108p ps=0.96u w=0.36u l=0.28u
X711 a_9951_2618# a_10286_3118# a_10918_2618# VSS nfet_03v3 ad=0.1728p pd=1.68u as=0.108p ps=0.96u w=0.36u l=0.28u
X712 a_5991_3632# a_3350_3448# a_6679_3448# VDD pfet_03v3 ad=0.1872p pd=1.24u as=0.1872p ps=1.24u w=0.72u l=0.28u
X713 a_27220_3448# a_27156_3632# a_26636_3392# VDD pfet_03v3 ad=0.1872p pd=1.24u as=0.1872p ps=1.24u w=0.72u l=0.28u
X714 VDD a_62612_3448# a_65317_3448# VDD pfet_03v3 ad=0.3168p pd=2.32u as=0.1872p ps=1.24u w=0.72u l=0.28u
X715 a_3350_3448# a_1758_3632# VSS VSS nfet_03v3 ad=0.1584p pd=1.6u as=93.59999f ps=0.88u w=0.36u l=0.28u
X716 a_1558_3448# PC0.t8 a_1454_3448# VDD pfet_03v3 ad=86.39999f pd=0.96u as=86.39999f ps=0.96u w=0.72u l=0.28u
X717 a_n467_2616# CLK.t57 VDD VDD pfet_03v3 ad=0.4032p pd=2.56u as=0.3168p ps=2.32u w=0.72u l=0.28u
X718 a_59332_2618# CLK.t58 a_59788_3118# VSS nfet_03v3 ad=0.1728p pd=1.68u as=0.108p ps=0.96u w=0.36u l=0.28u
X719 VSS a_26796_3404# a_28468_3908# VSS nfet_03v3 ad=93.59999f pd=0.88u as=57.59999f ps=0.68u w=0.36u l=0.28u
X720 a_40543_3448# a_39495_3404# VDD VDD pfet_03v3 ad=0.1872p pd=1.24u as=0.1872p ps=1.24u w=0.72u l=0.28u
X721 a_48383_3118# a_48048_2618# a_48535_2618# VSS nfet_03v3 ad=0.1728p pd=1.68u as=0.108p ps=0.96u w=0.36u l=0.28u
X722 DISP6.t1 BR.t42 a_26796_3404# VSS nfet_03v3 ad=0.3654p pd=2.75u as=0.1332p ps=1.1u w=0.36u l=0.28u
X723 a_13937_3392# a_11816_3448# a_14257_3908# VSS nfet_03v3 ad=93.59999f pd=0.88u as=43.2f ps=0.6u w=0.36u l=0.28u
X724 a_61020_3632# a_58379_3448# a_61708_3908# VSS nfet_03v3 ad=93.59999f pd=0.88u as=93.59999f ps=0.88u w=0.36u l=0.28u
X725 a_23617_3118# CLK.t59 VDD VDD pfet_03v3 ad=0.108p pd=0.96u as=0.1728p ps=1.68u w=0.36u l=0.28u
X726 a_39919_3908# a_39855_3632# a_39335_3392# VSS nfet_03v3 ad=93.59999f pd=0.88u as=93.59999f ps=0.88u w=0.36u l=0.28u
X727 VSS PC11.t10 a_49009_3908# VSS nfet_03v3 ad=93.59999f pd=0.88u as=0.1584p ps=1.6u w=0.36u l=0.28u
X728 a_59332_2618# a_59189_2866# a_59156_2618# VSS nfet_03v3 ad=0.1728p pd=1.68u as=0.108p ps=0.96u w=0.36u l=0.28u
X729 a_8992_3118# RSTn.t41 a_9144_2618# VSS nfet_03v3 ad=0.108p pd=0.96u as=0.108p ps=0.96u w=0.36u l=0.28u
X730 a_41863_4236# JMP.t37 VSS VSS nfet_03v3 ad=0.2016p pd=1.84u as=0.1584p ps=1.6u w=0.36u l=0.28u
X731 a_34238_2618# a_33934_2618# VDD VDD pfet_03v3 ad=0.1728p pd=1.68u as=0.1728p ps=1.68u w=0.36u l=0.28u
X732 a_29956_5022.t6 a_36206_4236# a_35262_3404# VDD.t433 pfet_03v3 ad=0.3654p pd=2.75u as=0.1332p ps=1.1u w=0.36u l=0.28u
X733 a_60716_3908# a_60660_3404# VSS VSS nfet_03v3 ad=43.2f pd=0.6u as=93.59999f ps=0.88u w=0.36u l=0.28u
X734 a_64893_3404# BR.t43 VSS VDD.t726 pfet_03v3 ad=0.1332p pd=1.1u as=0.2592p ps=2.16u w=0.36u l=0.28u
X735 VDD a_56267_3392# a_54959_4236# VDD pfet_03v3 ad=0.1872p pd=1.24u as=0.3168p ps=2.32u w=0.72u l=0.28u
X736 PC12.t2 SE.t34 a_54956_2866# VSS nfet_03v3 ad=0.2592p pd=2.16u as=0.1332p ps=1.1u w=0.36u l=0.28u
X737 a_50329_4236# JMP.t38 VDD.t402 VDD.t401 pfet_03v3 ad=0.4032p pd=2.56u as=0.3168p ps=2.32u w=0.72u l=0.28u
X738 a_1972_2618# RSTn.t42 VSS VSS nfet_03v3 ad=0.108p pd=0.96u as=0.1728p ps=1.68u w=0.36u l=0.28u
X739 a_29956_5022.t7 a_61604_4236# a_60660_3404# VDD.t438 pfet_03v3 ad=0.3654p pd=2.75u as=0.1332p ps=1.1u w=0.36u l=0.28u
X740 a_25772_2618# a_25468_2618# VSS VSS nfet_03v3 ad=0.1728p pd=1.68u as=0.1728p ps=1.68u w=0.36u l=0.28u
X741 a_14519_3118# a_14184_2618# a_14671_2618# VSS nfet_03v3 ad=0.1728p pd=1.68u as=0.108p ps=0.96u w=0.36u l=0.28u
X742 VDD a_14097_3404# a_14521_3448# VDD pfet_03v3 ad=0.1872p pd=1.24u as=0.1872p ps=1.24u w=0.72u l=0.28u
X743 PC8.t3 a_37630_3400# a_38024_2866# VDD pfet_03v3 ad=0.2592p pd=2.16u as=0.1332p ps=1.1u w=0.36u l=0.28u
X744 a_63565_2618# a_63028_2616# a_64021_3118# VDD pfet_03v3 ad=0.1728p pd=1.68u as=0.108p ps=0.96u w=0.36u l=0.28u
X745 a_18386_3908# a_18330_3404# VSS VSS nfet_03v3 ad=43.2f pd=0.6u as=93.59999f ps=0.88u w=0.36u l=0.28u
X746 VSS a_18330_3404# a_20002_3908# VSS nfet_03v3 ad=93.59999f pd=0.88u as=57.59999f ps=0.68u w=0.36u l=0.28u
X747 a_39917_3118# a_39582_2618# a_40069_2618# VSS nfet_03v3 ad=0.1728p pd=1.68u as=0.108p ps=0.96u w=0.36u l=0.28u
X748 DEST14.t1 JMP.t39 a_59192_3400# VSS nfet_03v3 ad=0.18p pd=1.72u as=0.1332p ps=1.1u w=0.36u l=0.28u
X749 a_43888_3448# PC10.t8 a_43784_3448# VDD pfet_03v3 ad=86.39999f pd=0.96u as=86.39999f ps=0.96u w=0.72u l=0.28u
X750 a_54562_3400# SE.t35 VDD VDD pfet_03v3 ad=0.4032p pd=2.56u as=0.3168p ps=2.32u w=0.72u l=0.28u
X751 a_21092_2866# a_20698_3400# a_21095_3400# VSS nfet_03v3 ad=0.1332p pd=1.1u as=0.3654p ps=2.75u w=0.36u l=0.28u
X752 a_31453_3908# a_31389_3632# a_30869_3392# VSS nfet_03v3 ad=93.59999f pd=0.88u as=93.59999f ps=0.88u w=0.36u l=0.28u
X753 a_36310_3908# a_35262_3404# VSS VSS nfet_03v3 ad=93.59999f pd=0.88u as=93.59999f ps=0.88u w=0.36u l=0.28u
X754 a_29164_3400# SE.t36 VSS VSS nfet_03v3 ad=0.2016p pd=1.84u as=0.1584p ps=1.6u w=0.36u l=0.28u
X755 a_21843_2618# a_21539_2618# VSS VSS nfet_03v3 ad=0.108p pd=0.96u as=0.1728p ps=1.68u w=0.36u l=0.28u
X756 a_43784_3448# a_43728_3404# VDD VDD pfet_03v3 ad=86.39999f pd=0.96u as=0.1872p ps=1.24u w=0.72u l=0.28u
X757 a_35349_2618# a_35684_3118# a_36316_2618# VSS nfet_03v3 ad=0.1728p pd=1.68u as=0.108p ps=0.96u w=0.36u l=0.28u
X758 a_33758_3118# CLK.t60 VDD VDD pfet_03v3 ad=0.108p pd=0.96u as=0.1728p ps=1.68u w=0.36u l=0.28u
X759 a_8536_2618# a_8393_2866# a_8360_2618# VSS nfet_03v3 ad=0.1728p pd=1.68u as=0.108p ps=0.96u w=0.36u l=0.28u
X760 a_33794_3400# JMP.t40 a_33794_4236# VDD.t450 pfet_03v3 ad=0.1332p pd=1.1u as=0.4446p ps=3.19u w=0.36u l=0.28u
X761 VSS a_1398_3404# a_3070_3908# VSS nfet_03v3 ad=93.59999f pd=0.88u as=57.59999f ps=0.68u w=0.36u l=0.28u
X762 a_26636_3392# a_24515_3448# a_26956_3448# VDD pfet_03v3 ad=0.1872p pd=1.24u as=86.39999f ps=0.96u w=0.72u l=0.28u
X763 a_30005_2618# a_29701_2618# VDD VDD pfet_03v3 ad=0.1728p pd=1.68u as=0.1728p ps=1.68u w=0.36u l=0.28u
X764 a_31973_4236# BR.t44 VDD.t728 VDD.t727 pfet_03v3 ad=0.4032p pd=2.56u as=0.3168p ps=2.32u w=0.72u l=0.28u
X765 VSS a_24515_3448# a_27220_3908# VSS nfet_03v3 ad=0.1584p pd=1.6u as=93.59999f ps=0.88u w=0.36u l=0.28u
X766 VDD a_5471_3392# a_4163_4236# VDD pfet_03v3 ad=0.1872p pd=1.24u as=0.3168p ps=2.32u w=0.72u l=0.28u
X767 a_20698_3400# SE.t37 VDD VDD pfet_03v3 ad=0.4032p pd=2.56u as=0.3168p ps=2.32u w=0.72u l=0.28u
X768 VDD PC9.t9 a_40543_3448# VDD pfet_03v3 ad=0.1872p pd=1.24u as=0.3168p ps=2.32u w=0.72u l=0.28u
X769 PC7.t0 a_31451_3118# VDD VDD pfet_03v3 ad=0.3456p pd=2.4u as=0.3456p ps=2.4u w=0.72u l=0.28u
X770 a_39335_3392# a_37214_3448# a_39655_3908# VSS nfet_03v3 ad=93.59999f pd=0.88u as=43.2f ps=0.6u w=0.36u l=0.28u
X771 a_36934_3448# PC8.t8 a_35622_3632# VDD pfet_03v3 ad=0.1152p pd=1.04u as=0.1872p ps=1.24u w=0.72u l=0.28u
X772 a_4911_2618# a_4607_2618# VSS VSS nfet_03v3 ad=0.108p pd=0.96u as=0.1728p ps=1.68u w=0.36u l=0.28u
X773 a_63425_3400# JMP.t41 a_63425_4236# VDD.t451 pfet_03v3 ad=0.1332p pd=1.1u as=0.4446p ps=3.19u w=0.36u l=0.28u
X774 DEST12.t1 JMP.t42 a_50726_3400# VSS nfet_03v3 ad=0.18p pd=1.72u as=0.1332p ps=1.1u w=0.36u l=0.28u
X775 a_60747_2618# a_58795_2616# a_59636_2618# VDD pfet_03v3 ad=0.1728p pd=1.68u as=0.1728p ps=1.68u w=0.36u l=0.28u
X776 a_54923_2618# a_54562_2616# VSS VSS nfet_03v3 ad=0.108p pd=0.96u as=0.1728p ps=1.68u w=0.36u l=0.28u
X777 VSS a_60500_3392# a_59192_4236# VSS nfet_03v3 ad=93.59999f pd=0.88u as=0.1584p ps=1.6u w=0.36u l=0.28u
X778 a_59636_2618# a_59332_2618# VDD VDD pfet_03v3 ad=0.1728p pd=1.68u as=0.1728p ps=1.68u w=0.36u l=0.28u
X779 a_44150_3118# a_43815_2618# VDD VDD pfet_03v3 ad=0.1728p pd=1.68u as=0.108p ps=0.96u w=0.36u l=0.28u
X780 a_3766_3400# SE.t38 VDD VDD pfet_03v3 ad=0.4032p pd=2.56u as=0.3168p ps=2.32u w=0.72u l=0.28u
X781 a_4759_3118# RSTn.t43 VDD VDD pfet_03v3 ad=0.108p pd=0.96u as=0.108p ps=0.96u w=0.36u l=0.28u
X782 a_526_3118# RSTn.t44 a_678_2618# VSS nfet_03v3 ad=0.108p pd=0.96u as=0.108p ps=0.96u w=0.36u l=0.28u
X783 a_50866_2618# CLK.t61 a_51322_3118# VSS nfet_03v3 ad=0.1728p pd=1.68u as=0.108p ps=0.96u w=0.36u l=0.28u
X784 a_55099_2618# a_54956_2866# a_54923_3118# VDD pfet_03v3 ad=0.1728p pd=1.68u as=0.108p ps=0.96u w=0.36u l=0.28u
X785 a_18417_2618# a_16465_2616# a_17306_2618# VDD pfet_03v3 ad=0.1728p pd=1.68u as=0.1728p ps=1.68u w=0.36u l=0.28u
X786 a_18330_3404# a_19274_4236# VSS VSS nfet_03v3 ad=0.1332p pd=1.1u as=0.2592p ps=2.16u w=0.36u l=0.28u
X787 a_52554_3632# a_49913_3448# a_53242_3908# VSS nfet_03v3 ad=93.59999f pd=0.88u as=93.59999f ps=0.88u w=0.36u l=0.28u
X788 a_44152_3448# a_44088_3632# a_43568_3392# VDD pfet_03v3 ad=0.1872p pd=1.24u as=0.1872p ps=1.24u w=0.72u l=0.28u
X789 a_49009_3448# a_47961_3404# VDD VDD pfet_03v3 ad=0.1872p pd=1.24u as=0.1872p ps=1.24u w=0.72u l=0.28u
X790 a_41863_2616# CLK.t62 VDD VDD pfet_03v3 ad=0.4032p pd=2.56u as=0.3168p ps=2.32u w=0.72u l=0.28u
X791 VSS a_1398_3404# a_1822_3908# VSS nfet_03v3 ad=93.59999f pd=0.88u as=93.59999f ps=0.88u w=0.36u l=0.28u
X792 VSS a_43728_3404# a_45400_3908# VSS nfet_03v3 ad=93.59999f pd=0.88u as=57.59999f ps=0.68u w=0.36u l=0.28u
X793 DEST4.t0 a_16465_4236# a_16862_3400# VDD.t124 pfet_03v3 ad=0.18p pd=1.72u as=0.1332p ps=1.1u w=0.36u l=0.28u
X794 a_30869_3392# a_28748_3448# a_31189_3908# VSS nfet_03v3 ad=93.59999f pd=0.88u as=43.2f ps=0.6u w=0.36u l=0.28u
X795 a_65315_3118# a_64980_2618# a_65467_2618# VSS nfet_03v3 ad=0.1728p pd=1.68u as=0.108p ps=0.96u w=0.36u l=0.28u
X796 a_40549_3118# CLK.t63 VDD VDD pfet_03v3 ad=0.108p pd=0.96u as=0.1728p ps=1.68u w=0.36u l=0.28u
X797 a_56851_3908# a_56787_3632# a_56267_3392# VSS nfet_03v3 ad=93.59999f pd=0.88u as=93.59999f ps=0.88u w=0.36u l=0.28u
X798 VDD a_51170_2618# a_51322_3118# VDD pfet_03v3 ad=0.108p pd=0.96u as=0.1728p ps=1.68u w=0.36u l=0.28u
X799 a_46490_2866# a_46096_3400# a_46493_3400# VSS nfet_03v3 ad=0.1332p pd=1.1u as=0.3654p ps=2.75u w=0.36u l=0.28u
X800 a_29956_5022.t1 a_53138_4236# a_52194_3404# VDD.t123 pfet_03v3 ad=0.3654p pd=2.75u as=0.1332p ps=1.1u w=0.36u l=0.28u
X801 VSS VSS a_1822_3908# VSS nfet_03v3 ad=0.1584p pd=1.6u as=93.59999f ps=0.88u w=0.36u l=0.28u
X802 a_15145_3448# a_14097_3404# VDD VDD pfet_03v3 ad=0.1872p pd=1.24u as=0.1872p ps=1.24u w=0.72u l=0.28u
X803 a_20282_3448# a_18690_3632# VDD VDD pfet_03v3 ad=0.3168p pd=2.32u as=0.1872p ps=1.24u w=0.72u l=0.28u
X804 a_63028_3400# SE.t39 VSS VSS nfet_03v3 ad=0.2016p pd=1.84u as=0.1584p ps=1.6u w=0.36u l=0.28u
X805 a_9864_3404# a_10808_4236# VSS VSS nfet_03v3 ad=0.1332p pd=1.1u as=0.2592p ps=2.16u w=0.36u l=0.28u
X806 a_16465_4236# JMP.t43 VSS VSS nfet_03v3 ad=0.2016p pd=1.84u as=0.1584p ps=1.6u w=0.36u l=0.28u
X807 a_42704_2618# a_42400_2618# VSS VSS nfet_03v3 ad=0.1728p pd=1.68u as=0.1728p ps=1.68u w=0.36u l=0.28u
X808 a_47089_3118# RSTn.t45 VDD VDD pfet_03v3 ad=0.108p pd=0.96u as=0.108p ps=0.96u w=0.36u l=0.28u
X809 a_12769_2618# a_12626_2866# a_12593_2618# VSS nfet_03v3 ad=0.1728p pd=1.68u as=0.108p ps=0.96u w=0.36u l=0.28u
X810 a_12626_2866# a_12232_3400# a_12629_3400# VSS nfet_03v3 ad=0.1332p pd=1.1u as=0.3654p ps=2.75u w=0.36u l=0.28u
X811 VDD a_31029_3404# a_31453_3448# VDD pfet_03v3 ad=0.1872p pd=1.24u as=0.1872p ps=1.24u w=0.72u l=0.28u
X812 a_35622_3632# a_32981_3448# a_36310_3448# VDD pfet_03v3 ad=0.1872p pd=1.24u as=0.1872p ps=1.24u w=0.72u l=0.28u
X813 PC12.t3 a_54562_3400# a_54956_2866# VDD pfet_03v3 ad=0.2592p pd=2.16u as=0.1332p ps=1.1u w=0.36u l=0.28u
X814 PC13.t2 a_56849_3118# VDD VDD pfet_03v3 ad=0.3456p pd=2.4u as=0.3456p ps=2.4u w=0.72u l=0.28u
X815 a_32981_3448# a_31389_3632# VSS VSS nfet_03v3 ad=0.1584p pd=1.6u as=93.59999f ps=0.88u w=0.36u l=0.28u
X816 a_35318_3908# a_35262_3404# VSS VSS nfet_03v3 ad=43.2f pd=0.6u as=93.59999f ps=0.88u w=0.36u l=0.28u
X817 a_31116_2618# a_31451_3118# a_32083_3118# VDD pfet_03v3 ad=0.1728p pd=1.68u as=0.108p ps=0.96u w=0.36u l=0.28u
X818 a_23137_2618# RSTn.t46 VSS VSS nfet_03v3 ad=0.108p pd=0.96u as=0.1728p ps=1.68u w=0.36u l=0.28u
X819 a_60820_3448# PC14.t8 a_60716_3448# VDD pfet_03v3 ad=86.39999f pd=0.96u as=86.39999f ps=0.96u w=0.72u l=0.28u
X820 a_46096_4236# JMP.t44 VSS VSS nfet_03v3 ad=0.2016p pd=1.84u as=0.1584p ps=1.6u w=0.36u l=0.28u
X821 a_26883_2618# a_27218_3118# a_27850_2618# VSS nfet_03v3 ad=0.1728p pd=1.68u as=0.108p ps=0.96u w=0.36u l=0.28u
X822 DEST3.t0 JMP.t45 a_12629_3400# VSS nfet_03v3 ad=0.18p pd=1.72u as=0.1332p ps=1.1u w=0.36u l=0.28u
X823 a_21092_2866# SE.t40 a_21095_3400# VDD pfet_03v3 ad=0.1332p pd=1.1u as=0.3654p ps=2.75u w=0.36u l=0.28u
X824 VDD a_56427_3404# a_58099_3448# VDD pfet_03v3 ad=0.1872p pd=1.24u as=0.1152p ps=1.04u w=0.72u l=0.28u
X825 a_52281_2618# a_52616_3118# a_53248_2618# VSS nfet_03v3 ad=0.1728p pd=1.68u as=0.108p ps=0.96u w=0.36u l=0.28u
X826 a_50690_3118# CLK.t64 VDD VDD pfet_03v3 ad=0.108p pd=0.96u as=0.1728p ps=1.68u w=0.36u l=0.28u
X827 a_18490_3448# PC4.t9 a_18386_3448# VDD pfet_03v3 ad=86.39999f pd=0.96u as=86.39999f ps=0.96u w=0.72u l=0.28u
X828 VSS.t601 a_29172_5022# a_29956_5022.t31 VSS nfet_03v3 ad=0.108p pd=0.96u as=0.108p ps=0.96u w=0.36u l=0.28u
X829 a_29164_3400# SE.t41 VDD VDD pfet_03v3 ad=0.4032p pd=2.56u as=0.3168p ps=2.32u w=0.72u l=0.28u
X830 VSS a_41447_3448# a_44152_3908# VSS nfet_03v3 ad=0.1584p pd=1.6u as=93.59999f ps=0.88u w=0.36u l=0.28u
X831 a_31116_2618# CLK.t65 a_30005_2618# VSS nfet_03v3 ad=0.1728p pd=1.68u as=0.1728p ps=1.68u w=0.36u l=0.28u
X832 a_17002_2618# a_16859_2866# a_16826_3118# VDD pfet_03v3 ad=0.1728p pd=1.68u as=0.108p ps=0.96u w=0.36u l=0.28u
X833 a_42260_3400# a_41863_4236# a_42260_4236# VSS nfet_03v3 ad=0.1332p pd=1.1u as=0.4446p ps=3.19u w=0.36u l=0.28u
X834 a_56267_3392# a_54146_3448# a_56587_3908# VSS nfet_03v3 ad=93.59999f pd=0.88u as=43.2f ps=0.6u w=0.36u l=0.28u
X835 a_65947_3118# CLK.t66 VDD VDD pfet_03v3 ad=0.108p pd=0.96u as=0.1728p ps=1.68u w=0.36u l=0.28u
X836 a_12232_3400# SE.t42 VSS VSS nfet_03v3 ad=0.2016p pd=1.84u as=0.1584p ps=1.6u w=0.36u l=0.28u
X837 a_n106_2618# a_n467_2616# VSS VSS nfet_03v3 ad=0.108p pd=0.96u as=0.1728p ps=1.68u w=0.36u l=0.28u
X838 a_30157_3118# RSTn.t47 a_30309_2618# VSS nfet_03v3 ad=0.108p pd=0.96u as=0.108p ps=0.96u w=0.36u l=0.28u
X839 a_9704_3392# a_7583_3448# a_10024_3448# VDD pfet_03v3 ad=0.1872p pd=1.24u as=86.39999f ps=0.96u w=0.72u l=0.28u
X840 VDD PC3.t9 a_15145_3448# VDD pfet_03v3 ad=0.1872p pd=1.24u as=0.3168p ps=2.32u w=0.72u l=0.28u
X841 a_53866_3448# PC12.t9 a_52554_3632# VDD pfet_03v3 ad=0.1152p pd=1.04u as=0.1872p ps=1.24u w=0.72u l=0.28u
X842 a_61082_3118# a_60747_2618# VDD VDD pfet_03v3 ad=0.1728p pd=1.68u as=0.108p ps=0.96u w=0.36u l=0.28u
X843 a_18904_2618# RSTn.t48 VSS VSS nfet_03v3 ad=0.108p pd=0.96u as=0.1728p ps=1.68u w=0.36u l=0.28u
X844 a_45680_3448# a_44088_3632# VDD VDD pfet_03v3 ad=0.3168p pd=2.32u as=0.1872p ps=1.24u w=0.72u l=0.28u
X845 a_35262_3404# a_36206_4236# VSS VSS nfet_03v3 ad=0.1332p pd=1.1u as=0.2592p ps=2.16u w=0.36u l=0.28u
X846 a_2446_3908# a_1398_3404# VSS VSS nfet_03v3 ad=93.59999f pd=0.88u as=93.59999f ps=0.88u w=0.36u l=0.28u
X847 a_22403_3392# a_20282_3448# a_22723_3908# VSS nfet_03v3 ad=93.59999f pd=0.88u as=43.2f ps=0.6u w=0.36u l=0.28u
X848 a_29525_2618# a_29164_2616# VSS VSS nfet_03v3 ad=0.108p pd=0.96u as=0.1728p ps=1.68u w=0.36u l=0.28u
X849 a_35349_2618# a_33397_2616# a_34238_2618# VDD pfet_03v3 ad=0.1728p pd=1.68u as=0.1728p ps=1.68u w=0.36u l=0.28u
X850 a_38027_3400# JMP.t46 a_38027_4236# VDD.t387 pfet_03v3 ad=0.1332p pd=1.1u as=0.4446p ps=3.19u w=0.36u l=0.28u
X851 VSS PC6.t9 a_27844_3908# VSS nfet_03v3 ad=93.59999f pd=0.88u as=0.1584p ps=1.6u w=0.36u l=0.28u
X852 VSS a_35102_3392# a_33794_4236# VSS nfet_03v3 ad=93.59999f pd=0.88u as=0.1584p ps=1.6u w=0.36u l=0.28u
X853 VDD a_56427_3404# a_56851_3448# VDD pfet_03v3 ad=0.1872p pd=1.24u as=0.1872p ps=1.24u w=0.72u l=0.28u
X854 a_65941_3448# a_64893_3404# VDD VDD pfet_03v3 ad=0.1872p pd=1.24u as=0.1872p ps=1.24u w=0.72u l=0.28u
X855 VDD a_42704_2618# a_42856_3118# VDD pfet_03v3 ad=0.108p pd=0.96u as=0.1728p ps=1.68u w=0.36u l=0.28u
X856 a_36206_4236# BR.t45 VDD.t730 VDD.t729 pfet_03v3 ad=0.4032p pd=2.56u as=0.3168p ps=2.32u w=0.72u l=0.28u
X857 a_59788_3118# RSTn.t49 a_59940_2618# VSS nfet_03v3 ad=0.108p pd=0.96u as=0.108p ps=0.96u w=0.36u l=0.28u
X858 DEST8.t1 a_33397_4236# a_33794_3400# VDD.t585 pfet_03v3 ad=0.18p pd=1.72u as=0.1332p ps=1.1u w=0.36u l=0.28u
X859 a_29956_5022.t12 BR.t46 a_31029_3404# VSS nfet_03v3 ad=0.3654p pd=2.75u as=0.1332p ps=1.1u w=0.36u l=0.28u
X860 VSS a_60660_3404# a_62332_3908# VSS nfet_03v3 ad=93.59999f pd=0.88u as=57.59999f ps=0.68u w=0.36u l=0.28u
X861 a_56514_2618# a_56849_3118# a_57481_3118# VDD pfet_03v3 ad=0.1728p pd=1.68u as=0.108p ps=0.96u w=0.36u l=0.28u
X862 a_18752_3118# a_18417_2618# VDD VDD pfet_03v3 ad=0.1728p pd=1.68u as=0.108p ps=0.96u w=0.36u l=0.28u
X863 a_1485_2618# a_1820_3118# a_2452_2618# VSS nfet_03v3 ad=0.1728p pd=1.68u as=0.108p ps=0.96u w=0.36u l=0.28u
X864 a_22723_3908# PC5.t9 a_22619_3908# VSS nfet_03v3 ad=43.2f pd=0.6u as=43.2f ps=0.6u w=0.36u l=0.28u
X865 a_63565_2618# PC_NEXT15.t5 a_63389_2618# VSS nfet_03v3 ad=0.1728p pd=1.68u as=0.108p ps=0.96u w=0.36u l=0.28u
X866 a_25468_2618# CLK.t67 a_25924_3118# VSS nfet_03v3 ad=0.1728p pd=1.68u as=0.108p ps=0.96u w=0.36u l=0.28u
X867 PC_NEXT15.t3 a_63028_3400# a_63425_3400# VSS nfet_03v3 ad=0.1332p pd=1.1u as=0.3654p ps=2.75u w=0.36u l=0.28u
X868 a_26883_2618# CLK.t68 a_25772_2618# VSS nfet_03v3 ad=0.1728p pd=1.68u as=0.1728p ps=1.68u w=0.36u l=0.28u
X869 a_11816_3448# a_10224_3632# VDD VDD pfet_03v3 ad=0.3168p pd=2.32u as=0.1872p ps=1.24u w=0.72u l=0.28u
X870 VSS a_22563_3404# a_22987_3908# VSS nfet_03v3 ad=93.59999f pd=0.88u as=93.59999f ps=0.88u w=0.36u l=0.28u
X871 a_27156_3632# a_24515_3448# a_27844_3908# VSS nfet_03v3 ad=93.59999f pd=0.88u as=93.59999f ps=0.88u w=0.36u l=0.28u
X872 VDD a_54146_3448# a_56851_3448# VDD pfet_03v3 ad=0.3168p pd=2.32u as=0.1872p ps=1.24u w=0.72u l=0.28u
X873 a_16465_2616# CLK.t69 VDD VDD pfet_03v3 ad=0.4032p pd=2.56u as=0.3168p ps=2.32u w=0.72u l=0.28u
X874 a_46490_2866# SE.t43 a_46493_3400# VDD pfet_03v3 ad=0.1332p pd=1.1u as=0.3654p ps=2.75u w=0.36u l=0.28u
X875 a_44152_3908# PC10.t9 VSS VSS nfet_03v3 ad=93.59999f pd=0.88u as=93.59999f ps=0.88u w=0.36u l=0.28u
X876 a_15151_3118# CLK.t70 VDD VDD pfet_03v3 ad=0.108p pd=0.96u as=0.1728p ps=1.68u w=0.36u l=0.28u
X877 a_8536_2618# CLK.t71 a_8992_3118# VSS nfet_03v3 ad=0.1728p pd=1.68u as=0.108p ps=0.96u w=0.36u l=0.28u
X878 a_5791_3908# PC1.t10 a_5687_3908# VSS nfet_03v3 ad=43.2f pd=0.6u as=43.2f ps=0.6u w=0.36u l=0.28u
X879 a_63028_3400# SE.t44 VDD VDD pfet_03v3 ad=0.4032p pd=2.56u as=0.3168p ps=2.32u w=0.72u l=0.28u
X880 a_64021_3118# RSTn.t50 VDD VDD pfet_03v3 ad=0.108p pd=0.96u as=0.108p ps=0.96u w=0.36u l=0.28u
X881 a_46096_2616# CLK.t72 VDD VDD pfet_03v3 ad=0.4032p pd=2.56u as=0.3168p ps=2.32u w=0.72u l=0.28u
X882 DISP6.t0 a_27740_4236# a_26796_3404# VDD.t392 pfet_03v3 ad=0.3654p pd=2.75u as=0.1332p ps=1.1u w=0.36u l=0.28u
X883 a_52250_3908# a_52194_3404# VSS VSS nfet_03v3 ad=43.2f pd=0.6u as=93.59999f ps=0.88u w=0.36u l=0.28u
X884 a_54562_2616# CLK.t73 VSS VSS nfet_03v3 ad=0.2016p pd=1.84u as=0.1584p ps=1.6u w=0.36u l=0.28u
X885 a_37630_3400# SE.t45 VSS VSS nfet_03v3 ad=0.2016p pd=1.84u as=0.1584p ps=1.6u w=0.36u l=0.28u
X886 a_21059_2618# a_20698_2616# VSS VSS nfet_03v3 ad=0.108p pd=0.96u as=0.1728p ps=1.68u w=0.36u l=0.28u
X887 a_12626_2866# SE.t46 a_12629_3400# VDD pfet_03v3 ad=0.1332p pd=1.1u as=0.3654p ps=2.75u w=0.36u l=0.28u
X888 a_10288_3908# PC2.t9 VSS VSS nfet_03v3 ad=93.59999f pd=0.88u as=93.59999f ps=0.88u w=0.36u l=0.28u
X889 a_15769_3908# PC3.t10 a_14457_3632# VSS nfet_03v3 ad=57.59999f pd=0.68u as=93.59999f ps=0.88u w=0.36u l=0.28u
X890 a_35102_3392# a_32981_3448# a_35422_3448# VDD pfet_03v3 ad=0.1872p pd=1.24u as=86.39999f ps=0.96u w=0.72u l=0.28u
X891 a_55555_3118# RSTn.t51 a_55707_2618# VSS nfet_03v3 ad=0.108p pd=0.96u as=0.108p ps=0.96u w=0.36u l=0.28u
X892 VSS PC0.t9 a_2446_3908# VSS nfet_03v3 ad=93.59999f pd=0.88u as=0.1584p ps=1.6u w=0.36u l=0.28u
X893 PC9.t1 a_39917_3118# VDD VDD pfet_03v3 ad=0.3456p pd=2.4u as=0.3456p ps=2.4u w=0.72u l=0.28u
X894 a_36316_2618# a_33397_2616# VSS VSS nfet_03v3 ad=0.108p pd=0.96u as=0.1728p ps=1.68u w=0.36u l=0.28u
X895 a_35422_3448# PC8.t9 a_35318_3448# VDD pfet_03v3 ad=86.39999f pd=0.96u as=86.39999f ps=0.96u w=0.72u l=0.28u
X896 VDD PC15.t6 a_65941_3448# VDD pfet_03v3 ad=0.1872p pd=1.24u as=0.3168p ps=2.32u w=0.72u l=0.28u
X897 VSS a_18330_3404# a_18754_3908# VSS nfet_03v3 ad=93.59999f pd=0.88u as=93.59999f ps=0.88u w=0.36u l=0.28u
X898 a_55099_2618# a_54562_2616# a_55555_3118# VDD pfet_03v3 ad=0.1728p pd=1.68u as=0.108p ps=0.96u w=0.36u l=0.28u
X899 a_33934_2618# a_33791_2866# a_33758_3118# VDD pfet_03v3 ad=0.1728p pd=1.68u as=0.108p ps=0.96u w=0.36u l=0.28u
X900 a_20698_2616# CLK.t74 VSS VSS nfet_03v3 ad=0.2016p pd=1.84u as=0.1584p ps=1.6u w=0.36u l=0.28u
X901 VDD RSTn.t52 a_14519_3118# VDD pfet_03v3 ad=0.108p pd=0.96u as=0.1728p ps=1.68u w=0.36u l=0.28u
X902 a_1485_2618# CLK.t75 a_374_2618# VSS nfet_03v3 ad=0.1728p pd=1.68u as=0.1728p ps=1.68u w=0.36u l=0.28u
X903 DEST14.t0 a_58795_4236# a_59192_3400# VDD.t4 pfet_03v3 ad=0.18p pd=1.72u as=0.1332p ps=1.1u w=0.36u l=0.28u
X904 a_21691_3118# RSTn.t53 a_21843_2618# VSS nfet_03v3 ad=0.108p pd=0.96u as=0.108p ps=0.96u w=0.36u l=0.28u
X905 VDD a_9864_3404# a_11536_3448# VDD pfet_03v3 ad=0.1872p pd=1.24u as=0.1152p ps=1.04u w=0.72u l=0.28u
X906 a_63869_2618# a_63565_2618# VDD VDD pfet_03v3 ad=0.1728p pd=1.68u as=0.1728p ps=1.68u w=0.36u l=0.28u
X907 a_25292_3118# CLK.t76 VDD VDD pfet_03v3 ad=0.108p pd=0.96u as=0.1728p ps=1.68u w=0.36u l=0.28u
X908 a_1758_3632# VSS a_2446_3448# VDD pfet_03v3 ad=0.1872p pd=1.24u as=0.1872p ps=1.24u w=0.72u l=0.28u
X909 VSS a_16049_3448# a_18754_3908# VSS nfet_03v3 ad=0.1584p pd=1.6u as=93.59999f ps=0.88u w=0.36u l=0.28u
X910 a_56851_3448# PC13.t9 VDD VDD pfet_03v3 ad=0.1872p pd=1.24u as=0.1872p ps=1.24u w=0.72u l=0.28u
X911 a_16862_3400# a_16465_4236# a_16862_4236# VSS nfet_03v3 ad=0.1332p pd=1.1u as=0.4446p ps=3.19u w=0.36u l=0.28u
X912 a_22987_3448# a_22923_3632# a_22403_3392# VDD pfet_03v3 ad=0.1872p pd=1.24u as=0.1872p ps=1.24u w=0.72u l=0.28u
X913 VDD PC7.t9 a_32077_3448# VDD pfet_03v3 ad=0.1872p pd=1.24u as=0.3168p ps=2.32u w=0.72u l=0.28u
X914 a_13377_2618# a_13073_2618# VSS VSS nfet_03v3 ad=0.108p pd=0.96u as=0.1728p ps=1.68u w=0.36u l=0.28u
X915 a_12232_3400# SE.t47 VDD VDD pfet_03v3 ad=0.4032p pd=2.56u as=0.3168p ps=2.32u w=0.72u l=0.28u
X916 a_3766_2616# CLK.t77 VSS VSS nfet_03v3 ad=0.2016p pd=1.84u as=0.1584p ps=1.6u w=0.36u l=0.28u
X917 a_44672_4236# BR.t47 VSS VSS nfet_03v3 ad=0.2016p pd=1.84u as=0.1584p ps=1.6u w=0.36u l=0.28u
X918 a_6055_3448# a_5991_3632# a_5471_3392# VDD pfet_03v3 ad=0.1872p pd=1.24u as=0.1872p ps=1.24u w=0.72u l=0.28u
X919 a_62612_3448# a_61020_3632# VDD VDD pfet_03v3 ad=0.3168p pd=2.32u as=0.1872p ps=1.24u w=0.72u l=0.28u
X920 a_52194_3404# a_53138_4236# VSS VSS nfet_03v3 ad=0.1332p pd=1.1u as=0.2592p ps=2.16u w=0.36u l=0.28u
X921 a_58795_4236# JMP.t47 VSS VSS nfet_03v3 ad=0.2016p pd=1.84u as=0.1584p ps=1.6u w=0.36u l=0.28u
X922 VSS PC10.t10 a_44776_3908# VSS nfet_03v3 ad=93.59999f pd=0.88u as=0.1584p ps=1.6u w=0.36u l=0.28u
X923 a_53138_4236# BR.t48 VDD.t408 VDD.t407 pfet_03v3 ad=0.4032p pd=2.56u as=0.3168p ps=2.32u w=0.72u l=0.28u
X924 DEST0.t1 JMP.t48 a_n70_3400# VSS nfet_03v3 ad=0.18p pd=1.72u as=0.1332p ps=1.1u w=0.36u l=0.28u
X925 VSS a_52034_3392# a_50726_4236# VSS nfet_03v3 ad=93.59999f pd=0.88u as=0.1584p ps=1.6u w=0.36u l=0.28u
X926 a_8360_3118# CLK.t78 VDD VDD pfet_03v3 ad=0.108p pd=0.96u as=0.1728p ps=1.68u w=0.36u l=0.28u
X927 a_22987_3448# PC5.t10 VDD VDD pfet_03v3 ad=0.1872p pd=1.24u as=0.1872p ps=1.24u w=0.72u l=0.28u
X928 a_28468_3448# PC6.t10 a_27156_3632# VDD pfet_03v3 ad=0.1152p pd=1.04u as=0.1872p ps=1.24u w=0.72u l=0.28u
X929 DEST12.t0 a_50329_4236# a_50726_3400# VDD.t152 pfet_03v3 ad=0.18p pd=1.72u as=0.1332p ps=1.1u w=0.36u l=0.28u
X930 a_6575_4236# BR.t49 VDD.t410 VDD.t409 pfet_03v3 ad=0.4032p pd=2.56u as=0.3168p ps=2.32u w=0.72u l=0.28u
X931 a_70_2618# CLK.t79 a_526_3118# VSS nfet_03v3 ad=0.1728p pd=1.68u as=0.108p ps=0.96u w=0.36u l=0.28u
X932 a_46457_2618# a_46096_2616# VSS VSS nfet_03v3 ad=0.108p pd=0.96u as=0.1728p ps=1.68u w=0.36u l=0.28u
X933 a_43815_2618# CLK.t80 a_42704_2618# VSS nfet_03v3 ad=0.1728p pd=1.68u as=0.1728p ps=1.68u w=0.36u l=0.28u
X934 PC1.t1 a_6053_3118# VDD VDD pfet_03v3 ad=0.3456p pd=2.4u as=0.3456p ps=2.4u w=0.72u l=0.28u
X935 a_10808_4236# BR.t50 VSS VSS nfet_03v3 ad=0.2016p pd=1.84u as=0.1584p ps=1.6u w=0.36u l=0.28u
X936 PC5.t3 a_22985_3118# VSS VSS nfet_03v3 ad=0.1728p pd=1.68u as=0.1728p ps=1.68u w=0.36u l=0.28u
X937 a_35686_3908# PC8.t10 VSS VSS nfet_03v3 ad=93.59999f pd=0.88u as=93.59999f ps=0.88u w=0.36u l=0.28u
X938 a_44088_3632# a_41447_3448# a_44776_3908# VSS nfet_03v3 ad=93.59999f pd=0.88u as=93.59999f ps=0.88u w=0.36u l=0.28u
X939 VDD a_17306_2618# a_17458_3118# VDD pfet_03v3 ad=0.108p pd=0.96u as=0.1728p ps=1.68u w=0.36u l=0.28u
X940 a_29956_5022.t19 a_29172_5022# VDD.t653 VDD.t439 pfet_03v3 ad=0.216p pd=1.32u as=0.216p ps=1.32u w=0.72u l=0.28u
X941 a_24931_4236# JMP.t49 VSS VSS nfet_03v3 ad=0.2016p pd=1.84u as=0.1584p ps=1.6u w=0.36u l=0.28u
X942 PC_NEXT15.t1 SE.t48 a_63425_3400# VDD pfet_03v3 ad=0.1332p pd=1.1u as=0.3654p ps=2.75u w=0.36u l=0.28u
X943 a_18330_3404# BR.t51 VSS VDD.t45 pfet_03v3 ad=0.1332p pd=1.1u as=0.2592p ps=2.16u w=0.36u l=0.28u
X944 a_61084_3908# PC14.t9 VSS VSS nfet_03v3 ad=93.59999f pd=0.88u as=93.59999f ps=0.88u w=0.36u l=0.28u
X945 a_66565_3908# PC15.t7 a_65253_3632# VSS nfet_03v3 ad=57.59999f pd=0.68u as=93.59999f ps=0.88u w=0.36u l=0.28u
X946 VDD a_35262_3404# a_36934_3448# VDD pfet_03v3 ad=0.1872p pd=1.24u as=0.1152p ps=1.04u w=0.72u l=0.28u
X947 a_13073_2618# a_12769_2618# VDD VDD pfet_03v3 ad=0.1728p pd=1.68u as=0.1728p ps=1.68u w=0.36u l=0.28u
X948 a_38024_2866# a_37630_3400# a_38027_3400# VSS nfet_03v3 ad=0.1332p pd=1.1u as=0.3654p ps=2.75u w=0.36u l=0.28u
X949 VDD a_7583_3448# a_10288_3448# VDD pfet_03v3 ad=0.3168p pd=2.32u as=0.1872p ps=1.24u w=0.72u l=0.28u
X950 a_56849_3118# a_56514_2618# a_57001_2618# VSS nfet_03v3 ad=0.1728p pd=1.68u as=0.108p ps=0.96u w=0.36u l=0.28u
X951 a_17002_2618# a_16465_2616# a_17458_3118# VDD pfet_03v3 ad=0.1728p pd=1.68u as=0.108p ps=0.96u w=0.36u l=0.28u
X952 a_n467_3400# SE.t49 VSS VSS nfet_03v3 ad=0.2016p pd=1.84u as=0.1584p ps=1.6u w=0.36u l=0.28u
X953 PC7.t2 SE.t50 a_33791_2866# VSS nfet_03v3 ad=0.2592p pd=2.16u as=0.1332p ps=1.1u w=0.36u l=0.28u
X954 a_1398_3404# a_2342_4236# VSS VSS nfet_03v3 ad=0.1332p pd=1.1u as=0.2592p ps=2.16u w=0.36u l=0.28u
X955 a_7999_4236# JMP.t50 VSS VSS nfet_03v3 ad=0.2016p pd=1.84u as=0.1584p ps=1.6u w=0.36u l=0.28u
X956 a_18754_3908# PC4.t10 VSS VSS nfet_03v3 ad=93.59999f pd=0.88u as=93.59999f ps=0.88u w=0.36u l=0.28u
X957 VSS.t600 a_29172_5022# a_29956_5022.t30 VSS nfet_03v3 ad=0.108p pd=0.96u as=0.108p ps=0.96u w=0.36u l=0.28u
X958 a_48905_4236# BR.t52 VDD.t47 VDD.t46 pfet_03v3 ad=0.4032p pd=2.56u as=0.3168p ps=2.32u w=0.72u l=0.28u
X959 a_32701_3908# PC7.t10 a_31389_3632# VSS nfet_03v3 ad=57.59999f pd=0.68u as=93.59999f ps=0.88u w=0.36u l=0.28u
X960 a_37630_3400# SE.t51 VDD VDD pfet_03v3 ad=0.4032p pd=2.56u as=0.3168p ps=2.32u w=0.72u l=0.28u
X961 VDD PC13.t10 a_57475_3448# VDD pfet_03v3 ad=0.1872p pd=1.24u as=0.3168p ps=2.32u w=0.72u l=0.28u
X962 a_50726_3400# a_50329_4236# a_50726_4236# VSS nfet_03v3 ad=0.1332p pd=1.1u as=0.4446p ps=3.19u w=0.36u l=0.28u
X963 PC11.t0 a_48383_3118# VDD VDD pfet_03v3 ad=0.3456p pd=2.4u as=0.3456p ps=2.4u w=0.72u l=0.28u
X964 a_5471_3392# a_3350_3448# a_5791_3448# VDD pfet_03v3 ad=0.1872p pd=1.24u as=86.39999f ps=0.96u w=0.72u l=0.28u
X965 a_24515_3448# a_22923_3632# VSS VSS nfet_03v3 ad=0.1584p pd=1.6u as=93.59999f ps=0.88u w=0.36u l=0.28u
X966 a_9864_3404# BR.t53 VSS VDD.t48 pfet_03v3 ad=0.1332p pd=1.1u as=0.2592p ps=2.16u w=0.36u l=0.28u
X967 a_52354_3448# PC12.t10 a_52250_3448# VDD pfet_03v3 ad=86.39999f pd=0.96u as=86.39999f ps=0.96u w=0.72u l=0.28u
X968 a_53248_2618# a_50329_2616# VSS VSS nfet_03v3 ad=0.108p pd=0.96u as=0.1728p ps=1.68u w=0.36u l=0.28u
X969 a_64173_2618# a_63869_2618# VSS VSS nfet_03v3 ad=0.108p pd=0.96u as=0.1728p ps=1.68u w=0.36u l=0.28u
X970 a_29164_2616# CLK.t81 VSS VSS nfet_03v3 ad=0.2016p pd=1.84u as=0.1584p ps=1.6u w=0.36u l=0.28u
X971 PC4.t3 a_18752_3118# VSS VSS nfet_03v3 ad=0.1728p pd=1.68u as=0.1728p ps=1.68u w=0.36u l=0.28u
X972 a_3070_3448# PC0.t10 a_1758_3632# VDD pfet_03v3 ad=0.1152p pd=1.04u as=0.1872p ps=1.24u w=0.72u l=0.28u
X973 a_26852_3448# a_26796_3404# VDD VDD pfet_03v3 ad=86.39999f pd=0.96u as=0.1872p ps=1.24u w=0.72u l=0.28u
X974 a_16826_3118# CLK.t82 VDD VDD pfet_03v3 ad=0.108p pd=0.96u as=0.1728p ps=1.68u w=0.36u l=0.28u
X975 a_6685_2618# a_3766_2616# VSS VSS nfet_03v3 ad=0.108p pd=0.96u as=0.1728p ps=1.68u w=0.36u l=0.28u
X976 VSS.t599 a_29172_5022# a_29956_5022.t29 VSS nfet_03v3 ad=0.108p pd=0.96u as=0.108p ps=0.96u w=0.36u l=0.28u
X977 VSS a_13937_3392# a_12629_4236# VSS nfet_03v3 ad=93.59999f pd=0.88u as=0.1584p ps=1.6u w=0.36u l=0.28u
X978 VDD RSTn.t54 a_31451_3118# VDD pfet_03v3 ad=0.108p pd=0.96u as=0.1728p ps=1.68u w=0.36u l=0.28u
X979 a_15041_4236# BR.t54 VDD.t201 VDD.t200 pfet_03v3 ad=0.4032p pd=2.56u as=0.3168p ps=2.32u w=0.72u l=0.28u
X980 a_54146_3448# a_52554_3632# VSS VSS nfet_03v3 ad=0.1584p pd=1.6u as=93.59999f ps=0.88u w=0.36u l=0.28u
X981 a_65053_3908# PC15.t8 a_64949_3908# VSS nfet_03v3 ad=43.2f pd=0.6u as=43.2f ps=0.6u w=0.36u l=0.28u
X982 VDD a_5631_3404# a_6055_3448# VDD pfet_03v3 ad=0.1872p pd=1.24u as=0.1872p ps=1.24u w=0.72u l=0.28u
X983 a_42224_3118# CLK.t83 VDD VDD pfet_03v3 ad=0.108p pd=0.96u as=0.1728p ps=1.68u w=0.36u l=0.28u
X984 PC3.t2 a_14519_3118# VDD VDD pfet_03v3 ad=0.3456p pd=2.4u as=0.3456p ps=2.4u w=0.72u l=0.28u
X985 a_29172_5022# DISP7.t4 VSS.t659 VSS nfet_03v3 ad=0.1728p pd=1.68u as=0.108p ps=0.96u w=0.36u l=0.28u
X986 DEST3.t1 a_12232_4236# a_12629_3400# VDD.t469 pfet_03v3 ad=0.18p pd=1.72u as=0.1332p ps=1.1u w=0.36u l=0.28u
X987 a_7583_3448# a_5991_3632# VSS VSS nfet_03v3 ad=0.1584p pd=1.6u as=93.59999f ps=0.88u w=0.36u l=0.28u
X988 a_44776_3908# a_43728_3404# VSS VSS nfet_03v3 ad=93.59999f pd=0.88u as=93.59999f ps=0.88u w=0.36u l=0.28u
X989 a_50866_2618# a_50723_2866# a_50690_3118# VDD pfet_03v3 ad=0.1728p pd=1.68u as=0.108p ps=0.96u w=0.36u l=0.28u
X990 a_58795_2616# CLK.t84 VDD VDD pfet_03v3 ad=0.4032p pd=2.56u as=0.3168p ps=2.32u w=0.72u l=0.28u
X991 a_9920_3448# a_9864_3404# VDD VDD pfet_03v3 ad=86.39999f pd=0.96u as=0.1872p ps=1.24u w=0.72u l=0.28u
X992 a_30309_2618# a_30005_2618# VSS VSS nfet_03v3 ad=0.108p pd=0.96u as=0.1728p ps=1.68u w=0.36u l=0.28u
X993 a_61604_4236# BR.t55 VSS VSS nfet_03v3 ad=0.2016p pd=1.84u as=0.1584p ps=1.6u w=0.36u l=0.28u
X994 a_47801_3392# a_45680_3448# a_48121_3908# VSS nfet_03v3 ad=93.59999f pd=0.88u as=43.2f ps=0.6u w=0.36u l=0.28u
X995 a_27218_3118# a_26883_2618# VDD VDD pfet_03v3 ad=0.1728p pd=1.68u as=0.108p ps=0.96u w=0.36u l=0.28u
X996 a_42260_3400# JMP.t51 a_42260_4236# VDD.t445 pfet_03v3 ad=0.1332p pd=1.1u as=0.4446p ps=3.19u w=0.36u l=0.28u
X997 VSS a_32981_3448# a_35686_3908# VSS nfet_03v3 ad=0.1584p pd=1.6u as=93.59999f ps=0.88u w=0.36u l=0.28u
X998 a_38471_2618# a_38167_2618# VDD VDD pfet_03v3 ad=0.1728p pd=1.68u as=0.1728p ps=1.68u w=0.36u l=0.28u
X999 VSS PC14.t10 a_61708_3908# VSS nfet_03v3 ad=93.59999f pd=0.88u as=0.1584p ps=1.6u w=0.36u l=0.28u
X1000 a_10912_3908# a_9864_3404# VSS VSS nfet_03v3 ad=93.59999f pd=0.88u as=93.59999f ps=0.88u w=0.36u l=0.28u
X1001 a_52768_2618# RSTn.t55 VSS VSS nfet_03v3 ad=0.108p pd=0.96u as=0.1728p ps=1.68u w=0.36u l=0.28u
X1002 a_54562_4236# JMP.t52 VDD.t447 VDD.t446 pfet_03v3 ad=0.4032p pd=2.56u as=0.3168p ps=2.32u w=0.72u l=0.28u
X1003 a_39919_3448# PC9.t10 VDD VDD pfet_03v3 ad=0.1872p pd=1.24u as=0.1872p ps=1.24u w=0.72u l=0.28u
X1004 a_45400_3448# PC10.t11 a_44088_3632# VDD pfet_03v3 ad=0.1152p pd=1.04u as=0.1872p ps=1.24u w=0.72u l=0.28u
X1005 PC13.t1 SE.t52 a_59189_2866# VSS nfet_03v3 ad=0.2592p pd=2.16u as=0.1332p ps=1.1u w=0.36u l=0.28u
X1006 a_29701_2618# CLK.t85 a_30157_3118# VSS nfet_03v3 ad=0.1728p pd=1.68u as=0.108p ps=0.96u w=0.36u l=0.28u
X1007 a_19274_4236# BR.t56 VSS VSS nfet_03v3 ad=0.2016p pd=1.84u as=0.1584p ps=1.6u w=0.36u l=0.28u
X1008 a_49015_2618# a_46096_2616# VSS VSS nfet_03v3 ad=0.108p pd=0.96u as=0.1728p ps=1.68u w=0.36u l=0.28u
X1009 a_63389_2618# a_63028_2616# VSS VSS nfet_03v3 ad=0.108p pd=0.96u as=0.1728p ps=1.68u w=0.36u l=0.28u
X1010 a_24931_2616# CLK.t86 VDD VDD pfet_03v3 ad=0.4032p pd=2.56u as=0.3168p ps=2.32u w=0.72u l=0.28u
X1011 a_37214_3448# a_35622_3632# VDD VDD pfet_03v3 ad=0.3168p pd=2.32u as=0.1872p ps=1.24u w=0.72u l=0.28u
X1012 VSS PC4.t11 a_19378_3908# VSS nfet_03v3 ad=93.59999f pd=0.88u as=0.1584p ps=1.6u w=0.36u l=0.28u
X1013 a_52618_3908# PC12.t11 VSS VSS nfet_03v3 ad=93.59999f pd=0.88u as=93.59999f ps=0.88u w=0.36u l=0.28u
X1014 VDD a_58379_3448# a_61084_3448# VDD pfet_03v3 ad=0.3168p pd=2.32u as=0.1872p ps=1.24u w=0.72u l=0.28u
X1015 VDD a_47961_3404# a_48385_3448# VDD pfet_03v3 ad=0.1872p pd=1.24u as=0.1872p ps=1.24u w=0.72u l=0.28u
X1016 a_29701_2618# a_29558_2866# a_29525_2618# VSS nfet_03v3 ad=0.1728p pd=1.68u as=0.108p ps=0.96u w=0.36u l=0.28u
X1017 VDD a_34238_2618# a_34390_3118# VDD pfet_03v3 ad=0.108p pd=0.96u as=0.1728p ps=1.68u w=0.36u l=0.28u
X1018 a_1454_3448# a_1398_3404# VDD VDD pfet_03v3 ad=86.39999f pd=0.96u as=0.1872p ps=1.24u w=0.72u l=0.28u
X1019 a_29558_2866# a_29164_3400# a_29561_3400# VSS nfet_03v3 ad=0.1332p pd=1.1u as=0.3654p ps=2.75u w=0.36u l=0.28u
X1020 a_35262_3404# BR.t57 VSS VDD.t202 pfet_03v3 ad=0.1332p pd=1.1u as=0.2592p ps=2.16u w=0.36u l=0.28u
X1021 VDD a_26636_3392# a_25328_4236# VDD pfet_03v3 ad=0.1872p pd=1.24u as=0.3168p ps=2.32u w=0.72u l=0.28u
X1022 a_49913_3448# a_48321_3632# VSS VSS nfet_03v3 ad=0.1584p pd=1.6u as=93.59999f ps=0.88u w=0.36u l=0.28u
X1023 a_48048_2618# a_48383_3118# a_49015_3118# VDD pfet_03v3 ad=0.1728p pd=1.68u as=0.108p ps=0.96u w=0.36u l=0.28u
X1024 a_11536_3448# PC2.t10 a_10224_3632# VDD pfet_03v3 ad=0.1152p pd=1.04u as=0.1872p ps=1.24u w=0.72u l=0.28u
X1025 a_20698_4236# JMP.t53 VDD.t449 VDD.t448 pfet_03v3 ad=0.4032p pd=2.56u as=0.3168p ps=2.32u w=0.72u l=0.28u
X1026 PC5.t0 SE.t53 a_25325_2866# VSS nfet_03v3 ad=0.2592p pd=2.16u as=0.1332p ps=1.1u w=0.36u l=0.28u
X1027 a_63028_2616# CLK.t87 VSS VSS nfet_03v3 ad=0.2016p pd=1.84u as=0.1584p ps=1.6u w=0.36u l=0.28u
X1028 a_7999_2616# CLK.t88 VDD VDD pfet_03v3 ad=0.4032p pd=2.56u as=0.3168p ps=2.32u w=0.72u l=0.28u
X1029 a_29956_5022.t2 a_31973_4236# a_31029_3404# VDD.t187 pfet_03v3 ad=0.3654p pd=2.75u as=0.1332p ps=1.1u w=0.36u l=0.28u
X1030 VDD RSTn.t56 a_56849_3118# VDD pfet_03v3 ad=0.108p pd=0.96u as=0.1728p ps=1.68u w=0.36u l=0.28u
X1031 a_33934_2618# a_33397_2616# a_34390_3118# VDD pfet_03v3 ad=0.1728p pd=1.68u as=0.108p ps=0.96u w=0.36u l=0.28u
X1032 a_14257_3908# PC3.t11 a_14153_3908# VSS nfet_03v3 ad=43.2f pd=0.6u as=43.2f ps=0.6u w=0.36u l=0.28u
X1033 a_41863_3400# SE.t54 VSS VSS nfet_03v3 ad=0.2016p pd=1.84u as=0.1584p ps=1.6u w=0.36u l=0.28u
X1034 a_38024_2866# SE.t55 a_38027_3400# VDD pfet_03v3 ad=0.1332p pd=1.1u as=0.3654p ps=2.75u w=0.36u l=0.28u
X1035 a_18690_3632# a_16049_3448# a_19378_3448# VDD pfet_03v3 ad=0.1872p pd=1.24u as=0.1872p ps=1.24u w=0.72u l=0.28u
X1036 VDD a_52194_3404# a_53866_3448# VDD pfet_03v3 ad=0.1872p pd=1.24u as=0.1152p ps=1.04u w=0.72u l=0.28u
X1037 a_65317_3908# a_65253_3632# a_64733_3392# VSS nfet_03v3 ad=93.59999f pd=0.88u as=93.59999f ps=0.88u w=0.36u l=0.28u
X1038 a_10286_3118# a_9951_2618# a_10438_2618# VSS nfet_03v3 ad=0.1728p pd=1.68u as=0.108p ps=0.96u w=0.36u l=0.28u
X1039 DEST7.t0 JMP.t54 a_29561_3400# VSS nfet_03v3 ad=0.18p pd=1.72u as=0.1332p ps=1.1u w=0.36u l=0.28u
X1040 a_16049_3448# a_14457_3632# VSS VSS nfet_03v3 ad=0.1584p pd=1.6u as=93.59999f ps=0.88u w=0.36u l=0.28u
X1041 a_14184_2618# a_14519_3118# a_15151_3118# VDD pfet_03v3 ad=0.1728p pd=1.68u as=0.108p ps=0.96u w=0.36u l=0.28u
X1042 DISP1.t1 BR.t58 a_5631_3404# VSS nfet_03v3 ad=0.3654p pd=2.75u as=0.1332p ps=1.1u w=0.36u l=0.28u
X1043 a_59192_3400# a_58795_4236# a_59192_4236# VSS nfet_03v3 ad=0.1332p pd=1.1u as=0.4446p ps=3.19u w=0.36u l=0.28u
X1044 a_n467_3400# SE.t56 VDD VDD pfet_03v3 ad=0.4032p pd=2.56u as=0.3168p ps=2.32u w=0.72u l=0.28u
X1045 VDD a_9704_3392# a_8396_4236# VDD pfet_03v3 ad=0.1872p pd=1.24u as=0.3168p ps=2.32u w=0.72u l=0.28u
X1046 PC7.t3 a_33397_3400# a_33791_2866# VDD pfet_03v3 ad=0.2592p pd=2.16u as=0.1332p ps=1.1u w=0.36u l=0.28u
X1047 a_55707_2618# a_55403_2618# VSS VSS nfet_03v3 ad=0.108p pd=0.96u as=0.1728p ps=1.68u w=0.36u l=0.28u
X1048 a_3766_4236# JMP.t55 VDD.t740 VDD.t739 pfet_03v3 ad=0.4032p pd=2.56u as=0.3168p ps=2.32u w=0.72u l=0.28u
X1049 PC1.t0 SE.t57 a_8393_2866# VSS nfet_03v3 ad=0.2592p pd=2.16u as=0.1332p ps=1.1u w=0.36u l=0.28u
X1050 a_1820_3118# a_1485_2618# VDD VDD pfet_03v3 ad=0.1728p pd=1.68u as=0.108p ps=0.96u w=0.36u l=0.28u
X1051 a_21235_2618# a_21092_2866# a_21059_2618# VSS nfet_03v3 ad=0.1728p pd=1.68u as=0.108p ps=0.96u w=0.36u l=0.28u
X1052 DEST13.t0 JMP.t56 a_54959_3400# VSS nfet_03v3 ad=0.18p pd=1.72u as=0.1332p ps=1.1u w=0.36u l=0.28u
X1053 a_64980_2618# a_63028_2616# a_63869_2618# VDD pfet_03v3 ad=0.1728p pd=1.68u as=0.1728p ps=1.68u w=0.36u l=0.28u
X1054 a_51170_2618# a_50866_2618# VSS VSS nfet_03v3 ad=0.1728p pd=1.68u as=0.1728p ps=1.68u w=0.36u l=0.28u
X1055 a_8840_2618# a_8536_2618# VSS VSS nfet_03v3 ad=0.1728p pd=1.68u as=0.1728p ps=1.68u w=0.36u l=0.28u
X1056 VSS PC2.t11 a_10912_3908# VSS nfet_03v3 ad=93.59999f pd=0.88u as=0.1584p ps=1.6u w=0.36u l=0.28u
X1057 VDD a_39495_3404# a_39919_3448# VDD pfet_03v3 ad=0.1872p pd=1.24u as=0.1872p ps=1.24u w=0.72u l=0.28u
X1058 a_65317_3448# PC15.t9 VDD VDD pfet_03v3 ad=0.1872p pd=1.24u as=0.1872p ps=1.24u w=0.72u l=0.28u
X1059 a_25328_3400# a_24931_4236# a_25328_4236# VSS nfet_03v3 ad=0.1332p pd=1.1u as=0.4446p ps=3.19u w=0.36u l=0.28u
X1060 VSS a_30869_3392# a_29561_4236# VSS nfet_03v3 ad=93.59999f pd=0.88u as=0.1584p ps=1.6u w=0.36u l=0.28u
X1061 a_4303_2618# a_4160_2866# a_4127_2618# VSS nfet_03v3 ad=0.1728p pd=1.68u as=0.108p ps=0.96u w=0.36u l=0.28u
X1062 a_4160_2866# a_3766_3400# a_4163_3400# VSS nfet_03v3 ad=0.1332p pd=1.1u as=0.3654p ps=2.75u w=0.36u l=0.28u
X1063 VSS a_52194_3404# a_52618_3908# VSS nfet_03v3 ad=93.59999f pd=0.88u as=93.59999f ps=0.88u w=0.36u l=0.28u
X1064 a_48385_3448# a_48321_3632# a_47801_3392# VDD pfet_03v3 ad=0.1872p pd=1.24u as=0.1872p ps=1.24u w=0.72u l=0.28u
X1065 PC15.t1 a_65315_3118# VSS VSS nfet_03v3 ad=0.1728p pd=1.68u as=0.1728p ps=1.68u w=0.36u l=0.28u
X1066 DEST5.t1 JMP.t57 a_21095_3400# VSS nfet_03v3 ad=0.18p pd=1.72u as=0.1332p ps=1.1u w=0.36u l=0.28u
X1067 VDD a_59636_2618# a_59788_3118# VDD pfet_03v3 ad=0.108p pd=0.96u as=0.1728p ps=1.68u w=0.36u l=0.28u
X1068 VDD a_1238_3392# a_n70_4236# VDD pfet_03v3 ad=0.1872p pd=1.24u as=0.3168p ps=2.32u w=0.72u l=0.28u
X1069 a_61708_3448# a_60660_3404# VDD VDD pfet_03v3 ad=0.1872p pd=1.24u as=0.1872p ps=1.24u w=0.72u l=0.28u
X1070 a_12232_2616# CLK.t89 VSS VSS nfet_03v3 ad=0.2016p pd=1.84u as=0.1584p ps=1.6u w=0.36u l=0.28u
X1071 a_44782_3118# CLK.t90 VDD VDD pfet_03v3 ad=0.108p pd=0.96u as=0.1728p ps=1.68u w=0.36u l=0.28u
X1072 a_29956_5022.t17 BR.t59 a_47961_3404# VSS nfet_03v3 ad=0.3654p pd=2.75u as=0.1332p ps=1.1u w=0.36u l=0.28u
X1073 a_10224_3632# a_7583_3448# a_10912_3448# VDD pfet_03v3 ad=0.1872p pd=1.24u as=0.1872p ps=1.24u w=0.72u l=0.28u
X1074 a_39655_3908# PC9.t11 a_39551_3908# VSS nfet_03v3 ad=43.2f pd=0.6u as=43.2f ps=0.6u w=0.36u l=0.28u
X1075 a_13225_3118# RSTn.t57 a_13377_2618# VSS nfet_03v3 ad=0.108p pd=0.96u as=0.108p ps=0.96u w=0.36u l=0.28u
X1076 a_8396_3400# a_7999_4236# a_8396_4236# VSS nfet_03v3 ad=0.1332p pd=1.1u as=0.4446p ps=3.19u w=0.36u l=0.28u
X1077 VSS a_49913_3448# a_52618_3908# VSS nfet_03v3 ad=0.1584p pd=1.6u as=93.59999f ps=0.88u w=0.36u l=0.28u
X1078 a_55403_2618# a_55099_2618# VDD VDD pfet_03v3 ad=0.1728p pd=1.68u as=0.1728p ps=1.68u w=0.36u l=0.28u
X1079 a_25468_2618# a_25325_2866# a_25292_3118# VDD pfet_03v3 ad=0.1728p pd=1.68u as=0.108p ps=0.96u w=0.36u l=0.28u
X1080 a_28748_3448# a_27156_3632# VDD VDD pfet_03v3 ad=0.3168p pd=2.32u as=0.1872p ps=1.24u w=0.72u l=0.28u
X1081 a_14521_3448# a_14457_3632# a_13937_3392# VDD pfet_03v3 ad=0.1872p pd=1.24u as=0.1872p ps=1.24u w=0.72u l=0.28u
X1082 a_19378_3448# a_18330_3404# VDD VDD pfet_03v3 ad=0.1872p pd=1.24u as=0.1872p ps=1.24u w=0.72u l=0.28u
X1083 a_62332_3448# PC14.t11 a_61020_3632# VDD pfet_03v3 ad=0.1152p pd=1.04u as=0.1872p ps=1.24u w=0.72u l=0.28u
X1084 DEST1.t0 JMP.t58 a_4163_3400# VSS nfet_03v3 ad=0.18p pd=1.72u as=0.1332p ps=1.1u w=0.36u l=0.28u
X1085 VSS a_18170_3392# a_16862_4236# VSS nfet_03v3 ad=93.59999f pd=0.88u as=0.1584p ps=1.6u w=0.36u l=0.28u
X1086 a_64733_3392# a_62612_3448# a_65053_3908# VSS nfet_03v3 ad=93.59999f pd=0.88u as=43.2f ps=0.6u w=0.36u l=0.28u
X1087 VSS a_14097_3404# a_15769_3908# VSS nfet_03v3 ad=93.59999f pd=0.88u as=57.59999f ps=0.68u w=0.36u l=0.28u
X1088 a_35684_3118# a_35349_2618# a_35836_2618# VSS nfet_03v3 ad=0.1728p pd=1.68u as=0.108p ps=0.96u w=0.36u l=0.28u
X1089 a_14184_2618# a_12232_2616# a_13073_2618# VDD pfet_03v3 ad=0.1728p pd=1.68u as=0.1728p ps=1.68u w=0.36u l=0.28u
X1090 a_16862_3400# JMP.t59 a_16862_4236# VDD.t741 pfet_03v3 ad=0.1332p pd=1.1u as=0.4446p ps=3.19u w=0.36u l=0.28u
X1091 DISP3.t0 BR.t60 a_14097_3404# VSS nfet_03v3 ad=0.3654p pd=2.75u as=0.1332p ps=1.1u w=0.36u l=0.28u
X1092 a_10918_3118# CLK.t91 VDD VDD pfet_03v3 ad=0.108p pd=0.96u as=0.1728p ps=1.68u w=0.36u l=0.28u
X1093 VSS PC8.t11 a_36310_3908# VSS nfet_03v3 ad=93.59999f pd=0.88u as=0.1584p ps=1.6u w=0.36u l=0.28u
X1094 PC13.t0 a_58795_3400# a_59189_2866# VDD pfet_03v3 ad=0.2592p pd=2.16u as=0.1332p ps=1.1u w=0.36u l=0.28u
X1095 a_46633_2618# a_46490_2866# a_46457_2618# VSS nfet_03v3 ad=0.1728p pd=1.68u as=0.108p ps=0.96u w=0.36u l=0.28u
X1096 VDD.t652 a_29172_5022# a_29956_5022.t18 VDD.t439 pfet_03v3 ad=0.216p pd=1.32u as=0.216p ps=1.32u w=0.72u l=0.28u
X1097 a_21539_2618# a_21235_2618# VDD VDD pfet_03v3 ad=0.1728p pd=1.68u as=0.1728p ps=1.68u w=0.36u l=0.28u
X1098 a_66845_3448# a_65253_3632# VSS VSS nfet_03v3 ad=0.1584p pd=1.6u as=93.59999f ps=0.88u w=0.36u l=0.28u
X1099 a_64980_2618# a_65315_3118# a_65947_3118# VDD pfet_03v3 ad=0.1728p pd=1.68u as=0.108p ps=0.96u w=0.36u l=0.28u
X1100 a_27370_2618# RSTn.t58 VSS VSS nfet_03v3 ad=0.108p pd=0.96u as=0.1728p ps=1.68u w=0.36u l=0.28u
X1101 a_29164_4236# JMP.t60 VDD.t377 VDD.t376 pfet_03v3 ad=0.4032p pd=2.56u as=0.3168p ps=2.32u w=0.72u l=0.28u
X1102 a_52194_3404# BR.t61 VSS VDD.t731 pfet_03v3 ad=0.1332p pd=1.1u as=0.2592p ps=2.16u w=0.36u l=0.28u
X1103 VDD a_43568_3392# a_42260_4236# VDD pfet_03v3 ad=0.1872p pd=1.24u as=0.3168p ps=2.32u w=0.72u l=0.28u
X1104 DEST0.t0 a_n467_4236# a_n70_3400# VDD.t119 pfet_03v3 ad=0.18p pd=1.72u as=0.1332p ps=1.1u w=0.36u l=0.28u
X1105 a_43728_3404# a_44672_4236# VSS VSS nfet_03v3 ad=0.1332p pd=1.1u as=0.2592p ps=2.16u w=0.36u l=0.28u
X1106 a_29558_2866# SE.t58 a_29561_3400# VDD pfet_03v3 ad=0.1332p pd=1.1u as=0.3654p ps=2.75u w=0.36u l=0.28u
X1107 PC9.t3 SE.t59 a_42257_2866# VSS nfet_03v3 ad=0.2592p pd=2.16u as=0.1332p ps=1.1u w=0.36u l=0.28u
X1108 VDD a_64893_3404# a_65317_3448# VDD pfet_03v3 ad=0.1872p pd=1.24u as=0.1872p ps=1.24u w=0.72u l=0.28u
X1109 a_27220_3908# PC6.t11 VSS VSS nfet_03v3 ad=93.59999f pd=0.88u as=93.59999f ps=0.88u w=0.36u l=0.28u
X1110 PC5.t1 a_24931_3400# a_25325_2866# VDD pfet_03v3 ad=0.2592p pd=2.16u as=0.1332p ps=1.1u w=0.36u l=0.28u
X1111 a_17458_3118# RSTn.t59 VDD VDD pfet_03v3 ad=0.108p pd=0.96u as=0.108p ps=0.96u w=0.36u l=0.28u
X1112 a_31189_3908# PC7.t11 a_31085_3908# VSS nfet_03v3 ad=43.2f pd=0.6u as=43.2f ps=0.6u w=0.36u l=0.28u
X1113 a_4607_2618# a_4303_2618# VDD VDD pfet_03v3 ad=0.1728p pd=1.68u as=0.1728p ps=1.68u w=0.36u l=0.28u
X1114 VSS a_45680_3448# a_48385_3908# VSS nfet_03v3 ad=0.1584p pd=1.6u as=93.59999f ps=0.88u w=0.36u l=0.28u
X1115 DEST11.t0 JMP.t61 a_46493_3400# VSS nfet_03v3 ad=0.18p pd=1.72u as=0.1332p ps=1.1u w=0.36u l=0.28u
X1116 a_41863_3400# SE.t60 VDD VDD pfet_03v3 ad=0.4032p pd=2.56u as=0.3168p ps=2.32u w=0.72u l=0.28u
X1117 a_37630_2616# CLK.t92 VSS VSS nfet_03v3 ad=0.2016p pd=1.84u as=0.1584p ps=1.6u w=0.36u l=0.28u
X1118 a_42856_3118# RSTn.t60 VDD VDD pfet_03v3 ad=0.108p pd=0.96u as=0.108p ps=0.96u w=0.36u l=0.28u
X1119 a_23611_3908# a_22563_3404# VSS VSS nfet_03v3 ad=93.59999f pd=0.88u as=93.59999f ps=0.88u w=0.36u l=0.28u
X1120 a_31085_3908# a_31029_3404# VSS VSS nfet_03v3 ad=43.2f pd=0.6u as=93.59999f ps=0.88u w=0.36u l=0.28u
X1121 a_3350_3448# a_1758_3632# VDD VDD pfet_03v3 ad=0.3168p pd=2.32u as=0.1872p ps=1.24u w=0.72u l=0.28u
X1122 a_16465_3400# SE.t61 VSS VSS nfet_03v3 ad=0.2016p pd=1.84u as=0.1584p ps=1.6u w=0.36u l=0.28u
X1123 a_38623_3118# RSTn.t61 a_38775_2618# VSS nfet_03v3 ad=0.108p pd=0.96u as=0.108p ps=0.96u w=0.36u l=0.28u
X1124 VDD a_26796_3404# a_28468_3448# VDD pfet_03v3 ad=0.1872p pd=1.24u as=0.1152p ps=1.04u w=0.72u l=0.28u
X1125 PC1.t3 a_7999_3400# a_8393_2866# VDD pfet_03v3 ad=0.2592p pd=2.16u as=0.1332p ps=1.1u w=0.36u l=0.28u
X1126 a_22650_2618# a_22985_3118# a_23617_2618# VSS nfet_03v3 ad=0.1728p pd=1.68u as=0.108p ps=0.96u w=0.36u l=0.28u
X1127 a_13937_3392# a_11816_3448# a_14257_3448# VDD pfet_03v3 ad=0.1872p pd=1.24u as=86.39999f ps=0.96u w=0.72u l=0.28u
X1128 a_39919_3448# a_39855_3632# a_39335_3392# VDD pfet_03v3 ad=0.1872p pd=1.24u as=0.1872p ps=1.24u w=0.72u l=0.28u
X1129 a_53242_3908# a_52194_3404# VSS VSS nfet_03v3 ad=93.59999f pd=0.88u as=93.59999f ps=0.88u w=0.36u l=0.28u
X1130 a_61020_3632# a_58379_3448# a_61708_3448# VDD pfet_03v3 ad=0.1872p pd=1.24u as=0.1872p ps=1.24u w=0.72u l=0.28u
X1131 a_29956_5022.t28 a_29172_5022# VSS.t598 VSS nfet_03v3 ad=0.108p pd=0.96u as=0.108p ps=0.96u w=0.36u l=0.28u
X1132 VSS a_11816_3448# a_14521_3908# VSS nfet_03v3 ad=0.1584p pd=1.6u as=93.59999f ps=0.88u w=0.36u l=0.28u
X1133 a_24235_3908# PC5.t11 a_22923_3632# VSS nfet_03v3 ad=57.59999f pd=0.68u as=93.59999f ps=0.88u w=0.36u l=0.28u
X1134 VDD PC11.t11 a_49009_3448# VDD pfet_03v3 ad=0.1872p pd=1.24u as=0.3168p ps=2.32u w=0.72u l=0.28u
X1135 a_1398_3404# BR.t62 VSS VDD.t411 pfet_03v3 ad=0.1332p pd=1.1u as=0.2592p ps=2.16u w=0.36u l=0.28u
X1136 a_1822_3908# a_1758_3632# a_1238_3392# VSS nfet_03v3 ad=93.59999f pd=0.88u as=93.59999f ps=0.88u w=0.36u l=0.28u
X1137 a_6679_3908# a_5631_3404# VSS VSS nfet_03v3 ad=93.59999f pd=0.88u as=93.59999f ps=0.88u w=0.36u l=0.28u
X1138 a_46096_3400# SE.t62 VSS VSS nfet_03v3 ad=0.2016p pd=1.84u as=0.1584p ps=1.6u w=0.36u l=0.28u
X1139 a_38167_2618# a_37630_2616# a_38623_3118# VDD pfet_03v3 ad=0.1728p pd=1.68u as=0.108p ps=0.96u w=0.36u l=0.28u
X1140 a_60716_3448# a_60660_3404# VDD VDD pfet_03v3 ad=86.39999f pd=0.96u as=0.1872p ps=1.24u w=0.72u l=0.28u
X1141 a_39582_2618# a_37630_2616# a_38471_2618# VDD pfet_03v3 ad=0.1728p pd=1.68u as=0.1728p ps=1.68u w=0.36u l=0.28u
X1142 VSS.t660 DISP7.t5 a_29172_5022# VSS nfet_03v3 ad=0.108p pd=0.96u as=0.108p ps=0.96u w=0.36u l=0.28u
X1143 a_n70_3400# a_n467_4236# a_n70_4236# VSS nfet_03v3 ad=0.1332p pd=1.1u as=0.4446p ps=3.19u w=0.36u l=0.28u
X1144 a_50726_3400# JMP.t62 a_50726_4236# VDD.t378 pfet_03v3 ad=0.1332p pd=1.1u as=0.4446p ps=3.19u w=0.36u l=0.28u
X1145 VSS a_64893_3404# a_66565_3908# VSS nfet_03v3 ad=93.59999f pd=0.88u as=57.59999f ps=0.68u w=0.36u l=0.28u
X1146 a_46937_2618# a_46633_2618# VDD VDD pfet_03v3 ad=0.1728p pd=1.68u as=0.1728p ps=1.68u w=0.36u l=0.28u
X1147 a_5718_2618# a_6053_3118# a_6685_2618# VSS nfet_03v3 ad=0.1728p pd=1.68u as=0.108p ps=0.96u w=0.36u l=0.28u
X1148 a_29956_5022.t27 a_29172_5022# VSS.t597 VSS nfet_03v3 ad=0.108p pd=0.96u as=0.108p ps=0.96u w=0.36u l=0.28u
X1149 a_4160_2866# SE.t63 a_4163_3400# VDD pfet_03v3 ad=0.1332p pd=1.1u as=0.3654p ps=2.75u w=0.36u l=0.28u
X1150 a_61714_3118# CLK.t93 VDD VDD pfet_03v3 ad=0.108p pd=0.96u as=0.1728p ps=1.68u w=0.36u l=0.28u
X1151 a_31451_3118# a_31116_2618# VDD VDD pfet_03v3 ad=0.1728p pd=1.68u as=0.108p ps=0.96u w=0.36u l=0.28u
X1152 a_1822_3908# PC0.t11 VSS VSS nfet_03v3 ad=93.59999f pd=0.88u as=93.59999f ps=0.88u w=0.36u l=0.28u
X1153 a_7303_3908# PC1.t11 a_5991_3632# VSS nfet_03v3 ad=57.59999f pd=0.68u as=93.59999f ps=0.88u w=0.36u l=0.28u
X1154 a_63028_4236# JMP.t63 VDD.t380 VDD.t379 pfet_03v3 ad=0.4032p pd=2.56u as=0.3168p ps=2.32u w=0.72u l=0.28u
X1155 a_18386_3448# a_18330_3404# VDD VDD pfet_03v3 ad=86.39999f pd=0.96u as=0.1872p ps=1.24u w=0.72u l=0.28u
X1156 VDD a_18330_3404# a_20002_3448# VDD pfet_03v3 ad=0.1872p pd=1.24u as=0.1152p ps=1.04u w=0.72u l=0.28u
X1157 VSS a_26796_3404# a_27220_3908# VSS nfet_03v3 ad=93.59999f pd=0.88u as=93.59999f ps=0.88u w=0.36u l=0.28u
X1158 a_27740_4236# BR.t63 VSS VSS nfet_03v3 ad=0.2016p pd=1.84u as=0.1584p ps=1.6u w=0.36u l=0.28u
X1159 a_42400_2618# a_42257_2866# a_42224_3118# VDD pfet_03v3 ad=0.1728p pd=1.68u as=0.108p ps=0.96u w=0.36u l=0.28u
X1160 a_39855_3632# a_37214_3448# a_40543_3908# VSS nfet_03v3 ad=93.59999f pd=0.88u as=93.59999f ps=0.88u w=0.36u l=0.28u
X1161 a_31453_3448# a_31389_3632# a_30869_3392# VDD pfet_03v3 ad=0.1872p pd=1.24u as=0.1872p ps=1.24u w=0.72u l=0.28u
X1162 a_36310_3448# a_35262_3404# VDD VDD pfet_03v3 ad=0.1872p pd=1.24u as=0.1872p ps=1.24u w=0.72u l=0.28u
X1163 a_56587_3908# PC13.t11 a_56483_3908# VSS nfet_03v3 ad=43.2f pd=0.6u as=43.2f ps=0.6u w=0.36u l=0.28u
X1164 a_70_2618# a_n73_2866# a_n106_3118# VDD pfet_03v3 ad=0.1728p pd=1.68u as=0.108p ps=0.96u w=0.36u l=0.28u
X1165 VSS a_31029_3404# a_32701_3908# VSS nfet_03v3 ad=93.59999f pd=0.88u as=57.59999f ps=0.68u w=0.36u l=0.28u
X1166 a_19384_3118# CLK.t94 VDD VDD pfet_03v3 ad=0.108p pd=0.96u as=0.1728p ps=1.68u w=0.36u l=0.28u
X1167 PC0.t2 a_1820_3118# VSS VSS nfet_03v3 ad=0.1728p pd=1.68u as=0.1728p ps=1.68u w=0.36u l=0.28u
X1168 VDD RSTn.t62 a_6053_3118# VDD pfet_03v3 ad=0.108p pd=0.96u as=0.1728p ps=1.68u w=0.36u l=0.28u
X1169 a_52616_3118# a_52281_2618# a_52768_2618# VSS nfet_03v3 ad=0.1728p pd=1.68u as=0.108p ps=0.96u w=0.36u l=0.28u
X1170 a_33791_2866# a_33397_3400# a_33794_3400# VSS nfet_03v3 ad=0.1332p pd=1.1u as=0.3654p ps=2.75u w=0.36u l=0.28u
X1171 a_56483_3908# a_56427_3404# VSS VSS nfet_03v3 ad=43.2f pd=0.6u as=93.59999f ps=0.88u w=0.36u l=0.28u
X1172 VDD a_1398_3404# a_3070_3448# VDD pfet_03v3 ad=0.1872p pd=1.24u as=0.1152p ps=1.04u w=0.72u l=0.28u
X1173 VDD a_24515_3448# a_27220_3448# VDD pfet_03v3 ad=0.3168p pd=2.32u as=0.1872p ps=1.24u w=0.72u l=0.28u
X1174 a_44302_2618# RSTn.t63 VSS VSS nfet_03v3 ad=0.108p pd=0.96u as=0.1728p ps=1.68u w=0.36u l=0.28u
X1175 a_21235_2618# CLK.t95 a_21691_3118# VSS nfet_03v3 ad=0.1728p pd=1.68u as=0.108p ps=0.96u w=0.36u l=0.28u
R0 VSS VSS.t658 11.8465
R1 VSS.n8 VSS.t603 11.6823
R2 VSS.n5 VSS.n4 6.69554
R3 VSS.n9 VSS.n0 6.43229
R4 VSS.n7 VSS.n1 6.43229
R5 VSS.n6 VSS.n2 6.43229
R6 VSS.n5 VSS.n3 6.43229
R7 VSS.n0 VSS.t659 5.2505
R8 VSS.n0 VSS.t660 5.2505
R9 VSS.n1 VSS.t598 5.2505
R10 VSS.n1 VSS.t600 5.2505
R11 VSS.n2 VSS.t597 5.2505
R12 VSS.n2 VSS.t599 5.2505
R13 VSS.n3 VSS.t605 5.2505
R14 VSS.n3 VSS.t604 5.2505
R15 VSS.n4 VSS.t602 5.2505
R16 VSS.n4 VSS.t601 5.2505
R17 VSS.n9 VSS.n8 0.3245
R18 VSS.n7 VSS.n6 0.26525
R19 VSS.n8 VSS.n7 0.2645
R20 VSS.n6 VSS.n5 0.26375
R21 VSS VSS.n9 0.10025
R22 VDD.t41 VDD.t527 5094.39
R23 VDD.t309 VDD.t72 5094.39
R24 VDD.t329 VDD.t124 5094.39
R25 VDD.t200 VDD.t469 5094.39
R26 VDD.t627 VDD.t224 5094.39
R27 VDD.t409 VDD.t414 5094.39
R28 VDD.t197 VDD.t119 5094.39
R29 VDD.t231 VDD.t351 5094.39
R30 VDD.t630 VDD.t4 5094.39
R31 VDD.t604 VDD.t470 5094.39
R32 VDD.t407 VDD.t152 5094.39
R33 VDD.t46 VDD.t250 5094.39
R34 VDD.t625 VDD.t34 5094.39
R35 VDD.t312 VDD.t251 5094.39
R36 VDD.t729 VDD.t585 5094.39
R37 VDD.t134 VDD.t7 1846.94
R38 VDD.t684 VDD.t566 1846.94
R39 VDD.t136 VDD.t354 1846.94
R40 VDD.t131 VDD.t204 1846.94
R41 VDD.t401 VDD.t51 1846.94
R42 VDD.t682 VDD.t203 1846.94
R43 VDD.t399 VDD.t187 1846.94
R44 VDD.t551 VDD.t134 1551.02
R45 VDD.t398 VDD.t448 1551.02
R46 VDD.t741 VDD.t684 1551.02
R47 VDD.t133 VDD.t548 1551.02
R48 VDD.t360 VDD.t136 1551.02
R49 VDD.t395 VDD.t739 1551.02
R50 VDD.t361 VDD.t680 1551.02
R51 VDD.t379 VDD.t451 1551.02
R52 VDD.t550 VDD.t131 1551.02
R53 VDD.t397 VDD.t446 1551.02
R54 VDD.t378 VDD.t401 1551.02
R55 VDD.t396 VDD.t686 1551.02
R56 VDD.t445 VDD.t682 1551.02
R57 VDD.t387 VDD.t358 1551.02
R58 VDD.t450 VDD.t399 1551.02
R59 VDD.t355 VDD.t41 1265.31
R60 VDD.t624 VDD.t309 1265.31
R61 VDD.t45 VDD.t329 1265.31
R62 VDD.t199 VDD.t200 1265.31
R63 VDD.t48 VDD.t627 1265.31
R64 VDD.t43 VDD.t409 1265.31
R65 VDD.t411 VDD.t197 1265.31
R66 VDD.t351 VDD.t726 1265.31
R67 VDD.t350 VDD.t630 1265.31
R68 VDD.t331 VDD.t604 1265.31
R69 VDD.t731 VDD.t407 1265.31
R70 VDD.t196 VDD.t46 1265.31
R71 VDD.t311 VDD.t625 1265.31
R72 VDD.t320 VDD.t312 1265.31
R73 VDD.t202 VDD.t729 1265.31
R74 VDD.t629 VDD.t727 1265.31
R75 VDD.n4 VDD.t392 1081.63
R76 VDD.n3 VDD.t738 1081.63
R77 VDD.n2 VDD.t679 1081.63
R78 VDD.n0 VDD.t120 1081.63
R79 VDD.n14 VDD.t438 1081.63
R80 VDD.n13 VDD.t123 1081.63
R81 VDD.n12 VDD.t468 1081.63
R82 VDD.n11 VDD.t433 1081.63
R83 VDD.t727 VDD.n10 1002.55
R84 VDD.t448 VDD.n3 765.307
R85 VDD.t548 VDD.n2 765.307
R86 VDD.t739 VDD.n0 765.307
R87 VDD.n14 VDD.t379 765.307
R88 VDD.t446 VDD.n13 765.307
R89 VDD.t686 VDD.n12 765.307
R90 VDD.t358 VDD.n11 765.307
R91 VDD.t392 VDD.t355 520.409
R92 VDD.t527 VDD.t551 520.409
R93 VDD.t7 VDD.t624 520.409
R94 VDD.t72 VDD.t398 520.409
R95 VDD.t738 VDD.t45 520.409
R96 VDD.t124 VDD.t741 520.409
R97 VDD.t566 VDD.t199 520.409
R98 VDD.t469 VDD.t133 520.409
R99 VDD.t679 VDD.t48 520.409
R100 VDD.t224 VDD.t360 520.409
R101 VDD.t354 VDD.t43 520.409
R102 VDD.t414 VDD.t395 520.409
R103 VDD.t120 VDD.t411 520.409
R104 VDD.t119 VDD.t361 520.409
R105 VDD.t726 VDD.t221 520.409
R106 VDD.t451 VDD.t231 520.409
R107 VDD.t438 VDD.t350 520.409
R108 VDD.t4 VDD.t550 520.409
R109 VDD.t204 VDD.t331 520.409
R110 VDD.t470 VDD.t397 520.409
R111 VDD.t123 VDD.t731 520.409
R112 VDD.t152 VDD.t378 520.409
R113 VDD.t51 VDD.t196 520.409
R114 VDD.t250 VDD.t396 520.409
R115 VDD.t468 VDD.t311 520.409
R116 VDD.t34 VDD.t445 520.409
R117 VDD.t203 VDD.t320 520.409
R118 VDD.t251 VDD.t387 520.409
R119 VDD.t433 VDD.t202 520.409
R120 VDD.t585 VDD.t450 520.409
R121 VDD.t187 VDD.t629 520.409
R122 VDD.n10 VDD.n4 234.695
R123 VDD.t276 VDD.t439 121.189
R124 VDD.n1 VDD.t353 16.706
R125 VDD.n1 VDD.t44 15.7005
R126 VDD.t376 VDD.t276 13.72
R127 VDD.n31 VDD.n11 12.757
R128 VDD.n26 VDD.n12 12.757
R129 VDD.n21 VDD.n13 12.757
R130 VDD.n58 VDD.n0 12.757
R131 VDD.n52 VDD.n2 12.757
R132 VDD.n47 VDD.n3 12.757
R133 VDD.n42 VDD.n4 12.757
R134 VDD.n16 VDD.n14 12.757
R135 VDD.n15 VDD.t352 9.99155
R136 VDD.n39 VDD.t660 8.30681
R137 VDD.n41 VDD.t473 8.30681
R138 VDD VDD.t681 8.04755
R139 VDD.n41 VDD.t377 7.8848
R140 VDD.n59 VDD.t198 7.8848
R141 VDD.n57 VDD.t740 7.8848
R142 VDD.n56 VDD.t410 7.8848
R143 VDD.n54 VDD.t137 7.8848
R144 VDD.n53 VDD.t628 7.8848
R145 VDD.n51 VDD.t549 7.8848
R146 VDD.n50 VDD.t201 7.8848
R147 VDD.n49 VDD.t685 7.8848
R148 VDD.n48 VDD.t330 7.8848
R149 VDD.n46 VDD.t449 7.8848
R150 VDD.n45 VDD.t310 7.8848
R151 VDD.n44 VDD.t135 7.8848
R152 VDD.n43 VDD.t42 7.8848
R153 VDD.n34 VDD.t728 7.8848
R154 VDD.n33 VDD.t400 7.8848
R155 VDD.n32 VDD.t730 7.8848
R156 VDD.n30 VDD.t359 7.8848
R157 VDD.n29 VDD.t313 7.8848
R158 VDD.n28 VDD.t683 7.8848
R159 VDD.n27 VDD.t626 7.8848
R160 VDD.n25 VDD.t687 7.8848
R161 VDD.n24 VDD.t47 7.8848
R162 VDD.n23 VDD.t402 7.8848
R163 VDD.n22 VDD.t408 7.8848
R164 VDD.n20 VDD.t447 7.8848
R165 VDD.n19 VDD.t605 7.8848
R166 VDD.n18 VDD.t132 7.8848
R167 VDD.n17 VDD.t631 7.8848
R168 VDD.n15 VDD.t380 7.8848
R169 VDD.n10 VDD.t376 7.62245
R170 VDD.n35 VDD.n9 5.39014
R171 VDD.n36 VDD.n8 5.39014
R172 VDD.n37 VDD.n7 5.39014
R173 VDD.n38 VDD.n6 5.39014
R174 VDD.n40 VDD.n5 5.39014
R175 VDD.n9 VDD.t659 2.91717
R176 VDD.n9 VDD.t658 2.91717
R177 VDD.n8 VDD.t653 2.91717
R178 VDD.n8 VDD.t652 2.91717
R179 VDD.n7 VDD.t654 2.91717
R180 VDD.n7 VDD.t656 2.91717
R181 VDD.n6 VDD.t655 2.91717
R182 VDD.n6 VDD.t657 2.91717
R183 VDD.n5 VDD.t526 2.91717
R184 VDD.n5 VDD.t440 2.91717
R185 VDD.n18 VDD.n17 2.10725
R186 VDD.n20 VDD.n19 2.10725
R187 VDD.n23 VDD.n22 2.10725
R188 VDD.n25 VDD.n24 2.10725
R189 VDD.n28 VDD.n27 2.10725
R190 VDD.n30 VDD.n29 2.10725
R191 VDD.n33 VDD.n32 2.10725
R192 VDD.n44 VDD.n43 2.10725
R193 VDD.n46 VDD.n45 2.10725
R194 VDD.n49 VDD.n48 2.10725
R195 VDD.n51 VDD.n50 2.10725
R196 VDD.n54 VDD.n53 2.10725
R197 VDD.n57 VDD.n56 2.10725
R198 VDD VDD.n59 1.9445
R199 VDD.n19 VDD.n18 1.0685
R200 VDD.n24 VDD.n23 1.0685
R201 VDD.n29 VDD.n28 1.0685
R202 VDD.n34 VDD.n33 1.0685
R203 VDD.n45 VDD.n44 1.0685
R204 VDD.n50 VDD.n49 1.0685
R205 VDD.n17 VDD.n16 0.9035
R206 VDD.n22 VDD.n21 0.9035
R207 VDD.n27 VDD.n26 0.9035
R208 VDD.n32 VDD.n31 0.9035
R209 VDD.n43 VDD.n42 0.9035
R210 VDD.n48 VDD.n47 0.9035
R211 VDD.n53 VDD.n52 0.9035
R212 VDD.n59 VDD.n58 0.9035
R213 VDD.n55 VDD.n54 0.7385
R214 VDD.n35 VDD.n34 0.46325
R215 VDD.n56 VDD.n55 0.3305
R216 VDD.n40 VDD.n39 0.32375
R217 VDD.n39 VDD.n38 0.26525
R218 VDD.n41 VDD.n40 0.26525
R219 VDD.n36 VDD.n35 0.2645
R220 VDD.n37 VDD.n36 0.2645
R221 VDD.n38 VDD.n37 0.26375
R222 VDD.n16 VDD.n15 0.1655
R223 VDD.n21 VDD.n20 0.1655
R224 VDD.n26 VDD.n25 0.1655
R225 VDD.n31 VDD.n30 0.1655
R226 VDD.n42 VDD.n41 0.1655
R227 VDD.n47 VDD.n46 0.1655
R228 VDD.n52 VDD.n51 0.1655
R229 VDD.n58 VDD.n57 0.1655
R230 VDD.n55 VDD.n1 0.12647
R231 PC12.n1 PC12.t10 130.792
R232 PC12.t9 PC12.n2 109.704
R233 PC12.n2 PC12.n1 79.4894
R234 PC12.t10 PC12.t8 55.2719
R235 PC12.t5 PC12.t11 55.2719
R236 PC12.t6 PC12.t4 55.2719
R237 PC12.n3 PC12.t9 30.3125
R238 PC12.n1 PC12.t5 23.7255
R239 PC12.n2 PC12.t6 23.7255
R240 PC12.n3 PC12.t7 20.1446
R241 PC12.n0 PC12.t3 16.7578
R242 PC12.n4 PC12.n0 16.5026
R243 PC12.n0 PC12.t2 15.7505
R244 PC12.n4 PC12.n3 12.5069
R245 PC12 PC12.t1 11.7847
R246 PC12.n5 PC12.t0 8.44265
R247 PC12.n5 PC12.n4 5.92282
R248 PC12 PC12.n5 0.0572123
R249 PC11.n1 PC11.t8 130.792
R250 PC11.t7 PC11.n2 109.704
R251 PC11.n2 PC11.n1 79.4894
R252 PC11.t8 PC11.t5 55.2719
R253 PC11.t9 PC11.t6 55.2719
R254 PC11.t11 PC11.t10 55.2719
R255 PC11.n3 PC11.t7 30.3125
R256 PC11.n1 PC11.t9 23.7255
R257 PC11.n2 PC11.t11 23.7255
R258 PC11.n3 PC11.t4 20.1446
R259 PC11.n0 PC11.t2 16.7578
R260 PC11.n4 PC11.n0 16.5026
R261 PC11.n0 PC11.t3 15.7505
R262 PC11.n4 PC11.n3 12.5069
R263 PC11 PC11.t1 11.7872
R264 PC11.n5 PC11.t0 8.44265
R265 PC11.n5 PC11.n4 5.92282
R266 PC11 PC11.n5 0.0547466
R267 RSTn.n61 RSTn.t13 38.1247
R268 RSTn.n57 RSTn.t43 38.1247
R269 RSTn.n53 RSTn.t10 38.1247
R270 RSTn.n49 RSTn.t27 38.1247
R271 RSTn.n45 RSTn.t59 38.1247
R272 RSTn.n41 RSTn.t22 38.1247
R273 RSTn.n37 RSTn.t9 38.1247
R274 RSTn.n33 RSTn.t17 38.1247
R275 RSTn.n29 RSTn.t0 38.1247
R276 RSTn.n25 RSTn.t32 38.1247
R277 RSTn.n21 RSTn.t60 38.1247
R278 RSTn.n17 RSTn.t45 38.1247
R279 RSTn.n13 RSTn.t6 38.1247
R280 RSTn.n9 RSTn.t20 38.1247
R281 RSTn.n5 RSTn.t19 38.1247
R282 RSTn.n1 RSTn.t50 38.1247
R283 RSTn.n59 RSTn.t12 35.7783
R284 RSTn.n55 RSTn.t62 35.7783
R285 RSTn.n51 RSTn.t36 35.7783
R286 RSTn.n47 RSTn.t52 35.7783
R287 RSTn.n43 RSTn.t18 35.7783
R288 RSTn.n39 RSTn.t15 35.7783
R289 RSTn.n35 RSTn.t29 35.7783
R290 RSTn.n31 RSTn.t54 35.7783
R291 RSTn.n27 RSTn.t38 35.7783
R292 RSTn.n23 RSTn.t3 35.7783
R293 RSTn.n19 RSTn.t34 35.7783
R294 RSTn.n15 RSTn.t2 35.7783
R295 RSTn.n11 RSTn.t24 35.7783
R296 RSTn.n7 RSTn.t56 35.7783
R297 RSTn.n3 RSTn.t39 35.7783
R298 RSTn.n0 RSTn.t7 35.7783
R299 RSTn.n59 RSTn.t42 25.8711
R300 RSTn.n55 RSTn.t28 25.8711
R301 RSTn.n51 RSTn.t1 25.8711
R302 RSTn.n47 RSTn.t16 25.8711
R303 RSTn.n43 RSTn.t48 25.8711
R304 RSTn.n39 RSTn.t46 25.8711
R305 RSTn.n35 RSTn.t58 25.8711
R306 RSTn.n31 RSTn.t21 25.8711
R307 RSTn.n27 RSTn.t4 25.8711
R308 RSTn.n23 RSTn.t33 25.8711
R309 RSTn.n19 RSTn.t63 25.8711
R310 RSTn.n15 RSTn.t31 25.8711
R311 RSTn.n11 RSTn.t55 25.8711
R312 RSTn.n7 RSTn.t23 25.8711
R313 RSTn.n3 RSTn.t5 25.8711
R314 RSTn.n0 RSTn.t37 25.8711
R315 RSTn.n61 RSTn.t44 23.5247
R316 RSTn.n57 RSTn.t8 23.5247
R317 RSTn.n53 RSTn.t41 23.5247
R318 RSTn.n49 RSTn.t57 23.5247
R319 RSTn.n45 RSTn.t25 23.5247
R320 RSTn.n41 RSTn.t53 23.5247
R321 RSTn.n37 RSTn.t40 23.5247
R322 RSTn.n33 RSTn.t47 23.5247
R323 RSTn.n29 RSTn.t30 23.5247
R324 RSTn.n25 RSTn.t61 23.5247
R325 RSTn.n21 RSTn.t26 23.5247
R326 RSTn.n17 RSTn.t11 23.5247
R327 RSTn.n13 RSTn.t35 23.5247
R328 RSTn.n9 RSTn.t51 23.5247
R329 RSTn.n5 RSTn.t49 23.5247
R330 RSTn.n1 RSTn.t14 23.5247
R331 RSTn.n2 RSTn.n0 18.9496
R332 RSTn.n62 RSTn.n61 17.1722
R333 RSTn.n58 RSTn.n57 17.1722
R334 RSTn.n54 RSTn.n53 17.1722
R335 RSTn.n50 RSTn.n49 17.1722
R336 RSTn.n46 RSTn.n45 17.1722
R337 RSTn.n42 RSTn.n41 17.1722
R338 RSTn.n38 RSTn.n37 17.1722
R339 RSTn.n34 RSTn.n33 17.1722
R340 RSTn.n30 RSTn.n29 17.1722
R341 RSTn.n26 RSTn.n25 17.1722
R342 RSTn.n22 RSTn.n21 17.1722
R343 RSTn.n18 RSTn.n17 17.1722
R344 RSTn.n14 RSTn.n13 17.1722
R345 RSTn.n10 RSTn.n9 17.1722
R346 RSTn.n6 RSTn.n5 17.1722
R347 RSTn.n2 RSTn.n1 17.1722
R348 RSTn.n60 RSTn.n59 17.1448
R349 RSTn.n56 RSTn.n55 17.1448
R350 RSTn.n52 RSTn.n51 17.1448
R351 RSTn.n48 RSTn.n47 17.1448
R352 RSTn.n44 RSTn.n43 17.1448
R353 RSTn.n40 RSTn.n39 17.1448
R354 RSTn.n36 RSTn.n35 17.1448
R355 RSTn.n32 RSTn.n31 17.1448
R356 RSTn.n28 RSTn.n27 17.1448
R357 RSTn.n24 RSTn.n23 17.1448
R358 RSTn.n20 RSTn.n19 17.1448
R359 RSTn.n16 RSTn.n15 17.1448
R360 RSTn.n12 RSTn.n11 17.1448
R361 RSTn.n8 RSTn.n7 17.1448
R362 RSTn.n4 RSTn.n3 17.1448
R363 RSTn.n4 RSTn.n2 4.99871
R364 RSTn.n8 RSTn.n6 4.99871
R365 RSTn.n12 RSTn.n10 4.99871
R366 RSTn.n16 RSTn.n14 4.99871
R367 RSTn.n20 RSTn.n18 4.99871
R368 RSTn.n24 RSTn.n22 4.99871
R369 RSTn.n28 RSTn.n26 4.99871
R370 RSTn.n32 RSTn.n30 4.99871
R371 RSTn.n36 RSTn.n34 4.99871
R372 RSTn.n40 RSTn.n38 4.99871
R373 RSTn.n44 RSTn.n42 4.99871
R374 RSTn.n48 RSTn.n46 4.99871
R375 RSTn.n52 RSTn.n50 4.99871
R376 RSTn.n56 RSTn.n54 4.99871
R377 RSTn.n60 RSTn.n58 4.99871
R378 RSTn RSTn.n62 2.363
R379 RSTn.n6 RSTn.n4 1.80532
R380 RSTn.n10 RSTn.n8 1.80532
R381 RSTn.n14 RSTn.n12 1.80532
R382 RSTn.n18 RSTn.n16 1.80532
R383 RSTn.n22 RSTn.n20 1.80532
R384 RSTn.n26 RSTn.n24 1.80532
R385 RSTn.n30 RSTn.n28 1.80532
R386 RSTn.n34 RSTn.n32 1.80532
R387 RSTn.n38 RSTn.n36 1.80532
R388 RSTn.n42 RSTn.n40 1.80532
R389 RSTn.n46 RSTn.n44 1.80532
R390 RSTn.n50 RSTn.n48 1.80532
R391 RSTn.n54 RSTn.n52 1.80532
R392 RSTn.n58 RSTn.n56 1.80532
R393 RSTn.n62 RSTn.n60 1.80532
R394 PC9.n1 PC9.t5 130.792
R395 PC9.t7 PC9.n2 109.704
R396 PC9.n2 PC9.n1 79.4894
R397 PC9.t5 PC9.t11 55.2719
R398 PC9.t10 PC9.t8 55.2719
R399 PC9.t9 PC9.t6 55.2719
R400 PC9.n3 PC9.t7 30.3125
R401 PC9.n1 PC9.t10 23.7255
R402 PC9.n2 PC9.t9 23.7255
R403 PC9.n3 PC9.t4 20.1446
R404 PC9.n0 PC9.t0 16.7578
R405 PC9.n4 PC9.n0 16.5026
R406 PC9.n0 PC9.t3 15.7505
R407 PC9.n4 PC9.n3 12.5069
R408 PC9.n5 PC9.t2 11.8415
R409 PC9 PC9.t1 8.3884
R410 PC9.n5 PC9.n4 5.92282
R411 PC9 PC9.n5 0.0547466
R412 CLK.n90 CLK.t75 46.3331
R413 CLK.n84 CLK.t49 46.3331
R414 CLK.n78 CLK.t1 46.3331
R415 CLK.n72 CLK.t37 46.3331
R416 CLK.n66 CLK.t15 46.3331
R417 CLK.n60 CLK.t47 46.3331
R418 CLK.n54 CLK.t68 46.3331
R419 CLK.n48 CLK.t65 46.3331
R420 CLK.n42 CLK.t20 46.3331
R421 CLK.n36 CLK.t42 46.3331
R422 CLK.n30 CLK.t80 46.3331
R423 CLK.n24 CLK.t51 46.3331
R424 CLK.n18 CLK.t0 46.3331
R425 CLK.n12 CLK.t46 46.3331
R426 CLK.n6 CLK.t12 46.3331
R427 CLK.n0 CLK.t32 46.3331
R428 CLK.n91 CLK.t79 42.1907
R429 CLK.n85 CLK.t3 42.1907
R430 CLK.n79 CLK.t71 42.1907
R431 CLK.n73 CLK.t6 42.1907
R432 CLK.n67 CLK.t27 42.1907
R433 CLK.n61 CLK.t95 42.1907
R434 CLK.n55 CLK.t67 42.1907
R435 CLK.n49 CLK.t85 42.1907
R436 CLK.n43 CLK.t31 42.1907
R437 CLK.n37 CLK.t41 42.1907
R438 CLK.n31 CLK.t52 42.1907
R439 CLK.n25 CLK.t5 42.1907
R440 CLK.n19 CLK.t61 42.1907
R441 CLK.n13 CLK.t21 42.1907
R442 CLK.n7 CLK.t58 42.1907
R443 CLK.n1 CLK.t10 42.1907
R444 CLK.n0 CLK.t66 37.6724
R445 CLK.n92 CLK.t23 36.2629
R446 CLK.n89 CLK.t16 36.2629
R447 CLK.n86 CLK.t54 36.2629
R448 CLK.n83 CLK.t35 36.2629
R449 CLK.n80 CLK.t78 36.2629
R450 CLK.n77 CLK.t91 36.2629
R451 CLK.n74 CLK.t9 36.2629
R452 CLK.n71 CLK.t70 36.2629
R453 CLK.n68 CLK.t82 36.2629
R454 CLK.n65 CLK.t94 36.2629
R455 CLK.n62 CLK.t28 36.2629
R456 CLK.n59 CLK.t59 36.2629
R457 CLK.n56 CLK.t76 36.2629
R458 CLK.n53 CLK.t11 36.2629
R459 CLK.n50 CLK.t25 36.2629
R460 CLK.n47 CLK.t55 36.2629
R461 CLK.n44 CLK.t60 36.2629
R462 CLK.n41 CLK.t29 36.2629
R463 CLK.n38 CLK.t14 36.2629
R464 CLK.n35 CLK.t63 36.2629
R465 CLK.n32 CLK.t83 36.2629
R466 CLK.n29 CLK.t90 36.2629
R467 CLK.n26 CLK.t30 36.2629
R468 CLK.n23 CLK.t40 36.2629
R469 CLK.n20 CLK.t64 36.2629
R470 CLK.n17 CLK.t34 36.2629
R471 CLK.n14 CLK.t19 36.2629
R472 CLK.n11 CLK.t56 36.2629
R473 CLK.n8 CLK.t4 36.2629
R474 CLK.n5 CLK.t93 36.2629
R475 CLK.n2 CLK.t39 36.2629
R476 CLK.n93 CLK.t2 35.7184
R477 CLK.n87 CLK.t77 35.7184
R478 CLK.n81 CLK.t26 35.7184
R479 CLK.n75 CLK.t89 35.7184
R480 CLK.n69 CLK.t17 35.7184
R481 CLK.n63 CLK.t74 35.7184
R482 CLK.n57 CLK.t24 35.7184
R483 CLK.n51 CLK.t81 35.7184
R484 CLK.n45 CLK.t44 35.7184
R485 CLK.n39 CLK.t92 35.7184
R486 CLK.n33 CLK.t8 35.7184
R487 CLK.n27 CLK.t18 35.7184
R488 CLK.n21 CLK.t50 35.7184
R489 CLK.n15 CLK.t73 35.7184
R490 CLK.n9 CLK.t22 35.7184
R491 CLK.n3 CLK.t87 35.7184
R492 CLK.n93 CLK.t57 23.2041
R493 CLK.n87 CLK.t38 23.2041
R494 CLK.n81 CLK.t88 23.2041
R495 CLK.n75 CLK.t48 23.2041
R496 CLK.n69 CLK.t69 23.2041
R497 CLK.n63 CLK.t36 23.2041
R498 CLK.n57 CLK.t86 23.2041
R499 CLK.n51 CLK.t43 23.2041
R500 CLK.n45 CLK.t7 23.2041
R501 CLK.n39 CLK.t53 23.2041
R502 CLK.n33 CLK.t62 23.2041
R503 CLK.n27 CLK.t72 23.2041
R504 CLK.n21 CLK.t13 23.2041
R505 CLK.n15 CLK.t33 23.2041
R506 CLK.n9 CLK.t84 23.2041
R507 CLK.n3 CLK.t45 23.2041
R508 CLK.n94 CLK.n93 17.2223
R509 CLK.n88 CLK.n87 17.2223
R510 CLK.n82 CLK.n81 17.2223
R511 CLK.n76 CLK.n75 17.2223
R512 CLK.n70 CLK.n69 17.2223
R513 CLK.n64 CLK.n63 17.2223
R514 CLK.n58 CLK.n57 17.2223
R515 CLK.n52 CLK.n51 17.2223
R516 CLK.n46 CLK.n45 17.2223
R517 CLK.n40 CLK.n39 17.2223
R518 CLK.n34 CLK.n33 17.2223
R519 CLK.n28 CLK.n27 17.2223
R520 CLK.n22 CLK.n21 17.2223
R521 CLK.n16 CLK.n15 17.2223
R522 CLK.n10 CLK.n9 17.2223
R523 CLK.n4 CLK.n3 17.2223
R524 CLK.n5 CLK.n4 2.19264
R525 CLK.n11 CLK.n10 2.19264
R526 CLK.n17 CLK.n16 2.19264
R527 CLK.n23 CLK.n22 2.19264
R528 CLK.n29 CLK.n28 2.19264
R529 CLK.n35 CLK.n34 2.19264
R530 CLK.n41 CLK.n40 2.19264
R531 CLK.n47 CLK.n46 2.19264
R532 CLK.n53 CLK.n52 2.19264
R533 CLK.n59 CLK.n58 2.19264
R534 CLK.n65 CLK.n64 2.19264
R535 CLK.n71 CLK.n70 2.19264
R536 CLK.n77 CLK.n76 2.19264
R537 CLK.n83 CLK.n82 2.19264
R538 CLK.n89 CLK.n88 2.19264
R539 CLK.n2 CLK.n1 1.91943
R540 CLK.n8 CLK.n7 1.91943
R541 CLK.n14 CLK.n13 1.91943
R542 CLK.n20 CLK.n19 1.91943
R543 CLK.n26 CLK.n25 1.91943
R544 CLK.n32 CLK.n31 1.91943
R545 CLK.n38 CLK.n37 1.91943
R546 CLK.n44 CLK.n43 1.91943
R547 CLK.n50 CLK.n49 1.91943
R548 CLK.n56 CLK.n55 1.91943
R549 CLK.n62 CLK.n61 1.91943
R550 CLK.n68 CLK.n67 1.91943
R551 CLK.n74 CLK.n73 1.91943
R552 CLK.n80 CLK.n79 1.91943
R553 CLK.n86 CLK.n85 1.91943
R554 CLK.n92 CLK.n91 1.91943
R555 CLK.n6 CLK.n5 1.40996
R556 CLK.n12 CLK.n11 1.40996
R557 CLK.n18 CLK.n17 1.40996
R558 CLK.n24 CLK.n23 1.40996
R559 CLK.n30 CLK.n29 1.40996
R560 CLK.n36 CLK.n35 1.40996
R561 CLK.n42 CLK.n41 1.40996
R562 CLK.n48 CLK.n47 1.40996
R563 CLK.n54 CLK.n53 1.40996
R564 CLK.n60 CLK.n59 1.40996
R565 CLK.n66 CLK.n65 1.40996
R566 CLK.n72 CLK.n71 1.40996
R567 CLK.n78 CLK.n77 1.40996
R568 CLK.n84 CLK.n83 1.40996
R569 CLK.n90 CLK.n89 1.40996
R570 CLK.n1 CLK.n0 0.783179
R571 CLK.n7 CLK.n6 0.783179
R572 CLK.n13 CLK.n12 0.783179
R573 CLK.n19 CLK.n18 0.783179
R574 CLK.n25 CLK.n24 0.783179
R575 CLK.n31 CLK.n30 0.783179
R576 CLK.n37 CLK.n36 0.783179
R577 CLK.n43 CLK.n42 0.783179
R578 CLK.n49 CLK.n48 0.783179
R579 CLK.n55 CLK.n54 0.783179
R580 CLK.n61 CLK.n60 0.783179
R581 CLK.n67 CLK.n66 0.783179
R582 CLK.n73 CLK.n72 0.783179
R583 CLK.n79 CLK.n78 0.783179
R584 CLK.n85 CLK.n84 0.783179
R585 CLK.n91 CLK.n90 0.783179
R586 CLK.n4 CLK.n2 0.500321
R587 CLK.n10 CLK.n8 0.500321
R588 CLK.n16 CLK.n14 0.500321
R589 CLK.n22 CLK.n20 0.500321
R590 CLK.n28 CLK.n26 0.500321
R591 CLK.n34 CLK.n32 0.500321
R592 CLK.n40 CLK.n38 0.500321
R593 CLK.n46 CLK.n44 0.500321
R594 CLK.n52 CLK.n50 0.500321
R595 CLK.n58 CLK.n56 0.500321
R596 CLK.n64 CLK.n62 0.500321
R597 CLK.n70 CLK.n68 0.500321
R598 CLK.n76 CLK.n74 0.500321
R599 CLK.n82 CLK.n80 0.500321
R600 CLK.n88 CLK.n86 0.500321
R601 CLK.n94 CLK.n92 0.500321
R602 CLK CLK.n94 0.260857
R603 JMP.n59 JMP.t48 63.412
R604 JMP.n55 JMP.t58 63.412
R605 JMP.n51 JMP.t27 63.412
R606 JMP.n47 JMP.t45 63.412
R607 JMP.n43 JMP.t31 63.412
R608 JMP.n39 JMP.t57 63.412
R609 JMP.n35 JMP.t26 63.412
R610 JMP.n31 JMP.t54 63.412
R611 JMP.n27 JMP.t36 63.412
R612 JMP.n23 JMP.t8 63.412
R613 JMP.n19 JMP.t12 63.412
R614 JMP.n15 JMP.t61 63.412
R615 JMP.n11 JMP.t42 63.412
R616 JMP.n7 JMP.t56 63.412
R617 JMP.n3 JMP.t39 63.412
R618 JMP.n0 JMP.t0 63.412
R619 JMP.n61 JMP.t34 35.7184
R620 JMP.n57 JMP.t20 35.7184
R621 JMP.n53 JMP.t50 35.7184
R622 JMP.n49 JMP.t29 35.7184
R623 JMP.n45 JMP.t43 35.7184
R624 JMP.n41 JMP.t18 35.7184
R625 JMP.n37 JMP.t49 35.7184
R626 JMP.n33 JMP.t25 35.7184
R627 JMP.n29 JMP.t2 35.7184
R628 JMP.n25 JMP.t30 35.7184
R629 JMP.n21 JMP.t37 35.7184
R630 JMP.n17 JMP.t44 35.7184
R631 JMP.n13 JMP.t7 35.7184
R632 JMP.n9 JMP.t16 35.7184
R633 JMP.n5 JMP.t47 35.7184
R634 JMP.n1 JMP.t28 35.7184
R635 JMP.n59 JMP.t9 27.8969
R636 JMP.n55 JMP.t17 27.8969
R637 JMP.n51 JMP.t6 27.8969
R638 JMP.n47 JMP.t22 27.8969
R639 JMP.n43 JMP.t59 27.8969
R640 JMP.n39 JMP.t33 27.8969
R641 JMP.n35 JMP.t4 27.8969
R642 JMP.n31 JMP.t15 27.8969
R643 JMP.n27 JMP.t40 27.8969
R644 JMP.n23 JMP.t46 27.8969
R645 JMP.n19 JMP.t51 27.8969
R646 JMP.n15 JMP.t19 27.8969
R647 JMP.n11 JMP.t62 27.8969
R648 JMP.n7 JMP.t32 27.8969
R649 JMP.n3 JMP.t3 27.8969
R650 JMP.n0 JMP.t41 27.8969
R651 JMP.n61 JMP.t10 23.2041
R652 JMP.n57 JMP.t55 23.2041
R653 JMP.n53 JMP.t24 23.2041
R654 JMP.n49 JMP.t1 23.2041
R655 JMP.n45 JMP.t13 23.2041
R656 JMP.n41 JMP.t53 23.2041
R657 JMP.n37 JMP.t23 23.2041
R658 JMP.n33 JMP.t60 23.2041
R659 JMP.n29 JMP.t35 23.2041
R660 JMP.n25 JMP.t5 23.2041
R661 JMP.n21 JMP.t11 23.2041
R662 JMP.n17 JMP.t14 23.2041
R663 JMP.n13 JMP.t38 23.2041
R664 JMP.n9 JMP.t52 23.2041
R665 JMP.n5 JMP.t21 23.2041
R666 JMP.n1 JMP.t63 23.2041
R667 JMP.n2 JMP.n0 18.3815
R668 JMP.n60 JMP.n59 17.2758
R669 JMP.n56 JMP.n55 17.2758
R670 JMP.n52 JMP.n51 17.2758
R671 JMP.n48 JMP.n47 17.2758
R672 JMP.n44 JMP.n43 17.2758
R673 JMP.n40 JMP.n39 17.2758
R674 JMP.n36 JMP.n35 17.2758
R675 JMP.n32 JMP.n31 17.2758
R676 JMP.n28 JMP.n27 17.2758
R677 JMP.n24 JMP.n23 17.2758
R678 JMP.n20 JMP.n19 17.2758
R679 JMP.n16 JMP.n15 17.2758
R680 JMP.n12 JMP.n11 17.2758
R681 JMP.n8 JMP.n7 17.2758
R682 JMP.n4 JMP.n3 17.2758
R683 JMP.n62 JMP.n61 17.1805
R684 JMP.n58 JMP.n57 17.1805
R685 JMP.n54 JMP.n53 17.1805
R686 JMP.n50 JMP.n49 17.1805
R687 JMP.n46 JMP.n45 17.1805
R688 JMP.n42 JMP.n41 17.1805
R689 JMP.n38 JMP.n37 17.1805
R690 JMP.n34 JMP.n33 17.1805
R691 JMP.n30 JMP.n29 17.1805
R692 JMP.n26 JMP.n25 17.1805
R693 JMP.n22 JMP.n21 17.1805
R694 JMP.n18 JMP.n17 17.1805
R695 JMP.n14 JMP.n13 17.1805
R696 JMP.n10 JMP.n9 17.1805
R697 JMP.n6 JMP.n5 17.1805
R698 JMP.n2 JMP.n1 17.1805
R699 JMP.n4 JMP.n2 5.69782
R700 JMP.n8 JMP.n6 5.69782
R701 JMP.n12 JMP.n10 5.69782
R702 JMP.n16 JMP.n14 5.69782
R703 JMP.n20 JMP.n18 5.69782
R704 JMP.n24 JMP.n22 5.69782
R705 JMP.n28 JMP.n26 5.69782
R706 JMP.n32 JMP.n30 5.69782
R707 JMP.n36 JMP.n34 5.69782
R708 JMP.n40 JMP.n38 5.69782
R709 JMP.n44 JMP.n42 5.69782
R710 JMP.n48 JMP.n46 5.69782
R711 JMP.n52 JMP.n50 5.69782
R712 JMP.n56 JMP.n54 5.69782
R713 JMP.n60 JMP.n58 5.69782
R714 JMP.n6 JMP.n4 1.10621
R715 JMP.n10 JMP.n8 1.10621
R716 JMP.n14 JMP.n12 1.10621
R717 JMP.n18 JMP.n16 1.10621
R718 JMP.n22 JMP.n20 1.10621
R719 JMP.n26 JMP.n24 1.10621
R720 JMP.n30 JMP.n28 1.10621
R721 JMP.n34 JMP.n32 1.10621
R722 JMP.n38 JMP.n36 1.10621
R723 JMP.n42 JMP.n40 1.10621
R724 JMP.n46 JMP.n44 1.10621
R725 JMP.n50 JMP.n48 1.10621
R726 JMP.n54 JMP.n52 1.10621
R727 JMP.n58 JMP.n56 1.10621
R728 JMP.n62 JMP.n60 1.10621
R729 JMP JMP.n62 0.294607
R730 DEST15.n0 DEST15.t0 12.856
R731 DEST15.n0 DEST15.t1 11.4227
R732 DEST15 DEST15.n0 5.99514
R733 SE.n59 SE.t19 42.6755
R734 SE.n55 SE.t24 42.6755
R735 SE.n51 SE.t57 42.6755
R736 SE.n47 SE.t13 42.6755
R737 SE.n43 SE.t0 42.6755
R738 SE.n39 SE.t23 42.6755
R739 SE.n35 SE.t53 42.6755
R740 SE.n31 SE.t22 42.6755
R741 SE.n27 SE.t50 42.6755
R742 SE.n23 SE.t30 42.6755
R743 SE.n19 SE.t59 42.6755
R744 SE.n15 SE.t12 42.6755
R745 SE.n11 SE.t10 42.6755
R746 SE.n7 SE.t34 42.6755
R747 SE.n3 SE.t52 42.6755
R748 SE.n0 SE.t27 42.6755
R749 SE.n61 SE.t49 34.6755
R750 SE.n57 SE.t33 34.6755
R751 SE.n53 SE.t6 34.6755
R752 SE.n49 SE.t42 34.6755
R753 SE.n45 SE.t61 34.6755
R754 SE.n41 SE.t32 34.6755
R755 SE.n37 SE.t5 34.6755
R756 SE.n33 SE.t36 34.6755
R757 SE.n29 SE.t18 34.6755
R758 SE.n25 SE.t45 34.6755
R759 SE.n21 SE.t54 34.6755
R760 SE.n17 SE.t62 34.6755
R761 SE.n13 SE.t20 34.6755
R762 SE.n9 SE.t31 34.6755
R763 SE.n5 SE.t3 34.6755
R764 SE.n1 SE.t39 34.6755
R765 SE.n61 SE.t56 31.0255
R766 SE.n57 SE.t38 31.0255
R767 SE.n53 SE.t11 31.0255
R768 SE.n49 SE.t47 31.0255
R769 SE.n45 SE.t1 31.0255
R770 SE.n41 SE.t37 31.0255
R771 SE.n37 SE.t9 31.0255
R772 SE.n33 SE.t41 31.0255
R773 SE.n29 SE.t21 31.0255
R774 SE.n25 SE.t51 31.0255
R775 SE.n21 SE.t60 31.0255
R776 SE.n17 SE.t2 31.0255
R777 SE.n13 SE.t25 31.0255
R778 SE.n9 SE.t35 31.0255
R779 SE.n5 SE.t8 31.0255
R780 SE.n1 SE.t44 31.0255
R781 SE.n59 SE.t29 28.5138
R782 SE.n55 SE.t63 28.5138
R783 SE.n51 SE.t16 28.5138
R784 SE.n47 SE.t46 28.5138
R785 SE.n43 SE.t17 28.5138
R786 SE.n39 SE.t40 28.5138
R787 SE.n35 SE.t14 28.5138
R788 SE.n31 SE.t58 28.5138
R789 SE.n27 SE.t4 28.5138
R790 SE.n23 SE.t55 28.5138
R791 SE.n19 SE.t28 28.5138
R792 SE.n15 SE.t43 28.5138
R793 SE.n11 SE.t7 28.5138
R794 SE.n7 SE.t15 28.5138
R795 SE.n3 SE.t26 28.5138
R796 SE.n0 SE.t48 28.5138
R797 SE.n4 SE.n2 24.061
R798 SE.n8 SE.n6 24.061
R799 SE.n12 SE.n10 24.061
R800 SE.n16 SE.n14 24.061
R801 SE.n20 SE.n18 24.061
R802 SE.n24 SE.n22 24.061
R803 SE.n28 SE.n26 24.061
R804 SE.n32 SE.n30 24.061
R805 SE.n36 SE.n34 24.061
R806 SE.n40 SE.n38 24.061
R807 SE.n44 SE.n42 24.061
R808 SE.n48 SE.n46 24.061
R809 SE.n52 SE.n50 24.061
R810 SE.n56 SE.n54 24.061
R811 SE.n60 SE.n58 24.061
R812 SE.n62 SE.n61 17.0005
R813 SE.n58 SE.n57 17.0005
R814 SE.n54 SE.n53 17.0005
R815 SE.n50 SE.n49 17.0005
R816 SE.n46 SE.n45 17.0005
R817 SE.n42 SE.n41 17.0005
R818 SE.n38 SE.n37 17.0005
R819 SE.n34 SE.n33 17.0005
R820 SE.n30 SE.n29 17.0005
R821 SE.n26 SE.n25 17.0005
R822 SE.n22 SE.n21 17.0005
R823 SE.n18 SE.n17 17.0005
R824 SE.n14 SE.n13 17.0005
R825 SE.n10 SE.n9 17.0005
R826 SE.n6 SE.n5 17.0005
R827 SE.n2 SE.n1 17.0005
R828 SE.n2 SE.n0 10.3649
R829 SE.n60 SE.n59 9.05344
R830 SE.n56 SE.n55 9.05344
R831 SE.n52 SE.n51 9.05344
R832 SE.n48 SE.n47 9.05344
R833 SE.n44 SE.n43 9.05344
R834 SE.n40 SE.n39 9.05344
R835 SE.n36 SE.n35 9.05344
R836 SE.n32 SE.n31 9.05344
R837 SE.n28 SE.n27 9.05344
R838 SE.n24 SE.n23 9.05344
R839 SE.n20 SE.n19 9.05344
R840 SE.n16 SE.n15 9.05344
R841 SE.n12 SE.n11 9.05344
R842 SE.n8 SE.n7 9.05344
R843 SE.n4 SE.n3 9.05344
R844 SE.n6 SE.n4 1.31193
R845 SE.n10 SE.n8 1.31193
R846 SE.n14 SE.n12 1.31193
R847 SE.n18 SE.n16 1.31193
R848 SE.n22 SE.n20 1.31193
R849 SE.n26 SE.n24 1.31193
R850 SE.n30 SE.n28 1.31193
R851 SE.n34 SE.n32 1.31193
R852 SE.n38 SE.n36 1.31193
R853 SE.n42 SE.n40 1.31193
R854 SE.n46 SE.n44 1.31193
R855 SE.n50 SE.n48 1.31193
R856 SE.n54 SE.n52 1.31193
R857 SE.n58 SE.n56 1.31193
R858 SE.n62 SE.n60 1.31193
R859 SE SE.n62 0.309071
R860 PC3.n1 PC3.t5 130.792
R861 PC3.t4 PC3.n2 109.704
R862 PC3.n2 PC3.n1 79.4894
R863 PC3.t5 PC3.t11 55.2719
R864 PC3.t8 PC3.t6 55.2719
R865 PC3.t9 PC3.t7 55.2719
R866 PC3.n3 PC3.t4 30.3125
R867 PC3.n1 PC3.t8 23.7255
R868 PC3.n2 PC3.t9 23.7255
R869 PC3.n3 PC3.t10 20.1446
R870 PC3.n0 PC3.t0 16.7578
R871 PC3.n4 PC3.n0 16.5026
R872 PC3.n0 PC3.t1 15.7505
R873 PC3.n4 PC3.n3 12.5069
R874 PC3.n5 PC3.t3 11.8415
R875 PC3 PC3.t2 8.30456
R876 PC3.n5 PC3.n4 5.92282
R877 PC3 PC3.n5 0.138582
R878 BR.n59 BR.t62 36.0094
R879 BR.n55 BR.t35 36.0094
R880 BR.n51 BR.t53 36.0094
R881 BR.n47 BR.t40 36.0094
R882 BR.n43 BR.t51 36.0094
R883 BR.n39 BR.t11 36.0094
R884 BR.n35 BR.t18 36.0094
R885 BR.n31 BR.t24 36.0094
R886 BR.n27 BR.t57 36.0094
R887 BR.n23 BR.t15 36.0094
R888 BR.n19 BR.t3 36.0094
R889 BR.n15 BR.t38 36.0094
R890 BR.n11 BR.t61 36.0094
R891 BR.n7 BR.t28 36.0094
R892 BR.n3 BR.t8 36.0094
R893 BR.n0 BR.t43 36.0094
R894 BR.n61 BR.t0 35.7184
R895 BR.n57 BR.t17 35.7184
R896 BR.n53 BR.t50 35.7184
R897 BR.n49 BR.t20 35.7184
R898 BR.n45 BR.t56 35.7184
R899 BR.n41 BR.t33 35.7184
R900 BR.n37 BR.t63 35.7184
R901 BR.n33 BR.t4 35.7184
R902 BR.n29 BR.t12 35.7184
R903 BR.n25 BR.t37 35.7184
R904 BR.n21 BR.t47 35.7184
R905 BR.n17 BR.t19 35.7184
R906 BR.n13 BR.t16 35.7184
R907 BR.n9 BR.t30 35.7184
R908 BR.n5 BR.t55 35.7184
R909 BR.n1 BR.t41 35.7184
R910 BR.n59 BR.t21 28.4013
R911 BR.n55 BR.t58 28.4013
R912 BR.n51 BR.t29 28.4013
R913 BR.n47 BR.t60 28.4013
R914 BR.n43 BR.t10 28.4013
R915 BR.n39 BR.t7 28.4013
R916 BR.n35 BR.t42 28.4013
R917 BR.n31 BR.t46 28.4013
R918 BR.n27 BR.t31 28.4013
R919 BR.n23 BR.t13 28.4013
R920 BR.n19 BR.t27 28.4013
R921 BR.n15 BR.t59 28.4013
R922 BR.n11 BR.t36 28.4013
R923 BR.n7 BR.t6 28.4013
R924 BR.n3 BR.t32 28.4013
R925 BR.n0 BR.t14 28.4013
R926 BR.n61 BR.t39 23.2041
R927 BR.n57 BR.t49 23.2041
R928 BR.n53 BR.t23 23.2041
R929 BR.n49 BR.t54 23.2041
R930 BR.n45 BR.t26 23.2041
R931 BR.n41 BR.t2 23.2041
R932 BR.n37 BR.t34 23.2041
R933 BR.n33 BR.t44 23.2041
R934 BR.n29 BR.t45 23.2041
R935 BR.n25 BR.t5 23.2041
R936 BR.n21 BR.t22 23.2041
R937 BR.n17 BR.t52 23.2041
R938 BR.n13 BR.t48 23.2041
R939 BR.n9 BR.t1 23.2041
R940 BR.n5 BR.t25 23.2041
R941 BR.n1 BR.t9 23.2041
R942 BR.n62 BR.n61 17.0005
R943 BR.n58 BR.n57 17.0005
R944 BR.n54 BR.n53 17.0005
R945 BR.n50 BR.n49 17.0005
R946 BR.n46 BR.n45 17.0005
R947 BR.n42 BR.n41 17.0005
R948 BR.n38 BR.n37 17.0005
R949 BR.n34 BR.n33 17.0005
R950 BR.n30 BR.n29 17.0005
R951 BR.n26 BR.n25 17.0005
R952 BR.n22 BR.n21 17.0005
R953 BR.n18 BR.n17 17.0005
R954 BR.n14 BR.n13 17.0005
R955 BR.n10 BR.n9 17.0005
R956 BR.n6 BR.n5 17.0005
R957 BR.n2 BR.n1 17.0005
R958 BR.n2 BR.n0 9.95354
R959 BR.n60 BR.n59 9.00693
R960 BR.n56 BR.n55 9.00693
R961 BR.n52 BR.n51 9.00693
R962 BR.n48 BR.n47 9.00693
R963 BR.n44 BR.n43 9.00693
R964 BR.n40 BR.n39 9.00693
R965 BR.n36 BR.n35 9.00693
R966 BR.n32 BR.n31 9.00693
R967 BR.n28 BR.n27 9.00693
R968 BR.n24 BR.n23 9.00693
R969 BR.n20 BR.n19 9.00693
R970 BR.n16 BR.n15 9.00693
R971 BR.n12 BR.n11 9.00693
R972 BR.n8 BR.n7 9.00693
R973 BR.n4 BR.n3 9.00693
R974 BR.n4 BR.n2 5.85693
R975 BR.n8 BR.n6 5.85693
R976 BR.n12 BR.n10 5.85693
R977 BR.n16 BR.n14 5.85693
R978 BR.n20 BR.n18 5.85693
R979 BR.n24 BR.n22 5.85693
R980 BR.n28 BR.n26 5.85693
R981 BR.n32 BR.n30 5.85693
R982 BR.n36 BR.n34 5.85693
R983 BR.n40 BR.n38 5.85693
R984 BR.n44 BR.n42 5.85693
R985 BR.n48 BR.n46 5.85693
R986 BR.n52 BR.n50 5.85693
R987 BR.n56 BR.n54 5.85693
R988 BR.n60 BR.n58 5.85693
R989 BR BR.n62 4.79139
R990 BR.n6 BR.n4 0.947107
R991 BR.n10 BR.n8 0.947107
R992 BR.n14 BR.n12 0.947107
R993 BR.n18 BR.n16 0.947107
R994 BR.n22 BR.n20 0.947107
R995 BR.n26 BR.n24 0.947107
R996 BR.n30 BR.n28 0.947107
R997 BR.n34 BR.n32 0.947107
R998 BR.n38 BR.n36 0.947107
R999 BR.n42 BR.n40 0.947107
R1000 BR.n46 BR.n44 0.947107
R1001 BR.n50 BR.n48 0.947107
R1002 BR.n54 BR.n52 0.947107
R1003 BR.n58 BR.n56 0.947107
R1004 BR.n62 BR.n60 0.947107
R1005 DEST7.n0 DEST7.t0 12.856
R1006 DEST7.n0 DEST7.t1 11.4227
R1007 DEST7 DEST7.n0 5.99032
R1008 DISP1.n0 DISP1.t1 18.1601
R1009 DISP1.n0 DISP1.t0 17.9631
R1010 DISP1 DISP1.n0 6.2555
R1011 DEST13.n0 DEST13.t0 12.856
R1012 DEST13.n0 DEST13.t1 11.4227
R1013 DEST13 DEST13.n0 5.92282
R1014 a_29956_5022.n20 a_29956_5022.t12 18.1601
R1015 a_29956_5022.n22 a_29956_5022.t16 18.1601
R1016 a_29956_5022.n24 a_29956_5022.t11 18.1601
R1017 a_29956_5022.n26 a_29956_5022.t10 18.1601
R1018 a_29956_5022.n5 a_29956_5022.t13 18.1601
R1019 a_29956_5022.n3 a_29956_5022.t15 18.1601
R1020 a_29956_5022.n1 a_29956_5022.t9 18.1601
R1021 a_29956_5022.n0 a_29956_5022.t14 18.1601
R1022 a_29956_5022.n29 a_29956_5022.t17 18.1601
R1023 a_29956_5022.n20 a_29956_5022.t2 17.9631
R1024 a_29956_5022.n22 a_29956_5022.t6 17.9631
R1025 a_29956_5022.n24 a_29956_5022.t3 17.9631
R1026 a_29956_5022.n26 a_29956_5022.t8 17.9631
R1027 a_29956_5022.n5 a_29956_5022.t1 17.9631
R1028 a_29956_5022.n3 a_29956_5022.t4 17.9631
R1029 a_29956_5022.n1 a_29956_5022.t7 17.9631
R1030 a_29956_5022.n0 a_29956_5022.t5 17.9631
R1031 a_29956_5022.t0 a_29956_5022.n29 17.9631
R1032 a_29956_5022.n2 a_29956_5022.n0 16.8385
R1033 a_29956_5022.n19 a_29956_5022.t32 11.9073
R1034 a_29956_5022.n21 a_29956_5022.n19 11.1284
R1035 a_29956_5022.n21 a_29956_5022.n20 10.0355
R1036 a_29956_5022.n23 a_29956_5022.n22 10.0355
R1037 a_29956_5022.n25 a_29956_5022.n24 10.0355
R1038 a_29956_5022.n27 a_29956_5022.n26 10.0355
R1039 a_29956_5022.n6 a_29956_5022.n5 10.0355
R1040 a_29956_5022.n4 a_29956_5022.n3 10.0355
R1041 a_29956_5022.n2 a_29956_5022.n1 10.0355
R1042 a_29956_5022.n29 a_29956_5022.n28 10.0355
R1043 a_29956_5022.n19 a_29956_5022.t25 8.4161
R1044 a_29956_5022.n4 a_29956_5022.n2 6.80354
R1045 a_29956_5022.n6 a_29956_5022.n4 6.80354
R1046 a_29956_5022.n28 a_29956_5022.n6 6.80354
R1047 a_29956_5022.n28 a_29956_5022.n27 6.80354
R1048 a_29956_5022.n27 a_29956_5022.n25 6.80354
R1049 a_29956_5022.n25 a_29956_5022.n23 6.80354
R1050 a_29956_5022.n23 a_29956_5022.n21 6.80354
R1051 a_29956_5022.n18 a_29956_5022.n7 6.65729
R1052 a_29956_5022.n17 a_29956_5022.n9 6.65729
R1053 a_29956_5022.n16 a_29956_5022.n11 6.65729
R1054 a_29956_5022.n15 a_29956_5022.n13 6.65729
R1055 a_29956_5022.n18 a_29956_5022.n8 5.49943
R1056 a_29956_5022.n17 a_29956_5022.n10 5.49943
R1057 a_29956_5022.n16 a_29956_5022.n12 5.49943
R1058 a_29956_5022.n15 a_29956_5022.n14 5.49943
R1059 a_29956_5022.n7 a_29956_5022.t31 5.2505
R1060 a_29956_5022.n7 a_29956_5022.t35 5.2505
R1061 a_29956_5022.n9 a_29956_5022.t34 5.2505
R1062 a_29956_5022.n9 a_29956_5022.t27 5.2505
R1063 a_29956_5022.n11 a_29956_5022.t29 5.2505
R1064 a_29956_5022.n11 a_29956_5022.t28 5.2505
R1065 a_29956_5022.n13 a_29956_5022.t30 5.2505
R1066 a_29956_5022.n13 a_29956_5022.t33 5.2505
R1067 a_29956_5022.n8 a_29956_5022.t24 2.91717
R1068 a_29956_5022.n8 a_29956_5022.t19 2.91717
R1069 a_29956_5022.n10 a_29956_5022.t18 2.91717
R1070 a_29956_5022.n10 a_29956_5022.t20 2.91717
R1071 a_29956_5022.n12 a_29956_5022.t22 2.91717
R1072 a_29956_5022.n12 a_29956_5022.t21 2.91717
R1073 a_29956_5022.n14 a_29956_5022.t23 2.91717
R1074 a_29956_5022.n14 a_29956_5022.t26 2.91717
R1075 a_29956_5022.n19 a_29956_5022.n18 0.566214
R1076 a_29956_5022.n18 a_29956_5022.n17 0.566214
R1077 a_29956_5022.n17 a_29956_5022.n16 0.566214
R1078 a_29956_5022.n16 a_29956_5022.n15 0.566214
R1079 DEST5.n0 DEST5.t1 12.856
R1080 DEST5.n0 DEST5.t0 11.4227
R1081 DEST5 DEST5.n0 5.88746
R1082 PC5.n1 PC5.t4 130.792
R1083 PC5.t6 PC5.n2 109.704
R1084 PC5.n2 PC5.n1 79.4894
R1085 PC5.t4 PC5.t9 55.2719
R1086 PC5.t10 PC5.t7 55.2719
R1087 PC5.t8 PC5.t5 55.2719
R1088 PC5.n3 PC5.t6 30.3125
R1089 PC5.n1 PC5.t10 23.7255
R1090 PC5.n2 PC5.t8 23.7255
R1091 PC5.n3 PC5.t11 20.1446
R1092 PC5.n0 PC5.t1 16.7578
R1093 PC5.n4 PC5.n0 16.5026
R1094 PC5.n0 PC5.t0 15.7505
R1095 PC5.n4 PC5.n3 12.5069
R1096 PC5.n5 PC5.t3 11.8415
R1097 PC5 PC5.t2 8.38717
R1098 PC5.n5 PC5.n4 5.92282
R1099 PC5 PC5.n5 0.0559795
R1100 PC7.n1 PC7.t6 130.792
R1101 PC7.t5 PC7.n2 109.704
R1102 PC7.n2 PC7.n1 79.4894
R1103 PC7.t6 PC7.t11 55.2719
R1104 PC7.t7 PC7.t4 55.2719
R1105 PC7.t9 PC7.t8 55.2719
R1106 PC7.n3 PC7.t5 30.3125
R1107 PC7.n1 PC7.t7 23.7255
R1108 PC7.n2 PC7.t9 23.7255
R1109 PC7.n3 PC7.t10 20.1446
R1110 PC7.n0 PC7.t3 16.7578
R1111 PC7.n4 PC7.n0 16.5026
R1112 PC7.n0 PC7.t2 15.7505
R1113 PC7.n4 PC7.n3 12.5069
R1114 PC7.n5 PC7.t1 11.8415
R1115 PC7 PC7.t0 8.32059
R1116 PC7.n5 PC7.n4 5.92282
R1117 PC7 PC7.n5 0.122555
R1118 DEST1.n0 DEST1.t0 12.856
R1119 DEST1.n0 DEST1.t1 11.4227
R1120 DEST1 DEST1.n0 5.97425
R1121 DISP3.n0 DISP3.t0 18.1601
R1122 DISP3.n0 DISP3.t1 17.9631
R1123 DISP3 DISP3.n0 6.14139
R1124 PC6.n1 PC6.t8 130.792
R1125 PC6.t10 PC6.n2 109.704
R1126 PC6.n2 PC6.n1 79.4894
R1127 PC6.t8 PC6.t5 55.2719
R1128 PC6.t6 PC6.t11 55.2719
R1129 PC6.t4 PC6.t9 55.2719
R1130 PC6.n3 PC6.t10 30.3125
R1131 PC6.n1 PC6.t6 23.7255
R1132 PC6.n2 PC6.t4 23.7255
R1133 PC6.n3 PC6.t7 20.1446
R1134 PC6.n0 PC6.t3 16.7578
R1135 PC6.n4 PC6.n0 16.5026
R1136 PC6.n0 PC6.t2 15.7505
R1137 PC6.n4 PC6.n3 12.5069
R1138 PC6.n5 PC6.t1 11.8415
R1139 PC6 PC6.t0 8.33908
R1140 PC6.n5 PC6.n4 5.92282
R1141 PC6 PC6.n5 0.104062
R1142 PC4.n1 PC4.t9 130.792
R1143 PC4.t8 PC4.n2 109.704
R1144 PC4.n2 PC4.n1 79.4894
R1145 PC4.t9 PC4.t7 55.2719
R1146 PC4.t4 PC4.t10 55.2719
R1147 PC4.t5 PC4.t11 55.2719
R1148 PC4.n3 PC4.t8 30.3125
R1149 PC4.n1 PC4.t4 23.7255
R1150 PC4.n2 PC4.t5 23.7255
R1151 PC4.n3 PC4.t6 20.1446
R1152 PC4.n0 PC4.t0 16.7578
R1153 PC4.n4 PC4.n0 16.5026
R1154 PC4.n0 PC4.t1 15.7505
R1155 PC4.n4 PC4.n3 12.5069
R1156 PC4.n5 PC4.t3 11.8415
R1157 PC4 PC4.t2 8.35511
R1158 PC4.n5 PC4.n4 5.92282
R1159 PC4 PC4.n5 0.0880342
R1160 DEST9.n0 DEST9.t0 12.856
R1161 DEST9.n0 DEST9.t1 11.4227
R1162 DEST9 DEST9.n0 5.93889
R1163 DEST11.n0 DEST11.t0 12.856
R1164 DEST11.n0 DEST11.t1 11.4227
R1165 DEST11 DEST11.n0 5.99996
R1166 PC10.n1 PC10.t8 130.792
R1167 PC10.t11 PC10.n2 109.704
R1168 PC10.n2 PC10.n1 79.4894
R1169 PC10.t8 PC10.t6 55.2719
R1170 PC10.t4 PC10.t9 55.2719
R1171 PC10.t5 PC10.t10 55.2719
R1172 PC10.n3 PC10.t11 30.3125
R1173 PC10.n1 PC10.t4 23.7255
R1174 PC10.n2 PC10.t5 23.7255
R1175 PC10.n3 PC10.t7 20.1446
R1176 PC10.n0 PC10.t3 16.7578
R1177 PC10.n4 PC10.n0 16.5026
R1178 PC10.n0 PC10.t0 15.7505
R1179 PC10.n4 PC10.n3 12.5069
R1180 PC10 PC10.t2 11.7835
R1181 PC10.n5 PC10.t1 8.44265
R1182 PC10.n5 PC10.n4 5.92282
R1183 PC10 PC10.n5 0.0584452
R1184 PC1.n1 PC1.t4 130.792
R1185 PC1.t7 PC1.n2 109.704
R1186 PC1.n2 PC1.n1 79.4894
R1187 PC1.t4 PC1.t10 55.2719
R1188 PC1.t8 PC1.t5 55.2719
R1189 PC1.t9 PC1.t6 55.2719
R1190 PC1.n3 PC1.t7 30.3125
R1191 PC1.n1 PC1.t8 23.7255
R1192 PC1.n2 PC1.t9 23.7255
R1193 PC1.n3 PC1.t11 20.1446
R1194 PC1.n0 PC1.t3 16.7578
R1195 PC1.n4 PC1.n0 16.5026
R1196 PC1.n0 PC1.t0 15.7505
R1197 PC1.n4 PC1.n3 12.5069
R1198 PC1.n5 PC1.t2 11.8415
R1199 PC1 PC1.t1 8.30333
R1200 PC1.n5 PC1.n4 5.92282
R1201 PC1 PC1.n5 0.139815
R1202 PC2.n1 PC2.t8 130.792
R1203 PC2.t10 PC2.n2 109.704
R1204 PC2.n2 PC2.n1 79.4894
R1205 PC2.t8 PC2.t5 55.2719
R1206 PC2.t4 PC2.t9 55.2719
R1207 PC2.t6 PC2.t11 55.2719
R1208 PC2.n3 PC2.t10 30.3125
R1209 PC2.n1 PC2.t4 23.7255
R1210 PC2.n2 PC2.t6 23.7255
R1211 PC2.n3 PC2.t7 20.1446
R1212 PC2.n0 PC2.t3 16.7578
R1213 PC2.n4 PC2.n0 16.5026
R1214 PC2.n0 PC2.t0 15.7505
R1215 PC2.n4 PC2.n3 12.5069
R1216 PC2.n5 PC2.t2 11.8415
R1217 PC2 PC2.t1 8.291
R1218 PC2.n5 PC2.n4 5.92282
R1219 PC2 PC2.n5 0.152144
R1220 PC0.n1 PC0.t8 130.792
R1221 PC0.t10 PC0.n2 109.704
R1222 PC0.n2 PC0.n1 79.4894
R1223 PC0.t8 PC0.t5 55.2719
R1224 PC0.t6 PC0.t11 55.2719
R1225 PC0.t4 PC0.t9 55.2719
R1226 PC0.n3 PC0.t10 30.3125
R1227 PC0.n1 PC0.t6 23.7255
R1228 PC0.n2 PC0.t4 23.7255
R1229 PC0.n3 PC0.t7 20.1446
R1230 PC0.n0 PC0.t3 16.7578
R1231 PC0.n4 PC0.n0 16.5026
R1232 PC0.n0 PC0.t0 15.7505
R1233 PC0.n4 PC0.n3 12.5069
R1234 PC0 PC0.t2 11.7478
R1235 PC0.n5 PC0.t1 8.44265
R1236 PC0.n5 PC0.n4 5.92282
R1237 PC0 PC0.n5 0.0941986
R1238 DISP5.n0 DISP5.t1 18.1601
R1239 DISP5.n0 DISP5.t0 17.9631
R1240 DISP5 DISP5.n0 6.14943
R1241 PC8.n1 PC8.t9 130.792
R1242 PC8.t8 PC8.n2 109.704
R1243 PC8.n2 PC8.n1 79.4894
R1244 PC8.t9 PC8.t7 55.2719
R1245 PC8.t4 PC8.t10 55.2719
R1246 PC8.t5 PC8.t11 55.2719
R1247 PC8.n3 PC8.t8 30.3125
R1248 PC8.n1 PC8.t4 23.7255
R1249 PC8.n2 PC8.t5 23.7255
R1250 PC8.n3 PC8.t6 20.1446
R1251 PC8.n0 PC8.t3 16.7578
R1252 PC8.n4 PC8.n0 16.5026
R1253 PC8.n0 PC8.t0 15.7505
R1254 PC8.n4 PC8.n3 12.5069
R1255 PC8.n5 PC8.t2 11.8415
R1256 PC8 PC8.t1 8.32922
R1257 PC8.n5 PC8.n4 5.92282
R1258 PC8 PC8.n5 0.113925
R1259 PC15.n0 PC15.t3 130.792
R1260 PC15.t2 PC15.n1 109.704
R1261 PC15.n1 PC15.n0 79.4894
R1262 PC15.t3 PC15.t8 55.2719
R1263 PC15.t9 PC15.t5 55.2719
R1264 PC15.t6 PC15.t4 55.2719
R1265 PC15.n2 PC15.t2 30.3125
R1266 PC15.n0 PC15.t9 23.7255
R1267 PC15.n1 PC15.t6 23.7255
R1268 PC15.n2 PC15.t7 20.1446
R1269 PC15.n3 PC15.n2 18.4292
R1270 PC15 PC15.t1 11.8094
R1271 PC15.n3 PC15.t0 8.44265
R1272 PC15 PC15.n3 0.0325548
R1273 DISP7.n0 DISP7.t1 35.1969
R1274 DISP7.n1 DISP7.t2 35.1969
R1275 DISP7.n2 DISP7.t0 34.1541
R1276 DISP7.n1 DISP7.n0 22.9434
R1277 DISP7.n2 DISP7.n1 22.1322
R1278 DISP7 DISP7.n2 19.3735
R1279 DISP7.n0 DISP7.t4 17.9898
R1280 DISP7.n1 DISP7.t5 17.9898
R1281 DISP7.n2 DISP7.t3 16.9469
R1282 PC14.n1 PC14.t8 130.792
R1283 PC14.t11 PC14.n2 109.704
R1284 PC14.n2 PC14.n1 79.4894
R1285 PC14.t8 PC14.t6 55.2719
R1286 PC14.t4 PC14.t9 55.2719
R1287 PC14.t5 PC14.t10 55.2719
R1288 PC14.n3 PC14.t11 30.3125
R1289 PC14.n1 PC14.t4 23.7255
R1290 PC14.n2 PC14.t5 23.7255
R1291 PC14.n3 PC14.t7 20.1446
R1292 PC14.n0 PC14.t1 16.7578
R1293 PC14.n4 PC14.n0 16.5026
R1294 PC14.n0 PC14.t0 15.7505
R1295 PC14.n4 PC14.n3 12.5069
R1296 PC14 PC14.t3 11.7638
R1297 PC14.n5 PC14.t2 8.44265
R1298 PC14.n5 PC14.n4 5.92282
R1299 PC14 PC14.n5 0.0781712
R1300 DISP4.n0 DISP4.t0 18.1601
R1301 DISP4.n0 DISP4.t1 17.9631
R1302 DISP4 DISP4.n0 6.19764
R1303 DEST10.n0 DEST10.t1 12.856
R1304 DEST10.n0 DEST10.t0 11.4227
R1305 DEST10 DEST10.n0 5.96621
R1306 PC13.n1 PC13.t5 130.792
R1307 PC13.t8 PC13.n2 109.704
R1308 PC13.n2 PC13.n1 79.4894
R1309 PC13.t5 PC13.t11 55.2719
R1310 PC13.t9 PC13.t6 55.2719
R1311 PC13.t10 PC13.t7 55.2719
R1312 PC13.n3 PC13.t8 30.3125
R1313 PC13.n1 PC13.t9 23.7255
R1314 PC13.n2 PC13.t10 23.7255
R1315 PC13.n3 PC13.t4 20.1446
R1316 PC13.n0 PC13.t0 16.7578
R1317 PC13.n4 PC13.n0 16.5026
R1318 PC13.n0 PC13.t1 15.7505
R1319 PC13.n4 PC13.n3 12.5069
R1320 PC13 PC13.t3 11.7724
R1321 PC13.n5 PC13.t2 8.44265
R1322 PC13.n5 PC13.n4 5.92282
R1323 PC13 PC13.n5 0.0695411
R1324 PC_NEXT15.n3 PC_NEXT15.t5 29.6271
R1325 PC_NEXT15.n3 PC_NEXT15.t4 29.525
R1326 PC_NEXT15 PC_NEXT15.n3 12.6837
R1327 PC_NEXT15.n2 PC_NEXT15.n1 7.96581
R1328 PC_NEXT15.n0 PC_NEXT15.t2 7.38939
R1329 PC_NEXT15.n0 PC_NEXT15.t1 7.0005
R1330 PC_NEXT15.n1 PC_NEXT15.t0 6.6505
R1331 PC_NEXT15.n1 PC_NEXT15.t3 6.3005
R1332 PC_NEXT15.n2 PC_NEXT15.n0 5.43354
R1333 PC_NEXT15 PC_NEXT15.n2 5.24943
R1334 SI.n0 SI.t1 16.7578
R1335 SI.n0 SI.t0 15.7505
R1336 SI SI.n0 4.66764
R1337 DEST6.n0 DEST6.t0 12.856
R1338 DEST6.n0 DEST6.t1 11.4227
R1339 DEST6 DEST6.n0 5.95496
R1340 DEST2.n0 DEST2.t0 12.856
R1341 DEST2.n0 DEST2.t1 11.4227
R1342 DEST2 DEST2.n0 5.92604
R1343 DISP2.n0 DISP2.t0 18.1601
R1344 DISP2.n0 DISP2.t1 17.9631
R1345 DISP2 DISP2.n0 6.20568
R1346 DEST4.n0 DEST4.t1 12.856
R1347 DEST4.n0 DEST4.t0 11.4227
R1348 DEST4 DEST4.n0 5.86175
R1349 DEST8.n0 DEST8.t0 12.856
R1350 DEST8.n0 DEST8.t1 11.4227
R1351 DEST8 DEST8.n0 5.85211
R1352 DISP6.n0 DISP6.t1 18.1601
R1353 DISP6.n0 DISP6.t0 17.9631
R1354 DISP6 DISP6.n0 6.18157
R1355 DEST14.n0 DEST14.t1 12.856
R1356 DEST14.n0 DEST14.t0 11.4227
R1357 DEST14 DEST14.n0 5.90675
R1358 DEST12.n0 DEST12.t1 12.856
R1359 DEST12.n0 DEST12.t0 11.4227
R1360 DEST12 DEST12.n0 6.00639
R1361 DEST3.n0 DEST3.t0 12.856
R1362 DEST3.n0 DEST3.t1 11.4227
R1363 DEST3 DEST3.n0 5.83282
R1364 DEST0.n0 DEST0.t1 12.856
R1365 DEST0.n0 DEST0.t0 11.4227
R1366 DEST0 DEST0.n0 6.02246
C0 VDD PC14 1.7882f
C1 a_40543_3448# a_39855_3632# 0.46435f
C2 JMP a_3766_4236# 0.43573f
C3 CLK a_24931_3400# 0.10495f
C4 BR a_57371_4236# 0.83286f
C5 a_3766_2616# a_6053_3118# 1.02622f
C6 a_17002_2618# a_17458_3118# 0.1162f
C7 a_24515_3448# a_26636_3392# 0.37502f
C8 a_18417_2618# a_18752_3118# 0.69325f
C9 a_51170_2618# a_51322_3118# 0.28406f
C10 VDD a_20282_3448# 0.44202f
C11 VDD a_14519_3118# 1.06174f
C12 PC3 a_11816_3448# 0.37733f
C13 RSTn a_24931_2616# 0.27129f
C14 CLK a_4160_2866# 0.11694f
C15 VDD a_56849_3118# 1.06174f
C16 VDD a_30157_3118# 0.39831f
C17 CLK a_37630_3400# 0.10495f
C18 VDD a_47801_3392# 0.29079f
C19 VDD DISP5 0.15572f
C20 a_58795_3400# a_59189_2866# 0.22149f
C21 a_25328_4236# a_24515_3448# 0.22621f
C22 SE a_33794_3400# 0.23287f
C23 VDD a_32981_3448# 0.44215f
C24 a_39919_3448# a_39855_3632# 0.41628f
C25 SE PC3 0.25118f
C26 VDD a_10286_3118# 1.06193f
C27 a_42704_2618# a_42856_3118# 0.28406f
C28 BR a_54562_4236# 0.43488f
C29 CLK a_29558_2866# 0.11694f
C30 a_21235_2618# a_21092_2866# 0.14626f
C31 VDD a_39917_3118# 1.06174f
C32 a_4303_2618# a_4607_2618# 0.84698f
C33 a_3766_2616# a_5718_2618# 0.91506f
C34 a_52281_2618# a_52616_3118# 0.69325f
C35 a_50866_2618# a_51322_3118# 0.1162f
C36 VDD a_14184_2618# 0.82759f
C37 a_61082_3118# VDD 1.06193f
C38 a_63869_2618# a_64021_3118# 0.28406f
C39 VDD a_56514_2618# 0.82759f
C40 a_58379_3448# a_61020_3632# 1.44431f
C41 VDD a_46490_2866# 0.94495f
C42 VDD PC1 1.78705f
C43 BR SE 0.74808f
C44 VDD a_9951_2618# 0.82759f
C45 PC1 a_5631_3404# 0.67968f
C46 a_43815_2618# a_44150_3118# 0.69325f
C47 a_42400_2618# a_42856_3118# 0.1162f
C48 BR a_53138_4236# 0.83286f
C49 a_3766_2616# a_4607_2618# 0.96902f
C50 VDD a_39582_2618# 0.82759f
C51 a_17306_2618# a_18417_2618# 0.13063f
C52 CLK a_50329_3400# 0.10495f
C53 VDD a_13073_2618# 0.55092f
C54 a_63565_2618# a_64021_3118# 0.1162f
C55 a_64980_2618# a_65315_3118# 0.69325f
C56 a_60747_2618# VDD 0.82759f
C57 VDD a_55403_2618# 0.55092f
C58 a_58379_3448# a_60500_3392# 0.37502f
C59 VDD a_31451_3118# 1.06174f
C60 VDD a_45680_3448# 0.44202f
C61 BR a_65837_4236# 0.83642f
C62 PC12 a_49913_3448# 0.37733f
C63 VDD DISP7 0.43932f
C64 a_56787_3632# a_58379_3448# 0.11329f
C65 a_70_2618# a_526_3118# 0.1162f
C66 a_61020_3632# a_60660_3404# 0.40854f
C67 a_47801_3392# a_46493_4236# 0.16156f
C68 a_46490_2866# a_46493_3400# 0.66814f
C69 a_45680_3448# a_47961_3404# 0.13484f
C70 VDD a_38027_4236# 0.48566f
C71 a_7999_3400# a_8393_2866# 0.22149f
C72 PC8 a_35684_3118# 0.15705f
C73 VDD a_8840_2618# 0.55092f
C74 a_16049_3448# a_18690_3632# 1.44431f
C75 CLK a_21092_2866# 0.11694f
C76 VDD PC15 1.63546f
C77 BR a_50329_4236# 0.43488f
C78 a_3766_2616# a_4303_2618# 1.08668f
C79 CLK a_62612_3448# 0.14168f
C80 VDD a_38471_2618# 0.55092f
C81 a_16465_2616# a_18752_3118# 1.02622f
C82 a_51170_2618# a_52281_2618# 0.13063f
C83 VDD a_12769_2618# 0.8199f
C84 RSTn a_21691_3118# 0.20597f
C85 a_n467_2616# a_70_2618# 1.08668f
C86 a_59636_2618# VDD 0.55092f
C87 VDD a_55099_2618# 0.8199f
C88 VDD a_31116_2618# 0.82759f
C89 CLK a_33791_2866# 0.11694f
C90 a_34238_2618# a_34390_3118# 0.28406f
C91 VDD a_n70_3400# 0.45706f
C92 a_18330_3404# a_18690_3632# 0.40854f
C93 PC2 a_10286_3118# 0.15705f
C94 a_50723_2866# a_50329_3400# 0.22149f
C95 SE a_29561_3400# 0.23287f
C96 VDD a_35262_3404# 0.90929f
C97 a_54146_3448# a_56787_3632# 1.44431f
C98 VDD DISP6 0.16925f
C99 a_63425_4236# a_63425_3400# 0.64028f
C100 a_37630_3400# a_38024_2866# 0.22149f
C101 a_21095_4236# a_21095_3400# 0.64024f
C102 VDD a_8536_2618# 0.8199f
C103 a_16049_3448# a_18170_3392# 0.37502f
C104 CLK a_14519_3118# 0.26522f
C105 a_42704_2618# a_43815_2618# 0.13063f
C106 BR a_48905_4236# 0.83286f
C107 CLK a_56849_3118# 0.26522f
C108 VDD a_38167_2618# 0.8199f
C109 a_17002_2618# a_17306_2618# 0.84698f
C110 RSTn a_47089_3118# 0.20597f
C111 a_16465_2616# a_18417_2618# 0.91506f
C112 a_50329_2616# a_52616_3118# 1.02622f
C113 VDD a_12232_2616# 0.77675f
C114 SE PC5 0.24969f
C115 a_59332_2618# VDD 0.8199f
C116 a_63869_2618# a_64980_2618# 0.13063f
C117 a_46490_2866# a_46633_2618# 0.14626f
C118 VDD a_54562_2616# 0.77675f
C119 a_25772_2618# a_25924_3118# 0.28406f
C120 VDD a_30005_2618# 0.55092f
C121 a_n70_4236# a_n70_3400# 0.64354f
C122 a_35349_2618# a_35684_3118# 0.69325f
C123 a_33934_2618# a_34390_3118# 0.1162f
C124 a_45680_3448# a_46493_4236# 0.22621f
C125 VDD a_33794_3400# 0.45706f
C126 a_54146_3448# a_56267_3392# 0.37502f
C127 a_5991_3632# a_7583_3448# 0.1133f
C128 CLK a_10286_3118# 0.26522f
C129 a_63028_4236# a_63425_3400# 0.27042f
C130 VDD a_7999_2616# 0.7767f
C131 PC10 a_44150_3118# 0.15705f
C132 CLK a_39917_3118# 0.26522f
C133 CLK a_14184_2618# 0.26136f
C134 VDD PC3 1.78705f
C135 a_41863_2616# a_44150_3118# 1.02622f
C136 a_61082_3118# CLK 0.26522f
C137 BR a_46096_4236# 0.43488f
C138 CLK a_56514_2618# 0.26136f
C139 VDD a_37630_2616# 0.77675f
C140 a_50329_2616# a_52281_2618# 0.91506f
C141 a_16465_2616# a_17306_2618# 0.96902f
C142 a_50866_2618# a_51170_2618# 0.84698f
C143 CLK a_46490_2866# 0.11694f
C144 SE a_29164_3400# 0.83303f
C145 RSTn a_22985_3118# 0.16502f
C146 a_25468_2618# a_25325_2866# 0.14626f
C147 a_63028_2616# a_65315_3118# 1.02622f
C148 a_58795_2616# VDD 0.7767f
C149 VDD a_19378_3448# 0.23699f
C150 a_25468_2618# a_25924_3118# 0.1162f
C151 a_26883_2618# a_27218_3118# 0.69325f
C152 VDD a_29701_2618# 0.8199f
C153 a_16465_3400# a_16859_2866# 0.22149f
C154 a_n467_2616# a_1820_3118# 1.02622f
C155 a_49913_3448# a_48321_3632# 0.1133f
C156 a_59189_2866# a_59192_3400# 0.66814f
C157 a_60500_3392# a_59192_4236# 0.16156f
C158 a_58379_3448# a_60660_3404# 0.13484f
C159 VDD a_33794_4236# 0.48579f
C160 CLK a_9951_2618# 0.26136f
C161 VDD BR 7.06465f
C162 a_35622_3632# a_37214_3448# 0.11332f
C163 a_63028_4236# a_63425_4236# 0.1158f
C164 a_4160_2866# a_3766_3400# 0.22149f
C165 a_38027_4236# a_37630_4236# 0.1158f
C166 CLK a_39582_2618# 0.26136f
C167 JMP a_38027_4236# 0.37058f
C168 CLK a_13073_2618# 0.16583f
C169 PC4 a_20282_3448# 0.59219f
C170 a_42400_2618# a_42704_2618# 0.84698f
C171 a_41863_2616# a_43815_2618# 0.91506f
C172 a_60747_2618# CLK 0.26136f
C173 BR a_44672_4236# 0.83286f
C174 CLK a_55403_2618# 0.16583f
C175 CLK a_31451_3118# 0.26522f
C176 RSTn a_48383_3118# 0.16502f
C177 a_50329_2616# a_51170_2618# 0.96902f
C178 a_16465_2616# a_17002_2618# 1.08668f
C179 RSTn a_22650_2618# 0.8943f
C180 SE a_63028_3400# 0.80655f
C181 a_63028_2616# a_64980_2618# 0.91506f
C182 VDD a_18754_3448# 0.18062f
C183 a_63565_2618# a_63869_2618# 0.84698f
C184 VDD RSTn 8.65288f
C185 VDD a_29164_2616# 0.77675f
C186 VDD a_53242_3448# 0.23699f
C187 a_34238_2618# a_35349_2618# 0.13063f
C188 a_16862_4236# a_18170_3392# 0.16156f
C189 a_18330_3404# a_16049_3448# 0.13484f
C190 a_16862_3400# a_16859_2866# 0.66814f
C191 a_65253_3632# a_66845_3448# 0.10836f
C192 SE a_n73_2866# 0.11747f
C193 a_n467_2616# a_1485_2618# 0.91506f
C194 SE a_25328_3400# 0.23287f
C195 VDD a_31029_3404# 0.90618f
C196 CLK a_8840_2618# 0.16583f
C197 a_56787_3632# a_56427_3404# 0.40854f
C198 CLK a_38471_2618# 0.16583f
C199 CLK a_12769_2618# 0.22753f
C200 a_41863_2616# a_42704_2618# 0.96902f
C201 a_59636_2618# CLK 0.16583f
C202 VDD DEST8 0.25905f
C203 BR a_41863_4236# 0.43488f
C204 CLK a_55099_2618# 0.22753f
C205 SE a_20698_3400# 0.83303f
C206 CLK a_31116_2618# 0.26136f
C207 a_50329_2616# a_50866_2618# 1.08668f
C208 RSTn a_48048_2618# 0.8943f
C209 VDD a_10912_3448# 0.23699f
C210 RSTn a_21539_2618# 0.97182f
C211 a_63028_2616# a_63869_2618# 0.96902f
C212 PC5 a_22985_3118# 0.15705f
C213 a_25772_2618# a_26883_2618# 0.13063f
C214 VDD a_52618_3448# 0.18062f
C215 a_41447_3448# a_44088_3632# 1.44431f
C216 a_14457_3632# a_16049_3448# 0.1133f
C217 a_33397_2616# a_35684_3118# 1.02622f
C218 PC6 a_28748_3448# 0.63444f
C219 SE a_58795_3400# 0.83303f
C220 SE a_n467_3400# 0.81366f
C221 VDD a_49009_3448# 0.23699f
C222 SE PC7 0.25043f
C223 a_58379_3448# a_59192_4236# 0.22621f
C224 VDD a_29561_3400# 0.45706f
C225 CLK a_8536_2618# 0.22753f
C226 a_1485_2618# a_1820_3118# 0.69325f
C227 PC9 a_41447_3448# 0.61268f
C228 CLK a_38167_2618# 0.22753f
C229 CLK a_12232_2616# 0.68184f
C230 a_41863_2616# a_42400_2618# 1.08668f
C231 a_59332_2618# CLK 0.22753f
C232 BR a_40439_4236# 0.83286f
C233 CLK a_54562_2616# 0.68184f
C234 CLK a_30005_2618# 0.16583f
C235 RSTn a_46937_2618# 0.97182f
C236 VDD a_10288_3448# 0.18062f
C237 SE a_25325_2866# 0.11227f
C238 a_63028_2616# a_63565_2618# 1.08668f
C239 a_24931_2616# a_27218_3118# 1.02622f
C240 VDD PC5 1.78698f
C241 a_41447_3448# a_43568_3392# 0.37502f
C242 a_33934_2618# a_34238_2618# 0.84698f
C243 a_33397_2616# a_35349_2618# 0.91506f
C244 a_16862_4236# a_16049_3448# 0.22621f
C245 VDD a_48385_3448# 0.18062f
C246 VDD a_29561_4236# 0.55109f
C247 CLK a_7999_2616# 0.68184f
C248 a_38027_4236# a_39335_3392# 0.16156f
C249 a_4160_2866# a_4303_2618# 0.14626f
C250 CLK a_37630_2616# 0.68184f
C251 JMP a_33794_4236# 0.37058f
C252 SE a_3350_3448# 1.27755f
C253 a_58795_2616# CLK 0.68184f
C254 BR a_3042_4236# 0.55934f
C255 BR a_37630_4236# 0.43488f
C256 JMP BR 30.643f
C257 VDD DEST1 0.25905f
C258 CLK a_29701_2618# 0.22753f
C259 SE a_24515_3448# 1.27744f
C260 RSTn a_20698_2616# 0.27129f
C261 SE a_59189_2866# 0.11227f
C262 VDD a_29164_3400# 0.45634f
C263 a_25468_2618# a_25772_2618# 0.84698f
C264 a_24931_2616# a_26883_2618# 0.91506f
C265 SE a_46096_3400# 0.83303f
C266 VDD a_36310_3448# 0.23699f
C267 a_33397_2616# a_34238_2618# 0.96902f
C268 SE a_63425_3400# 0.23226f
C269 a_52554_3632# a_53242_3448# 0.46435f
C270 SE a_21095_3400# 0.23287f
C271 VDD a_26796_3404# 0.90929f
C272 PC13 a_56787_3632# 0.38167f
C273 a_54146_3448# a_56427_3404# 0.13484f
C274 a_54956_2866# a_54959_3400# 0.66814f
C275 a_56267_3392# a_54959_4236# 0.16156f
C276 a_59192_4236# a_59192_3400# 0.64024f
C277 a_38027_4236# a_38027_3400# 0.64024f
C278 a_58795_4236# a_59192_3400# 0.27047f
C279 a_16862_4236# a_16862_3400# 0.64024f
C280 a_33794_3400# a_33397_4236# 0.27043f
C281 PC8 a_35622_3632# 0.38237f
C282 BR a_36206_4236# 0.83286f
C283 CLK RSTn 33.899f
C284 SE a_16859_2866# 0.11227f
C285 CLK a_29164_2616# 0.68184f
C286 RSTn a_46096_2616# 0.27129f
C287 DEST14 a_59192_4236# 0.13565f
C288 a_23611_3448# a_22923_3632# 0.46435f
C289 DEST14 a_58795_4236# 0.23425f
C290 SE a_58379_3448# 1.27732f
C291 VDD a_27156_3632# 0.48868f
C292 VDD a_51322_3118# 0.39831f
C293 a_24931_2616# a_25772_2618# 0.96902f
C294 VDD a_63028_3400# 0.45759f
C295 VDD DEST10 0.25905f
C296 VDD a_35686_3448# 0.18062f
C297 a_33397_2616# a_33934_2618# 1.08668f
C298 SE a_54956_2866# 0.11227f
C299 a_62612_3448# a_65941_3908# 0.42094f
C300 a_52554_3632# a_52618_3448# 0.41628f
C301 a_49009_3908# a_45680_3448# 0.42094f
C302 DEST9 a_38027_4236# 0.13565f
C303 VDD a_n73_2866# 0.93829f
C304 VDD a_25328_3400# 0.45706f
C305 a_32981_3448# a_36310_3908# 0.42094f
C306 PC_NEXT15 a_63028_3400# 0.22149f
C307 SE PC9 0.25006f
C308 a_58795_4236# a_59192_4236# 0.1158f
C309 a_14457_3632# a_14097_3404# 0.40854f
C310 a_33794_4236# a_33397_4236# 0.1158f
C311 a_38027_4236# a_37214_3448# 0.22621f
C312 DEST12 a_50329_4236# 0.23425f
C313 BR a_33397_4236# 0.43488f
C314 SE a_16049_3448# 1.27733f
C315 PC1 a_6053_3118# 0.15705f
C316 VDD a_20698_3400# 0.45608f
C317 a_22987_3448# a_22923_3632# 0.41628f
C318 VDD a_26636_3392# 0.29079f
C319 a_24931_2616# a_25468_2618# 1.08668f
C320 DEST1 a_4163_4236# 0.13918f
C321 VDD a_61020_3632# 0.48868f
C322 a_38167_2618# a_38024_2866# 0.14626f
C323 SE a_54146_3448# 1.27748f
C324 a_62612_3448# a_65317_3908# 0.41897f
C325 SE a_16465_3400# 0.83303f
C326 PC13 a_58379_3448# 0.63822f
C327 VDD a_58795_3400# 0.45608f
C328 VDD a_n467_3400# 0.45172f
C329 DEST10 a_41863_4236# 0.23425f
C330 VDD PC7 1.78702f
C331 VDD a_25328_4236# 0.48579f
C332 DEST2 a_8396_4236# 0.13918f
C333 a_54146_3448# a_54959_4236# 0.22621f
C334 a_11816_3448# a_14457_3632# 1.44431f
C335 a_32981_3448# a_35686_3908# 0.41897f
C336 PC1 a_7583_3448# 0.63072f
C337 JMP a_29561_4236# 0.37052f
C338 DEST3 a_12629_4236# 0.13918f
C339 BR a_31973_4236# 0.83286f
C340 VDD a_18690_3632# 0.48868f
C341 VDD a_25325_2866# 0.94509f
C342 VDD a_52616_3118# 1.06193f
C343 DEST4 a_16862_4236# 0.13918f
C344 PC0 a_3350_3448# 0.57929f
C345 SE a_42257_2866# 0.11227f
C346 DEST8 a_33397_4236# 0.23425f
C347 VDD a_25924_3118# 0.39831f
C348 VDD a_60500_3392# 0.29079f
C349 a_11816_3448# a_15145_3908# 0.42094f
C350 VDD DEST2 0.25905f
C351 SE a_59192_3400# 0.23287f
C352 a_14457_3632# a_15145_3448# 0.46435f
C353 VDD a_56787_3632# 0.48868f
C354 a_44776_3448# a_44088_3632# 0.46435f
C355 SE a_16862_3400# 0.23287f
C356 VDD a_64893_3404# 0.87966f
C357 DEST5 a_21095_4236# 0.13918f
C358 VDD a_22563_3404# 0.90353f
C359 PC13 a_54146_3448# 0.37733f
C360 a_11816_3448# a_13937_3392# 0.37502f
C361 DEST12 a_50726_4236# 0.13565f
C362 DEST6 a_25328_4236# 0.13918f
C363 PC8 a_32981_3448# 0.37733f
C364 BR a_29164_4236# 0.43488f
C365 CLK a_29164_3400# 0.10495f
C366 VDD a_3350_3448# 0.44209f
C367 a_8393_2866# a_8536_2618# 0.14626f
C368 VDD a_18170_3392# 0.29079f
C369 DEST7 a_29561_4236# 0.13918f
C370 VDD a_24515_3448# 0.44215f
C371 VDD a_52281_2618# 0.82759f
C372 VDD a_70_2618# 0.8199f
C373 SE a_41447_3448# 1.27741f
C374 a_3350_3448# a_5631_3404# 0.13484f
C375 VDD a_59189_2866# 0.94509f
C376 a_11816_3448# a_14521_3908# 0.41897f
C377 VDD a_46096_3400# 0.45608f
C378 VDD a_56267_3392# 0.29079f
C379 a_44152_3448# a_44088_3632# 0.41628f
C380 VDD a_63425_3400# 0.45706f
C381 VDD a_526_3118# 0.39831f
C382 VDD a_21095_3400# 0.45706f
C383 VDD DEST12 0.25905f
C384 RSTn a_4759_3118# 0.20597f
C385 a_12626_2866# a_12629_3400# 0.66814f
C386 a_13937_3392# a_12629_4236# 0.16156f
C387 a_11816_3448# a_14097_3404# 0.13484f
C388 BR a_27740_4236# 0.83286f
C389 PC_NEXT15 a_63425_3400# 0.66814f
C390 CLK a_63028_3400# 0.10495f
C391 SE PC11 0.25118f
C392 VDD a_16859_2866# 0.94509f
C393 VDD a_51170_2618# 0.55092f
C394 VDD a_n467_2616# 0.76424f
C395 VDD a_27218_3118# 1.06193f
C396 VDD a_58379_3448# 0.44215f
C397 CLK a_n73_2866# 0.11694f
C398 a_10224_3632# a_10912_3448# 0.46435f
C399 VDD a_44088_3632# 0.48868f
C400 SE a_12626_2866# 0.11227f
C401 VDD a_54956_2866# 0.94495f
C402 VDD a_63425_4236# 0.49107f
C403 VDD a_21095_4236# 0.48566f
C404 PC13 a_58795_4236# 0.12468f
C405 PC0 a_1820_3118# 0.15705f
C406 a_54562_4236# a_54959_3400# 0.27038f
C407 a_29561_3400# a_29164_4236# 0.27046f
C408 VDD PC9 1.787f
C409 JMP a_25328_4236# 0.37058f
C410 a_65315_3118# PC15 0.15705f
C411 CLK a_20698_3400# 0.10495f
C412 BR a_24931_4236# 0.43488f
C413 VDD a_16049_3448# 0.44215f
C414 RSTn a_17458_3118# 0.20597f
C415 VDD a_50866_2618# 0.8199f
C416 CLK a_58795_3400# 0.10495f
C417 a_3350_3448# a_4163_4236# 0.22621f
C418 VDD a_26883_2618# 0.82759f
C419 CLK a_n467_3400# 0.10495f
C420 a_10224_3632# a_10288_3448# 0.41628f
C421 VDD a_43568_3392# 0.29079f
C422 SE a_54959_3400# 0.23287f
C423 a_45680_3448# a_48385_3908# 0.41897f
C424 PC11 a_50329_4236# 0.12489f
C425 SE a_11816_3448# 1.27736f
C426 VDD a_54146_3448# 0.44202f
C427 SE a_12629_3400# 0.23287f
C428 DEST10 a_42260_4236# 0.13565f
C429 VDD a_60660_3404# 0.90929f
C430 VDD a_16465_3400# 0.45608f
C431 VDD a_1820_3118# 1.06193f
C432 a_33934_2618# a_33791_2866# 0.14626f
C433 VDD a_18330_3404# 0.90929f
C434 VDD a_63028_4236# 0.32071f
C435 RSTn a_6053_3118# 0.16502f
C436 VDD DEST3 0.25905f
C437 BR DISP1 0.55934f
C438 PC13 a_56427_3404# 0.67966f
C439 a_54959_4236# a_54959_3400# 0.64024f
C440 a_54562_4236# a_54959_4236# 0.1158f
C441 a_11816_3448# a_12629_4236# 0.22621f
C442 a_12629_4236# a_12629_3400# 0.64024f
C443 a_29561_4236# a_29164_4236# 0.11575f
C444 BR a_23507_4236# 0.83286f
C445 CLK a_25325_2866# 0.11694f
C446 CLK a_52616_3118# 0.26522f
C447 PC8 a_35262_3404# 0.67974f
C448 RSTn a_42856_3118# 0.20597f
C449 PC9 a_41863_4236# 0.12618f
C450 a_64021_3118# RSTn 0.20597f
C451 VDD a_50329_2616# 0.7767f
C452 a_28748_3448# a_31389_3632# 1.44431f
C453 VDD a_65941_3448# 0.23699f
C454 VDD a_25772_2618# 0.55092f
C455 VDD a_42257_2866# 0.94509f
C456 a_61020_3632# a_61708_3448# 0.46435f
C457 a_33397_3400# a_33791_2866# 0.22149f
C458 VDD a_59192_3400# 0.45706f
C459 VDD a_1485_2618# 0.82759f
C460 VDD a_14457_3632# 0.48868f
C461 VDD a_16862_3400# 0.45706f
C462 VDD a_61604_4236# 0.32961f
C463 a_54562_3400# a_54956_2866# 0.22149f
C464 RSTn a_5718_2618# 0.8943f
C465 PC7 a_33397_4236# 0.12575f
C466 VDD DEST14 0.25905f
C467 BR a_20698_4236# 0.43488f
C468 CLK a_52281_2618# 0.26136f
C469 CLK a_70_2618# 0.22753f
C470 CLK a_59189_2866# 0.11694f
C471 CLK a_46096_3400# 0.10495f
C472 RSTn a_18752_3118# 0.16502f
C473 a_28748_3448# a_30869_3392# 0.37502f
C474 VDD a_65317_3448# 0.18062f
C475 VDD a_25468_2618# 0.8199f
C476 RSTn a_34390_3118# 0.20597f
C477 VDD a_41447_3448# 0.44215f
C478 a_61020_3632# a_61084_3448# 0.41628f
C479 SE PC13 0.25136f
C480 a_44088_3632# a_43728_3404# 0.40854f
C481 VDD a_59192_4236# 0.48579f
C482 PC5 a_24931_4236# 0.12661f
C483 VDD a_13937_3392# 0.29079f
C484 VDD a_16862_4236# 0.48579f
C485 VDD a_58795_4236# 0.32066f
C486 RSTn a_4607_2618# 0.97182f
C487 JMP a_63425_4236# 0.23995f
C488 VDD a_n467_4236# 0.31467f
C489 JMP a_21095_4236# 0.37058f
C490 CLK a_16859_2866# 0.11694f
C491 PC4 a_18690_3632# 0.38237f
C492 BR a_19274_4236# 0.83286f
C493 CLK a_51170_2618# 0.16583f
C494 CLK a_n467_2616# 0.68027f
C495 CLK a_27218_3118# 0.26522f
C496 PC11 a_48383_3118# 0.15705f
C497 PC10 a_45680_3448# 0.63822f
C498 RSTn a_44150_3118# 0.16502f
C499 RSTn a_18417_2618# 0.8943f
C500 VDD PC11 1.78705f
C501 PC3 a_16465_4236# 0.12489f
C502 a_65315_3118# RSTn 0.1649f
C503 CLK a_54956_2866# 0.11694f
C504 VDD a_24931_2616# 0.7767f
C505 PC11 a_47961_3404# 0.67967f
C506 SE a_50726_3400# 0.23287f
C507 a_31389_3632# a_32981_3448# 0.11331f
C508 SE a_8396_3400# 0.23287f
C509 VDD a_56427_3404# 0.90353f
C510 VDD a_12626_2866# 0.94495f
C511 VDD a_14097_3404# 0.90353f
C512 VDD a_57371_4236# 0.32925f
C513 a_52554_3632# a_54146_3448# 0.11332f
C514 PC6 a_26796_3404# 0.67967f
C515 a_n70_4236# a_n467_4236# 0.1158f
C516 PC1 a_5991_3632# 0.38167f
C517 PC1 a_7999_4236# 0.12511f
C518 JMP a_63028_4236# 0.43487f
C519 VDD DEST4 0.25905f
C520 BR DISP2 0.55934f
C521 BR a_16465_4236# 0.43488f
C522 CLK a_50866_2618# 0.22753f
C523 CLK a_26883_2618# 0.26136f
C524 RSTn a_43815_2618# 0.8943f
C525 RSTn a_17306_2618# 0.97182f
C526 a_64980_2618# RSTn 0.8943f
C527 RSTn a_35684_3118# 0.16502f
C528 CLK a_16465_3400# 0.10495f
C529 CLK a_1820_3118# 0.26522f
C530 PC6 a_27156_3632# 0.38167f
C531 a_62612_3448# a_65253_3632# 1.44431f
C532 SE PC0 0.24824f
C533 VDD a_54959_3400# 0.45706f
C534 VDD a_11816_3448# 0.44202f
C535 VDD a_12629_3400# 0.45706f
C536 VDD a_54562_4236# 0.32071f
C537 RSTn a_3766_2616# 0.27129f
C538 a_50329_4236# a_50726_3400# 0.27046f
C539 a_25328_3400# a_24931_4236# 0.2704f
C540 VDD a_29172_5022# 1.73511f
C541 BR a_15041_4236# 0.83286f
C542 CLK a_50329_2616# 0.68184f
C543 a_20282_3448# a_22923_3632# 1.44431f
C544 CLK a_25772_2618# 0.16583f
C545 RSTn a_42704_2618# 0.97182f
C546 CLK a_42257_2866# 0.11694f
C547 PC9 a_39855_3632# 0.38187f
C548 a_63869_2618# RSTn 0.97182f
C549 VDD a_15145_3448# 0.23699f
C550 VDD SE 9.49032f
C551 RSTn a_35349_2618# 0.8943f
C552 RSTn a_374_2618# 0.97182f
C553 CLK a_1485_2618# 0.26136f
C554 a_50723_2866# a_50866_2618# 0.14626f
C555 a_62612_3448# a_64733_3392# 0.37795f
C556 a_42257_2866# a_42260_3400# 0.66814f
C557 a_43568_3392# a_42260_4236# 0.16156f
C558 VDD a_54959_4236# 0.48566f
C559 a_41447_3448# a_43728_3404# 0.13484f
C560 VDD a_12629_4236# 0.48566f
C561 VDD a_53138_4236# 0.32961f
C562 a_42257_2866# a_41863_3400# 0.22149f
C563 SE PC_NEXT15 0.11189f
C564 a_32981_3448# a_35622_3632# 1.44431f
C565 a_50329_4236# a_50726_4236# 0.1158f
C566 JMP a_59192_4236# 0.37058f
C567 a_25328_4236# a_24931_4236# 0.1158f
C568 JMP a_16862_4236# 0.37058f
C569 JMP a_58795_4236# 0.43573f
C570 PC4 a_16049_3448# 0.37733f
C571 VDD a_65837_4236# 0.33674f
C572 BR a_12232_4236# 0.43488f
C573 a_20282_3448# a_22403_3392# 0.37502f
C574 CLK a_25468_2618# 0.22753f
C575 PC9 a_39495_3404# 0.6797f
C576 RSTn a_16465_2616# 0.27129f
C577 JMP a_n467_4236# 0.43464f
C578 VDD a_21691_3118# 0.39831f
C579 RSTn a_34238_2618# 0.97182f
C580 PC4 a_18330_3404# 0.67974f
C581 SE a_46493_3400# 0.23287f
C582 SE a_4163_3400# 0.23287f
C583 VDD PC13 1.78706f
C584 VDD a_52194_3404# 0.90929f
C585 VDD a_9864_3404# 0.90929f
C586 VDD a_50329_4236# 0.32066f
C587 PC14 a_62612_3448# 0.61857f
C588 a_50726_4236# a_50726_3400# 0.64024f
C589 a_32981_3448# a_35102_3392# 0.37502f
C590 a_8396_4236# a_8396_3400# 0.64024f
C591 BR a_10808_4236# 0.83286f
C592 PC2 a_11816_3448# 0.62703f
C593 CLK a_24931_2616# 0.68184f
C594 RSTn a_41863_2616# 0.27129f
C595 VDD a_6679_3448# 0.23704f
C596 a_63028_2616# RSTn 0.27129f
C597 VDD a_47089_3118# 0.39831f
C598 a_21539_2618# a_21691_3118# 0.28406f
C599 VDD DEST5 0.25905f
C600 BR DISP3 0.55934f
C601 CLK a_12626_2866# 0.11694f
C602 PC6 a_24515_3448# 0.37733f
C603 SE a_54562_3400# 0.83303f
C604 VDD a_44776_3448# 0.23699f
C605 a_41447_3448# a_42260_4236# 0.22621f
C606 VDD a_50726_3400# 0.45706f
C607 VDD a_8396_3400# 0.45706f
C608 VDD a_48905_4236# 0.32925f
C609 a_41447_3448# a_39855_3632# 0.11331f
C610 SE PC2 0.25081f
C611 JMP a_54562_4236# 0.43573f
C612 PC15 a_65253_3632# 0.37505f
C613 BR a_7999_4236# 0.43488f
C614 a_13073_2618# a_13225_3118# 0.28406f
C615 VDD a_6055_3448# 0.18062f
C616 PC9 a_37214_3448# 0.37733f
C617 a_21235_2618# a_21691_3118# 0.1162f
C618 a_22650_2618# a_22985_3118# 0.69325f
C619 a_55403_2618# a_55555_3118# 0.28406f
C620 VDD a_22985_3118# 1.06174f
C621 RSTn a_33397_2616# 0.27129f
C622 PC6 a_27218_3118# 0.15705f
C623 a_3350_3448# a_1758_3632# 0.11333f
C624 VDD a_44152_3448# 0.18062f
C625 a_28748_3448# a_32077_3908# 0.42094f
C626 VDD a_50726_4236# 0.48579f
C627 JMP SE 0.27219f
C628 VDD PC0 1.7881f
C629 VDD a_8396_4236# 0.48579f
C630 a_61082_3118# PC14 0.15705f
C631 VDD a_46096_4236# 0.32071f
C632 a_49913_3448# a_53242_3908# 0.42094f
C633 JMP a_54959_4236# 0.37058f
C634 a_35262_3404# a_35622_3632# 0.40854f
C635 JMP a_12629_4236# 0.37058f
C636 BR a_6575_4236# 0.83282f
C637 SE CLK 7.26569f
C638 a_14184_2618# a_14519_3118# 0.69325f
C639 a_12769_2618# a_13225_3118# 0.1162f
C640 a_46937_2618# a_47089_3118# 0.28406f
C641 PC2 a_9864_3404# 0.67968f
C642 VDD a_48383_3118# 1.06174f
C643 a_56514_2618# a_56849_3118# 0.69325f
C644 a_55099_2618# a_55555_3118# 0.1162f
C645 VDD a_22650_2618# 0.82759f
C646 PC11 a_49913_3448# 0.63444f
C647 SE a_42260_3400# 0.23287f
C648 a_45680_3448# a_48321_3632# 1.44431f
C649 DEST0 a_n467_4236# 0.23425f
C650 a_28748_3448# a_31453_3908# 0.41897f
C651 a_8840_2618# a_8992_3118# 0.28406f
C652 SE a_41863_3400# 0.83303f
C653 VDD a_47961_3404# 0.90353f
C654 VDD a_5631_3404# 0.96658f
C655 VDD a_44672_4236# 0.32961f
C656 a_31029_3404# a_31389_3632# 0.40854f
C657 a_49913_3448# a_52618_3908# 0.41897f
C658 VDD a_32077_3448# 0.23699f
C659 a_52554_3632# a_52194_3404# 0.40854f
C660 a_12232_3400# a_12626_2866# 0.22149f
C661 a_46096_4236# a_46493_3400# 0.27047f
C662 VDD PC_NEXT15 0.94495f
C663 a_21095_3400# a_20698_4236# 0.27038f
C664 JMP a_50329_4236# 0.43573f
C665 a_38471_2618# a_38623_3118# 0.28406f
C666 BR a_3766_4236# 0.43488f
C667 PC15 a_62612_3448# 0.37877f
C668 a_48048_2618# a_48383_3118# 0.69325f
C669 a_46633_2618# a_47089_3118# 0.1162f
C670 a_59636_2618# a_59788_3118# 0.28406f
C671 VDD a_48048_2618# 0.82759f
C672 a_21539_2618# a_22650_2618# 0.13063f
C673 a_3350_3448# a_6679_3908# 0.42094f
C674 VDD a_21539_2618# 0.55092f
C675 VDD a_n70_4236# 0.47672f
C676 a_29701_2618# a_29558_2866# 0.14626f
C677 SE a_50723_2866# 0.11227f
C678 a_45680_3448# a_47801_3392# 0.37502f
C679 a_27156_3632# a_27844_3448# 0.46435f
C680 a_8536_2618# a_8992_3118# 0.1162f
C681 VDD a_46493_3400# 0.45706f
C682 a_9951_2618# a_10286_3118# 0.69325f
C683 VDD a_4163_3400# 0.45706f
C684 BR DISP4 0.55934f
C685 VDD a_41863_4236# 0.32066f
C686 VDD DEST6 0.25905f
C687 VDD a_31453_3448# 0.18062f
C688 a_46096_4236# a_46493_4236# 0.1158f
C689 a_21095_4236# a_20698_4236# 0.1158f
C690 a_39582_2618# a_39917_3118# 0.69325f
C691 a_38167_2618# a_38623_3118# 0.1162f
C692 BR a_2342_4236# 0.83286f
C693 SE PC4 0.24896f
C694 a_13073_2618# a_14184_2618# 0.13063f
C695 a_59332_2618# a_59788_3118# 0.1162f
C696 a_60747_2618# a_61082_3118# 0.69325f
C697 VDD a_46937_2618# 0.55092f
C698 a_20698_2616# a_22985_3118# 1.02622f
C699 a_3350_3448# a_6055_3908# 0.41897f
C700 a_55403_2618# a_56514_2618# 0.13063f
C701 VDD a_21235_2618# 0.8199f
C702 SE a_49913_3448# 1.27733f
C703 SE a_12232_3400# 0.83303f
C704 VDD a_54562_3400# 0.45608f
C705 a_27156_3632# a_27220_3448# 0.41628f
C706 VDD a_46493_4236# 0.48566f
C707 VDD a_2446_3448# 0.23699f
C708 VDD a_4163_4236# 0.48566f
C709 VDD a_40439_4236# 0.32925f
C710 a_10224_3632# a_11816_3448# 0.1133f
C711 JMP a_50726_4236# 0.37058f
C712 VDD PC2 1.78823f
C713 a_33794_4236# a_35102_3392# 0.16156f
C714 a_35262_3404# a_32981_3448# 0.13484f
C715 a_33794_3400# a_33791_2866# 0.66814f
C716 JMP a_8396_4236# 0.37058f
C717 JMP a_46096_4236# 0.43573f
C718 CLK a_22985_3118# 0.26522f
C719 a_12232_2616# a_14519_3118# 1.02622f
C720 a_46937_2618# a_48048_2618# 0.13063f
C721 RSTn a_13225_3118# 0.20597f
C722 VDD a_46633_2618# 0.8199f
C723 a_20698_2616# a_22650_2618# 0.91506f
C724 a_21235_2618# a_21539_2618# 0.84698f
C725 RSTn a_55555_3118# 0.20597f
C726 a_54562_2616# a_56849_3118# 1.02622f
C727 VDD a_20698_2616# 0.77675f
C728 a_30005_2618# a_30157_3118# 0.28406f
C729 a_70_2618# a_374_2618# 0.84698f
C730 SE a_38027_3400# 0.23287f
C731 VDD a_52554_3632# 0.48868f
C732 VDD a_43728_3404# 0.90929f
C733 a_8840_2618# a_9951_2618# 0.13063f
C734 SE a_38024_2866# 0.11227f
C735 VDD a_1822_3448# 0.18062f
C736 VDD a_3042_4236# 0.15672f
C737 a_29561_4236# a_30869_3392# 0.16156f
C738 a_29561_3400# a_29558_2866# 0.66814f
C739 VDD a_37630_4236# 0.32071f
C740 a_31029_3404# a_28748_3448# 0.13484f
C741 a_40543_3908# a_37214_3448# 0.42094f
C742 VDD JMP 9.70464f
C743 a_52034_3392# a_50726_4236# 0.16156f
C744 a_50723_2866# a_50726_3400# 0.66814f
C745 a_49913_3448# a_52194_3404# 0.13484f
C746 a_374_2618# a_526_3118# 0.28406f
C747 a_46493_4236# a_46493_3400# 0.64024f
C748 PC0 a_1398_3404# 0.67976f
C749 a_4163_4236# a_4163_3400# 0.64024f
C750 RSTn a_8992_3118# 0.20597f
C751 PC3 a_14519_3118# 0.15705f
C752 a_38471_2618# a_39582_2618# 0.13063f
C753 CLK a_48383_3118# 0.26522f
C754 a_17002_2618# a_16859_2866# 0.14626f
C755 CLK a_22650_2618# 0.26136f
C756 a_12769_2618# a_13073_2618# 0.84698f
C757 RSTn a_38623_3118# 0.20597f
C758 a_12232_2616# a_14184_2618# 0.91506f
C759 a_46096_2616# a_48383_3118# 1.02622f
C760 VDD CLK 18.44011f
C761 PC5 a_22923_3632# 0.38204f
C762 a_59636_2618# a_60747_2618# 0.13063f
C763 a_59788_3118# RSTn 0.20597f
C764 VDD a_46096_2616# 0.77675f
C765 a_20698_2616# a_21539_2618# 0.96902f
C766 a_54562_2616# a_56514_2618# 0.91506f
C767 a_55099_2618# a_55403_2618# 0.84698f
C768 DEST1 a_3766_4236# 0.23425f
C769 a_29701_2618# a_30157_3118# 0.1162f
C770 a_31116_2618# a_31451_3118# 0.69325f
C771 a_n467_2616# a_374_2618# 0.96902f
C772 VDD a_52034_3392# 0.29079f
C773 a_7999_2616# a_10286_3118# 1.02622f
C774 SE a_37214_3448# 1.27749f
C775 VDD a_42260_3400# 0.45706f
C776 a_56787_3632# a_57475_3448# 0.46435f
C777 JMP a_n70_4236# 0.37058f
C778 VDD a_1398_3404# 0.90929f
C779 VDD a_36206_4236# 0.32961f
C780 VDD a_41863_3400# 0.45608f
C781 PC_NEXT15 CLK 0.11694f
C782 a_39919_3908# a_37214_3448# 0.41897f
C783 a_10224_3632# a_9864_3404# 0.40854f
C784 a_33794_4236# a_32981_3448# 0.22621f
C785 JMP a_41863_4236# 0.43573f
C786 BR DISP5 0.55934f
C787 VDD DEST7 0.30137f
C788 a_37630_2616# a_39917_3118# 1.02622f
C789 CLK a_48048_2618# 0.26136f
C790 a_14457_3632# a_14521_3448# 0.41628f
C791 CLK a_21539_2618# 0.16583f
C792 a_12232_2616# a_13073_2618# 0.96902f
C793 a_46096_2616# a_48048_2618# 0.91506f
C794 a_46633_2618# a_46937_2618# 0.84698f
C795 RSTn a_14519_3118# 0.16502f
C796 a_58795_2616# a_61082_3118# 1.02622f
C797 a_29164_3400# a_29558_2866# 0.22149f
C798 a_54562_2616# a_55403_2618# 0.96902f
C799 RSTn a_56849_3118# 0.16502f
C800 a_20698_2616# a_21235_2618# 1.08668f
C801 RSTn a_30157_3118# 0.20597f
C802 SE PC6 0.25118f
C803 VDD a_61708_3448# 0.23699f
C804 SE a_8393_2866# 0.11227f
C805 VDD a_50723_2866# 0.94509f
C806 a_8536_2618# a_8840_2618# 0.84698f
C807 a_7999_2616# a_9951_2618# 0.91506f
C808 VDD a_42260_4236# 0.48579f
C809 a_56787_3632# a_56851_3448# 0.41628f
C810 PC7 a_31389_3632# 0.38174f
C811 a_29561_4236# a_28748_3448# 0.22621f
C812 a_49009_3448# a_48321_3632# 0.46435f
C813 VDD a_33397_4236# 0.32066f
C814 a_36310_3448# a_35622_3632# 0.46435f
C815 VDD a_39855_3632# 0.48868f
C816 DEST2 a_7999_4236# 0.23425f
C817 SE a_3766_3400# 0.83303f
C818 a_49913_3448# a_50726_4236# 0.22621f
C819 a_41863_4236# a_42260_3400# 0.27042f
C820 JMP a_46493_4236# 0.37058f
C821 a_16862_3400# a_16465_4236# 0.27046f
C822 RSTn a_10286_3118# 0.16502f
C823 JMP a_4163_4236# 0.37058f
C824 a_37630_2616# a_39582_2618# 0.91506f
C825 a_38167_2618# a_38471_2618# 0.84698f
C826 CLK a_46937_2618# 0.16583f
C827 CLK a_21235_2618# 0.22753f
C828 PC10 a_44088_3632# 0.38167f
C829 RSTn a_39917_3118# 0.16502f
C830 a_46096_2616# a_46937_2618# 0.96902f
C831 a_12232_2616# a_12769_2618# 1.08668f
C832 RSTn a_14184_2618# 0.8943f
C833 VDD PC4 1.78814f
C834 a_58795_2616# a_60747_2618# 0.91506f
C835 a_59332_2618# a_59636_2618# 0.84698f
C836 a_61082_3118# RSTn 0.16502f
C837 a_54562_2616# a_55099_2618# 1.08668f
C838 RSTn a_56514_2618# 0.8943f
C839 a_3350_3448# a_5991_3632# 1.44431f
C840 CLK a_54562_3400# 0.10495f
C841 a_30005_2618# a_31116_2618# 0.13063f
C842 VDD a_61084_3448# 0.18062f
C843 SE a_7583_3448# 1.27735f
C844 VDD a_49913_3448# 0.44215f
C845 a_7999_2616# a_8840_2618# 0.96902f
C846 VDD a_39495_3404# 0.90353f
C847 VDD a_12232_3400# 0.45608f
C848 a_48385_3448# a_48321_3632# 0.41628f
C849 VDD a_31973_4236# 0.32925f
C850 VDD a_39335_3392# 0.29079f
C851 a_35686_3448# a_35622_3632# 0.41628f
C852 a_374_2618# a_1485_2618# 0.13063f
C853 a_41863_4236# a_42260_4236# 0.1158f
C854 a_16862_4236# a_16465_4236# 0.1158f
C855 RSTn a_9951_2618# 0.8943f
C856 JMP a_37630_4236# 0.43573f
C857 DEST3 a_12232_4236# 0.23425f
C858 VDD DEST0 0.25905f
C859 a_37630_2616# a_38471_2618# 0.96902f
C860 CLK a_46633_2618# 0.22753f
C861 CLK a_20698_2616# 0.68184f
C862 a_46096_2616# a_46633_2618# 1.08668f
C863 RSTn a_39582_2618# 0.8943f
C864 a_25325_2866# a_24931_3400# 0.22149f
C865 RSTn a_13073_2618# 0.97182f
C866 PC5 a_20282_3448# 0.37733f
C867 a_58795_2616# a_59636_2618# 0.96902f
C868 a_42257_2866# a_42400_2618# 0.14626f
C869 a_60747_2618# RSTn 0.8943f
C870 a_27156_3632# a_28748_3448# 0.1133f
C871 RSTn a_55403_2618# 0.97182f
C872 a_3350_3448# a_5471_3392# 0.37502f
C873 RSTn a_31451_3118# 0.16502f
C874 PC12 a_52616_3118# 0.15705f
C875 a_29164_2616# a_31451_3118# 1.02622f
C876 VDD a_38027_3400# 0.45706f
C877 a_7999_2616# a_8536_2618# 1.08668f
C878 VDD a_10224_3632# 0.48868f
C879 VDD a_29164_4236# 0.32729f
C880 VDD a_38024_2866# 0.94495f
C881 VDD a_4759_3118# 0.39831f
C882 a_7583_3448# a_10912_3908# 0.42094f
C883 a_7583_3448# a_9864_3404# 0.13484f
C884 a_8393_2866# a_8396_3400# 0.66814f
C885 a_9704_3392# a_8396_4236# 0.16156f
C886 a_1398_3404# a_3042_4236# 0.82016f
C887 RSTn a_8840_2618# 0.97182f
C888 DEST0 a_n70_4236# 0.13918f
C889 a_37630_2616# a_38167_2618# 1.08668f
C890 CLK a_46096_2616# 0.68184f
C891 RSTn a_38471_2618# 0.97182f
C892 a_58795_2616# a_59332_2618# 1.08668f
C893 a_59636_2618# RSTn 0.97182f
C894 VDD DEST9 0.25905f
C895 BR DISP6 0.55934f
C896 DEST4 a_16465_4236# 0.23425f
C897 RSTn a_31116_2618# 0.8943f
C898 DEST15 a_63425_4236# 0.13565f
C899 a_29164_2616# a_31116_2618# 0.91506f
C900 a_29701_2618# a_30005_2618# 0.84698f
C901 CLK a_41863_3400# 0.10495f
C902 a_22563_3404# a_22923_3632# 0.40854f
C903 VDD a_9704_3392# 0.29079f
C904 PC7 a_28748_3448# 0.37733f
C905 VDD a_27740_4236# 0.32961f
C906 a_65253_3632# a_64893_3404# 0.40873f
C907 VDD a_37214_3448# 0.44202f
C908 SE PC8 0.24896f
C909 a_7583_3448# a_10288_3908# 0.41897f
C910 JMP a_42260_4236# 0.37058f
C911 JMP a_33397_4236# 0.43573f
C912 a_33794_4236# a_33794_3400# 0.64024f
C913 a_20698_3400# a_21092_2866# 0.22149f
C914 PC10 a_41447_3448# 0.37733f
C915 a_24515_3448# a_22923_3632# 0.11331f
C916 RSTn a_12232_2616# 0.27129f
C917 RSTn a_54562_2616# 0.27129f
C918 CLK a_50723_2866# 0.11694f
C919 VDD a_17458_3118# 0.39831f
C920 RSTn a_30005_2618# 0.97182f
C921 a_29164_2616# a_30005_2618# 0.96902f
C922 a_61020_3632# a_62612_3448# 0.11331f
C923 DEST15 a_63028_4236# 0.23425f
C924 VDD PC6 1.78824f
C925 VDD a_8393_2866# 0.94509f
C926 DEST5 a_20698_4236# 0.23425f
C927 VDD a_24931_4236# 0.32066f
C928 a_49913_3448# a_52554_3632# 1.44431f
C929 PC14 a_61020_3632# 0.3818f
C930 a_42260_4236# a_42260_3400# 0.64024f
C931 VDD a_3766_3400# 0.45608f
C932 VDD a_6053_3118# 1.06174f
C933 a_7583_3448# a_8396_4236# 0.22621f
C934 RSTn a_7999_2616# 0.27129f
C935 PC0 a_1758_3632# 0.38271f
C936 PC2 a_10224_3632# 0.38167f
C937 DEST13 a_54562_4236# 0.23425f
C938 RSTn a_37630_2616# 0.27129f
C939 a_58795_2616# RSTn 0.27129f
C940 VDD a_42856_3118# 0.39831f
C941 VDD DISP1 0.25723f
C942 a_64021_3118# VDD 0.39831f
C943 CLK a_12232_3400# 0.10495f
C944 a_29164_2616# a_29701_2618# 1.08668f
C945 DISP1 a_5631_3404# 0.82016f
C946 VDD a_7583_3448# 0.44215f
C947 PC12 a_54146_3448# 0.59551f
C948 VDD a_23507_4236# 0.32925f
C949 a_49913_3448# a_52034_3392# 0.37502f
C950 a_62612_3448# a_64893_3404# 0.13582f
C951 VDD a_1758_3632# 0.48868f
C952 VDD a_5718_2618# 0.82779f
C953 DEST11 a_46096_4236# 0.23425f
C954 a_37630_4236# a_38027_3400# 0.27038f
C955 DISP2 a_9864_3404# 0.82016f
C956 a_12629_3400# a_12232_4236# 0.27045f
C957 PC7 a_32981_3448# 0.6198f
C958 DEST6 a_24931_4236# 0.23425f
C959 JMP a_29164_4236# 0.43573f
C960 a_18690_3632# a_20282_3448# 0.11332f
C961 DEST13 a_54959_4236# 0.13565f
C962 DISP3 a_14097_3404# 0.82016f
C963 VDD a_18752_3118# 1.06193f
C964 RSTn a_29164_2616# 0.27129f
C965 DEST8 a_33794_4236# 0.13565f
C966 CLK a_38024_2866# 0.11694f
C967 VDD a_34390_3118# 0.39831f
C968 DISP4 a_18330_3404# 0.82016f
C969 DEST9 a_37630_4236# 0.23425f
C970 a_21095_4236# a_22403_3392# 0.16156f
C971 a_22563_3404# a_20282_3448# 0.13484f
C972 a_21095_3400# a_21092_2866# 0.66814f
C973 VDD DEST11 0.25905f
C974 VDD a_20698_4236# 0.32071f
C975 a_64733_3392# a_63425_4236# 0.16156f
C976 VDD a_1238_3392# 0.29079f
C977 DISP5 a_22563_3404# 0.82016f
C978 VDD a_4607_2618# 0.55092f
C979 a_39855_3632# a_39495_3404# 0.40854f
C980 a_12629_4236# a_12232_4236# 0.1158f
C981 SE PC10 0.25136f
C982 DISP6 a_26796_3404# 0.82016f
C983 DEST7 a_29164_4236# 0.23425f
C984 VDD a_44150_3118# 1.06193f
C985 a_24515_3448# a_27844_3908# 0.42094f
C986 VDD a_18417_2618# 0.82759f
C987 a_65253_3632# a_65941_3448# 0.46435f
C988 a_65315_3118# VDD 1.05929f
C989 SE a_7999_3400# 0.83303f
C990 VDD a_19274_4236# 0.32961f
C991 a_62612_3448# a_63425_4236# 0.23341f
C992 PC7 a_31451_3118# 0.15705f
C993 PC14 a_58379_3448# 0.37733f
C994 a_n70_4236# a_1238_3392# 0.16156f
C995 a_n70_3400# a_n73_2866# 0.66814f
C996 VDD a_4303_2618# 0.8199f
C997 VDD PC8 1.78814f
C998 VDD a_14521_3448# 0.18062f
C999 JMP a_24931_4236# 0.43573f
C1000 a_2446_3448# a_1758_3632# 0.46435f
C1001 PC2 a_7583_3448# 0.37733f
C1002 VDD a_43815_2618# 0.82759f
C1003 a_24515_3448# a_27220_3908# 0.41897f
C1004 SE a_33397_3400# 0.83303f
C1005 VDD a_17306_2618# 0.55092f
C1006 a_64980_2618# VDD 0.82689f
C1007 a_65253_3632# a_65317_3448# 0.41628f
C1008 CLK a_8393_2866# 0.11694f
C1009 VDD a_23611_3448# 0.23699f
C1010 VDD a_35684_3118# 1.06193f
C1011 a_46096_3400# a_46490_2866# 0.22149f
C1012 PC1 a_3350_3448# 0.37733f
C1013 a_21095_4236# a_20282_3448# 0.22621f
C1014 CLK a_3766_3400# 0.10495f
C1015 CLK a_6053_3118# 0.26522f
C1016 VDD DISP2 0.15672f
C1017 VDD a_16465_4236# 0.32066f
C1018 DEST11 a_46493_4236# 0.13565f
C1019 VDD a_3766_2616# 0.77675f
C1020 a_37214_3448# a_39855_3632# 1.44431f
C1021 PC14 a_60660_3404# 0.67969f
C1022 a_1822_3448# a_1758_3632# 0.41628f
C1023 PC14 a_63028_4236# 0.12596f
C1024 a_23611_3908# a_20282_3448# 0.42094f
C1025 VDD a_42704_2618# 0.55092f
C1026 PC15 a_64893_3404# 0.63827f
C1027 VDD a_17002_2618# 0.8199f
C1028 a_63869_2618# VDD 0.55103f
C1029 VDD a_22987_3448# 0.18062f
C1030 a_58379_3448# a_61708_3908# 0.42094f
C1031 VDD a_35349_2618# 0.82759f
C1032 VDD a_374_2618# 0.54831f
C1033 CLK a_5718_2618# 0.26136f
C1034 VDD a_15041_4236# 0.32925f
C1035 PC12 a_54562_4236# 0.12727f
C1036 PC9 a_39917_3118# 0.15705f
C1037 a_38024_2866# a_38027_3400# 0.66814f
C1038 a_37214_3448# a_39495_3404# 0.13484f
C1039 VDD DEST13 0.25905f
C1040 a_37214_3448# a_39335_3392# 0.37502f
C1041 JMP a_20698_4236# 0.43573f
C1042 a_29561_4236# a_29561_3400# 0.64024f
C1043 a_1398_3404# a_1758_3632# 0.40854f
C1044 CLK a_18752_3118# 0.26522f
C1045 a_22987_3908# a_20282_3448# 0.41897f
C1046 SE a_24931_3400# 0.83303f
C1047 VDD a_42400_2618# 0.8199f
C1048 RSTn a_51322_3118# 0.20597f
C1049 VDD a_16465_2616# 0.7767f
C1050 SE PC12 0.24914f
C1051 a_63565_2618# VDD 0.8199f
C1052 a_5991_3632# a_6679_3448# 0.46435f
C1053 PC10 a_46096_4236# 0.12468f
C1054 a_58379_3448# a_61084_3908# 0.41897f
C1055 VDD a_34238_2618# 0.55092f
C1056 a_44088_3632# a_45680_3448# 0.11329f
C1057 SE a_4160_2866# 0.11227f
C1058 SE a_37630_3400# 0.83303f
C1059 CLK a_4607_2618# 0.16583f
C1060 VDD a_12232_4236# 0.32071f
C1061 VDD a_27844_3448# 0.23699f
C1062 a_63565_2618# PC_NEXT15 0.14626f
C1063 a_8396_3400# a_7999_4236# 0.27045f
C1064 CLK a_44150_3118# 0.26522f
C1065 a_16049_3448# a_19378_3908# 0.42094f
C1066 PC8 a_37630_4236# 0.12749f
C1067 CLK a_18417_2618# 0.26136f
C1068 VDD PC10 1.78825f
C1069 a_19378_3448# a_18690_3632# 0.46435f
C1070 a_65315_3118# CLK 0.25701f
C1071 VDD a_41863_2616# 0.7767f
C1072 SE a_29558_2866# 0.11227f
C1073 a_59332_2618# a_59189_2866# 0.14626f
C1074 PC11 a_48321_3632# 0.38167f
C1075 a_63028_2616# VDD 0.77675f
C1076 a_5991_3632# a_6055_3448# 0.41628f
C1077 VDD a_33934_2618# 0.8199f
C1078 VDD a_57475_3448# 0.23699f
C1079 a_54956_2866# a_55099_2618# 0.14626f
C1080 VDD a_7999_3400# 0.45608f
C1081 CLK a_4303_2618# 0.22753f
C1082 VDD a_10808_4236# 0.32961f
C1083 VDD a_27220_3448# 0.18062f
C1084 PC12 a_52194_3404# 0.67973f
C1085 a_54146_3448# a_57475_3908# 0.42094f
C1086 PC6 a_29164_4236# 0.12489f
C1087 a_8396_4236# a_7999_4236# 0.1158f
C1088 VDD DISP3 0.15572f
C1089 JMP a_16465_4236# 0.43573f
C1090 PC7 a_31029_3404# 0.67969f
C1091 CLK a_43815_2618# 0.26136f
C1092 a_16049_3448# a_18754_3908# 0.41897f
C1093 CLK a_17306_2618# 0.16583f
C1094 PC4 a_18752_3118# 0.15705f
C1095 a_18754_3448# a_18690_3632# 0.41628f
C1096 a_64980_2618# CLK 0.26117f
C1097 CLK a_35684_3118# 0.26522f
C1098 RSTn a_52616_3118# 0.16502f
C1099 SE a_28748_3448# 1.27733f
C1100 RSTn a_25924_3118# 0.20597f
C1101 VDD a_33397_3400# 0.45608f
C1102 SE a_50329_3400# 0.83303f
C1103 SE SI 0.13089f
C1104 VDD a_33397_2616# 0.7767f
C1105 VDD a_56851_3448# 0.18062f
C1106 PC4 a_20698_4236# 0.12749f
C1107 VDD a_40543_3448# 0.23699f
C1108 VDD a_5991_3632# 0.48873f
C1109 CLK a_3766_2616# 0.68184f
C1110 VDD a_7999_4236# 0.32066f
C1111 a_54146_3448# a_56851_3908# 0.41897f
C1112 a_7583_3448# a_10224_3632# 1.44431f
C1113 a_5991_3632# a_5631_3404# 0.40854f
C1114 CLK a_42704_2618# 0.16583f
C1115 CLK a_17002_2618# 0.22753f
C1116 PC2 a_12232_4236# 0.12532f
C1117 a_63869_2618# CLK 0.16583f
C1118 VDD DEST15 0.25905f
C1119 SE a_21092_2866# 0.11227f
C1120 CLK a_35349_2618# 0.26136f
C1121 RSTn a_52281_2618# 0.8943f
C1122 CLK a_374_2618# 0.16583f
C1123 VDD a_31389_3632# 0.48868f
C1124 SE a_62612_3448# 0.685f
C1125 VDD a_39919_3448# 0.18062f
C1126 SE a_33791_2866# 0.11227f
C1127 VDD a_5471_3392# 0.29079f
C1128 RSTn a_526_3118# 0.20597f
C1129 VDD a_6575_4236# 0.54974f
C1130 a_26796_3404# a_27156_3632# 0.40854f
C1131 a_31389_3632# a_32077_3448# 0.46435f
C1132 SE PC14 0.2347f
C1133 a_7583_3448# a_9704_3392# 0.37502f
C1134 PC0 a_3766_4236# 0.12839f
C1135 PC3 a_16049_3448# 0.63444f
C1136 JMP a_12232_4236# 0.43573f
C1137 CLK a_42400_2618# 0.22753f
C1138 BR a_63425_4236# 0.15874f
C1139 CLK a_16465_2616# 0.68184f
C1140 a_63565_2618# CLK 0.22753f
C1141 SE a_20282_3448# 1.27749f
C1142 CLK a_34238_2618# 0.16583f
C1143 a_4607_2618# a_4759_3118# 0.28406f
C1144 RSTn a_51170_2618# 0.97182f
C1145 VDD a_24931_3400# 0.45608f
C1146 RSTn a_n467_2616# 0.2711f
C1147 RSTn a_27218_3118# 0.16502f
C1148 PC10 a_43728_3404# 0.67966f
C1149 PC11 a_45680_3448# 0.37733f
C1150 VDD a_30869_3392# 0.29126f
C1151 VDD PC12 1.78815f
C1152 SE a_32981_3448# 1.27739f
C1153 VDD a_4160_2866# 0.94495f
C1154 VDD a_3766_4236# 0.32071f
C1155 VDD a_37630_3400# 0.45608f
C1156 a_31389_3632# a_31453_3448# 0.41628f
C1157 PC5 a_22563_3404# 0.67971f
C1158 CLK a_41863_2616# 0.68184f
C1159 a_n70_3400# a_n467_4236# 0.27201f
C1160 a_63028_2616# CLK 0.68151f
C1161 BR a_63028_4236# 0.43488f
C1162 VDD DISP4 0.15672f
C1163 CLK a_33934_2618# 0.22753f
C1164 a_5718_2618# a_6053_3118# 0.69325f
C1165 a_4303_2618# a_4759_3118# 0.1162f
C1166 VDD a_22923_3632# 0.48868f
C1167 PC5 a_24515_3448# 0.60569f
C1168 RSTn a_26883_2618# 0.8943f
C1169 PC3 a_14457_3632# 0.38167f
C1170 VDD a_29558_2866# 0.94507f
C1171 CLK a_7999_3400# 0.10495f
C1172 SE a_46490_2866# 0.11227f
C1173 VDD a_65253_3632# 0.48042f
C1174 a_41447_3448# a_44776_3908# 0.42094f
C1175 a_12626_2866# a_12769_2618# 0.14626f
C1176 PC13 a_56849_3118# 0.15705f
C1177 RSTn a_1820_3118# 0.16502f
C1178 VDD a_2342_4236# 0.32961f
C1179 VDD a_35622_3632# 0.48868f
C1180 SE PC1 0.25099f
C1181 a_5471_3392# a_4163_4236# 0.16156f
C1182 a_4160_2866# a_4163_3400# 0.66814f
C1183 a_n467_3400# a_n73_2866# 0.22149f
C1184 a_4163_3400# a_3766_4236# 0.27035f
C1185 JMP a_7999_4236# 0.43573f
C1186 a_25328_4236# a_25328_3400# 0.64024f
C1187 PC8 a_37214_3448# 0.59219f
C1188 DISP7 a_29172_5022# 0.26374f
C1189 CLK a_33397_3400# 0.10495f
C1190 BR a_61604_4236# 0.83286f
C1191 CLK a_33397_2616# 0.68184f
C1192 RSTn a_50329_2616# 0.27129f
C1193 VDD a_22403_3392# 0.29079f
C1194 VDD a_13225_3118# 0.39831f
C1195 RSTn a_25772_2618# 0.97182f
C1196 VDD a_28748_3448# 0.44227f
C1197 VDD a_55555_3118# 0.39831f
C1198 SE a_45680_3448# 1.27732f
C1199 VDD a_64733_3392# 0.29079f
C1200 a_41447_3448# a_44152_3908# 0.41897f
C1201 VDD SI 0.11453f
C1202 VDD a_50329_3400# 0.45608f
C1203 RSTn a_1485_2618# 0.8943f
C1204 a_25328_4236# a_26636_3392# 0.16156f
C1205 a_25328_3400# a_25325_2866# 0.66814f
C1206 a_26796_3404# a_24515_3448# 0.13484f
C1207 VDD a_35102_3392# 0.29079f
C1208 a_4163_4236# a_3766_4236# 0.1158f
C1209 VDD a_8992_3118# 0.39831f
C1210 BR a_58795_4236# 0.43488f
C1211 a_4607_2618# a_5718_2618# 0.13063f
C1212 a_17306_2618# a_17458_3118# 0.28406f
C1213 a_24515_3448# a_27156_3632# 1.44431f
C1214 VDD a_38623_3118# 0.39831f
C1215 VDD a_21092_2866# 0.94495f
C1216 a_59788_3118# VDD 0.39831f
C1217 PC3 a_14097_3404# 0.67967f
C1218 BR a_n467_4236# 0.43472f
C1219 SE a_n70_3400# 0.24349f
C1220 VDD a_62612_3448# 0.48641f
C1221 VDD a_48321_3632# 0.48868f
C1222 PC12 a_52554_3632# 0.38229f
C1223 a_70_2618# a_n73_2866# 0.14626f
C1224 VDD a_33791_2866# 0.94509f
C1225 a_48321_3632# a_47961_3404# 0.40854f
C1226 RSTn VSS 8.33862f
C1227 CLK VSS 12.94765f
C1228 PC15 VSS 1.08895f
C1229 PC_NEXT15 VSS 0.67899f
C1230 PC14 VSS 1.3693f
C1231 PC13 VSS 1.36829f
C1232 PC12 VSS 1.37015f
C1233 PC11 VSS 1.36837f
C1234 PC10 VSS 1.36877f
C1235 PC9 VSS 1.36893f
C1236 PC8 VSS 1.3703f
C1237 PC7 VSS 1.36869f
C1238 PC6 VSS 1.36885f
C1239 PC5 VSS 1.36922f
C1240 PC4 VSS 1.3703f
C1241 PC3 VSS 1.36837f
C1242 PC2 VSS 1.36901f
C1243 PC1 VSS 1.36845f
C1244 PC0 VSS 1.74807f
C1245 SI VSS 0.30329f
C1246 SE VSS 11.9977f
C1247 DEST15 VSS 0.37412f
C1248 DEST14 VSS 0.37412f
C1249 DEST13 VSS 0.37412f
C1250 DEST12 VSS 0.37412f
C1251 DEST11 VSS 0.37412f
C1252 DEST10 VSS 0.37412f
C1253 DEST9 VSS 0.37412f
C1254 DEST8 VSS 0.37412f
C1255 DEST7 VSS 0.28402f
C1256 DISP6 VSS 0.3371f
C1257 DEST6 VSS 0.37412f
C1258 DISP5 VSS 0.37938f
C1259 DEST5 VSS 0.37412f
C1260 DISP4 VSS 0.37944f
C1261 DEST4 VSS 0.37412f
C1262 DISP3 VSS 0.37938f
C1263 DEST3 VSS 0.37412f
C1264 DISP2 VSS 0.37944f
C1265 DEST2 VSS 0.37412f
C1266 DISP1 VSS 0.27812f
C1267 DEST1 VSS 0.37412f
C1268 DEST0 VSS 0.40408f
C1269 BR VSS 13.70948f
C1270 JMP VSS 13.47524f
C1271 DISP7 VSS 1.01826f
C1272 VDD VSS 0.29174p
C1273 a_64021_3118# VSS 0.11855f
C1274 a_65315_3118# VSS 1.09799f
C1275 a_64980_2618# VSS 1.01815f
C1276 a_63869_2618# VSS 0.62165f
C1277 a_63565_2618# VSS 1.12304f
C1278 a_63028_2616# VSS 0.95589f
C1279 a_59788_3118# VSS 0.11855f
C1280 a_61082_3118# VSS 1.06522f
C1281 a_60747_2618# VSS 1.01336f
C1282 a_59636_2618# VSS 0.62116f
C1283 a_59332_2618# VSS 1.12304f
C1284 a_58795_2616# VSS 0.95048f
C1285 a_55555_3118# VSS 0.11855f
C1286 a_56849_3118# VSS 1.06522f
C1287 a_56514_2618# VSS 1.01336f
C1288 a_55403_2618# VSS 0.62116f
C1289 a_55099_2618# VSS 1.12304f
C1290 a_54562_2616# VSS 0.95048f
C1291 a_51322_3118# VSS 0.11855f
C1292 a_52616_3118# VSS 1.06522f
C1293 a_52281_2618# VSS 1.01336f
C1294 a_51170_2618# VSS 0.62116f
C1295 a_50866_2618# VSS 1.12304f
C1296 a_50329_2616# VSS 0.95048f
C1297 a_47089_3118# VSS 0.11855f
C1298 a_48383_3118# VSS 1.06522f
C1299 a_48048_2618# VSS 1.01336f
C1300 a_46937_2618# VSS 0.62116f
C1301 a_46633_2618# VSS 1.12304f
C1302 a_46096_2616# VSS 0.95048f
C1303 a_42856_3118# VSS 0.11855f
C1304 a_44150_3118# VSS 1.06522f
C1305 a_43815_2618# VSS 1.01336f
C1306 a_42704_2618# VSS 0.62116f
C1307 a_42400_2618# VSS 1.12304f
C1308 a_41863_2616# VSS 0.95048f
C1309 a_38623_3118# VSS 0.11855f
C1310 a_39917_3118# VSS 1.06522f
C1311 a_39582_2618# VSS 1.01336f
C1312 a_38471_2618# VSS 0.62116f
C1313 a_38167_2618# VSS 1.12304f
C1314 a_37630_2616# VSS 0.95048f
C1315 a_34390_3118# VSS 0.11855f
C1316 a_35684_3118# VSS 1.06522f
C1317 a_35349_2618# VSS 1.01336f
C1318 a_34238_2618# VSS 0.62116f
C1319 a_33934_2618# VSS 1.12304f
C1320 a_33397_2616# VSS 0.95048f
C1321 a_30157_3118# VSS 0.11855f
C1322 a_31451_3118# VSS 1.06522f
C1323 a_31116_2618# VSS 1.01336f
C1324 a_30005_2618# VSS 0.62116f
C1325 a_29701_2618# VSS 1.12304f
C1326 a_29164_2616# VSS 0.95048f
C1327 a_25924_3118# VSS 0.11855f
C1328 a_27218_3118# VSS 1.06522f
C1329 a_26883_2618# VSS 1.01336f
C1330 a_25772_2618# VSS 0.62116f
C1331 a_25468_2618# VSS 1.12304f
C1332 a_24931_2616# VSS 0.95048f
C1333 a_21691_3118# VSS 0.11855f
C1334 a_22985_3118# VSS 1.06522f
C1335 a_22650_2618# VSS 1.01336f
C1336 a_21539_2618# VSS 0.62116f
C1337 a_21235_2618# VSS 1.12304f
C1338 a_20698_2616# VSS 0.95048f
C1339 a_17458_3118# VSS 0.11855f
C1340 a_18752_3118# VSS 1.06522f
C1341 a_18417_2618# VSS 1.01336f
C1342 a_17306_2618# VSS 0.62116f
C1343 a_17002_2618# VSS 1.12304f
C1344 a_16465_2616# VSS 0.95048f
C1345 a_13225_3118# VSS 0.11855f
C1346 a_14519_3118# VSS 1.06522f
C1347 a_14184_2618# VSS 1.01336f
C1348 a_13073_2618# VSS 0.62116f
C1349 a_12769_2618# VSS 1.12304f
C1350 a_12232_2616# VSS 0.95048f
C1351 a_8992_3118# VSS 0.11855f
C1352 a_10286_3118# VSS 1.06522f
C1353 a_9951_2618# VSS 1.01336f
C1354 a_8840_2618# VSS 0.62116f
C1355 a_8536_2618# VSS 1.12304f
C1356 a_7999_2616# VSS 0.95048f
C1357 a_4759_3118# VSS 0.11855f
C1358 a_6053_3118# VSS 1.06522f
C1359 a_5718_2618# VSS 1.01319f
C1360 a_4607_2618# VSS 0.62116f
C1361 a_4303_2618# VSS 1.12304f
C1362 a_3766_2616# VSS 0.95048f
C1363 a_526_3118# VSS 0.11877f
C1364 a_1820_3118# VSS 1.06548f
C1365 a_1485_2618# VSS 1.01389f
C1366 a_374_2618# VSS 0.62863f
C1367 a_70_2618# VSS 1.13315f
C1368 a_n467_2616# VSS 1.00617f
C1369 a_66845_3448# VSS 0.16655f
C1370 a_65941_3908# VSS 0.3035f
C1371 a_65317_3908# VSS 0.28953f
C1372 a_65253_3632# VSS 0.59951f
C1373 a_64733_3392# VSS 0.39834f
C1374 a_62612_3448# VSS 1.01419f
C1375 a_61708_3908# VSS 0.3035f
C1376 a_61084_3908# VSS 0.28953f
C1377 a_63028_3400# VSS 0.43171f
C1378 a_61020_3632# VSS 0.57947f
C1379 a_60500_3392# VSS 0.39834f
C1380 a_59189_2866# VSS 0.67899f
C1381 a_58379_3448# VSS 1.00633f
C1382 a_57475_3908# VSS 0.3035f
C1383 a_56851_3908# VSS 0.28953f
C1384 a_58795_3400# VSS 0.4308f
C1385 a_56787_3632# VSS 0.57908f
C1386 a_56267_3392# VSS 0.39834f
C1387 a_54956_2866# VSS 0.67899f
C1388 a_54146_3448# VSS 1.00747f
C1389 a_53242_3908# VSS 0.3035f
C1390 a_52618_3908# VSS 0.28953f
C1391 a_54562_3400# VSS 0.4308f
C1392 a_52554_3632# VSS 0.57947f
C1393 a_52034_3392# VSS 0.39834f
C1394 a_50723_2866# VSS 0.67899f
C1395 a_49913_3448# VSS 1.00641f
C1396 a_49009_3908# VSS 0.3035f
C1397 a_48385_3908# VSS 0.28953f
C1398 a_50329_3400# VSS 0.4308f
C1399 a_48321_3632# VSS 0.57908f
C1400 a_47801_3392# VSS 0.39834f
C1401 a_46490_2866# VSS 0.67899f
C1402 a_45680_3448# VSS 1.00644f
C1403 a_44776_3908# VSS 0.3035f
C1404 a_44152_3908# VSS 0.28953f
C1405 a_46096_3400# VSS 0.4308f
C1406 a_44088_3632# VSS 0.57947f
C1407 a_43568_3392# VSS 0.39834f
C1408 a_42257_2866# VSS 0.67899f
C1409 a_41447_3448# VSS 1.00693f
C1410 a_40543_3908# VSS 0.3035f
C1411 a_39919_3908# VSS 0.28953f
C1412 a_41863_3400# VSS 0.4308f
C1413 a_39855_3632# VSS 0.57908f
C1414 a_39335_3392# VSS 0.39834f
C1415 a_38024_2866# VSS 0.67899f
C1416 a_37214_3448# VSS 1.00756f
C1417 a_36310_3908# VSS 0.3035f
C1418 a_35686_3908# VSS 0.28953f
C1419 a_37630_3400# VSS 0.4308f
C1420 a_35622_3632# VSS 0.57947f
C1421 a_35102_3392# VSS 0.39834f
C1422 a_33791_2866# VSS 0.67899f
C1423 a_32981_3448# VSS 1.00676f
C1424 a_32077_3908# VSS 0.3035f
C1425 a_31453_3908# VSS 0.28953f
C1426 a_33397_3400# VSS 0.4308f
C1427 a_31389_3632# VSS 0.57908f
C1428 a_30869_3392# VSS 0.39735f
C1429 a_29558_2866# VSS 0.67887f
C1430 a_28748_3448# VSS 1.00515f
C1431 a_27844_3908# VSS 0.3035f
C1432 a_27220_3908# VSS 0.28953f
C1433 a_29164_3400# VSS 0.43049f
C1434 a_27156_3632# VSS 0.57947f
C1435 a_26636_3392# VSS 0.39834f
C1436 a_25325_2866# VSS 0.67899f
C1437 a_24515_3448# VSS 1.0071f
C1438 a_23611_3908# VSS 0.3035f
C1439 a_22987_3908# VSS 0.28953f
C1440 a_24931_3400# VSS 0.4308f
C1441 a_22923_3632# VSS 0.57908f
C1442 a_22403_3392# VSS 0.39834f
C1443 a_21092_2866# VSS 0.67899f
C1444 a_20282_3448# VSS 1.00756f
C1445 a_19378_3908# VSS 0.3035f
C1446 a_18754_3908# VSS 0.28953f
C1447 a_20698_3400# VSS 0.4308f
C1448 a_18690_3632# VSS 0.57947f
C1449 a_18170_3392# VSS 0.39834f
C1450 a_16859_2866# VSS 0.67899f
C1451 a_16049_3448# VSS 1.00641f
C1452 a_15145_3908# VSS 0.3035f
C1453 a_14521_3908# VSS 0.28953f
C1454 a_16465_3400# VSS 0.4308f
C1455 a_14457_3632# VSS 0.57908f
C1456 a_13937_3392# VSS 0.39834f
C1457 a_12626_2866# VSS 0.67899f
C1458 a_11816_3448# VSS 1.0067f
C1459 a_10912_3908# VSS 0.3035f
C1460 a_10288_3908# VSS 0.28953f
C1461 a_12232_3400# VSS 0.4308f
C1462 a_10224_3632# VSS 0.57947f
C1463 a_9704_3392# VSS 0.39834f
C1464 a_8393_2866# VSS 0.67899f
C1465 a_7583_3448# VSS 1.0065f
C1466 a_6679_3908# VSS 0.30342f
C1467 a_6055_3908# VSS 0.28953f
C1468 a_7999_3400# VSS 0.4308f
C1469 a_5991_3632# VSS 0.57903f
C1470 a_5471_3392# VSS 0.39834f
C1471 a_4160_2866# VSS 0.67899f
C1472 a_3350_3448# VSS 1.00833f
C1473 a_2446_3908# VSS 0.72444f
C1474 a_1822_3908# VSS 0.70818f
C1475 a_3766_3400# VSS 0.43106f
C1476 a_1758_3632# VSS 2.02365f
C1477 a_1238_3392# VSS 0.7727f
C1478 a_n73_2866# VSS 0.70901f
C1479 a_n467_3400# VSS 0.48952f
C1480 a_64893_3404# VSS 2.71485f
C1481 a_63425_3400# VSS 0.66487f
C1482 a_63425_4236# VSS 0.57813f
C1483 a_60660_3404# VSS 2.60003f
C1484 a_59192_3400# VSS 0.665f
C1485 a_59192_4236# VSS 0.57705f
C1486 a_56427_3404# VSS 2.57142f
C1487 a_54959_3400# VSS 0.66487f
C1488 a_54959_4236# VSS 0.57705f
C1489 a_52194_3404# VSS 2.60003f
C1490 a_50726_3400# VSS 0.665f
C1491 a_50726_4236# VSS 0.57705f
C1492 a_47961_3404# VSS 2.57142f
C1493 a_46493_3400# VSS 0.66487f
C1494 a_46493_4236# VSS 0.57705f
C1495 a_43728_3404# VSS 2.60003f
C1496 a_42260_3400# VSS 0.665f
C1497 a_42260_4236# VSS 0.57705f
C1498 a_39495_3404# VSS 2.57142f
C1499 a_38027_3400# VSS 0.66487f
C1500 a_38027_4236# VSS 0.57705f
C1501 a_35262_3404# VSS 2.60003f
C1502 a_33794_3400# VSS 0.665f
C1503 a_33794_4236# VSS 0.57705f
C1504 a_31029_3404# VSS 2.56449f
C1505 a_29561_3400# VSS 0.66487f
C1506 a_29561_4236# VSS 0.62851f
C1507 a_26796_3404# VSS 2.60003f
C1508 a_25328_3400# VSS 0.665f
C1509 a_25328_4236# VSS 0.72604f
C1510 a_22563_3404# VSS 2.57142f
C1511 a_21095_3400# VSS 0.66487f
C1512 a_21095_4236# VSS 0.72604f
C1513 a_18330_3404# VSS 2.60003f
C1514 a_16862_3400# VSS 0.665f
C1515 a_16862_4236# VSS 0.72604f
C1516 a_14097_3404# VSS 2.57142f
C1517 a_12629_3400# VSS 0.66487f
C1518 a_12629_4236# VSS 0.72604f
C1519 a_9864_3404# VSS 2.60003f
C1520 a_8396_3400# VSS 0.665f
C1521 a_8396_4236# VSS 0.72604f
C1522 a_5631_3404# VSS 2.50798f
C1523 a_4163_3400# VSS 0.66487f
C1524 a_4163_4236# VSS 0.72604f
C1525 a_3042_4236# VSS 0.37944f
C1526 a_1398_3404# VSS 2.73475f
C1527 a_n70_3400# VSS 0.7002f
C1528 a_n70_4236# VSS 0.9967f
C1529 a_65837_4236# VSS 0.83327f
C1530 a_63028_4236# VSS 0.50366f
C1531 a_61604_4236# VSS 0.80643f
C1532 a_58795_4236# VSS 0.50379f
C1533 a_57371_4236# VSS 0.806f
C1534 a_54562_4236# VSS 0.50351f
C1535 a_53138_4236# VSS 0.80634f
C1536 a_50329_4236# VSS 0.50376f
C1537 a_48905_4236# VSS 0.80599f
C1538 a_46096_4236# VSS 0.5038f
C1539 a_44672_4236# VSS 0.80648f
C1540 a_41863_4236# VSS 0.50361f
C1541 a_40439_4236# VSS 0.80594f
C1542 a_37630_4236# VSS 0.50349f
C1543 a_36206_4236# VSS 0.80632f
C1544 a_33397_4236# VSS 0.50366f
C1545 a_31973_4236# VSS 0.80595f
C1546 a_29164_4236# VSS 0.48998f
C1547 a_27740_4236# VSS 0.80647f
C1548 a_24931_4236# VSS 0.50357f
C1549 a_23507_4236# VSS 0.8059f
C1550 a_20698_4236# VSS 0.50349f
C1551 a_19274_4236# VSS 0.80632f
C1552 a_16465_4236# VSS 0.50376f
C1553 a_15041_4236# VSS 0.80599f
C1554 a_12232_4236# VSS 0.50373f
C1555 a_10808_4236# VSS 0.80646f
C1556 a_7999_4236# VSS 0.50373f
C1557 a_6575_4236# VSS 0.58445f
C1558 a_3766_4236# VSS 0.50339f
C1559 a_2342_4236# VSS 0.80996f
C1560 a_n467_4236# VSS 0.55759f
C1561 a_29172_5022# VSS 2.86274f
C1562 a_29956_5022.n0 VSS 0.41366f
C1563 a_29956_5022.n1 VSS 0.17374f
C1564 a_29956_5022.n2 VSS 1.32943f
C1565 a_29956_5022.n3 VSS 0.17374f
C1566 a_29956_5022.n4 VSS 0.97552f
C1567 a_29956_5022.n5 VSS 0.17374f
C1568 a_29956_5022.n6 VSS 0.97552f
C1569 a_29956_5022.n15 VSS 0.14219f
C1570 a_29956_5022.n16 VSS 0.17193f
C1571 a_29956_5022.n17 VSS 0.17212f
C1572 a_29956_5022.n18 VSS 0.17212f
C1573 a_29956_5022.n19 VSS 0.21111f
C1574 a_29956_5022.n20 VSS 0.17374f
C1575 a_29956_5022.n21 VSS 0.82335f
C1576 a_29956_5022.n22 VSS 0.17374f
C1577 a_29956_5022.n23 VSS 0.97552f
C1578 a_29956_5022.n24 VSS 0.17374f
C1579 a_29956_5022.n25 VSS 0.97552f
C1580 a_29956_5022.n26 VSS 0.17374f
C1581 a_29956_5022.n27 VSS 0.97552f
C1582 a_29956_5022.n28 VSS 0.97552f
C1583 a_29956_5022.n29 VSS 0.17374f
C1584 BR.n0 VSS 0.37196f
C1585 BR.n1 VSS 0.15506f
C1586 BR.n2 VSS 1.40414f
C1587 BR.n3 VSS 0.33013f
C1588 BR.n4 VSS 0.97191f
C1589 BR.n5 VSS 0.15506f
C1590 BR.n6 VSS 1.00608f
C1591 BR.n7 VSS 0.33013f
C1592 BR.n8 VSS 0.97191f
C1593 BR.n9 VSS 0.15506f
C1594 BR.n10 VSS 1.00608f
C1595 BR.n11 VSS 0.33013f
C1596 BR.n12 VSS 0.97191f
C1597 BR.n13 VSS 0.15506f
C1598 BR.n14 VSS 1.00608f
C1599 BR.n15 VSS 0.33013f
C1600 BR.n16 VSS 0.97191f
C1601 BR.n17 VSS 0.15506f
C1602 BR.n18 VSS 1.00608f
C1603 BR.n19 VSS 0.33013f
C1604 BR.n20 VSS 0.97191f
C1605 BR.n21 VSS 0.15506f
C1606 BR.n22 VSS 1.00608f
C1607 BR.n23 VSS 0.33013f
C1608 BR.n24 VSS 0.97191f
C1609 BR.n25 VSS 0.15506f
C1610 BR.n26 VSS 1.00608f
C1611 BR.n27 VSS 0.33013f
C1612 BR.n28 VSS 0.97191f
C1613 BR.n29 VSS 0.15506f
C1614 BR.n30 VSS 1.00608f
C1615 BR.n31 VSS 0.33013f
C1616 BR.n32 VSS 0.97191f
C1617 BR.n33 VSS 0.15506f
C1618 BR.n34 VSS 1.00608f
C1619 BR.n35 VSS 0.33013f
C1620 BR.n36 VSS 0.97191f
C1621 BR.n37 VSS 0.15506f
C1622 BR.n38 VSS 1.00608f
C1623 BR.n39 VSS 0.33013f
C1624 BR.n40 VSS 0.97191f
C1625 BR.n41 VSS 0.15506f
C1626 BR.n42 VSS 1.00608f
C1627 BR.n43 VSS 0.33013f
C1628 BR.n44 VSS 0.97191f
C1629 BR.n45 VSS 0.15506f
C1630 BR.n46 VSS 1.00608f
C1631 BR.n47 VSS 0.33013f
C1632 BR.n48 VSS 0.97191f
C1633 BR.n49 VSS 0.15506f
C1634 BR.n50 VSS 1.00608f
C1635 BR.n51 VSS 0.33013f
C1636 BR.n52 VSS 0.97191f
C1637 BR.n53 VSS 0.15506f
C1638 BR.n54 VSS 1.00608f
C1639 BR.n55 VSS 0.33013f
C1640 BR.n56 VSS 0.97191f
C1641 BR.n57 VSS 0.15506f
C1642 BR.n58 VSS 1.00608f
C1643 BR.n59 VSS 0.33013f
C1644 BR.n60 VSS 0.97191f
C1645 BR.n61 VSS 0.15506f
C1646 BR.n62 VSS 0.8575f
C1647 SE.n0 VSS 0.13645f
C1648 SE.n2 VSS 0.50852f
C1649 SE.n3 VSS 0.12253f
C1650 SE.n4 VSS 0.40384f
C1651 SE.n6 VSS 0.41241f
C1652 SE.n7 VSS 0.12253f
C1653 SE.n8 VSS 0.40384f
C1654 SE.n10 VSS 0.41241f
C1655 SE.n11 VSS 0.12253f
C1656 SE.n12 VSS 0.40384f
C1657 SE.n14 VSS 0.41241f
C1658 SE.n15 VSS 0.12253f
C1659 SE.n16 VSS 0.40384f
C1660 SE.n18 VSS 0.41241f
C1661 SE.n19 VSS 0.12253f
C1662 SE.n20 VSS 0.40384f
C1663 SE.n22 VSS 0.41241f
C1664 SE.n23 VSS 0.12253f
C1665 SE.n24 VSS 0.40384f
C1666 SE.n26 VSS 0.41241f
C1667 SE.n27 VSS 0.12253f
C1668 SE.n28 VSS 0.40384f
C1669 SE.n30 VSS 0.41241f
C1670 SE.n31 VSS 0.12253f
C1671 SE.n32 VSS 0.40384f
C1672 SE.n34 VSS 0.41241f
C1673 SE.n35 VSS 0.12253f
C1674 SE.n36 VSS 0.40384f
C1675 SE.n38 VSS 0.41241f
C1676 SE.n39 VSS 0.12253f
C1677 SE.n40 VSS 0.40384f
C1678 SE.n42 VSS 0.41241f
C1679 SE.n43 VSS 0.12253f
C1680 SE.n44 VSS 0.40384f
C1681 SE.n46 VSS 0.41241f
C1682 SE.n47 VSS 0.12253f
C1683 SE.n48 VSS 0.40384f
C1684 SE.n50 VSS 0.41241f
C1685 SE.n51 VSS 0.12253f
C1686 SE.n52 VSS 0.40384f
C1687 SE.n54 VSS 0.41241f
C1688 SE.n55 VSS 0.12253f
C1689 SE.n56 VSS 0.40384f
C1690 SE.n58 VSS 0.41241f
C1691 SE.n59 VSS 0.12253f
C1692 SE.n60 VSS 0.40384f
C1693 SE.n62 VSS 0.10115f
C1694 JMP.n0 VSS 0.22928f
C1695 JMP.n1 VSS 0.17216f
C1696 JMP.n2 VSS 1.47288f
C1697 JMP.n3 VSS 0.20377f
C1698 JMP.n4 VSS 1.08279f
C1699 JMP.n5 VSS 0.17216f
C1700 JMP.n6 VSS 1.07445f
C1701 JMP.n7 VSS 0.20377f
C1702 JMP.n8 VSS 1.08279f
C1703 JMP.n9 VSS 0.17216f
C1704 JMP.n10 VSS 1.07445f
C1705 JMP.n11 VSS 0.20377f
C1706 JMP.n12 VSS 1.08279f
C1707 JMP.n13 VSS 0.17216f
C1708 JMP.n14 VSS 1.07445f
C1709 JMP.n15 VSS 0.20377f
C1710 JMP.n16 VSS 1.08279f
C1711 JMP.n17 VSS 0.17216f
C1712 JMP.n18 VSS 1.07445f
C1713 JMP.n19 VSS 0.20377f
C1714 JMP.n20 VSS 1.08279f
C1715 JMP.n21 VSS 0.17216f
C1716 JMP.n22 VSS 1.07445f
C1717 JMP.n23 VSS 0.20377f
C1718 JMP.n24 VSS 1.08279f
C1719 JMP.n25 VSS 0.17216f
C1720 JMP.n26 VSS 1.07445f
C1721 JMP.n27 VSS 0.20377f
C1722 JMP.n28 VSS 1.08279f
C1723 JMP.n29 VSS 0.17216f
C1724 JMP.n30 VSS 1.07445f
C1725 JMP.n31 VSS 0.20377f
C1726 JMP.n32 VSS 1.08279f
C1727 JMP.n33 VSS 0.17216f
C1728 JMP.n34 VSS 1.07445f
C1729 JMP.n35 VSS 0.20377f
C1730 JMP.n36 VSS 1.08279f
C1731 JMP.n37 VSS 0.17216f
C1732 JMP.n38 VSS 1.07445f
C1733 JMP.n39 VSS 0.20377f
C1734 JMP.n40 VSS 1.08279f
C1735 JMP.n41 VSS 0.17216f
C1736 JMP.n42 VSS 1.07445f
C1737 JMP.n43 VSS 0.20377f
C1738 JMP.n44 VSS 1.08279f
C1739 JMP.n45 VSS 0.17216f
C1740 JMP.n46 VSS 1.07445f
C1741 JMP.n47 VSS 0.20377f
C1742 JMP.n48 VSS 1.08279f
C1743 JMP.n49 VSS 0.17216f
C1744 JMP.n50 VSS 1.07445f
C1745 JMP.n51 VSS 0.20377f
C1746 JMP.n52 VSS 1.08279f
C1747 JMP.n53 VSS 0.17216f
C1748 JMP.n54 VSS 1.07445f
C1749 JMP.n55 VSS 0.20377f
C1750 JMP.n56 VSS 1.08279f
C1751 JMP.n57 VSS 0.17216f
C1752 JMP.n58 VSS 1.07445f
C1753 JMP.n59 VSS 0.20377f
C1754 JMP.n60 VSS 1.08279f
C1755 JMP.n61 VSS 0.17216f
C1756 JMP.n62 VSS 0.29477f
C1757 CLK.t66 VSS 0.13285f
C1758 CLK.t32 VSS 0.12485f
C1759 CLK.n0 VSS 1.49303f
C1760 CLK.t10 VSS 0.12055f
C1761 CLK.n1 VSS 0.68722f
C1762 CLK.n2 VSS 0.50493f
C1763 CLK.n3 VSS 0.17721f
C1764 CLK.n4 VSS 0.4947f
C1765 CLK.n5 VSS 0.67728f
C1766 CLK.t12 VSS 0.12485f
C1767 CLK.n6 VSS 0.62381f
C1768 CLK.t58 VSS 0.12055f
C1769 CLK.n7 VSS 0.68722f
C1770 CLK.n8 VSS 0.50493f
C1771 CLK.n9 VSS 0.17721f
C1772 CLK.n10 VSS 0.4947f
C1773 CLK.n11 VSS 0.67728f
C1774 CLK.t46 VSS 0.12485f
C1775 CLK.n12 VSS 0.62381f
C1776 CLK.t21 VSS 0.12055f
C1777 CLK.n13 VSS 0.68722f
C1778 CLK.n14 VSS 0.50493f
C1779 CLK.n15 VSS 0.17721f
C1780 CLK.n16 VSS 0.4947f
C1781 CLK.n17 VSS 0.67728f
C1782 CLK.t0 VSS 0.12485f
C1783 CLK.n18 VSS 0.62381f
C1784 CLK.t61 VSS 0.12055f
C1785 CLK.n19 VSS 0.68722f
C1786 CLK.n20 VSS 0.50493f
C1787 CLK.n21 VSS 0.17721f
C1788 CLK.n22 VSS 0.4947f
C1789 CLK.n23 VSS 0.67728f
C1790 CLK.t51 VSS 0.12485f
C1791 CLK.n24 VSS 0.62381f
C1792 CLK.t5 VSS 0.12055f
C1793 CLK.n25 VSS 0.68722f
C1794 CLK.n26 VSS 0.50493f
C1795 CLK.n27 VSS 0.17721f
C1796 CLK.n28 VSS 0.4947f
C1797 CLK.n29 VSS 0.67728f
C1798 CLK.t80 VSS 0.12485f
C1799 CLK.n30 VSS 0.62381f
C1800 CLK.t52 VSS 0.12055f
C1801 CLK.n31 VSS 0.68722f
C1802 CLK.n32 VSS 0.50493f
C1803 CLK.n33 VSS 0.17721f
C1804 CLK.n34 VSS 0.4947f
C1805 CLK.n35 VSS 0.67728f
C1806 CLK.t42 VSS 0.12485f
C1807 CLK.n36 VSS 0.62381f
C1808 CLK.t41 VSS 0.12055f
C1809 CLK.n37 VSS 0.68722f
C1810 CLK.n38 VSS 0.50493f
C1811 CLK.n39 VSS 0.17721f
C1812 CLK.n40 VSS 0.4947f
C1813 CLK.n41 VSS 0.67728f
C1814 CLK.t20 VSS 0.12485f
C1815 CLK.n42 VSS 0.62381f
C1816 CLK.t31 VSS 0.12055f
C1817 CLK.n43 VSS 0.68722f
C1818 CLK.n44 VSS 0.50493f
C1819 CLK.n45 VSS 0.17721f
C1820 CLK.n46 VSS 0.4947f
C1821 CLK.n47 VSS 0.67728f
C1822 CLK.t65 VSS 0.12485f
C1823 CLK.n48 VSS 0.62381f
C1824 CLK.t85 VSS 0.12055f
C1825 CLK.n49 VSS 0.68722f
C1826 CLK.n50 VSS 0.50493f
C1827 CLK.n51 VSS 0.17721f
C1828 CLK.n52 VSS 0.4947f
C1829 CLK.n53 VSS 0.67728f
C1830 CLK.t68 VSS 0.12485f
C1831 CLK.n54 VSS 0.62381f
C1832 CLK.t67 VSS 0.12055f
C1833 CLK.n55 VSS 0.68722f
C1834 CLK.n56 VSS 0.50493f
C1835 CLK.n57 VSS 0.17721f
C1836 CLK.n58 VSS 0.4947f
C1837 CLK.n59 VSS 0.67728f
C1838 CLK.t47 VSS 0.12485f
C1839 CLK.n60 VSS 0.62381f
C1840 CLK.t95 VSS 0.12055f
C1841 CLK.n61 VSS 0.68722f
C1842 CLK.n62 VSS 0.50493f
C1843 CLK.n63 VSS 0.17721f
C1844 CLK.n64 VSS 0.4947f
C1845 CLK.n65 VSS 0.67728f
C1846 CLK.t15 VSS 0.12485f
C1847 CLK.n66 VSS 0.62381f
C1848 CLK.t27 VSS 0.12055f
C1849 CLK.n67 VSS 0.68722f
C1850 CLK.n68 VSS 0.50493f
C1851 CLK.n69 VSS 0.17721f
C1852 CLK.n70 VSS 0.4947f
C1853 CLK.n71 VSS 0.67728f
C1854 CLK.t37 VSS 0.12485f
C1855 CLK.n72 VSS 0.62381f
C1856 CLK.t6 VSS 0.12055f
C1857 CLK.n73 VSS 0.68722f
C1858 CLK.n74 VSS 0.50493f
C1859 CLK.n75 VSS 0.17721f
C1860 CLK.n76 VSS 0.4947f
C1861 CLK.n77 VSS 0.67728f
C1862 CLK.t1 VSS 0.12485f
C1863 CLK.n78 VSS 0.62381f
C1864 CLK.t71 VSS 0.12055f
C1865 CLK.n79 VSS 0.68722f
C1866 CLK.n80 VSS 0.50493f
C1867 CLK.n81 VSS 0.17721f
C1868 CLK.n82 VSS 0.4947f
C1869 CLK.n83 VSS 0.67728f
C1870 CLK.t49 VSS 0.12485f
C1871 CLK.n84 VSS 0.62381f
C1872 CLK.t3 VSS 0.12055f
C1873 CLK.n85 VSS 0.68722f
C1874 CLK.n86 VSS 0.50493f
C1875 CLK.n87 VSS 0.17721f
C1876 CLK.n88 VSS 0.4947f
C1877 CLK.n89 VSS 0.67728f
C1878 CLK.t75 VSS 0.12485f
C1879 CLK.n90 VSS 0.62381f
C1880 CLK.t79 VSS 0.12055f
C1881 CLK.n91 VSS 0.68722f
C1882 CLK.n92 VSS 0.50493f
C1883 CLK.n93 VSS 0.17721f
C1884 CLK.n94 VSS 0.21323f
C1885 RSTn.n0 VSS 0.28864f
C1886 RSTn.n1 VSS 0.18693f
C1887 RSTn.n2 VSS 2.01105f
C1888 RSTn.n3 VSS 0.18695f
C1889 RSTn.n4 VSS 1.04512f
C1890 RSTn.n5 VSS 0.18693f
C1891 RSTn.n6 VSS 1.04509f
C1892 RSTn.n7 VSS 0.18695f
C1893 RSTn.n8 VSS 1.04512f
C1894 RSTn.n9 VSS 0.18693f
C1895 RSTn.n10 VSS 1.04509f
C1896 RSTn.n11 VSS 0.18695f
C1897 RSTn.n12 VSS 1.04512f
C1898 RSTn.n13 VSS 0.18693f
C1899 RSTn.n14 VSS 1.04509f
C1900 RSTn.n15 VSS 0.18695f
C1901 RSTn.n16 VSS 1.04512f
C1902 RSTn.n17 VSS 0.18693f
C1903 RSTn.n18 VSS 1.04509f
C1904 RSTn.n19 VSS 0.18695f
C1905 RSTn.n20 VSS 1.04512f
C1906 RSTn.n21 VSS 0.18693f
C1907 RSTn.n22 VSS 1.04509f
C1908 RSTn.n23 VSS 0.18695f
C1909 RSTn.n24 VSS 1.04512f
C1910 RSTn.n25 VSS 0.18693f
C1911 RSTn.n26 VSS 1.04509f
C1912 RSTn.n27 VSS 0.18695f
C1913 RSTn.n28 VSS 1.04512f
C1914 RSTn.n29 VSS 0.18693f
C1915 RSTn.n30 VSS 1.04509f
C1916 RSTn.n31 VSS 0.18695f
C1917 RSTn.n32 VSS 1.04512f
C1918 RSTn.n33 VSS 0.18693f
C1919 RSTn.n34 VSS 1.04509f
C1920 RSTn.n35 VSS 0.18695f
C1921 RSTn.n36 VSS 1.04512f
C1922 RSTn.n37 VSS 0.18693f
C1923 RSTn.n38 VSS 1.04509f
C1924 RSTn.n39 VSS 0.18695f
C1925 RSTn.n40 VSS 1.04512f
C1926 RSTn.n41 VSS 0.18693f
C1927 RSTn.n42 VSS 1.04509f
C1928 RSTn.n43 VSS 0.18695f
C1929 RSTn.n44 VSS 1.04512f
C1930 RSTn.n45 VSS 0.18693f
C1931 RSTn.n46 VSS 1.04509f
C1932 RSTn.n47 VSS 0.18695f
C1933 RSTn.n48 VSS 1.04512f
C1934 RSTn.n49 VSS 0.18693f
C1935 RSTn.n50 VSS 1.04509f
C1936 RSTn.n51 VSS 0.18695f
C1937 RSTn.n52 VSS 1.04512f
C1938 RSTn.n53 VSS 0.18693f
C1939 RSTn.n54 VSS 1.04509f
C1940 RSTn.n55 VSS 0.18695f
C1941 RSTn.n56 VSS 1.04512f
C1942 RSTn.n57 VSS 0.18693f
C1943 RSTn.n58 VSS 1.04509f
C1944 RSTn.n59 VSS 0.18695f
C1945 RSTn.n60 VSS 1.04512f
C1946 RSTn.n61 VSS 0.18693f
C1947 RSTn.n62 VSS 0.67563f
C1948 VDD.t680 VSS 0.31307f
C1949 VDD.t361 VSS 0.24826f
C1950 VDD.t119 VSS 0.67292f
C1951 VDD.t197 VSS 0.7622f
C1952 VDD.t411 VSS 0.21401f
C1953 VDD.t120 VSS 0.192f
C1954 VDD.n0 VSS 0.21494f
C1955 VDD.t739 VSS 0.27761f
C1956 VDD.t395 VSS 0.24826f
C1957 VDD.t414 VSS 0.67292f
C1958 VDD.t409 VSS 0.7622f
C1959 VDD.t43 VSS 0.21401f
C1960 VDD.t354 VSS 0.28372f
C1961 VDD.t136 VSS 0.40724f
C1962 VDD.t360 VSS 0.24826f
C1963 VDD.t224 VSS 0.67292f
C1964 VDD.t627 VSS 0.7622f
C1965 VDD.t48 VSS 0.21401f
C1966 VDD.t679 VSS 0.192f
C1967 VDD.n2 VSS 0.21494f
C1968 VDD.t548 VSS 0.27761f
C1969 VDD.t133 VSS 0.24826f
C1970 VDD.t469 VSS 0.67292f
C1971 VDD.t200 VSS 0.7622f
C1972 VDD.t199 VSS 0.21401f
C1973 VDD.t566 VSS 0.28372f
C1974 VDD.t684 VSS 0.40724f
C1975 VDD.t741 VSS 0.24826f
C1976 VDD.t124 VSS 0.67292f
C1977 VDD.t329 VSS 0.7622f
C1978 VDD.t45 VSS 0.21401f
C1979 VDD.t738 VSS 0.192f
C1980 VDD.n3 VSS 0.21494f
C1981 VDD.t448 VSS 0.27761f
C1982 VDD.t398 VSS 0.24826f
C1983 VDD.t72 VSS 0.67292f
C1984 VDD.t309 VSS 0.7622f
C1985 VDD.t624 VSS 0.21401f
C1986 VDD.t7 VSS 0.28372f
C1987 VDD.t134 VSS 0.40724f
C1988 VDD.t551 VSS 0.24826f
C1989 VDD.t527 VSS 0.67292f
C1990 VDD.t41 VSS 0.7622f
C1991 VDD.t355 VSS 0.21401f
C1992 VDD.t392 VSS 0.192f
C1993 VDD.n4 VSS 0.15134f
C1994 VDD.t439 VSS 1.51445f
C1995 VDD.t276 VSS 0.72448f
C1996 VDD.t376 VSS 0.11461f
C1997 VDD.n10 VSS 0.99146f
C1998 VDD.t727 VSS 0.2718f
C1999 VDD.t629 VSS 0.21401f
C2000 VDD.t187 VSS 0.28372f
C2001 VDD.t399 VSS 0.40724f
C2002 VDD.t450 VSS 0.24826f
C2003 VDD.t585 VSS 0.67292f
C2004 VDD.t729 VSS 0.7622f
C2005 VDD.t202 VSS 0.21401f
C2006 VDD.t433 VSS 0.192f
C2007 VDD.n11 VSS 0.21494f
C2008 VDD.t358 VSS 0.27761f
C2009 VDD.t387 VSS 0.24826f
C2010 VDD.t251 VSS 0.67292f
C2011 VDD.t312 VSS 0.7622f
C2012 VDD.t320 VSS 0.21401f
C2013 VDD.t203 VSS 0.28372f
C2014 VDD.t682 VSS 0.40724f
C2015 VDD.t445 VSS 0.24826f
C2016 VDD.t34 VSS 0.67292f
C2017 VDD.t625 VSS 0.7622f
C2018 VDD.t311 VSS 0.21401f
C2019 VDD.t468 VSS 0.192f
C2020 VDD.n12 VSS 0.21494f
C2021 VDD.t686 VSS 0.27761f
C2022 VDD.t396 VSS 0.24826f
C2023 VDD.t250 VSS 0.67292f
C2024 VDD.t46 VSS 0.7622f
C2025 VDD.t196 VSS 0.21401f
C2026 VDD.t51 VSS 0.28372f
C2027 VDD.t401 VSS 0.40724f
C2028 VDD.t378 VSS 0.24826f
C2029 VDD.t152 VSS 0.67292f
C2030 VDD.t407 VSS 0.7622f
C2031 VDD.t731 VSS 0.21401f
C2032 VDD.t123 VSS 0.192f
C2033 VDD.n13 VSS 0.21494f
C2034 VDD.t221 VSS 0.37789f
C2035 VDD.t726 VSS 0.21401f
C2036 VDD.t351 VSS 0.7622f
C2037 VDD.t231 VSS 0.67292f
C2038 VDD.t451 VSS 0.24826f
C2039 VDD.t379 VSS 0.27761f
C2040 VDD.t446 VSS 0.27761f
C2041 VDD.t397 VSS 0.24826f
C2042 VDD.t470 VSS 0.67292f
C2043 VDD.t604 VSS 0.7622f
C2044 VDD.t331 VSS 0.21401f
C2045 VDD.t204 VSS 0.28372f
C2046 VDD.t131 VSS 0.40724f
C2047 VDD.t550 VSS 0.24826f
C2048 VDD.t4 VSS 0.67292f
C2049 VDD.t630 VSS 0.7622f
C2050 VDD.t350 VSS 0.21401f
C2051 VDD.t438 VSS 0.192f
C2052 VDD.n14 VSS 0.21494f
C2053 VDD.t352 VSS 0.11738f
C2054 VDD.n15 VSS 0.67765f
C2055 VDD.n16 VSS 0.13507f
C2056 VDD.n17 VSS 0.38813f
C2057 VDD.n18 VSS 0.40872f
C2058 VDD.n19 VSS 0.40872f
C2059 VDD.n20 VSS 0.29603f
C2060 VDD.n21 VSS 0.13507f
C2061 VDD.n22 VSS 0.38813f
C2062 VDD.n23 VSS 0.40872f
C2063 VDD.n24 VSS 0.40872f
C2064 VDD.n25 VSS 0.29603f
C2065 VDD.n26 VSS 0.13507f
C2066 VDD.n27 VSS 0.38813f
C2067 VDD.n28 VSS 0.40872f
C2068 VDD.n29 VSS 0.40872f
C2069 VDD.n30 VSS 0.29603f
C2070 VDD.n31 VSS 0.13507f
C2071 VDD.n32 VSS 0.38813f
C2072 VDD.n33 VSS 0.40872f
C2073 VDD.n34 VSS 0.20356f
C2074 VDD.n35 VSS 0.10689f
C2075 VDD.n42 VSS 0.13507f
C2076 VDD.n43 VSS 0.38813f
C2077 VDD.n44 VSS 0.40872f
C2078 VDD.n45 VSS 0.40872f
C2079 VDD.n46 VSS 0.29603f
C2080 VDD.n47 VSS 0.13507f
C2081 VDD.n48 VSS 0.38813f
C2082 VDD.n49 VSS 0.40872f
C2083 VDD.n50 VSS 0.40872f
C2084 VDD.n51 VSS 0.29603f
C2085 VDD.n52 VSS 0.13507f
C2086 VDD.n53 VSS 0.38813f
C2087 VDD.n54 VSS 0.36754f
C2088 VDD.n55 VSS 0.13594f
C2089 VDD.n56 VSS 0.31662f
C2090 VDD.n57 VSS 0.29603f
C2091 VDD.n58 VSS 0.13507f
C2092 VDD.n59 VSS 0.36782f
.ends
