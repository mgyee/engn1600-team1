** sch_path: /foss/designs/engn1600-team1/CAD7/sign_zero_extender.sch
.subckt sign_zero_extender EXTEND OUT IN VDD VSS
*.PININFO VDD:B VSS:B IN:I OUT:O EXTEND:I
M1 net1 net2 VDD VDD pfet_03v3 L=0.28u W='3*0.72u' nf=1 m=1
M2 net1 net2 VSS VSS nfet_03v3 L=0.28u W='3*0.36u' nf=1 m=1
M3 OUT net1 VDD VDD pfet_03v3 L=0.28u W='9*0.72u' nf=1 m=1
M4 OUT net1 VSS VSS nfet_03v3 L=0.28u W='9*0.36u' nf=1 m=1
x1 VDD net3 net2 VSS datapath_inv kINV=1
x2 VDD net3 EXTEND IN VSS datapath_nand2
.ends

* expanding   symbol:  engn1600-team1/CAD7/datapath_inv.sym # of pins=4
** sym_path: /foss/designs/engn1600-team1/CAD7/datapath_inv.sym
** sch_path: /foss/designs/engn1600-team1/CAD7/datapath_inv.sch
.subckt datapath_inv VDD IN OUT VSS  kINV=1
*.PININFO IN:I OUT:O VDD:B VSS:B
M1 OUT IN VDD VDD pfet_03v3 L=0.28u W='1*0.72u' nf=1 m=1
M2 OUT IN VSS VSS nfet_03v3 L=0.28u W='1*0.36u' nf=1 m=1
**** begin user architecture code

.param kINV=1

**** end user architecture code
.ends

* expanding   symbol:  engn1600-team1/CAD7/datapath_nand2.sym # of pins=5
** sym_path: /foss/designs/engn1600-team1/CAD7/datapath_nand2.sym
** sch_path: /foss/designs/engn1600-team1/CAD7/datapath_nand2.sch
.subckt datapath_nand2 VDD OUT IN0 IN1 VSS
*.PININFO VSS:B VDD:B IN0:I IN1:I OUT:O
M1 net1 IN1 VSS VSS nfet_03v3 L=0.28u W=0.72u nf=1 m=1
M2 OUT IN0 net1 VSS nfet_03v3 L=0.28u W=0.72u nf=1 m=1
M3 OUT IN1 VDD VDD pfet_03v3 L=0.28u W=0.72u nf=1 m=1
M4 OUT IN0 VDD VDD pfet_03v3 L=0.28u W=0.72u nf=1 m=1
.ends
