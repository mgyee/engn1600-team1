* CONTROL
* Instantiation
acontrol [ INSTR15 INSTR14 INSTR13 INSTR12 INSTR11 INSTR10 INSTR9 INSTR8 INSTR7 INSTR6 INSTR5 INSTR4 INSTR3 INSTR2 INSTR1 INSTR0 ALU_Z ALU_N ALU_F CLK ] [ REG_WRITE RA15 RA14 RA13 RA12 RA11 RA10 RA9 RA8 RA7 RA6 RA5 RA4 RA3 RA2 RA1 RA0 RB15 RB14 RB13 RB12 RB11 RB10 RB9 RB8 RB7 RB6 RB5 RB4 RB3 RB2 RB1 RB0 WE15 WE14 WE13 WE12 WE11 WE10 WE9 WE8 WE7 WE6 WE5 WE4 WE3 WE2 WE1 WE0 ALU_SEL1 ALU_SEL0 ALU_SRC_B ALU_SRC_A ALU_CIN EXTEND SHIFT_VAL_SRC IS_LUI SHIFT_AMT_SRC MEM_WRITE DATA_OUT3 DATA_OUT2 DATA_OUT1 DATA_OUT0 PC_BR PC_JMP ] null control
.model control d_cosim simulation="/foss/designs/engn1600-team1/CAD7/control.so" delay=10p

* Termination
Rcontrol_INSTR15 INSTR15 0 1G
Rcontrol_INSTR14 INSTR14 0 1G
Rcontrol_INSTR13 INSTR13 0 1G
Rcontrol_INSTR12 INSTR12 0 1G
Rcontrol_INSTR11 INSTR11 0 1G
Rcontrol_INSTR10 INSTR10 0 1G
Rcontrol_INSTR9 INSTR9 0 1G
Rcontrol_INSTR8 INSTR8 0 1G
Rcontrol_INSTR7 INSTR7 0 1G
Rcontrol_INSTR6 INSTR6 0 1G
Rcontrol_INSTR5 INSTR5 0 1G
Rcontrol_INSTR4 INSTR4 0 1G
Rcontrol_INSTR3 INSTR3 0 1G
Rcontrol_INSTR2 INSTR2 0 1G
Rcontrol_INSTR1 INSTR1 0 1G
Rcontrol_INSTR0 INSTR0 0 1G
Rcontrol_ALU_Z ALU_Z 0 1G
Rcontrol_ALU_N ALU_N 0 1G
Rcontrol_ALU_F ALU_F 0 1G
Rcontrol_CLK CLK 0 1G
Rcontrol_REG_WRITE REG_WRITE 0 1G
Rcontrol_RA15 RA15 0 1G
Rcontrol_RA14 RA14 0 1G
Rcontrol_RA13 RA13 0 1G
Rcontrol_RA12 RA12 0 1G
Rcontrol_RA11 RA11 0 1G
Rcontrol_RA10 RA10 0 1G
Rcontrol_RA9 RA9 0 1G
Rcontrol_RA8 RA8 0 1G
Rcontrol_RA7 RA7 0 1G
Rcontrol_RA6 RA6 0 1G
Rcontrol_RA5 RA5 0 1G
Rcontrol_RA4 RA4 0 1G
Rcontrol_RA3 RA3 0 1G
Rcontrol_RA2 RA2 0 1G
Rcontrol_RA1 RA1 0 1G
Rcontrol_RA0 RA0 0 1G
Rcontrol_RB15 RB15 0 1G
Rcontrol_RB14 RB14 0 1G
Rcontrol_RB13 RB13 0 1G
Rcontrol_RB12 RB12 0 1G
Rcontrol_RB11 RB11 0 1G
Rcontrol_RB10 RB10 0 1G
Rcontrol_RB9 RB9 0 1G
Rcontrol_RB8 RB8 0 1G
Rcontrol_RB7 RB7 0 1G
Rcontrol_RB6 RB6 0 1G
Rcontrol_RB5 RB5 0 1G
Rcontrol_RB4 RB4 0 1G
Rcontrol_RB3 RB3 0 1G
Rcontrol_RB2 RB2 0 1G
Rcontrol_RB1 RB1 0 1G
Rcontrol_RB0 RB0 0 1G
Rcontrol_WE15 WE15 0 1G
Rcontrol_WE14 WE14 0 1G
Rcontrol_WE13 WE13 0 1G
Rcontrol_WE12 WE12 0 1G
Rcontrol_WE11 WE11 0 1G
Rcontrol_WE10 WE10 0 1G
Rcontrol_WE9 WE9 0 1G
Rcontrol_WE8 WE8 0 1G
Rcontrol_WE7 WE7 0 1G
Rcontrol_WE6 WE6 0 1G
Rcontrol_WE5 WE5 0 1G
Rcontrol_WE4 WE4 0 1G
Rcontrol_WE3 WE3 0 1G
Rcontrol_WE2 WE2 0 1G
Rcontrol_WE1 WE1 0 1G
Rcontrol_WE0 WE0 0 1G
Rcontrol_ALU_SEL1 ALU_SEL1 0 1G
Rcontrol_ALU_SEL0 ALU_SEL0 0 1G
Rcontrol_ALU_SRC_B ALU_SRC_B 0 1G
Rcontrol_ALU_SRC_A ALU_SRC_A 0 1G
Rcontrol_ALU_CIN ALU_CIN 0 1G
Rcontrol_EXTEND EXTEND 0 1G
Rcontrol_SHIFT_VAL_SRC SHIFT_VAL_SRC 0 1G
Rcontrol_IS_LUI IS_LUI 0 1G
Rcontrol_SHIFT_AMT_SRC SHIFT_AMT_SRC 0 1G
Rcontrol_MEM_WRITE MEM_WRITE 0 1G
Rcontrol_DATA_OUT3 DATA_OUT3 0 1G
Rcontrol_DATA_OUT2 DATA_OUT2 0 1G
Rcontrol_DATA_OUT1 DATA_OUT1 0 1G
Rcontrol_DATA_OUT0 DATA_OUT0 0 1G
Rcontrol_PC_BR PC_BR 0 1G
Rcontrol_PC_JMP PC_JMP 0 1G

* DMEM
* Instantiation
admem [ CLK MEM_WRITE DMEM_ADDR15 DMEM_ADDR14 DMEM_ADDR13 DMEM_ADDR12 DMEM_ADDR11 DMEM_ADDR10 DMEM_ADDR9 DMEM_ADDR8 DMEM_ADDR7 DMEM_ADDR6 DMEM_ADDR5 DMEM_ADDR4 DMEM_ADDR3 DMEM_ADDR2 DMEM_ADDR1 DMEM_ADDR0 RDST15 RDST14 RDST13 RDST12 RDST11 RDST10 RDST9 RDST8 RDST7 RDST6 RDST5 RDST4 RDST3 RDST2 RDST1 RDST0 ] [ DMEM_Q15 DMEM_Q14 DMEM_Q13 DMEM_Q12 DMEM_Q11 DMEM_Q10 DMEM_Q9 DMEM_Q8 DMEM_Q7 DMEM_Q6 DMEM_Q5 DMEM_Q4 DMEM_Q3 DMEM_Q2 DMEM_Q1 DMEM_Q0 ] null dmem
.model dmem d_cosim simulation="/foss/designs/engn1600-team1/CAD7/dmem.so" delay=10p irreversible=2

* Termination
Rdmem_CLK CLK 0 1G
Rdmem_MEM_WRITE MEM_WRITE 0 1G
Rdmem_DMEM_ADDR15 DMEM_ADDR15 0 1G
Rdmem_DMEM_ADDR14 DMEM_ADDR14 0 1G
Rdmem_DMEM_ADDR13 DMEM_ADDR13 0 1G
Rdmem_DMEM_ADDR12 DMEM_ADDR12 0 1G
Rdmem_DMEM_ADDR11 DMEM_ADDR11 0 1G
Rdmem_DMEM_ADDR10 DMEM_ADDR10 0 1G
Rdmem_DMEM_ADDR9 DMEM_ADDR9 0 1G
Rdmem_DMEM_ADDR8 DMEM_ADDR8 0 1G
Rdmem_DMEM_ADDR7 DMEM_ADDR7 0 1G
Rdmem_DMEM_ADDR6 DMEM_ADDR6 0 1G
Rdmem_DMEM_ADDR5 DMEM_ADDR5 0 1G
Rdmem_DMEM_ADDR4 DMEM_ADDR4 0 1G
Rdmem_DMEM_ADDR3 DMEM_ADDR3 0 1G
Rdmem_DMEM_ADDR2 DMEM_ADDR2 0 1G
Rdmem_DMEM_ADDR1 DMEM_ADDR1 0 1G
Rdmem_DMEM_ADDR0 DMEM_ADDR0 0 1G
Rdmem_RDST15 RDST15 0 1G
Rdmem_RDST14 RDST14 0 1G
Rdmem_RDST13 RDST13 0 1G
Rdmem_RDST12 RDST12 0 1G
Rdmem_RDST11 RDST11 0 1G
Rdmem_RDST10 RDST10 0 1G
Rdmem_RDST9 RDST9 0 1G
Rdmem_RDST8 RDST8 0 1G
Rdmem_RDST7 RDST7 0 1G
Rdmem_RDST6 RDST6 0 1G
Rdmem_RDST5 RDST5 0 1G
Rdmem_RDST4 RDST4 0 1G
Rdmem_RDST3 RDST3 0 1G
Rdmem_RDST2 RDST2 0 1G
Rdmem_RDST1 RDST1 0 1G
Rdmem_RDST0 RDST0 0 1G
Rdmem_DMEM_Q15 DMEM_Q15 0 1G
Rdmem_DMEM_Q14 DMEM_Q14 0 1G
Rdmem_DMEM_Q13 DMEM_Q13 0 1G
Rdmem_DMEM_Q12 DMEM_Q12 0 1G
Rdmem_DMEM_Q11 DMEM_Q11 0 1G
Rdmem_DMEM_Q10 DMEM_Q10 0 1G
Rdmem_DMEM_Q9 DMEM_Q9 0 1G
Rdmem_DMEM_Q8 DMEM_Q8 0 1G
Rdmem_DMEM_Q7 DMEM_Q7 0 1G
Rdmem_DMEM_Q6 DMEM_Q6 0 1G
Rdmem_DMEM_Q5 DMEM_Q5 0 1G
Rdmem_DMEM_Q4 DMEM_Q4 0 1G
Rdmem_DMEM_Q3 DMEM_Q3 0 1G
Rdmem_DMEM_Q2 DMEM_Q2 0 1G
Rdmem_DMEM_Q1 DMEM_Q1 0 1G
Rdmem_DMEM_Q0 DMEM_Q0 0 1G

* IMEM
* Instantiation
aimem [ PC15 PC14 PC13 PC12 PC11 PC10 PC9 PC8 PC7 PC6 PC5 PC4 PC3 PC2 PC1 PC0 ] [ IMEM_Q15 IMEM_Q14 IMEM_Q13 IMEM_Q12 IMEM_Q11 IMEM_Q10 IMEM_Q9 IMEM_Q8 IMEM_Q7 IMEM_Q6 IMEM_Q5 IMEM_Q4 IMEM_Q3 IMEM_Q2 IMEM_Q1 IMEM_Q0 ] null imem
.model imem d_cosim simulation="/foss/designs/engn1600-team1/CAD7/imem.so" delay=10p irreversible=3

* Termination
Rimem_PC15 PC15 0 1G
Rimem_PC14 PC14 0 1G
Rimem_PC13 PC13 0 1G
Rimem_PC12 PC12 0 1G
Rimem_PC11 PC11 0 1G
Rimem_PC10 PC10 0 1G
Rimem_PC9 PC9 0 1G
Rimem_PC8 PC8 0 1G
Rimem_PC7 PC7 0 1G
Rimem_PC6 PC6 0 1G
Rimem_PC5 PC5 0 1G
Rimem_PC4 PC4 0 1G
Rimem_PC3 PC3 0 1G
Rimem_PC2 PC2 0 1G
Rimem_PC1 PC1 0 1G
Rimem_PC0 PC0 0 1G
Rimem_IMEM_Q15 IMEM_Q15 0 1G
Rimem_IMEM_Q14 IMEM_Q14 0 1G
Rimem_IMEM_Q13 IMEM_Q13 0 1G
Rimem_IMEM_Q12 IMEM_Q12 0 1G
Rimem_IMEM_Q11 IMEM_Q11 0 1G
Rimem_IMEM_Q10 IMEM_Q10 0 1G
Rimem_IMEM_Q9 IMEM_Q9 0 1G
Rimem_IMEM_Q8 IMEM_Q8 0 1G
Rimem_IMEM_Q7 IMEM_Q7 0 1G
Rimem_IMEM_Q6 IMEM_Q6 0 1G
Rimem_IMEM_Q5 IMEM_Q5 0 1G
Rimem_IMEM_Q4 IMEM_Q4 0 1G
Rimem_IMEM_Q3 IMEM_Q3 0 1G
Rimem_IMEM_Q2 IMEM_Q2 0 1G
Rimem_IMEM_Q1 IMEM_Q1 0 1G
Rimem_IMEM_Q0 IMEM_Q0 0 1G
