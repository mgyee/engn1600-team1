* CONTROL
* Instantiation
acontrol [ INSTR15 INSTR14 INSTR13 INSTR12 INSTR11 INSTR10 INSTR9 INSTR8 INSTR7 INSTR6 INSTR5 INSTR4 INSTR3 INSTR2 INSTR1 INSTR0 PSR_Z PSR_N PSR_F CLK ] [ REG_WRITE RA15 RA14 RA13 RA12 RA11 RA10 RA9 RA8 RA7 RA6 RA5 RA4 RA3 RA2 RA1 RA0 RB15 RB14 RB13 RB12 RB11 RB10 RB9 RB8 RB7 RB6 RB5 RB4 RB3 RB2 RB1 RB0 WE15 WE14 WE13 WE12 WE11 WE10 WE9 WE8 WE7 WE6 WE5 WE4 WE3 WE2 WE1 WE0 ALU_SEL1 ALU_SEL0 ALU_SRC_B ALU_SRC_A CIN EXTEND SHIFT_VAL_SRC IS_LUI SHIFT_AMT_SRC MEM_WRITE DATA_OUT3 DATA_OUT2 DATA_OUT1 DATA_OUT0 PC_BR PC_JMP ] null control
.model control d_cosim simulation="/foss/designs/engn1600-team1/CAD7/control.so" delay=10p

* Termination
Rcontrol_INSTR15 INSTR15 0 1G
Rcontrol_INSTR14 INSTR14 0 1G
Rcontrol_INSTR13 INSTR13 0 1G
Rcontrol_INSTR12 INSTR12 0 1G
Rcontrol_INSTR11 INSTR11 0 1G
Rcontrol_INSTR10 INSTR10 0 1G
Rcontrol_INSTR9 INSTR9 0 1G
Rcontrol_INSTR8 INSTR8 0 1G
Rcontrol_INSTR7 INSTR7 0 1G
Rcontrol_INSTR6 INSTR6 0 1G
Rcontrol_INSTR5 INSTR5 0 1G
Rcontrol_INSTR4 INSTR4 0 1G
Rcontrol_INSTR3 INSTR3 0 1G
Rcontrol_INSTR2 INSTR2 0 1G
Rcontrol_INSTR1 INSTR1 0 1G
Rcontrol_INSTR0 INSTR0 0 1G
Rcontrol_PSR_Z PSR_Z 0 1G
Rcontrol_PSR_N PSR_N 0 1G
Rcontrol_PSR_F PSR_F 0 1G
Rcontrol_CLK CLK 0 1G
Rcontrol_REG_WRITE REG_WRITE 0 1G
Rcontrol_RA15 RA15 0 1G
Rcontrol_RA14 RA14 0 1G
Rcontrol_RA13 RA13 0 1G
Rcontrol_RA12 RA12 0 1G
Rcontrol_RA11 RA11 0 1G
Rcontrol_RA10 RA10 0 1G
Rcontrol_RA9 RA9 0 1G
Rcontrol_RA8 RA8 0 1G
Rcontrol_RA7 RA7 0 1G
Rcontrol_RA6 RA6 0 1G
Rcontrol_RA5 RA5 0 1G
Rcontrol_RA4 RA4 0 1G
Rcontrol_RA3 RA3 0 1G
Rcontrol_RA2 RA2 0 1G
Rcontrol_RA1 RA1 0 1G
Rcontrol_RA0 RA0 0 1G
Rcontrol_RB15 RB15 0 1G
Rcontrol_RB14 RB14 0 1G
Rcontrol_RB13 RB13 0 1G
Rcontrol_RB12 RB12 0 1G
Rcontrol_RB11 RB11 0 1G
Rcontrol_RB10 RB10 0 1G
Rcontrol_RB9 RB9 0 1G
Rcontrol_RB8 RB8 0 1G
Rcontrol_RB7 RB7 0 1G
Rcontrol_RB6 RB6 0 1G
Rcontrol_RB5 RB5 0 1G
Rcontrol_RB4 RB4 0 1G
Rcontrol_RB3 RB3 0 1G
Rcontrol_RB2 RB2 0 1G
Rcontrol_RB1 RB1 0 1G
Rcontrol_RB0 RB0 0 1G
Rcontrol_WE15 WE15 0 1G
Rcontrol_WE14 WE14 0 1G
Rcontrol_WE13 WE13 0 1G
Rcontrol_WE12 WE12 0 1G
Rcontrol_WE11 WE11 0 1G
Rcontrol_WE10 WE10 0 1G
Rcontrol_WE9 WE9 0 1G
Rcontrol_WE8 WE8 0 1G
Rcontrol_WE7 WE7 0 1G
Rcontrol_WE6 WE6 0 1G
Rcontrol_WE5 WE5 0 1G
Rcontrol_WE4 WE4 0 1G
Rcontrol_WE3 WE3 0 1G
Rcontrol_WE2 WE2 0 1G
Rcontrol_WE1 WE1 0 1G
Rcontrol_WE0 WE0 0 1G
Rcontrol_ALU_SEL1 ALU_SEL1 0 1G
Rcontrol_ALU_SEL0 ALU_SEL0 0 1G
Rcontrol_ALU_SRC_B ALU_SRC_B 0 1G
Rcontrol_ALU_SRC_A ALU_SRC_A 0 1G
Rcontrol_CIN CIN 0 1G
Rcontrol_EXTEND EXTEND 0 1G
Rcontrol_SHIFT_VAL_SRC SHIFT_VAL_SRC 0 1G
Rcontrol_IS_LUI IS_LUI 0 1G
Rcontrol_SHIFT_AMT_SRC SHIFT_AMT_SRC 0 1G
Rcontrol_MEM_WRITE MEM_WRITE 0 1G
Rcontrol_DATA_OUT3 DATA_OUT3 0 1G
Rcontrol_DATA_OUT2 DATA_OUT2 0 1G
Rcontrol_DATA_OUT1 DATA_OUT1 0 1G
Rcontrol_DATA_OUT0 DATA_OUT0 0 1G
Rcontrol_PC_BR PC_BR 0 1G
Rcontrol_PC_JMP PC_JMP 0 1G

* DMEM
* Instantiation
admem [ CLK WE ADDR15 ADDR14 ADDR13 ADDR12 ADDR11 ADDR10 ADDR9 ADDR8 ADDR7 ADDR6 ADDR5 ADDR4 ADDR3 ADDR2 ADDR1 ADDR0 WDATA15 WDATA14 WDATA13 WDATA12 WDATA11 WDATA10 WDATA9 WDATA8 WDATA7 WDATA6 WDATA5 WDATA4 WDATA3 WDATA2 WDATA1 WDATA0 ] [ RDATA15 RDATA14 RDATA13 RDATA12 RDATA11 RDATA10 RDATA9 RDATA8 RDATA7 RDATA6 RDATA5 RDATA4 RDATA3 RDATA2 RDATA1 RDATA0 ] null dmem
.model dmem d_cosim simulation="/foss/designs/engn1600-team1/CAD7/dmem.so" delay=10p irreversible=2

* Termination
Rdmem_CLK CLK 0 1G
Rdmem_WE WE 0 1G
Rdmem_ADDR15 ADDR15 0 1G
Rdmem_ADDR14 ADDR14 0 1G
Rdmem_ADDR13 ADDR13 0 1G
Rdmem_ADDR12 ADDR12 0 1G
Rdmem_ADDR11 ADDR11 0 1G
Rdmem_ADDR10 ADDR10 0 1G
Rdmem_ADDR9 ADDR9 0 1G
Rdmem_ADDR8 ADDR8 0 1G
Rdmem_ADDR7 ADDR7 0 1G
Rdmem_ADDR6 ADDR6 0 1G
Rdmem_ADDR5 ADDR5 0 1G
Rdmem_ADDR4 ADDR4 0 1G
Rdmem_ADDR3 ADDR3 0 1G
Rdmem_ADDR2 ADDR2 0 1G
Rdmem_ADDR1 ADDR1 0 1G
Rdmem_ADDR0 ADDR0 0 1G
Rdmem_WDATA15 WDATA15 0 1G
Rdmem_WDATA14 WDATA14 0 1G
Rdmem_WDATA13 WDATA13 0 1G
Rdmem_WDATA12 WDATA12 0 1G
Rdmem_WDATA11 WDATA11 0 1G
Rdmem_WDATA10 WDATA10 0 1G
Rdmem_WDATA9 WDATA9 0 1G
Rdmem_WDATA8 WDATA8 0 1G
Rdmem_WDATA7 WDATA7 0 1G
Rdmem_WDATA6 WDATA6 0 1G
Rdmem_WDATA5 WDATA5 0 1G
Rdmem_WDATA4 WDATA4 0 1G
Rdmem_WDATA3 WDATA3 0 1G
Rdmem_WDATA2 WDATA2 0 1G
Rdmem_WDATA1 WDATA1 0 1G
Rdmem_WDATA0 WDATA0 0 1G
Rdmem_RDATA15 RDATA15 0 1G
Rdmem_RDATA14 RDATA14 0 1G
Rdmem_RDATA13 RDATA13 0 1G
Rdmem_RDATA12 RDATA12 0 1G
Rdmem_RDATA11 RDATA11 0 1G
Rdmem_RDATA10 RDATA10 0 1G
Rdmem_RDATA9 RDATA9 0 1G
Rdmem_RDATA8 RDATA8 0 1G
Rdmem_RDATA7 RDATA7 0 1G
Rdmem_RDATA6 RDATA6 0 1G
Rdmem_RDATA5 RDATA5 0 1G
Rdmem_RDATA4 RDATA4 0 1G
Rdmem_RDATA3 RDATA3 0 1G
Rdmem_RDATA2 RDATA2 0 1G
Rdmem_RDATA1 RDATA1 0 1G
Rdmem_RDATA0 RDATA0 0 1G

* IMEM
* Instantiation
aimem [ ADDR15 ADDR14 ADDR13 ADDR12 ADDR11 ADDR10 ADDR9 ADDR8 ADDR7 ADDR6 ADDR5 ADDR4 ADDR3 ADDR2 ADDR1 ADDR0 ] [ DATA15 DATA14 DATA13 DATA12 DATA11 DATA10 DATA9 DATA8 DATA7 DATA6 DATA5 DATA4 DATA3 DATA2 DATA1 DATA0 ] null imem
.model imem d_cosim simulation="/foss/designs/engn1600-team1/CAD7/imem.so" delay=10p irreversible=3

* Termination
Rimem_ADDR15 ADDR15 0 1G
Rimem_ADDR14 ADDR14 0 1G
Rimem_ADDR13 ADDR13 0 1G
Rimem_ADDR12 ADDR12 0 1G
Rimem_ADDR11 ADDR11 0 1G
Rimem_ADDR10 ADDR10 0 1G
Rimem_ADDR9 ADDR9 0 1G
Rimem_ADDR8 ADDR8 0 1G
Rimem_ADDR7 ADDR7 0 1G
Rimem_ADDR6 ADDR6 0 1G
Rimem_ADDR5 ADDR5 0 1G
Rimem_ADDR4 ADDR4 0 1G
Rimem_ADDR3 ADDR3 0 1G
Rimem_ADDR2 ADDR2 0 1G
Rimem_ADDR1 ADDR1 0 1G
Rimem_ADDR0 ADDR0 0 1G
Rimem_DATA15 DATA15 0 1G
Rimem_DATA14 DATA14 0 1G
Rimem_DATA13 DATA13 0 1G
Rimem_DATA12 DATA12 0 1G
Rimem_DATA11 DATA11 0 1G
Rimem_DATA10 DATA10 0 1G
Rimem_DATA9 DATA9 0 1G
Rimem_DATA8 DATA8 0 1G
Rimem_DATA7 DATA7 0 1G
Rimem_DATA6 DATA6 0 1G
Rimem_DATA5 DATA5 0 1G
Rimem_DATA4 DATA4 0 1G
Rimem_DATA3 DATA3 0 1G
Rimem_DATA2 DATA2 0 1G
Rimem_DATA1 DATA1 0 1G
Rimem_DATA0 DATA0 0 1G
