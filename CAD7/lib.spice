acontrol [ instr15 instr14 instr13 instr12 instr11 instr10 instr9 instr8 instr7 instr6 instr5 instr4 instr3 instr2 instr1 instr0 psr_z psr_n psr_f clk ] [ reg_write ra15 ra14 ra13 ra12 ra11 ra10 ra9 ra8 ra7 ra6 ra5 ra4 ra3 ra2 ra1 ra0 rb15 rb14 rb13 rb12 rb11 rb10 rb9 rb8 rb7 rb6 rb5 rb4 rb3 rb2 rb1 rb0 we15 we14 we13 we12 we11 we10 we9 we8 we7 we6 we5 we4 we3 we2 we1 we0 alu_sel1 alu_sel0 alu_src_b alu_src_a cin extend shift_val_src is_lui shift_amt_src mem_write data_out3 data_out2 data_out1 data_out0 pc_br pc_jmp ] null control
.model control d_cosim simulation="/foss/designs/engn1600-team1/CAD7/control.so"

admem [ clk we addr15 addr14 addr13 addr12 addr11 addr10 addr9 addr8 addr7 addr6 addr5 addr4 addr3 addr2 addr1 addr0 wdata15 wdata14 wdata13 wdata12 wdata11 wdata10 wdata9 wdata8 wdata7 wdata6 wdata5 wdata4 wdata3 wdata2 wdata1 wdata0 ] [ rdata15 rdata14 rdata13 rdata12 rdata11 rdata10 rdata9 rdata8 rdata7 rdata6 rdata5 rdata4 rdata3 rdata2 rdata1 rdata0 ] null dmem
.model dmem d_cosim simulation="/foss/designs/engn1600-team1/CAD7/dmem.so"

aimem [ addr15 addr14 addr13 addr12 addr11 addr10 addr9 addr8 addr7 addr6 addr5 addr4 addr3 addr2 addr1 addr0 ] [ data15 data14 data13 data12 data11 data10 data9 data8 data7 data6 data5 data4 data3 data2 data1 data0 ] null imem
.model imem d_cosim simulation="/foss/designs/engn1600-team1/CAD7/imem.so"
