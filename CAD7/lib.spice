* CPU_PERIPHERALS
* Instantiation
acpu_peripherals [ clk alu_z alu_n alu_f instr15 instr14 instr13 instr12 instr11 instr10 instr9 instr8 instr7 instr6 instr5 instr4 instr3 instr2 instr1 instr0 dmem_addr15 dmem_addr14 dmem_addr13 dmem_addr12 dmem_addr11 dmem_addr10 dmem_addr9 dmem_addr8 dmem_addr7 dmem_addr6 dmem_addr5 dmem_addr4 dmem_addr3 dmem_addr2 dmem_addr1 dmem_addr0 rdst15 rdst14 rdst13 rdst12 rdst11 rdst10 rdst9 rdst8 rdst7 rdst6 rdst5 rdst4 rdst3 rdst2 rdst1 rdst0 pc15 pc14 pc13 pc12 pc11 pc10 pc9 pc8 pc7 pc6 pc5 pc4 pc3 pc2 pc1 pc0 ] [ reg_write alu_sel1 alu_sel0 alu_src_b alu_src_a alu_cin extend shift_val_src is_lui shift_amt_src mem_write data_out3 data_out2 data_out1 data_out0 pc_br pc_jmp ra15 ra14 ra13 ra12 ra11 ra10 ra9 ra8 ra7 ra6 ra5 ra4 ra3 ra2 ra1 ra0 rb15 rb14 rb13 rb12 rb11 rb10 rb9 rb8 rb7 rb6 rb5 rb4 rb3 rb2 rb1 rb0 we15 we14 we13 we12 we11 we10 we9 we8 we7 we6 we5 we4 we3 we2 we1 we0 dmem_q15 dmem_q14 dmem_q13 dmem_q12 dmem_q11 dmem_q10 dmem_q9 dmem_q8 dmem_q7 dmem_q6 dmem_q5 dmem_q4 dmem_q3 dmem_q2 dmem_q1 dmem_q0 imem_q15 imem_q14 imem_q13 imem_q12 imem_q11 imem_q10 imem_q9 imem_q8 imem_q7 imem_q6 imem_q5 imem_q4 imem_q3 imem_q2 imem_q1 imem_q0 ] null cpu_peripherals
.model cpu_peripherals d_cosim simulation="/foss/designs/engn1600-team1/CAD7/cpu_peripherals.so" delay=10p irreversible=2

* Termination
Rcpu_peripherals_clk clk 0 1G
Rcpu_peripherals_alu_z alu_z 0 1G
Rcpu_peripherals_alu_n alu_n 0 1G
Rcpu_peripherals_alu_f alu_f 0 1G
Rcpu_peripherals_instr15 instr15 0 1G
Rcpu_peripherals_instr14 instr14 0 1G
Rcpu_peripherals_instr13 instr13 0 1G
Rcpu_peripherals_instr12 instr12 0 1G
Rcpu_peripherals_instr11 instr11 0 1G
Rcpu_peripherals_instr10 instr10 0 1G
Rcpu_peripherals_instr9 instr9 0 1G
Rcpu_peripherals_instr8 instr8 0 1G
Rcpu_peripherals_instr7 instr7 0 1G
Rcpu_peripherals_instr6 instr6 0 1G
Rcpu_peripherals_instr5 instr5 0 1G
Rcpu_peripherals_instr4 instr4 0 1G
Rcpu_peripherals_instr3 instr3 0 1G
Rcpu_peripherals_instr2 instr2 0 1G
Rcpu_peripherals_instr1 instr1 0 1G
Rcpu_peripherals_instr0 instr0 0 1G
Rcpu_peripherals_dmem_addr15 dmem_addr15 0 1G
Rcpu_peripherals_dmem_addr14 dmem_addr14 0 1G
Rcpu_peripherals_dmem_addr13 dmem_addr13 0 1G
Rcpu_peripherals_dmem_addr12 dmem_addr12 0 1G
Rcpu_peripherals_dmem_addr11 dmem_addr11 0 1G
Rcpu_peripherals_dmem_addr10 dmem_addr10 0 1G
Rcpu_peripherals_dmem_addr9 dmem_addr9 0 1G
Rcpu_peripherals_dmem_addr8 dmem_addr8 0 1G
Rcpu_peripherals_dmem_addr7 dmem_addr7 0 1G
Rcpu_peripherals_dmem_addr6 dmem_addr6 0 1G
Rcpu_peripherals_dmem_addr5 dmem_addr5 0 1G
Rcpu_peripherals_dmem_addr4 dmem_addr4 0 1G
Rcpu_peripherals_dmem_addr3 dmem_addr3 0 1G
Rcpu_peripherals_dmem_addr2 dmem_addr2 0 1G
Rcpu_peripherals_dmem_addr1 dmem_addr1 0 1G
Rcpu_peripherals_dmem_addr0 dmem_addr0 0 1G
Rcpu_peripherals_rdst15 rdst15 0 1G
Rcpu_peripherals_rdst14 rdst14 0 1G
Rcpu_peripherals_rdst13 rdst13 0 1G
Rcpu_peripherals_rdst12 rdst12 0 1G
Rcpu_peripherals_rdst11 rdst11 0 1G
Rcpu_peripherals_rdst10 rdst10 0 1G
Rcpu_peripherals_rdst9 rdst9 0 1G
Rcpu_peripherals_rdst8 rdst8 0 1G
Rcpu_peripherals_rdst7 rdst7 0 1G
Rcpu_peripherals_rdst6 rdst6 0 1G
Rcpu_peripherals_rdst5 rdst5 0 1G
Rcpu_peripherals_rdst4 rdst4 0 1G
Rcpu_peripherals_rdst3 rdst3 0 1G
Rcpu_peripherals_rdst2 rdst2 0 1G
Rcpu_peripherals_rdst1 rdst1 0 1G
Rcpu_peripherals_rdst0 rdst0 0 1G
Rcpu_peripherals_pc15 pc15 0 1G
Rcpu_peripherals_pc14 pc14 0 1G
Rcpu_peripherals_pc13 pc13 0 1G
Rcpu_peripherals_pc12 pc12 0 1G
Rcpu_peripherals_pc11 pc11 0 1G
Rcpu_peripherals_pc10 pc10 0 1G
Rcpu_peripherals_pc9 pc9 0 1G
Rcpu_peripherals_pc8 pc8 0 1G
Rcpu_peripherals_pc7 pc7 0 1G
Rcpu_peripherals_pc6 pc6 0 1G
Rcpu_peripherals_pc5 pc5 0 1G
Rcpu_peripherals_pc4 pc4 0 1G
Rcpu_peripherals_pc3 pc3 0 1G
Rcpu_peripherals_pc2 pc2 0 1G
Rcpu_peripherals_pc1 pc1 0 1G
Rcpu_peripherals_pc0 pc0 0 1G
Rcpu_peripherals_reg_write reg_write 0 1G
Rcpu_peripherals_alu_sel1 alu_sel1 0 1G
Rcpu_peripherals_alu_sel0 alu_sel0 0 1G
Rcpu_peripherals_alu_src_b alu_src_b 0 1G
Rcpu_peripherals_alu_src_a alu_src_a 0 1G
Rcpu_peripherals_alu_cin alu_cin 0 1G
Rcpu_peripherals_extend extend 0 1G
Rcpu_peripherals_shift_val_src shift_val_src 0 1G
Rcpu_peripherals_is_lui is_lui 0 1G
Rcpu_peripherals_shift_amt_src shift_amt_src 0 1G
Rcpu_peripherals_mem_write mem_write 0 1G
Rcpu_peripherals_data_out3 data_out3 0 1G
Rcpu_peripherals_data_out2 data_out2 0 1G
Rcpu_peripherals_data_out1 data_out1 0 1G
Rcpu_peripherals_data_out0 data_out0 0 1G
Rcpu_peripherals_pc_br pc_br 0 1G
Rcpu_peripherals_pc_jmp pc_jmp 0 1G
Rcpu_peripherals_ra15 ra15 0 1G
Rcpu_peripherals_ra14 ra14 0 1G
Rcpu_peripherals_ra13 ra13 0 1G
Rcpu_peripherals_ra12 ra12 0 1G
Rcpu_peripherals_ra11 ra11 0 1G
Rcpu_peripherals_ra10 ra10 0 1G
Rcpu_peripherals_ra9 ra9 0 1G
Rcpu_peripherals_ra8 ra8 0 1G
Rcpu_peripherals_ra7 ra7 0 1G
Rcpu_peripherals_ra6 ra6 0 1G
Rcpu_peripherals_ra5 ra5 0 1G
Rcpu_peripherals_ra4 ra4 0 1G
Rcpu_peripherals_ra3 ra3 0 1G
Rcpu_peripherals_ra2 ra2 0 1G
Rcpu_peripherals_ra1 ra1 0 1G
Rcpu_peripherals_ra0 ra0 0 1G
Rcpu_peripherals_rb15 rb15 0 1G
Rcpu_peripherals_rb14 rb14 0 1G
Rcpu_peripherals_rb13 rb13 0 1G
Rcpu_peripherals_rb12 rb12 0 1G
Rcpu_peripherals_rb11 rb11 0 1G
Rcpu_peripherals_rb10 rb10 0 1G
Rcpu_peripherals_rb9 rb9 0 1G
Rcpu_peripherals_rb8 rb8 0 1G
Rcpu_peripherals_rb7 rb7 0 1G
Rcpu_peripherals_rb6 rb6 0 1G
Rcpu_peripherals_rb5 rb5 0 1G
Rcpu_peripherals_rb4 rb4 0 1G
Rcpu_peripherals_rb3 rb3 0 1G
Rcpu_peripherals_rb2 rb2 0 1G
Rcpu_peripherals_rb1 rb1 0 1G
Rcpu_peripherals_rb0 rb0 0 1G
Rcpu_peripherals_we15 we15 0 1G
Rcpu_peripherals_we14 we14 0 1G
Rcpu_peripherals_we13 we13 0 1G
Rcpu_peripherals_we12 we12 0 1G
Rcpu_peripherals_we11 we11 0 1G
Rcpu_peripherals_we10 we10 0 1G
Rcpu_peripherals_we9 we9 0 1G
Rcpu_peripherals_we8 we8 0 1G
Rcpu_peripherals_we7 we7 0 1G
Rcpu_peripherals_we6 we6 0 1G
Rcpu_peripherals_we5 we5 0 1G
Rcpu_peripherals_we4 we4 0 1G
Rcpu_peripherals_we3 we3 0 1G
Rcpu_peripherals_we2 we2 0 1G
Rcpu_peripherals_we1 we1 0 1G
Rcpu_peripherals_we0 we0 0 1G
Rcpu_peripherals_dmem_q15 dmem_q15 0 1G
Rcpu_peripherals_dmem_q14 dmem_q14 0 1G
Rcpu_peripherals_dmem_q13 dmem_q13 0 1G
Rcpu_peripherals_dmem_q12 dmem_q12 0 1G
Rcpu_peripherals_dmem_q11 dmem_q11 0 1G
Rcpu_peripherals_dmem_q10 dmem_q10 0 1G
Rcpu_peripherals_dmem_q9 dmem_q9 0 1G
Rcpu_peripherals_dmem_q8 dmem_q8 0 1G
Rcpu_peripherals_dmem_q7 dmem_q7 0 1G
Rcpu_peripherals_dmem_q6 dmem_q6 0 1G
Rcpu_peripherals_dmem_q5 dmem_q5 0 1G
Rcpu_peripherals_dmem_q4 dmem_q4 0 1G
Rcpu_peripherals_dmem_q3 dmem_q3 0 1G
Rcpu_peripherals_dmem_q2 dmem_q2 0 1G
Rcpu_peripherals_dmem_q1 dmem_q1 0 1G
Rcpu_peripherals_dmem_q0 dmem_q0 0 1G
Rcpu_peripherals_imem_q15 imem_q15 0 1G
Rcpu_peripherals_imem_q14 imem_q14 0 1G
Rcpu_peripherals_imem_q13 imem_q13 0 1G
Rcpu_peripherals_imem_q12 imem_q12 0 1G
Rcpu_peripherals_imem_q11 imem_q11 0 1G
Rcpu_peripherals_imem_q10 imem_q10 0 1G
Rcpu_peripherals_imem_q9 imem_q9 0 1G
Rcpu_peripherals_imem_q8 imem_q8 0 1G
Rcpu_peripherals_imem_q7 imem_q7 0 1G
Rcpu_peripherals_imem_q6 imem_q6 0 1G
Rcpu_peripherals_imem_q5 imem_q5 0 1G
Rcpu_peripherals_imem_q4 imem_q4 0 1G
Rcpu_peripherals_imem_q3 imem_q3 0 1G
Rcpu_peripherals_imem_q2 imem_q2 0 1G
Rcpu_peripherals_imem_q1 imem_q1 0 1G
Rcpu_peripherals_imem_q0 imem_q0 0 1G
