* CONTROL
* Instantiation
acontrol [ instr15 instr14 instr13 instr12 instr11 instr10 instr9 instr8 instr7 instr6 instr5 instr4 instr3 instr2 instr1 instr0 psr_z psr_n psr_f clk ] [ reg_write ra15 ra14 ra13 ra12 ra11 ra10 ra9 ra8 ra7 ra6 ra5 ra4 ra3 ra2 ra1 ra0 rb15 rb14 rb13 rb12 rb11 rb10 rb9 rb8 rb7 rb6 rb5 rb4 rb3 rb2 rb1 rb0 we15 we14 we13 we12 we11 we10 we9 we8 we7 we6 we5 we4 we3 we2 we1 we0 alu_sel1 alu_sel0 alu_src_b alu_src_a cin extend shift_val_src is_lui shift_amt_src mem_write data_out3 data_out2 data_out1 data_out0 pc_br pc_jmp ] null control
.model control d_cosim simulation="/foss/designs/engn1600-team1/CAD7/control.so" delay=10p

* Termination
Rcontrol_instr15_term instr15 0 1G
Rcontrol_instr14_term instr14 0 1G
Rcontrol_instr13_term instr13 0 1G
Rcontrol_instr12_term instr12 0 1G
Rcontrol_instr11_term instr11 0 1G
Rcontrol_instr10_term instr10 0 1G
Rcontrol_instr9_term instr9 0 1G
Rcontrol_instr8_term instr8 0 1G
Rcontrol_instr7_term instr7 0 1G
Rcontrol_instr6_term instr6 0 1G
Rcontrol_instr5_term instr5 0 1G
Rcontrol_instr4_term instr4 0 1G
Rcontrol_instr3_term instr3 0 1G
Rcontrol_instr2_term instr2 0 1G
Rcontrol_instr1_term instr1 0 1G
Rcontrol_instr0_term instr0 0 1G
Rcontrol_psr_z_term psr_z 0 1G
Rcontrol_psr_n_term psr_n 0 1G
Rcontrol_psr_f_term psr_f 0 1G
Rcontrol_clk_term clk 0 1G
Rcontrol_reg_write_term reg_write 0 1G
Rcontrol_ra15_term ra15 0 1G
Rcontrol_ra14_term ra14 0 1G
Rcontrol_ra13_term ra13 0 1G
Rcontrol_ra12_term ra12 0 1G
Rcontrol_ra11_term ra11 0 1G
Rcontrol_ra10_term ra10 0 1G
Rcontrol_ra9_term ra9 0 1G
Rcontrol_ra8_term ra8 0 1G
Rcontrol_ra7_term ra7 0 1G
Rcontrol_ra6_term ra6 0 1G
Rcontrol_ra5_term ra5 0 1G
Rcontrol_ra4_term ra4 0 1G
Rcontrol_ra3_term ra3 0 1G
Rcontrol_ra2_term ra2 0 1G
Rcontrol_ra1_term ra1 0 1G
Rcontrol_ra0_term ra0 0 1G
Rcontrol_rb15_term rb15 0 1G
Rcontrol_rb14_term rb14 0 1G
Rcontrol_rb13_term rb13 0 1G
Rcontrol_rb12_term rb12 0 1G
Rcontrol_rb11_term rb11 0 1G
Rcontrol_rb10_term rb10 0 1G
Rcontrol_rb9_term rb9 0 1G
Rcontrol_rb8_term rb8 0 1G
Rcontrol_rb7_term rb7 0 1G
Rcontrol_rb6_term rb6 0 1G
Rcontrol_rb5_term rb5 0 1G
Rcontrol_rb4_term rb4 0 1G
Rcontrol_rb3_term rb3 0 1G
Rcontrol_rb2_term rb2 0 1G
Rcontrol_rb1_term rb1 0 1G
Rcontrol_rb0_term rb0 0 1G
Rcontrol_we15_term we15 0 1G
Rcontrol_we14_term we14 0 1G
Rcontrol_we13_term we13 0 1G
Rcontrol_we12_term we12 0 1G
Rcontrol_we11_term we11 0 1G
Rcontrol_we10_term we10 0 1G
Rcontrol_we9_term we9 0 1G
Rcontrol_we8_term we8 0 1G
Rcontrol_we7_term we7 0 1G
Rcontrol_we6_term we6 0 1G
Rcontrol_we5_term we5 0 1G
Rcontrol_we4_term we4 0 1G
Rcontrol_we3_term we3 0 1G
Rcontrol_we2_term we2 0 1G
Rcontrol_we1_term we1 0 1G
Rcontrol_we0_term we0 0 1G
Rcontrol_alu_sel1_term alu_sel1 0 1G
Rcontrol_alu_sel0_term alu_sel0 0 1G
Rcontrol_alu_src_b_term alu_src_b 0 1G
Rcontrol_alu_src_a_term alu_src_a 0 1G
Rcontrol_cin_term cin 0 1G
Rcontrol_extend_term extend 0 1G
Rcontrol_shift_val_src_term shift_val_src 0 1G
Rcontrol_is_lui_term is_lui 0 1G
Rcontrol_shift_amt_src_term shift_amt_src 0 1G
Rcontrol_mem_write_term mem_write 0 1G
Rcontrol_data_out3_term data_out3 0 1G
Rcontrol_data_out2_term data_out2 0 1G
Rcontrol_data_out1_term data_out1 0 1G
Rcontrol_data_out0_term data_out0 0 1G
Rcontrol_pc_br_term pc_br 0 1G
Rcontrol_pc_jmp_term pc_jmp 0 1G

* DMEM
* Instantiation
admem [ clk we addr15 addr14 addr13 addr12 addr11 addr10 addr9 addr8 addr7 addr6 addr5 addr4 addr3 addr2 addr1 addr0 wdata15 wdata14 wdata13 wdata12 wdata11 wdata10 wdata9 wdata8 wdata7 wdata6 wdata5 wdata4 wdata3 wdata2 wdata1 wdata0 ] [ rdata15 rdata14 rdata13 rdata12 rdata11 rdata10 rdata9 rdata8 rdata7 rdata6 rdata5 rdata4 rdata3 rdata2 rdata1 rdata0 ] null dmem
.model dmem d_cosim simulation="/foss/designs/engn1600-team1/CAD7/dmem.so" delay=10p

* Termination
Rdmem_clk_term clk 0 1G
Rdmem_we_term we 0 1G
Rdmem_addr15_term addr15 0 1G
Rdmem_addr14_term addr14 0 1G
Rdmem_addr13_term addr13 0 1G
Rdmem_addr12_term addr12 0 1G
Rdmem_addr11_term addr11 0 1G
Rdmem_addr10_term addr10 0 1G
Rdmem_addr9_term addr9 0 1G
Rdmem_addr8_term addr8 0 1G
Rdmem_addr7_term addr7 0 1G
Rdmem_addr6_term addr6 0 1G
Rdmem_addr5_term addr5 0 1G
Rdmem_addr4_term addr4 0 1G
Rdmem_addr3_term addr3 0 1G
Rdmem_addr2_term addr2 0 1G
Rdmem_addr1_term addr1 0 1G
Rdmem_addr0_term addr0 0 1G
Rdmem_wdata15_term wdata15 0 1G
Rdmem_wdata14_term wdata14 0 1G
Rdmem_wdata13_term wdata13 0 1G
Rdmem_wdata12_term wdata12 0 1G
Rdmem_wdata11_term wdata11 0 1G
Rdmem_wdata10_term wdata10 0 1G
Rdmem_wdata9_term wdata9 0 1G
Rdmem_wdata8_term wdata8 0 1G
Rdmem_wdata7_term wdata7 0 1G
Rdmem_wdata6_term wdata6 0 1G
Rdmem_wdata5_term wdata5 0 1G
Rdmem_wdata4_term wdata4 0 1G
Rdmem_wdata3_term wdata3 0 1G
Rdmem_wdata2_term wdata2 0 1G
Rdmem_wdata1_term wdata1 0 1G
Rdmem_wdata0_term wdata0 0 1G
Rdmem_rdata15_term rdata15 0 1G
Rdmem_rdata14_term rdata14 0 1G
Rdmem_rdata13_term rdata13 0 1G
Rdmem_rdata12_term rdata12 0 1G
Rdmem_rdata11_term rdata11 0 1G
Rdmem_rdata10_term rdata10 0 1G
Rdmem_rdata9_term rdata9 0 1G
Rdmem_rdata8_term rdata8 0 1G
Rdmem_rdata7_term rdata7 0 1G
Rdmem_rdata6_term rdata6 0 1G
Rdmem_rdata5_term rdata5 0 1G
Rdmem_rdata4_term rdata4 0 1G
Rdmem_rdata3_term rdata3 0 1G
Rdmem_rdata2_term rdata2 0 1G
Rdmem_rdata1_term rdata1 0 1G
Rdmem_rdata0_term rdata0 0 1G

* IMEM
* Instantiation
aimem [ addr15 addr14 addr13 addr12 addr11 addr10 addr9 addr8 addr7 addr6 addr5 addr4 addr3 addr2 addr1 addr0 ] [ data15 data14 data13 data12 data11 data10 data9 data8 data7 data6 data5 data4 data3 data2 data1 data0 ] null imem
.model imem d_cosim simulation="/foss/designs/engn1600-team1/CAD7/imem.so" delay=10p

* Termination
Rimem_addr15_term addr15 0 1G
Rimem_addr14_term addr14 0 1G
Rimem_addr13_term addr13 0 1G
Rimem_addr12_term addr12 0 1G
Rimem_addr11_term addr11 0 1G
Rimem_addr10_term addr10 0 1G
Rimem_addr9_term addr9 0 1G
Rimem_addr8_term addr8 0 1G
Rimem_addr7_term addr7 0 1G
Rimem_addr6_term addr6 0 1G
Rimem_addr5_term addr5 0 1G
Rimem_addr4_term addr4 0 1G
Rimem_addr3_term addr3 0 1G
Rimem_addr2_term addr2 0 1G
Rimem_addr1_term addr1 0 1G
Rimem_addr0_term addr0 0 1G
Rimem_data15_term data15 0 1G
Rimem_data14_term data14 0 1G
Rimem_data13_term data13 0 1G
Rimem_data12_term data12 0 1G
Rimem_data11_term data11 0 1G
Rimem_data10_term data10 0 1G
Rimem_data9_term data9 0 1G
Rimem_data8_term data8 0 1G
Rimem_data7_term data7 0 1G
Rimem_data6_term data6 0 1G
Rimem_data5_term data5 0 1G
Rimem_data4_term data4 0 1G
Rimem_data3_term data3 0 1G
Rimem_data2_term data2 0 1G
Rimem_data1_term data1 0 1G
Rimem_data0_term data0 0 1G
