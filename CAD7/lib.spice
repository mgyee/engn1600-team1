acontrol [ instr.15 instr.14 instr.13 instr.12 instr.11 instr.10 instr.9 instr.8 instr.7 instr.6 instr.5 instr.4 instr.3 instr.2 instr.1 instr.0 psr_z psr_n psr_f clk ] [ reg_write ra.15 ra.14 ra.13 ra.12 ra.11 ra.10 ra.9 ra.8 ra.7 ra.6 ra.5 ra.4 ra.3 ra.2 ra.1 ra.0 rb.15 rb.14 rb.13 rb.12 rb.11 rb.10 rb.9 rb.8 rb.7 rb.6 rb.5 rb.4 rb.3 rb.2 rb.1 rb.0 we.15 we.14 we.13 we.12 we.11 we.10 we.9 we.8 we.7 we.6 we.5 we.4 we.3 we.2 we.1 we.0 alu_sel.1 alu_sel.0 alu_src_b alu_src_a cin extend shift_val_src is_lui shift_amt_src mem_write data_out.3 data_out.2 data_out.1 data_out.0 pc_br pc_jmp ] null control
.model control d_cosim simulation="/foss/designs/engn1600-team1/CAD7/control.so"

* --- terminations ---
Rcontrol_instr15_term instr.15 0 1G
Rcontrol_instr14_term instr.14 0 1G
Rcontrol_instr13_term instr.13 0 1G
Rcontrol_instr12_term instr.12 0 1G
Rcontrol_instr11_term instr.11 0 1G
Rcontrol_instr10_term instr.10 0 1G
Rcontrol_instr9_term instr.9 0 1G
Rcontrol_instr8_term instr.8 0 1G
Rcontrol_instr7_term instr.7 0 1G
Rcontrol_instr6_term instr.6 0 1G
Rcontrol_instr5_term instr.5 0 1G
Rcontrol_instr4_term instr.4 0 1G
Rcontrol_instr3_term instr.3 0 1G
Rcontrol_instr2_term instr.2 0 1G
Rcontrol_instr1_term instr.1 0 1G
Rcontrol_instr0_term instr.0 0 1G
Rcontrol_psr_z_term psr_z 0 1G
Rcontrol_psr_n_term psr_n 0 1G
Rcontrol_psr_f_term psr_f 0 1G
Rcontrol_clk_term clk 0 1G
Rcontrol_reg_write_term reg_write 0 1G
Rcontrol_ra15_term ra.15 0 1G
Rcontrol_ra14_term ra.14 0 1G
Rcontrol_ra13_term ra.13 0 1G
Rcontrol_ra12_term ra.12 0 1G
Rcontrol_ra11_term ra.11 0 1G
Rcontrol_ra10_term ra.10 0 1G
Rcontrol_ra9_term ra.9 0 1G
Rcontrol_ra8_term ra.8 0 1G
Rcontrol_ra7_term ra.7 0 1G
Rcontrol_ra6_term ra.6 0 1G
Rcontrol_ra5_term ra.5 0 1G
Rcontrol_ra4_term ra.4 0 1G
Rcontrol_ra3_term ra.3 0 1G
Rcontrol_ra2_term ra.2 0 1G
Rcontrol_ra1_term ra.1 0 1G
Rcontrol_ra0_term ra.0 0 1G
Rcontrol_rb15_term rb.15 0 1G
Rcontrol_rb14_term rb.14 0 1G
Rcontrol_rb13_term rb.13 0 1G
Rcontrol_rb12_term rb.12 0 1G
Rcontrol_rb11_term rb.11 0 1G
Rcontrol_rb10_term rb.10 0 1G
Rcontrol_rb9_term rb.9 0 1G
Rcontrol_rb8_term rb.8 0 1G
Rcontrol_rb7_term rb.7 0 1G
Rcontrol_rb6_term rb.6 0 1G
Rcontrol_rb5_term rb.5 0 1G
Rcontrol_rb4_term rb.4 0 1G
Rcontrol_rb3_term rb.3 0 1G
Rcontrol_rb2_term rb.2 0 1G
Rcontrol_rb1_term rb.1 0 1G
Rcontrol_rb0_term rb.0 0 1G
Rcontrol_we15_term we.15 0 1G
Rcontrol_we14_term we.14 0 1G
Rcontrol_we13_term we.13 0 1G
Rcontrol_we12_term we.12 0 1G
Rcontrol_we11_term we.11 0 1G
Rcontrol_we10_term we.10 0 1G
Rcontrol_we9_term we.9 0 1G
Rcontrol_we8_term we.8 0 1G
Rcontrol_we7_term we.7 0 1G
Rcontrol_we6_term we.6 0 1G
Rcontrol_we5_term we.5 0 1G
Rcontrol_we4_term we.4 0 1G
Rcontrol_we3_term we.3 0 1G
Rcontrol_we2_term we.2 0 1G
Rcontrol_we1_term we.1 0 1G
Rcontrol_we0_term we.0 0 1G
Rcontrol_alu_sel1_term alu_sel.1 0 1G
Rcontrol_alu_sel0_term alu_sel.0 0 1G
Rcontrol_alu_src_b_term alu_src_b 0 1G
Rcontrol_alu_src_a_term alu_src_a 0 1G
Rcontrol_cin_term cin 0 1G
Rcontrol_extend_term extend 0 1G
Rcontrol_shift_val_src_term shift_val_src 0 1G
Rcontrol_is_lui_term is_lui 0 1G
Rcontrol_shift_amt_src_term shift_amt_src 0 1G
Rcontrol_mem_write_term mem_write 0 1G
Rcontrol_data_out3_term data_out.3 0 1G
Rcontrol_data_out2_term data_out.2 0 1G
Rcontrol_data_out1_term data_out.1 0 1G
Rcontrol_data_out0_term data_out.0 0 1G
Rcontrol_pc_br_term pc_br 0 1G
Rcontrol_pc_jmp_term pc_jmp 0 1G
* --- end terminations ---

aimem [ addr.15 addr.14 addr.13 addr.12 addr.11 addr.10 addr.9 addr.8 addr.7 addr.6 addr.5 addr.4 addr.3 addr.2 addr.1 addr.0 ] [ data.15 data.14 data.13 data.12 data.11 data.10 data.9 data.8 data.7 data.6 data.5 data.4 data.3 data.2 data.1 data.0 ] null imem
.model imem d_cosim simulation="/foss/designs/engn1600-team1/CAD7/imem.so"

* --- terminations ---
Rimem_addr15_term addr.15 0 1G
Rimem_addr14_term addr.14 0 1G
Rimem_addr13_term addr.13 0 1G
Rimem_addr12_term addr.12 0 1G
Rimem_addr11_term addr.11 0 1G
Rimem_addr10_term addr.10 0 1G
Rimem_addr9_term addr.9 0 1G
Rimem_addr8_term addr.8 0 1G
Rimem_addr7_term addr.7 0 1G
Rimem_addr6_term addr.6 0 1G
Rimem_addr5_term addr.5 0 1G
Rimem_addr4_term addr.4 0 1G
Rimem_addr3_term addr.3 0 1G
Rimem_addr2_term addr.2 0 1G
Rimem_addr1_term addr.1 0 1G
Rimem_addr0_term addr.0 0 1G
Rimem_data15_term data.15 0 1G
Rimem_data14_term data.14 0 1G
Rimem_data13_term data.13 0 1G
Rimem_data12_term data.12 0 1G
Rimem_data11_term data.11 0 1G
Rimem_data10_term data.10 0 1G
Rimem_data9_term data.9 0 1G
Rimem_data8_term data.8 0 1G
Rimem_data7_term data.7 0 1G
Rimem_data6_term data.6 0 1G
Rimem_data5_term data.5 0 1G
Rimem_data4_term data.4 0 1G
Rimem_data3_term data.3 0 1G
Rimem_data2_term data.2 0 1G
Rimem_data1_term data.1 0 1G
Rimem_data0_term data.0 0 1G
* --- end terminations ---

admem [ clk we addr.15 addr.14 addr.13 addr.12 addr.11 addr.10 addr.9 addr.8 addr.7 addr.6 addr.5 addr.4 addr.3 addr.2 addr.1 addr.0 wdata.15 wdata.14 wdata.13 wdata.12 wdata.11 wdata.10 wdata.9 wdata.8 wdata.7 wdata.6 wdata.5 wdata.4 wdata.3 wdata.2 wdata.1 wdata.0 ] [ rdata.15 rdata.14 rdata.13 rdata.12 rdata.11 rdata.10 rdata.9 rdata.8 rdata.7 rdata.6 rdata.5 rdata.4 rdata.3 rdata.2 rdata.1 rdata.0 ] null dmem
.model dmem d_cosim simulation="/foss/designs/engn1600-team1/CAD7/dmem.so"

* --- terminations ---
Rdmem_clk_term clk 0 1G
Rdmem_we_term we 0 1G
Rdmem_addr15_term addr.15 0 1G
Rdmem_addr14_term addr.14 0 1G
Rdmem_addr13_term addr.13 0 1G
Rdmem_addr12_term addr.12 0 1G
Rdmem_addr11_term addr.11 0 1G
Rdmem_addr10_term addr.10 0 1G
Rdmem_addr9_term addr.9 0 1G
Rdmem_addr8_term addr.8 0 1G
Rdmem_addr7_term addr.7 0 1G
Rdmem_addr6_term addr.6 0 1G
Rdmem_addr5_term addr.5 0 1G
Rdmem_addr4_term addr.4 0 1G
Rdmem_addr3_term addr.3 0 1G
Rdmem_addr2_term addr.2 0 1G
Rdmem_addr1_term addr.1 0 1G
Rdmem_addr0_term addr.0 0 1G
Rdmem_wdata15_term wdata.15 0 1G
Rdmem_wdata14_term wdata.14 0 1G
Rdmem_wdata13_term wdata.13 0 1G
Rdmem_wdata12_term wdata.12 0 1G
Rdmem_wdata11_term wdata.11 0 1G
Rdmem_wdata10_term wdata.10 0 1G
Rdmem_wdata9_term wdata.9 0 1G
Rdmem_wdata8_term wdata.8 0 1G
Rdmem_wdata7_term wdata.7 0 1G
Rdmem_wdata6_term wdata.6 0 1G
Rdmem_wdata5_term wdata.5 0 1G
Rdmem_wdata4_term wdata.4 0 1G
Rdmem_wdata3_term wdata.3 0 1G
Rdmem_wdata2_term wdata.2 0 1G
Rdmem_wdata1_term wdata.1 0 1G
Rdmem_wdata0_term wdata.0 0 1G
Rdmem_rdata15_term rdata.15 0 1G
Rdmem_rdata14_term rdata.14 0 1G
Rdmem_rdata13_term rdata.13 0 1G
Rdmem_rdata12_term rdata.12 0 1G
Rdmem_rdata11_term rdata.11 0 1G
Rdmem_rdata10_term rdata.10 0 1G
Rdmem_rdata9_term rdata.9 0 1G
Rdmem_rdata8_term rdata.8 0 1G
Rdmem_rdata7_term rdata.7 0 1G
Rdmem_rdata6_term rdata.6 0 1G
Rdmem_rdata5_term rdata.5 0 1G
Rdmem_rdata4_term rdata.4 0 1G
Rdmem_rdata3_term rdata.3 0 1G
Rdmem_rdata2_term rdata.2 0 1G
Rdmem_rdata1_term rdata.1 0 1G
Rdmem_rdata0_term rdata.0 0 1G
* --- end terminations ---
