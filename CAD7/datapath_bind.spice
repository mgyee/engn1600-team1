** sch_path: /foss/designs/engn1600-team1/CAD7/datapath_bind.sch
.subckt datapath_bind

x1 RDST15 RDST14 RDST13 RDST12 RDST11 RDST10 RDST9 RDST8 RDST7 RDST6 RDST5 RDST4 RDST3 RDST2 RDST1 RDST0 DMEM_ADDR15 DMEM_ADDR14
+ DMEM_ADDR13 DMEM_ADDR12 DMEM_ADDR11 DMEM_ADDR10 DMEM_ADDR9 DMEM_ADDR8 DMEM_ADDR7 DMEM_ADDR6 DMEM_ADDR5 DMEM_ADDR4 DMEM_ADDR3 DMEM_ADDR2
+ DMEM_ADDR1 DMEM_ADDR0 DMEM_Q15 DMEM_Q14 DMEM_Q13 DMEM_Q12 DMEM_Q11 DMEM_Q10 DMEM_Q9 DMEM_Q8 DMEM_Q7 DMEM_Q6 DMEM_Q5 DMEM_Q4 DMEM_Q3 DMEM_Q2
+ DMEM_Q1 DMEM_Q0 ALU_SRC_B PC_BR REG_WRITE ALU_CIN WE15 WE14 WE13 WE12 WE11 WE10 WE9 WE8 WE7 WE6 WE5 WE4 WE3 WE2 WE1 WE0 ALU_F PC_JMP
+ ALU_SEL1 ALU_SEL0 RA15 RA14 RA13 RA12 RA11 RA10 RA9 RA8 RA7 RA6 RA5 RA4 RA3 RA2 RA1 RA0 RB15 RB14 RB13 RB12 RB11 RB10 RB9 RB8 RB7 RB6 RB5
+ RB4 RB3 RB2 RB1 RB0 ALU_Z ALU_N SI SE ALU_SRC_A CLK DATA_OUT3 DATA_OUT2 DATA_OUT1 DATA_OUT0 RSTn VSS INSTR15 INSTR14 INSTR13 INSTR12
+ INSTR11 INSTR10 INSTR9 INSTR8 INSTR7 INSTR6 INSTR5 INSTR4 INSTR3 INSTR2 INSTR1 INSTR0 VDD SHIFT_AMT_SRC IS_LUI IMEM_Q15 IMEM_Q14 IMEM_Q13
+ IMEM_Q12 IMEM_Q11 IMEM_Q10 IMEM_Q9 IMEM_Q8 IMEM_Q7 IMEM_Q6 IMEM_Q5 IMEM_Q4 IMEM_Q3 IMEM_Q2 IMEM_Q1 IMEM_Q0 PC15 PC14 PC13 PC12 PC11 PC10
+ PC9 PC8 PC7 PC6 PC5 PC4 PC3 PC2 PC1 PC0 EXTEND SHIFT_VAL_SRC datapath
VDMEM_Q15 DMEM_Q15 GND 0
VDMEM_Q14 DMEM_Q14 GND 0
VDMEM_Q13 DMEM_Q13 GND 0
VDMEM_Q12 DMEM_Q12 GND 0
VDMEM_Q11 DMEM_Q11 GND 0
VDMEM_Q10 DMEM_Q10 GND 0
VDMEM_Q9 DMEM_Q9 GND 0
VDMEM_Q8 DMEM_Q8 GND 0
VDMEM_Q7 DMEM_Q7 GND 0
VDMEM_Q6 DMEM_Q6 GND 0
VDMEM_Q5 DMEM_Q5 GND 0
VDMEM_Q4 DMEM_Q4 GND 0
VDMEM_Q3 DMEM_Q3 GND 0
VDMEM_Q2 DMEM_Q2 GND 0
VDMEM_Q1 DMEM_Q1 GND 0
VDMEM_Q0 DMEM_Q0 GND 0
VALU_SRC_B ALU_SRC_B GND 0
VPC_BR PC_BR GND 0
VREG_WRITE REG_WRITE GND 0
VALU_CIN ALU_CIN GND 0
VWE15 WE15 GND 0
VWE14 WE14 GND 0
VWE13 WE13 GND 0
VWE12 WE12 GND 0
VWE11 WE11 GND 0
VWE10 WE10 GND 0
VWE9 WE9 GND 0
VWE8 WE8 GND 0
VWE7 WE7 GND 0
VWE6 WE6 GND 0
VWE5 WE5 GND 0
VWE4 WE4 GND 0
VWE3 WE3 GND 0
VWE2 WE2 GND 0
VWE1 WE1 GND 0
VWE0 WE0 GND 0
VPC_JMP PC_JMP GND 0
VALU_SEL1 ALU_SEL1 GND 0
VALU_SEL0 ALU_SEL0 GND 0
VRA15 RA15 GND 0
VRA14 RA14 GND 0
VRA13 RA13 GND 0
VRA12 RA12 GND 0
VRA11 RA11 GND 0
VRA10 RA10 GND 0
VRA9 RA9 GND 0
VRA8 RA8 GND 0
VRA7 RA7 GND 0
VRA6 RA6 GND 0
VRA5 RA5 GND 0
VRA4 RA4 GND 0
VRA3 RA3 GND 0
VRA2 RA2 GND 0
VRA1 RA1 GND 0
VRA0 RA0 GND 0
VRB15 RB15 GND 0
VRB14 RB14 GND 0
VRB13 RB13 GND 0
VRB12 RB12 GND 0
VRB11 RB11 GND 0
VRB10 RB10 GND 0
VRB9 RB9 GND 0
VRB8 RB8 GND 0
VRB7 RB7 GND 0
VRB6 RB6 GND 0
VRB5 RB5 GND 0
VRB4 RB4 GND 0
VRB3 RB3 GND 0
VRB2 RB2 GND 0
VRB1 RB1 GND 0
VRB0 RB0 GND 0
VSI SI GND 0
VSE SE GND 0
VALU_SRC_A ALU_SRC_A GND 0
VCLK CLK GND 0
VDATA_OUT3 DATA_OUT3 GND 0
VDATA_OUT2 DATA_OUT2 GND 0
VDATA_OUT1 DATA_OUT1 GND 0
VDATA_OUT0 DATA_OUT0 GND 0
VRSTn RSTn GND 0
VVSS VSS GND 0
VVDD VDD GND 0
VSHIFT_AMT_SRC SHIFT_AMT_SRC GND 0
VIS_LUI IS_LUI GND 0
VIMEM_Q15 IMEM_Q15 GND 0
VIMEM_Q14 IMEM_Q14 GND 0
VIMEM_Q13 IMEM_Q13 GND 0
VIMEM_Q12 IMEM_Q12 GND 0
VIMEM_Q11 IMEM_Q11 GND 0
VIMEM_Q10 IMEM_Q10 GND 0
VIMEM_Q9 IMEM_Q9 GND 0
VIMEM_Q8 IMEM_Q8 GND 0
VIMEM_Q7 IMEM_Q7 GND 0
VIMEM_Q6 IMEM_Q6 GND 0
VIMEM_Q5 IMEM_Q5 GND 0
VIMEM_Q4 IMEM_Q4 GND 0
VIMEM_Q3 IMEM_Q3 GND 0
VIMEM_Q2 IMEM_Q2 GND 0
VIMEM_Q1 IMEM_Q1 GND 0
VIMEM_Q0 IMEM_Q0 GND 0
VEXTEND EXTEND GND 0
VSHIFT_VAL_SRC SHIFT_VAL_SRC GND 0
**** begin user architecture code

.include /foss/pdks/gf180mcuD/libs.tech/ngspice/design.ngspice
.lib /foss/pdks/gf180mcuD/libs.tech/ngspice/sm141064.ngspice typical

**** end user architecture code
.ends

* expanding   symbol:  engn1600-team1/CAD7/datapath.sym # of pins=30
** sym_path: /foss/designs/engn1600-team1/CAD7/datapath.sym
** sch_path: /foss/designs/engn1600-team1/CAD7/datapath.sch
.subckt datapath RDST15 RDST14 RDST13 RDST12 RDST11 RDST10 RDST9 RDST8 RDST7 RDST6 RDST5 RDST4 RDST3 RDST2 RDST1 RDST0 DMEM_ADDR15
+ DMEM_ADDR14 DMEM_ADDR13 DMEM_ADDR12 DMEM_ADDR11 DMEM_ADDR10 DMEM_ADDR9 DMEM_ADDR8 DMEM_ADDR7 DMEM_ADDR6 DMEM_ADDR5 DMEM_ADDR4 DMEM_ADDR3
+ DMEM_ADDR2 DMEM_ADDR1 DMEM_ADDR0 DMEM_Q15 DMEM_Q14 DMEM_Q13 DMEM_Q12 DMEM_Q11 DMEM_Q10 DMEM_Q9 DMEM_Q8 DMEM_Q7 DMEM_Q6 DMEM_Q5 DMEM_Q4
+ DMEM_Q3 DMEM_Q2 DMEM_Q1 DMEM_Q0 ALU_SRC_B PC_BR REG_WRITE ALU_CIN WE15 WE14 WE13 WE12 WE11 WE10 WE9 WE8 WE7 WE6 WE5 WE4 WE3 WE2 WE1 WE0
+ ALU_F PC_JMP ALU_SEL1 ALU_SEL0 RA15 RA14 RA13 RA12 RA11 RA10 RA9 RA8 RA7 RA6 RA5 RA4 RA3 RA2 RA1 RA0 RB15 RB14 RB13 RB12 RB11 RB10 RB9
+ RB8 RB7 RB6 RB5 RB4 RB3 RB2 RB1 RB0 ALU_Z ALU_N SI SE ALU_SRC_A CLK DATA_OUT3 DATA_OUT2 DATA_OUT1 DATA_OUT0 RSTn VSS INSTR15 INSTR14
+ INSTR13 INSTR12 INSTR11 INSTR10 INSTR9 INSTR8 INSTR7 INSTR6 INSTR5 INSTR4 INSTR3 INSTR2 INSTR1 INSTR0 VDD SHIFT_AMT_SRC IS_LUI IMEM_Q15
+ IMEM_Q14 IMEM_Q13 IMEM_Q12 IMEM_Q11 IMEM_Q10 IMEM_Q9 IMEM_Q8 IMEM_Q7 IMEM_Q6 IMEM_Q5 IMEM_Q4 IMEM_Q3 IMEM_Q2 IMEM_Q1 IMEM_Q0 PC15 PC14
+ PC13 PC12 PC11 PC10 PC9 PC8 PC7 PC6 PC5 PC4 PC3 PC2 PC1 PC0 EXTEND SHIFT_VAL_SRC
*.PININFO RA[15..0]:I RB[15..0]:I ALU_F:O ALU_Z:O ALU_N:O RDST[15..0]:O DMEM_Q[15..0]:I DMEM_ADDR[15..0]:O WE[15..0]:I PC[15..0]:O
*+ IMEM_Q[15..0]:I INSTR[15..0]:O ALU_SRC_B:I ALU_SRC_A:I IS_LUI:I SHIFT_VAL_SRC:I ALU_SEL[1..0]:I REG_WRITE:I ALU_CIN:I PC_BR:I PC_JMP:I CLK:I
*+ RSTn:I VSS:B VDD:B EXTEND:I SHIFT_AMT_SRC:I SI:I SE:I DATA_OUT[3..0]:I
x1 VDD VSS ALU_A15 ALU_A14 ALU_A13 ALU_A12 ALU_A11 ALU_A10 ALU_A9 ALU_A8 ALU_A7 ALU_A6 ALU_A5 ALU_A4 ALU_A3 ALU_A2 ALU_A1 ALU_A0
+ ALU_B15 ALU_B14 ALU_B13 ALU_B12 ALU_B11 ALU_B10 ALU_B9 ALU_B8 ALU_B7 ALU_B6 ALU_B5 ALU_B4 ALU_B3 ALU_B2 ALU_B1 ALU_B0 ALU_CIN ALU_SEL1
+ ALU_SEL0 ALU_Y15b ALU_Y14b ALU_Y13b ALU_Y12b ALU_Y11b ALU_Y10b ALU_Y9b ALU_Y8b ALU_Y7b ALU_Y6b ALU_Y5b ALU_Y4b ALU_Y3b ALU_Y2b ALU_Y1b
+ ALU_Y0b ALU_F ALU_Z ALU_N alu
x2 CLK REG_WRITE VDD VSS WE15 WE14 WE13 WE12 WE11 WE10 WE9 WE8 WE7 WE6 WE5 WE4 WE3 WE2 WE1 WE0 RA15 RA14 RA13 RA12 RA11 RA10 RA9
+ RA8 RA7 RA6 RA5 RA4 RA3 RA2 RA1 RA0 RB15 RB14 RB13 RB12 RB11 RB10 RB9 RB8 RB7 RB6 RB5 RB4 RB3 RB2 RB1 RB0 RF_D15 RF_D14 RF_D13 RF_D12
+ RF_D11 RF_D10 RF_D9 RF_D8 RF_D7 RF_D6 RF_D5 RF_D4 RF_D3 RF_D2 RF_D1 RF_D0 RSRC15b RSRC14b RSRC13b RSRC12b RSRC11b RSRC10b RSRC9b RSRC8b
+ RSRC7b RSRC6b RSRC5b RSRC4b RSRC3b RSRC2b RSRC1b RSRC0b RDST15b RDST14b RDST13b RDST12b RDST11b RDST10b RDST9b RDST8b RDST7b RDST6b
+ RDST5b RDST4b RDST3b RDST2b RDST1b RDST0b rf
x3 VDD VSS CLK RSTn PC_BR INSTR7 INSTR6 INSTR5 INSTR4 INSTR3 INSTR2 INSTR1 INSTR0 PC_JMP DEST15 DEST14 DEST13 DEST12 DEST11 DEST10
+ DEST9 DEST8 DEST7 DEST6 DEST5 DEST4 DEST3 DEST2 DEST1 DEST0 SI SE PC15 PC14 PC13 PC12 PC11 PC10 PC9 PC8 PC7 PC6 PC5 PC4 PC3 PC2 PC1 PC0
+ PC_NEXT15 pc
x4 VDD VSS SHIFTER_D15b SHIFTER_D14b SHIFTER_D13b SHIFTER_D12b SHIFTER_D11b SHIFTER_D10b SHIFTER_D9b SHIFTER_D8b SHIFTER_D7b
+ SHIFTER_D6b SHIFTER_D5b SHIFTER_D4b SHIFTER_D3b SHIFTER_D2b SHIFTER_D1b SHIFTER_D0b SHIFTER_I3 SHIFTER_I2 SHIFTER_I1 SHIFTER_I0 SHIFTER_R3
+ SHIFTER_R2 SHIFTER_R1 SHIFTER_R0 SHIFT_AMT_SRC SHIFTER_Q15b SHIFTER_Q14b SHIFTER_Q13b SHIFTER_Q12b SHIFTER_Q11b SHIFTER_Q10b SHIFTER_Q9b
+ SHIFTER_Q8b SHIFTER_Q7b SHIFTER_Q6b SHIFTER_Q5b SHIFTER_Q4b SHIFTER_Q3b SHIFTER_Q2b SHIFTER_Q1b SHIFTER_Q0b shifter
x515 DATA_OUT0 DMEM_Q15b DATA_OUT1 ALU_Y15b VSS net1[15] DATA_OUT2 SHIFTER_Q15b DATA_OUT3 PC15b 4x1_mux
x514 DATA_OUT0 DMEM_Q14b DATA_OUT1 ALU_Y14b VSS net1[14] DATA_OUT2 SHIFTER_Q14b DATA_OUT3 PC14b 4x1_mux
x513 DATA_OUT0 DMEM_Q13b DATA_OUT1 ALU_Y13b VSS net1[13] DATA_OUT2 SHIFTER_Q13b DATA_OUT3 PC13b 4x1_mux
x512 DATA_OUT0 DMEM_Q12b DATA_OUT1 ALU_Y12b VSS net1[12] DATA_OUT2 SHIFTER_Q12b DATA_OUT3 PC12b 4x1_mux
x511 DATA_OUT0 DMEM_Q11b DATA_OUT1 ALU_Y11b VSS net1[11] DATA_OUT2 SHIFTER_Q11b DATA_OUT3 PC11b 4x1_mux
x510 DATA_OUT0 DMEM_Q10b DATA_OUT1 ALU_Y10b VSS net1[10] DATA_OUT2 SHIFTER_Q10b DATA_OUT3 PC10b 4x1_mux
x59 DATA_OUT0 DMEM_Q9b DATA_OUT1 ALU_Y9b VSS net1[9] DATA_OUT2 SHIFTER_Q9b DATA_OUT3 PC9b 4x1_mux
x58 DATA_OUT0 DMEM_Q8b DATA_OUT1 ALU_Y8b VSS net1[8] DATA_OUT2 SHIFTER_Q8b DATA_OUT3 PC8b 4x1_mux
x57 DATA_OUT0 DMEM_Q7b DATA_OUT1 ALU_Y7b VSS net1[7] DATA_OUT2 SHIFTER_Q7b DATA_OUT3 PC7b 4x1_mux
x56 DATA_OUT0 DMEM_Q6b DATA_OUT1 ALU_Y6b VSS net1[6] DATA_OUT2 SHIFTER_Q6b DATA_OUT3 PC6b 4x1_mux
x55 DATA_OUT0 DMEM_Q5b DATA_OUT1 ALU_Y5b VSS net1[5] DATA_OUT2 SHIFTER_Q5b DATA_OUT3 PC5b 4x1_mux
x54 DATA_OUT0 DMEM_Q4b DATA_OUT1 ALU_Y4b VSS net1[4] DATA_OUT2 SHIFTER_Q4b DATA_OUT3 PC4b 4x1_mux
x53 DATA_OUT0 DMEM_Q3b DATA_OUT1 ALU_Y3b VSS net1[3] DATA_OUT2 SHIFTER_Q3b DATA_OUT3 PC3b 4x1_mux
x52 DATA_OUT0 DMEM_Q2b DATA_OUT1 ALU_Y2b VSS net1[2] DATA_OUT2 SHIFTER_Q2b DATA_OUT3 PC2b 4x1_mux
x51 DATA_OUT0 DMEM_Q1b DATA_OUT1 ALU_Y1b VSS net1[1] DATA_OUT2 SHIFTER_Q1b DATA_OUT3 PC1b 4x1_mux
x50 DATA_OUT0 DMEM_Q0b DATA_OUT1 ALU_Y0b VSS net1[0] DATA_OUT2 SHIFTER_Q0b DATA_OUT3 PC0b 4x1_mux
x115 VDD net1[15] RF_D15 VSS inv kINV=1
x114 VDD net1[14] RF_D14 VSS inv kINV=1
x113 VDD net1[13] RF_D13 VSS inv kINV=1
x112 VDD net1[12] RF_D12 VSS inv kINV=1
x111 VDD net1[11] RF_D11 VSS inv kINV=1
x110 VDD net1[10] RF_D10 VSS inv kINV=1
x19 VDD net1[9] RF_D9 VSS inv kINV=1
x18 VDD net1[8] RF_D8 VSS inv kINV=1
x17 VDD net1[7] RF_D7 VSS inv kINV=1
x16 VDD net1[6] RF_D6 VSS inv kINV=1
x15 VDD net1[5] RF_D5 VSS inv kINV=1
x14 VDD net1[4] RF_D4 VSS inv kINV=1
x13 VDD net1[3] RF_D3 VSS inv kINV=1
x12 VDD net1[2] RF_D2 VSS inv kINV=1
x11 VDD net1[1] RF_D1 VSS inv kINV=1
x10 VDD net1[0] RF_D0 VSS inv kINV=1
x23 INSTR3 IS_LUI IS_LUI3b SHIFTER_I3 VDD VSS VDD 2x1_mux
x22 INSTR2 IS_LUI IS_LUI2b SHIFTER_I2 VDD VSS VSS 2x1_mux
x21 INSTR1 IS_LUI IS_LUI1b SHIFTER_I1 VDD VSS VSS 2x1_mux
x20 INSTR0 IS_LUI IS_LUI0b SHIFTER_I0 VDD VSS VSS 2x1_mux
x33 VDD RSRC3b SHIFTER_R3 VSS inv kINV=1
x32 VDD RSRC2b SHIFTER_R2 VSS inv kINV=1
x31 VDD RSRC1b SHIFTER_R1 VSS inv kINV=1
x30 VDD RSRC0b SHIFTER_R0 VSS inv kINV=1
x415 RDST15b ALU_SRC_A net2[15] VDD VSS VDD 2x1_mux_pass
x414 RDST14b ALU_SRC_A net2[14] VDD VSS VDD 2x1_mux_pass
x413 RDST13b ALU_SRC_A net2[13] VDD VSS VDD 2x1_mux_pass
x412 RDST12b ALU_SRC_A net2[12] VDD VSS VDD 2x1_mux_pass
x411 RDST11b ALU_SRC_A net2[11] VDD VSS VDD 2x1_mux_pass
x410 RDST10b ALU_SRC_A net2[10] VDD VSS VDD 2x1_mux_pass
x49 RDST9b ALU_SRC_A net2[9] VDD VSS VDD 2x1_mux_pass
x48 RDST8b ALU_SRC_A net2[8] VDD VSS VDD 2x1_mux_pass
x47 RDST7b ALU_SRC_A net2[7] VDD VSS VDD 2x1_mux_pass
x46 RDST6b ALU_SRC_A net2[6] VDD VSS VDD 2x1_mux_pass
x45 RDST5b ALU_SRC_A net2[5] VDD VSS VDD 2x1_mux_pass
x44 RDST4b ALU_SRC_A net2[4] VDD VSS VDD 2x1_mux_pass
x43 RDST3b ALU_SRC_A net2[3] VDD VSS VDD 2x1_mux_pass
x42 RDST2b ALU_SRC_A net2[2] VDD VSS VDD 2x1_mux_pass
x41 RDST1b ALU_SRC_A net2[1] VDD VSS VDD 2x1_mux_pass
x40 RDST0b ALU_SRC_A net2[0] VDD VSS VDD 2x1_mux_pass
x615 VDD net2[15] ALU_A15 VSS inv kINV=1
x614 VDD net2[14] ALU_A14 VSS inv kINV=1
x613 VDD net2[13] ALU_A13 VSS inv kINV=1
x612 VDD net2[12] ALU_A12 VSS inv kINV=1
x611 VDD net2[11] ALU_A11 VSS inv kINV=1
x610 VDD net2[10] ALU_A10 VSS inv kINV=1
x69 VDD net2[9] ALU_A9 VSS inv kINV=1
x68 VDD net2[8] ALU_A8 VSS inv kINV=1
x67 VDD net2[7] ALU_A7 VSS inv kINV=1
x66 VDD net2[6] ALU_A6 VSS inv kINV=1
x65 VDD net2[5] ALU_A5 VSS inv kINV=1
x64 VDD net2[4] ALU_A4 VSS inv kINV=1
x63 VDD net2[3] ALU_A3 VSS inv kINV=1
x62 VDD net2[2] ALU_A2 VSS inv kINV=1
x61 VDD net2[1] ALU_A1 VSS inv kINV=1
x60 VDD net2[0] ALU_A0 VSS inv kINV=1
x715 RSRC15b ALU_SRC_B net3[15] VDD VSS IMM15b 2x1_mux_pass
x714 RSRC14b ALU_SRC_B net3[14] VDD VSS IMM14b 2x1_mux_pass
x713 RSRC13b ALU_SRC_B net3[13] VDD VSS IMM13b 2x1_mux_pass
x712 RSRC12b ALU_SRC_B net3[12] VDD VSS IMM12b 2x1_mux_pass
x711 RSRC11b ALU_SRC_B net3[11] VDD VSS IMM11b 2x1_mux_pass
x710 RSRC10b ALU_SRC_B net3[10] VDD VSS IMM10b 2x1_mux_pass
x79 RSRC9b ALU_SRC_B net3[9] VDD VSS IMM9b 2x1_mux_pass
x78 RSRC8b ALU_SRC_B net3[8] VDD VSS IMM8b 2x1_mux_pass
x77 RSRC7b ALU_SRC_B net3[7] VDD VSS IMM7b 2x1_mux_pass
x76 RSRC6b ALU_SRC_B net3[6] VDD VSS IMM6b 2x1_mux_pass
x75 RSRC5b ALU_SRC_B net3[5] VDD VSS IMM5b 2x1_mux_pass
x74 RSRC4b ALU_SRC_B net3[4] VDD VSS IMM4b 2x1_mux_pass
x73 RSRC3b ALU_SRC_B net3[3] VDD VSS IMM3b 2x1_mux_pass
x72 RSRC2b ALU_SRC_B net3[2] VDD VSS IMM2b 2x1_mux_pass
x71 RSRC1b ALU_SRC_B net3[1] VDD VSS IMM1b 2x1_mux_pass
x70 RSRC0b ALU_SRC_B net3[0] VDD VSS IMM0b 2x1_mux_pass
x815 VDD net3[15] ALU_B15 VSS inv kINV=1
x814 VDD net3[14] ALU_B14 VSS inv kINV=1
x813 VDD net3[13] ALU_B13 VSS inv kINV=1
x812 VDD net3[12] ALU_B12 VSS inv kINV=1
x811 VDD net3[11] ALU_B11 VSS inv kINV=1
x810 VDD net3[10] ALU_B10 VSS inv kINV=1
x89 VDD net3[9] ALU_B9 VSS inv kINV=1
x88 VDD net3[8] ALU_B8 VSS inv kINV=1
x87 VDD net3[7] ALU_B7 VSS inv kINV=1
x86 VDD net3[6] ALU_B6 VSS inv kINV=1
x85 VDD net3[5] ALU_B5 VSS inv kINV=1
x84 VDD net3[4] ALU_B4 VSS inv kINV=1
x83 VDD net3[3] ALU_B3 VSS inv kINV=1
x82 VDD net3[2] ALU_B2 VSS inv kINV=1
x81 VDD net3[1] ALU_B1 VSS inv kINV=1
x80 VDD net3[0] ALU_B0 VSS inv kINV=1
x915 VDD RSRC15b DMEM_ADDR15 VSS inv kINV=1
x914 VDD RSRC14b DMEM_ADDR14 VSS inv kINV=1
x913 VDD RSRC13b DMEM_ADDR13 VSS inv kINV=1
x912 VDD RSRC12b DMEM_ADDR12 VSS inv kINV=1
x911 VDD RSRC11b DMEM_ADDR11 VSS inv kINV=1
x910 VDD RSRC10b DMEM_ADDR10 VSS inv kINV=1
x99 VDD RSRC9b DMEM_ADDR9 VSS inv kINV=1
x98 VDD RSRC8b DMEM_ADDR8 VSS inv kINV=1
x97 VDD RSRC7b DMEM_ADDR7 VSS inv kINV=1
x96 VDD RSRC6b DMEM_ADDR6 VSS inv kINV=1
x95 VDD RSRC5b DMEM_ADDR5 VSS inv kINV=1
x94 VDD RSRC4b DMEM_ADDR4 VSS inv kINV=1
x93 VDD RSRC3b DMEM_ADDR3 VSS inv kINV=1
x92 VDD RSRC2b DMEM_ADDR2 VSS inv kINV=1
x91 VDD RSRC1b DMEM_ADDR1 VSS inv kINV=1
x90 VDD RSRC0b DMEM_ADDR0 VSS inv kINV=1
x1015 VDD DMEM_Q15 DMEM_Q15b VSS inv kINV=1
x1014 VDD DMEM_Q14 DMEM_Q14b VSS inv kINV=1
x1013 VDD DMEM_Q13 DMEM_Q13b VSS inv kINV=1
x1012 VDD DMEM_Q12 DMEM_Q12b VSS inv kINV=1
x1011 VDD DMEM_Q11 DMEM_Q11b VSS inv kINV=1
x1010 VDD DMEM_Q10 DMEM_Q10b VSS inv kINV=1
x109 VDD DMEM_Q9 DMEM_Q9b VSS inv kINV=1
x108 VDD DMEM_Q8 DMEM_Q8b VSS inv kINV=1
x107 VDD DMEM_Q7 DMEM_Q7b VSS inv kINV=1
x106 VDD DMEM_Q6 DMEM_Q6b VSS inv kINV=1
x105 VDD DMEM_Q5 DMEM_Q5b VSS inv kINV=1
x104 VDD DMEM_Q4 DMEM_Q4b VSS inv kINV=1
x103 VDD DMEM_Q3 DMEM_Q3b VSS inv kINV=1
x102 VDD DMEM_Q2 DMEM_Q2b VSS inv kINV=1
x101 VDD DMEM_Q1 DMEM_Q1b VSS inv kINV=1
x100 VDD DMEM_Q0 DMEM_Q0b VSS inv kINV=1
x1215 RDST15b SHIFT_VAL_SRC SHIFTER_D15b VDD VSS IMM15b 2x1_mux_pass
x1214 RDST14b SHIFT_VAL_SRC SHIFTER_D14b VDD VSS IMM14b 2x1_mux_pass
x1213 RDST13b SHIFT_VAL_SRC SHIFTER_D13b VDD VSS IMM13b 2x1_mux_pass
x1212 RDST12b SHIFT_VAL_SRC SHIFTER_D12b VDD VSS IMM12b 2x1_mux_pass
x1211 RDST11b SHIFT_VAL_SRC SHIFTER_D11b VDD VSS IMM11b 2x1_mux_pass
x1210 RDST10b SHIFT_VAL_SRC SHIFTER_D10b VDD VSS IMM10b 2x1_mux_pass
x129 RDST9b SHIFT_VAL_SRC SHIFTER_D9b VDD VSS IMM9b 2x1_mux_pass
x128 RDST8b SHIFT_VAL_SRC SHIFTER_D8b VDD VSS IMM8b 2x1_mux_pass
x127 RDST7b SHIFT_VAL_SRC SHIFTER_D7b VDD VSS IMM7b 2x1_mux_pass
x126 RDST6b SHIFT_VAL_SRC SHIFTER_D6b VDD VSS IMM6b 2x1_mux_pass
x125 RDST5b SHIFT_VAL_SRC SHIFTER_D5b VDD VSS IMM5b 2x1_mux_pass
x124 RDST4b SHIFT_VAL_SRC SHIFTER_D4b VDD VSS IMM4b 2x1_mux_pass
x123 RDST3b SHIFT_VAL_SRC SHIFTER_D3b VDD VSS IMM3b 2x1_mux_pass
x122 RDST2b SHIFT_VAL_SRC SHIFTER_D2b VDD VSS IMM2b 2x1_mux_pass
x121 RDST1b SHIFT_VAL_SRC SHIFTER_D1b VDD VSS IMM1b 2x1_mux_pass
x120 RDST0b SHIFT_VAL_SRC SHIFTER_D0b VDD VSS IMM0b 2x1_mux_pass
x1415 VDD OUT IMM15b VSS inv kINV=1
x1414 VDD OUT IMM14b VSS inv kINV=1
x1413 VDD OUT IMM13b VSS inv kINV=1
x1412 VDD OUT IMM12b VSS inv kINV=1
x1411 VDD OUT IMM11b VSS inv kINV=1
x1410 VDD OUT IMM10b VSS inv kINV=1
x149 VDD OUT IMM9b VSS inv kINV=1
x148 VDD OUT IMM8b VSS inv kINV=1
x147 VDD INSTR7 IMM7b VSS inv kINV=1
x146 VDD INSTR6 IMM6b VSS inv kINV=1
x145 VDD INSTR5 IMM5b VSS inv kINV=1
x144 VDD INSTR4 IMM4b VSS inv kINV=1
x143 VDD INSTR3 IMM3b VSS inv kINV=1
x142 VDD INSTR2 IMM2b VSS inv kINV=1
x141 VDD INSTR1 IMM1b VSS inv kINV=1
x140 VDD INSTR0 IMM0b VSS inv kINV=1
x1615 CLK15b IMEM_Q15 INSTR15 RSTn CLK VDD VSS dff
x1614 CLK14b IMEM_Q14 INSTR14 RSTn CLK VDD VSS dff
x1613 CLK13b IMEM_Q13 INSTR13 RSTn CLK VDD VSS dff
x1612 CLK12b IMEM_Q12 INSTR12 RSTn CLK VDD VSS dff
x1611 CLK11b IMEM_Q11 INSTR11 RSTn CLK VDD VSS dff
x1610 CLK10b IMEM_Q10 INSTR10 RSTn CLK VDD VSS dff
x169 CLK9b IMEM_Q9 INSTR9 RSTn CLK VDD VSS dff
x168 CLK8b IMEM_Q8 INSTR8 RSTn CLK VDD VSS dff
x167 CLK7b IMEM_Q7 INSTR7 RSTn CLK VDD VSS dff
x166 CLK6b IMEM_Q6 INSTR6 RSTn CLK VDD VSS dff
x165 CLK5b IMEM_Q5 INSTR5 RSTn CLK VDD VSS dff
x164 CLK4b IMEM_Q4 INSTR4 RSTn CLK VDD VSS dff
x163 CLK3b IMEM_Q3 INSTR3 RSTn CLK VDD VSS dff
x162 CLK2b IMEM_Q2 INSTR2 RSTn CLK VDD VSS dff
x161 CLK1b IMEM_Q1 INSTR1 RSTn CLK VDD VSS dff
x160 CLK0b IMEM_Q0 INSTR0 RSTn CLK VDD VSS dff
x1515 VDD RSRC15b DEST15 VSS inv kINV=1
x1514 VDD RSRC14b DEST14 VSS inv kINV=1
x1513 VDD RSRC13b DEST13 VSS inv kINV=1
x1512 VDD RSRC12b DEST12 VSS inv kINV=1
x1511 VDD RSRC11b DEST11 VSS inv kINV=1
x1510 VDD RSRC10b DEST10 VSS inv kINV=1
x159 VDD RSRC9b DEST9 VSS inv kINV=1
x158 VDD RSRC8b DEST8 VSS inv kINV=1
x157 VDD RSRC7b DEST7 VSS inv kINV=1
x156 VDD RSRC6b DEST6 VSS inv kINV=1
x155 VDD RSRC5b DEST5 VSS inv kINV=1
x154 VDD RSRC4b DEST4 VSS inv kINV=1
x153 VDD RSRC3b DEST3 VSS inv kINV=1
x152 VDD RSRC2b DEST2 VSS inv kINV=1
x151 VDD RSRC1b DEST1 VSS inv kINV=1
x150 VDD RSRC0b DEST0 VSS inv kINV=1
x5 EXTEND OUT INSTR7 VDD VSS sign_zero_extender
x173 VDD IS_LUI IS_LUI3b VSS inv kINV=1
x172 VDD IS_LUI IS_LUI2b VSS inv kINV=1
x171 VDD IS_LUI IS_LUI1b VSS inv kINV=1
x170 VDD IS_LUI IS_LUI0b VSS inv kINV=1
x1815 VDD PC15 PC15b VSS inv kINV=1
x1814 VDD PC14 PC14b VSS inv kINV=1
x1813 VDD PC13 PC13b VSS inv kINV=1
x1812 VDD PC12 PC12b VSS inv kINV=1
x1811 VDD PC11 PC11b VSS inv kINV=1
x1810 VDD PC10 PC10b VSS inv kINV=1
x189 VDD PC9 PC9b VSS inv kINV=1
x188 VDD PC8 PC8b VSS inv kINV=1
x187 VDD PC7 PC7b VSS inv kINV=1
x186 VDD PC6 PC6b VSS inv kINV=1
x185 VDD PC5 PC5b VSS inv kINV=1
x184 VDD PC4 PC4b VSS inv kINV=1
x183 VDD PC3 PC3b VSS inv kINV=1
x182 VDD PC2 PC2b VSS inv kINV=1
x181 VDD PC1 PC1b VSS inv kINV=1
x180 VDD PC0 PC0b VSS inv kINV=1
x1915 VDD CLK CLK15b VSS inv kINV=1
x1914 VDD CLK CLK14b VSS inv kINV=1
x1913 VDD CLK CLK13b VSS inv kINV=1
x1912 VDD CLK CLK12b VSS inv kINV=1
x1911 VDD CLK CLK11b VSS inv kINV=1
x1910 VDD CLK CLK10b VSS inv kINV=1
x199 VDD CLK CLK9b VSS inv kINV=1
x198 VDD CLK CLK8b VSS inv kINV=1
x197 VDD CLK CLK7b VSS inv kINV=1
x196 VDD CLK CLK6b VSS inv kINV=1
x195 VDD CLK CLK5b VSS inv kINV=1
x194 VDD CLK CLK4b VSS inv kINV=1
x193 VDD CLK CLK3b VSS inv kINV=1
x192 VDD CLK CLK2b VSS inv kINV=1
x191 VDD CLK CLK1b VSS inv kINV=1
x190 VDD CLK CLK0b VSS inv kINV=1
x2015 VDD RDST15b RDST15 VSS inv kINV=1
x2014 VDD RDST14b RDST14 VSS inv kINV=1
x2013 VDD RDST13b RDST13 VSS inv kINV=1
x2012 VDD RDST12b RDST12 VSS inv kINV=1
x2011 VDD RDST11b RDST11 VSS inv kINV=1
x2010 VDD RDST10b RDST10 VSS inv kINV=1
x209 VDD RDST9b RDST9 VSS inv kINV=1
x208 VDD RDST8b RDST8 VSS inv kINV=1
x207 VDD RDST7b RDST7 VSS inv kINV=1
x206 VDD RDST6b RDST6 VSS inv kINV=1
x205 VDD RDST5b RDST5 VSS inv kINV=1
x204 VDD RDST4b RDST4 VSS inv kINV=1
x203 VDD RDST3b RDST3 VSS inv kINV=1
x202 VDD RDST2b RDST2 VSS inv kINV=1
x201 VDD RDST1b RDST1 VSS inv kINV=1
x200 VDD RDST0b RDST0 VSS inv kINV=1
.ends

* expanding   symbol:  engn1600-team1/CAD4/alu.sym # of pins=10
** sym_path: /foss/designs/engn1600-team1/CAD4/alu.sym
** sch_path: /foss/designs/engn1600-team1/CAD4/alu.sch
.subckt alu VDD VSS A15 A14 A13 A12 A11 A10 A9 A8 A7 A6 A5 A4 A3 A2 A1 A0 B15 B14 B13 B12 B11 B10 B9 B8 B7 B6 B5 B4 B3 B2 B1 B0
+ CIN SEL1 SEL0 Y15 Y14 Y13 Y12 Y11 Y10 Y9 Y8 Y7 Y6 Y5 Y4 Y3 Y2 Y1 Y0 F Z N
*.PININFO VDD:B VSS:B A[15..0]:I B[15..0]:I SEL[1..0]:I Y[15..0]:O F:O Z:O N:O CIN:I
x1 VDD VSS A0 B0p CIN SUM0b COUT0 full_adder kSUMb='kSUMb' kTS='kTS'
x2 VDD VSS A1 B1p COUT0 SUM1b COUT1 full_adder kSUMb='kSUMb' kTS='kTS'
x3 VDD VSS A2 B2p COUT1 SUM2b COUT2 full_adder kSUMb='kSUMb' kTS='kTS'
x4 VDD VSS A3 B3p COUT2 SUM3b COUT3 full_adder kSUMb='kSUMb' kTS='kTS'
x5 NOR0 VDD VSS XNOR0 A0 B0p NAND0 XOR0 logic
x1015 SA SUM15b SB NAND15 VSS Y15b SC NOR15 SD XNOR15 4x1_mux
x1014 SA SUM14b SB NAND14 VSS Y14b SC NOR14 SD XNOR14 4x1_mux
x1013 SA SUM13b SB NAND13 VSS Y13b SC NOR13 SD XNOR13 4x1_mux
x1012 SA SUM12b SB NAND12 VSS Y12b SC NOR12 SD XNOR12 4x1_mux
x1011 SA SUM11b SB NAND11 VSS Y11b SC NOR11 SD XNOR11 4x1_mux
x1010 SA SUM10b SB NAND10 VSS Y10b SC NOR10 SD XNOR10 4x1_mux
x109 SA SUM9b SB NAND9 VSS Y9b SC NOR9 SD XNOR9 4x1_mux
x108 SA SUM8b SB NAND8 VSS Y8b SC NOR8 SD XNOR8 4x1_mux
x107 SA SUM7b SB NAND7 VSS Y7b SC NOR7 SD XNOR7 4x1_mux
x106 SA SUM6b SB NAND6 VSS Y6b SC NOR6 SD XNOR6 4x1_mux
x105 SA SUM5b SB NAND5 VSS Y5b SC NOR5 SD XNOR5 4x1_mux
x104 SA SUM4b SB NAND4 VSS Y4b SC NOR4 SD XNOR4 4x1_mux
x103 SA SUM3b SB NAND3 VSS Y3b SC NOR3 SD XNOR3 4x1_mux
x102 SA SUM2b SB NAND2 VSS Y2b SC NOR2 SD XNOR2 4x1_mux
x101 SA SUM1b SB NAND1 VSS Y1b SC NOR1 SD XNOR1 4x1_mux
x100 SA SUM0b SB NAND0 VSS Y0b SC NOR0 SD XNOR0 4x1_mux
x1115 VDD Y15b Y15 VSS inv
x1114 VDD Y14b Y14 VSS inv
x1113 VDD Y13b Y13 VSS inv
x1112 VDD Y12b Y12 VSS inv
x1111 VDD Y11b Y11 VSS inv
x1110 VDD Y10b Y10 VSS inv
x119 VDD Y9b Y9 VSS inv
x118 VDD Y8b Y8 VSS inv
x117 VDD Y7b Y7 VSS inv
x116 VDD Y6b Y6 VSS inv
x115 VDD Y5b Y5 VSS inv
x114 VDD Y4b Y4 VSS inv
x113 VDD Y3b Y3 VSS inv
x112 VDD Y2b Y2 VSS inv
x111 VDD Y1b Y1 VSS inv
x110 VDD Y0b Y0 VSS inv
x8 NOR1 VDD VSS XNOR1 A1 B1p NAND1 XOR1 logic
x11 NOR2 VDD VSS XNOR2 A2 B2p NAND2 XOR2 logic
x14 NOR3 VDD VSS XNOR3 A3 B3p NAND3 XOR3 logic
x17 AND4 XOR4 OR4 NOR4 VDD VSS XNOR4 A4 B4p NAND4 logic_extended
x18 VDD VSS A5 B5p AND4 SUM_05b COUT_05 full_adder kSUMb='kSUMb' kTS='kTS'
x19 VDD VSS A6 B6p COUT_05 SUM_06b COUT_06 full_adder kSUMb='kSUMb' kTS='kTS'
x20 VDD VSS A7 B7p COUT_06 SUM_07b COUT_07 full_adder kSUMb='kSUMb' kTS='kTS'
x24 NOR5 VDD VSS XNOR5 A5 B5p NAND5 XOR5 logic
x25 NOR6 VDD VSS XNOR6 A6 B6p NAND6 XOR6 logic
x26 NOR7 VDD VSS XNOR7 A7 B7p NAND7 XOR7 logic
x35 SUM_07b COUT3 COUT3b SUM7b VDD VSS SUM_17b 2x1_mux
x36 SUM_06b COUT3 COUT3b SUM6b VDD VSS SUM_16b 2x1_mux
x37 SUM_05b COUT3 COUT3b SUM5b VDD VSS SUM_15b 2x1_mux
x38 XOR4 COUT3b COUT3 SUM4b VDD VSS XNOR4 2x1_mux
x21 VDD VSS A5 B5p OR4 SUM_15b COUT_15 full_adder kSUMb='kSUMb' kTS='kTS'
x22 VDD VSS A6 B6p COUT_15 SUM_16b COUT_16 full_adder kSUMb='kSUMb' kTS='kTS'
x23 VDD VSS A7 B7p COUT_16 SUM_17b COUT_17 full_adder kSUMb='kSUMb' kTS='kTS'
x39 COUT_17 COUT3b COUT3 COUT7 VDD VSS COUT_07 COUT7b 2x1_mux_cmos kI='kI' kYb='kYb' kY='kY'
x40 VDD COUT3 COUT3b VSS inv
x42 AND8 XOR8 OR8 NOR8 VDD VSS XNOR8 A8 B8p NAND8 logic_extended
x43 VDD VSS A9 B9p AND8 SUM_09b COUT_09 full_adder kSUMb='kSUMb' kTS='kTS'
x44 VDD VSS A10 B10p COUT_09 SUM_010b COUT_010 full_adder kSUMb='kSUMb' kTS='kTS'
x45 VDD VSS A11 B11p COUT_010 SUM_011b COUT_011 full_adder kSUMb='kSUMb' kTS='kTS'
x46 NOR9 VDD VSS XNOR9 A9 B9p NAND9 XOR9 logic
x47 NOR10 VDD VSS XNOR10 A10 B10p NAND10 XOR10 logic
x48 NOR11 VDD VSS XNOR11 A11 B11p NAND11 XOR11 logic
x57 SUM_011b COUT7 COUT7b SUM11b VDD VSS SUM_111b 2x1_mux
x58 SUM_010b COUT7 COUT7b SUM10b VDD VSS SUM_110b 2x1_mux
x59 SUM_09b COUT7 COUT7b SUM9b VDD VSS SUM_19b 2x1_mux
x60 XOR8 COUT7b COUT7 SUM8b VDD VSS XNOR8 2x1_mux
x61 VDD VSS A9 B9p OR8 SUM_19b COUT_19 full_adder kSUMb='kSUMb' kTS='kTS'
x62 VDD VSS A10 B10p COUT_19 SUM_110b COUT_110 full_adder kSUMb='kSUMb' kTS='kTS'
x63 VDD VSS A11 B11p COUT_110 SUM_111b COUT_111 full_adder kSUMb='kSUMb' kTS='kTS'
x64 COUT_111 COUT7b COUT7 COUT11 VDD VSS COUT_011 COUT11b 2x1_mux_cmos kI='kI' kYb='kYb' kY='kY'
x66 AND12 XOR12 OR12 NOR12 VDD VSS XNOR12 A12 B12p NAND12 logic_extended
x67 VDD VSS A13 B13p AND12 SUM_013b COUT_013 full_adder kSUMb='kSUMb' kTS='kTS'
x68 VDD VSS A14 B14p COUT_013 SUM_014b COUT_014 full_adder kSUMb='kSUMb' kTS='kTS'
x69 VDD VSS A15 B15p COUT_014 SUM_015b COUT_015 full_adder kSUMb='kSUMb' kTS='kTS'
x70 NOR13 VDD VSS XNOR13 A13 B13p NAND13 XOR13 logic
x71 NOR14 VDD VSS XNOR14 A14 B14p NAND14 XOR14 logic
x72 NOR15 VDD VSS XNOR15 A15 B15p NAND15 XOR15 logic
x81 SUM_015b COUT11 COUT11b SUM15b VDD VSS SUM_115b 2x1_mux
x82 SUM_014b COUT11 COUT11b SUM14b VDD VSS SUM_114b 2x1_mux
x83 SUM_013b COUT11 COUT11b SUM13b VDD VSS SUM_113b 2x1_mux
x84 XOR12 COUT11b COUT11 SUM12b VDD VSS XNOR12 2x1_mux
x85 VDD VSS A13 B13p OR12 SUM_113b COUT_113 full_adder kSUMb='kSUMb' kTS='kTS'
x86 VDD VSS A14 B14p COUT_113 SUM_114b COUT_114 full_adder kSUMb='kSUMb' kTS='kTS'
x87 VDD VSS A15 B15p COUT_114 SUM_115b COUT_115 full_adder kSUMb='kSUMb' kTS='kTS'
x88 VDD VSS SEL0 SEL1 SA SB SC SD 2x4_decoder
x89 XOR15 XOR14 XOR13 XOR12 XOR11 XOR10 XOR9 XOR8 XOR7 XOR6 XOR5 XOR4 XOR3 XOR2 XOR1 XOR0 VDD Z VSS and16
x91 COUT_115 COUT11b COUT11 COUT15 VDD VSS COUT_015 COUT15b 2x1_mux_cmos kI='kI' kYb='kYb' kY='kY'
x94 COUT_014 COUT11 COUT11b COUT14 VDD VSS COUT_114 COUT14b 2x1_mux_cmos kI='kI' kYb='kYb' kY='kY'
x93 VDD F COUT14 COUT15 VSS xor2
x95 VDD N F Y15 VSS xor2
x1215 VDD B15p B15 CIN VSS xor2
x1214 VDD B14p B14 CIN VSS xor2
x1213 VDD B13p B13 CIN VSS xor2
x1212 VDD B12p B12 CIN VSS xor2
x1211 VDD B11p B11 CIN VSS xor2
x1210 VDD B10p B10 CIN VSS xor2
x129 VDD B9p B9 CIN VSS xor2
x128 VDD B8p B8 CIN VSS xor2
x127 VDD B7p B7 CIN VSS xor2
x126 VDD B6p B6 CIN VSS xor2
x125 VDD B5p B5 CIN VSS xor2
x124 VDD B4p B4 CIN VSS xor2
x123 VDD B3p B3 CIN VSS xor2
x122 VDD B2p B2 CIN VSS xor2
x121 VDD B1p B1 CIN VSS xor2
x120 VDD B0p B0 CIN VSS xor2
**** begin user architecture code

.param kSUMb=1
.param kTS=1
.param kI=2.5
.param kYb=1.875
.param kY=0.775/0.36

**** end user architecture code
.ends

* expanding   symbol:  engn1600-team1/CAD3/rf.sym # of pins=10
** sym_path: /foss/designs/engn1600-team1/CAD3/rf.sym
** sch_path: /foss/designs/engn1600-team1/CAD3/rf.sch
.subckt rf CLK WEM VDD VSS WE15 WE14 WE13 WE12 WE11 WE10 WE9 WE8 WE7 WE6 WE5 WE4 WE3 WE2 WE1 WE0 RA15 RA14 RA13 RA12 RA11 RA10 RA9
+ RA8 RA7 RA6 RA5 RA4 RA3 RA2 RA1 RA0 RB15 RB14 RB13 RB12 RB11 RB10 RB9 RB8 RB7 RB6 RB5 RB4 RB3 RB2 RB1 RB0 D15 D14 D13 D12 D11 D10 D9
+ D8 D7 D6 D5 D4 D3 D2 D1 D0 QA15b QA14b QA13b QA12b QA11b QA10b QA9b QA8b QA7b QA6b QA5b QA4b QA3b QA2b QA1b QA0b QB15b QB14b QB13b
+ QB12b QB11b QB10b QB9b QB8b QB7b QB6b QB5b QB4b QB3b QB2b QB1b QB0b
*.PININFO RA[15..0]:I RB[15..0]:I WE[15..0]:I CLK:I WEM:I D[15..0]:I VDD:B VSS:B QA[15..0]b:O QB[15..0]b:O
x0_0 VDD VSS QA0 WE0CLK WE0CLKb RA0 RB0 QB0 N0 slave_latch kQ='kQ'
x0_1 VDD VSS QA1 WE0CLK WE0CLKb RA0 RB0 QB1 N1 slave_latch kQ='kQ'
x0_2 VDD VSS QA2 WE0CLK WE0CLKb RA0 RB0 QB2 N2 slave_latch kQ='kQ'
x0_3 VDD VSS QA3 WE0CLK WE0CLKb RA0 RB0 QB3 N3 slave_latch kQ='kQ'
x0_4 VDD VSS QA4 WE0CLK WE0CLKb RA0 RB0 QB4 N4 slave_latch kQ='kQ'
x0_5 VDD VSS QA5 WE0CLK WE0CLKb RA0 RB0 QB5 N5 slave_latch kQ='kQ'
x0_6 VDD VSS QA6 WE0CLK WE0CLKb RA0 RB0 QB6 N6 slave_latch kQ='kQ'
x0_7 VDD VSS QA7 WE0CLK WE0CLKb RA0 RB0 QB7 N7 slave_latch kQ='kQ'
x0_8 VDD VSS QA8 WE0CLK WE0CLKb RA0 RB0 QB8 N8 slave_latch kQ='kQ'
x0_9 VDD VSS QA9 WE0CLK WE0CLKb RA0 RB0 QB9 N9 slave_latch kQ='kQ'
x0_10 VDD VSS QA10 WE0CLK WE0CLKb RA0 RB0 QB10 N10 slave_latch kQ='kQ'
x0_11 VDD VSS QA11 WE0CLK WE0CLKb RA0 RB0 QB11 N11 slave_latch kQ='kQ'
x0_12 VDD VSS QA12 WE0CLK WE0CLKb RA0 RB0 QB12 N12 slave_latch kQ='kQ'
x0_13 VDD VSS QA13 WE0CLK WE0CLKb RA0 RB0 QB13 N13 slave_latch kQ='kQ'
x0_14 VDD VSS QA14 WE0CLK WE0CLKb RA0 RB0 QB14 N14 slave_latch kQ='kQ'
x0_15 VDD VSS QA15 WE0CLK WE0CLKb RA0 RB0 QB15 N15 slave_latch kQ='kQ'
x1_0 VDD VSS QA0 WE1CLK WE1CLKb RA1 RB1 QB0 N0 slave_latch kQ='kQ'
x1_1 VDD VSS QA1 WE1CLK WE1CLKb RA1 RB1 QB1 N1 slave_latch kQ='kQ'
x1_2 VDD VSS QA2 WE1CLK WE1CLKb RA1 RB1 QB2 N2 slave_latch kQ='kQ'
x1_3 VDD VSS QA3 WE1CLK WE1CLKb RA1 RB1 QB3 N3 slave_latch kQ='kQ'
x1_4 VDD VSS QA4 WE1CLK WE1CLKb RA1 RB1 QB4 N4 slave_latch kQ='kQ'
x1_5 VDD VSS QA5 WE1CLK WE1CLKb RA1 RB1 QB5 N5 slave_latch kQ='kQ'
x1_6 VDD VSS QA6 WE1CLK WE1CLKb RA1 RB1 QB6 N6 slave_latch kQ='kQ'
x1_7 VDD VSS QA7 WE1CLK WE1CLKb RA1 RB1 QB7 N7 slave_latch kQ='kQ'
x1_8 VDD VSS QA8 WE1CLK WE1CLKb RA1 RB1 QB8 N8 slave_latch kQ='kQ'
x1_9 VDD VSS QA9 WE1CLK WE1CLKb RA1 RB1 QB9 N9 slave_latch kQ='kQ'
x1_10 VDD VSS QA10 WE1CLK WE1CLKb RA1 RB1 QB10 N10 slave_latch kQ='kQ'
x1_11 VDD VSS QA11 WE1CLK WE1CLKb RA1 RB1 QB11 N11 slave_latch kQ='kQ'
x1_12 VDD VSS QA12 WE1CLK WE1CLKb RA1 RB1 QB12 N12 slave_latch kQ='kQ'
x1_13 VDD VSS QA13 WE1CLK WE1CLKb RA1 RB1 QB13 N13 slave_latch kQ='kQ'
x1_14 VDD VSS QA14 WE1CLK WE1CLKb RA1 RB1 QB14 N14 slave_latch kQ='kQ'
x1_15 VDD VSS QA15 WE1CLK WE1CLKb RA1 RB1 QB15 N15 slave_latch kQ='kQ'
x2_0 VDD VSS QA0 WE2CLK WE2CLKb RA2 RB2 QB0 N0 slave_latch kQ='kQ'
x2_1 VDD VSS QA1 WE2CLK WE2CLKb RA2 RB2 QB1 N1 slave_latch kQ='kQ'
x2_2 VDD VSS QA2 WE2CLK WE2CLKb RA2 RB2 QB2 N2 slave_latch kQ='kQ'
x2_3 VDD VSS QA3 WE2CLK WE2CLKb RA2 RB2 QB3 N3 slave_latch kQ='kQ'
x2_4 VDD VSS QA4 WE2CLK WE2CLKb RA2 RB2 QB4 N4 slave_latch kQ='kQ'
x2_5 VDD VSS QA5 WE2CLK WE2CLKb RA2 RB2 QB5 N5 slave_latch kQ='kQ'
x2_6 VDD VSS QA6 WE2CLK WE2CLKb RA2 RB2 QB6 N6 slave_latch kQ='kQ'
x2_7 VDD VSS QA7 WE2CLK WE2CLKb RA2 RB2 QB7 N7 slave_latch kQ='kQ'
x2_8 VDD VSS QA8 WE2CLK WE2CLKb RA2 RB2 QB8 N8 slave_latch kQ='kQ'
x2_9 VDD VSS QA9 WE2CLK WE2CLKb RA2 RB2 QB9 N9 slave_latch kQ='kQ'
x2_10 VDD VSS QA10 WE2CLK WE2CLKb RA2 RB2 QB10 N10 slave_latch kQ='kQ'
x2_11 VDD VSS QA11 WE2CLK WE2CLKb RA2 RB2 QB11 N11 slave_latch kQ='kQ'
x2_12 VDD VSS QA12 WE2CLK WE2CLKb RA2 RB2 QB12 N12 slave_latch kQ='kQ'
x2_13 VDD VSS QA13 WE2CLK WE2CLKb RA2 RB2 QB13 N13 slave_latch kQ='kQ'
x2_14 VDD VSS QA14 WE2CLK WE2CLKb RA2 RB2 QB14 N14 slave_latch kQ='kQ'
x2_15 VDD VSS QA15 WE2CLK WE2CLKb RA2 RB2 QB15 N15 slave_latch kQ='kQ'
x3_0 VDD VSS QA0 WE3CLK WE3CLKb RA3 RB3 QB0 N0 slave_latch kQ='kQ'
x3_1 VDD VSS QA1 WE3CLK WE3CLKb RA3 RB3 QB1 N1 slave_latch kQ='kQ'
x3_2 VDD VSS QA2 WE3CLK WE3CLKb RA3 RB3 QB2 N2 slave_latch kQ='kQ'
x3_3 VDD VSS QA3 WE3CLK WE3CLKb RA3 RB3 QB3 N3 slave_latch kQ='kQ'
x3_4 VDD VSS QA4 WE3CLK WE3CLKb RA3 RB3 QB4 N4 slave_latch kQ='kQ'
x3_5 VDD VSS QA5 WE3CLK WE3CLKb RA3 RB3 QB5 N5 slave_latch kQ='kQ'
x3_6 VDD VSS QA6 WE3CLK WE3CLKb RA3 RB3 QB6 N6 slave_latch kQ='kQ'
x3_7 VDD VSS QA7 WE3CLK WE3CLKb RA3 RB3 QB7 N7 slave_latch kQ='kQ'
x3_8 VDD VSS QA8 WE3CLK WE3CLKb RA3 RB3 QB8 N8 slave_latch kQ='kQ'
x3_9 VDD VSS QA9 WE3CLK WE3CLKb RA3 RB3 QB9 N9 slave_latch kQ='kQ'
x3_10 VDD VSS QA10 WE3CLK WE3CLKb RA3 RB3 QB10 N10 slave_latch kQ='kQ'
x3_11 VDD VSS QA11 WE3CLK WE3CLKb RA3 RB3 QB11 N11 slave_latch kQ='kQ'
x3_12 VDD VSS QA12 WE3CLK WE3CLKb RA3 RB3 QB12 N12 slave_latch kQ='kQ'
x3_13 VDD VSS QA13 WE3CLK WE3CLKb RA3 RB3 QB13 N13 slave_latch kQ='kQ'
x3_14 VDD VSS QA14 WE3CLK WE3CLKb RA3 RB3 QB14 N14 slave_latch kQ='kQ'
x3_15 VDD VSS QA15 WE3CLK WE3CLKb RA3 RB3 QB15 N15 slave_latch kQ='kQ'
x4_0 VDD VSS QA0 WE4CLK WE4CLKb RA4 RB4 QB0 N0 slave_latch kQ='kQ'
x4_1 VDD VSS QA1 WE4CLK WE4CLKb RA4 RB4 QB1 N1 slave_latch kQ='kQ'
x4_2 VDD VSS QA2 WE4CLK WE4CLKb RA4 RB4 QB2 N2 slave_latch kQ='kQ'
x4_3 VDD VSS QA3 WE4CLK WE4CLKb RA4 RB4 QB3 N3 slave_latch kQ='kQ'
x4_4 VDD VSS QA4 WE4CLK WE4CLKb RA4 RB4 QB4 N4 slave_latch kQ='kQ'
x4_5 VDD VSS QA5 WE4CLK WE4CLKb RA4 RB4 QB5 N5 slave_latch kQ='kQ'
x4_6 VDD VSS QA6 WE4CLK WE4CLKb RA4 RB4 QB6 N6 slave_latch kQ='kQ'
x4_7 VDD VSS QA7 WE4CLK WE4CLKb RA4 RB4 QB7 N7 slave_latch kQ='kQ'
x4_8 VDD VSS QA8 WE4CLK WE4CLKb RA4 RB4 QB8 N8 slave_latch kQ='kQ'
x4_9 VDD VSS QA9 WE4CLK WE4CLKb RA4 RB4 QB9 N9 slave_latch kQ='kQ'
x4_10 VDD VSS QA10 WE4CLK WE4CLKb RA4 RB4 QB10 N10 slave_latch kQ='kQ'
x4_11 VDD VSS QA11 WE4CLK WE4CLKb RA4 RB4 QB11 N11 slave_latch kQ='kQ'
x4_12 VDD VSS QA12 WE4CLK WE4CLKb RA4 RB4 QB12 N12 slave_latch kQ='kQ'
x4_13 VDD VSS QA13 WE4CLK WE4CLKb RA4 RB4 QB13 N13 slave_latch kQ='kQ'
x4_14 VDD VSS QA14 WE4CLK WE4CLKb RA4 RB4 QB14 N14 slave_latch kQ='kQ'
x4_15 VDD VSS QA15 WE4CLK WE4CLKb RA4 RB4 QB15 N15 slave_latch kQ='kQ'
x5_0 VDD VSS QA0 WE5CLK WE5CLKb RA5 RB5 QB0 N0 slave_latch kQ='kQ'
x5_1 VDD VSS QA1 WE5CLK WE5CLKb RA5 RB5 QB1 N1 slave_latch kQ='kQ'
x5_2 VDD VSS QA2 WE5CLK WE5CLKb RA5 RB5 QB2 N2 slave_latch kQ='kQ'
x5_3 VDD VSS QA3 WE5CLK WE5CLKb RA5 RB5 QB3 N3 slave_latch kQ='kQ'
x5_4 VDD VSS QA4 WE5CLK WE5CLKb RA5 RB5 QB4 N4 slave_latch kQ='kQ'
x5_5 VDD VSS QA5 WE5CLK WE5CLKb RA5 RB5 QB5 N5 slave_latch kQ='kQ'
x5_6 VDD VSS QA6 WE5CLK WE5CLKb RA5 RB5 QB6 N6 slave_latch kQ='kQ'
x5_7 VDD VSS QA7 WE5CLK WE5CLKb RA5 RB5 QB7 N7 slave_latch kQ='kQ'
x5_8 VDD VSS QA8 WE5CLK WE5CLKb RA5 RB5 QB8 N8 slave_latch kQ='kQ'
x5_9 VDD VSS QA9 WE5CLK WE5CLKb RA5 RB5 QB9 N9 slave_latch kQ='kQ'
x5_10 VDD VSS QA10 WE5CLK WE5CLKb RA5 RB5 QB10 N10 slave_latch kQ='kQ'
x5_11 VDD VSS QA11 WE5CLK WE5CLKb RA5 RB5 QB11 N11 slave_latch kQ='kQ'
x5_12 VDD VSS QA12 WE5CLK WE5CLKb RA5 RB5 QB12 N12 slave_latch kQ='kQ'
x5_13 VDD VSS QA13 WE5CLK WE5CLKb RA5 RB5 QB13 N13 slave_latch kQ='kQ'
x5_14 VDD VSS QA14 WE5CLK WE5CLKb RA5 RB5 QB14 N14 slave_latch kQ='kQ'
x5_15 VDD VSS QA15 WE5CLK WE5CLKb RA5 RB5 QB15 N15 slave_latch kQ='kQ'
x6_0 VDD VSS QA0 WE6CLK WE6CLKb RA6 RB6 QB0 N0 slave_latch kQ='kQ'
x6_1 VDD VSS QA1 WE6CLK WE6CLKb RA6 RB6 QB1 N1 slave_latch kQ='kQ'
x6_2 VDD VSS QA2 WE6CLK WE6CLKb RA6 RB6 QB2 N2 slave_latch kQ='kQ'
x6_3 VDD VSS QA3 WE6CLK WE6CLKb RA6 RB6 QB3 N3 slave_latch kQ='kQ'
x6_4 VDD VSS QA4 WE6CLK WE6CLKb RA6 RB6 QB4 N4 slave_latch kQ='kQ'
x6_5 VDD VSS QA5 WE6CLK WE6CLKb RA6 RB6 QB5 N5 slave_latch kQ='kQ'
x6_6 VDD VSS QA6 WE6CLK WE6CLKb RA6 RB6 QB6 N6 slave_latch kQ='kQ'
x6_7 VDD VSS QA7 WE6CLK WE6CLKb RA6 RB6 QB7 N7 slave_latch kQ='kQ'
x6_8 VDD VSS QA8 WE6CLK WE6CLKb RA6 RB6 QB8 N8 slave_latch kQ='kQ'
x6_9 VDD VSS QA9 WE6CLK WE6CLKb RA6 RB6 QB9 N9 slave_latch kQ='kQ'
x6_10 VDD VSS QA10 WE6CLK WE6CLKb RA6 RB6 QB10 N10 slave_latch kQ='kQ'
x6_11 VDD VSS QA11 WE6CLK WE6CLKb RA6 RB6 QB11 N11 slave_latch kQ='kQ'
x6_12 VDD VSS QA12 WE6CLK WE6CLKb RA6 RB6 QB12 N12 slave_latch kQ='kQ'
x6_13 VDD VSS QA13 WE6CLK WE6CLKb RA6 RB6 QB13 N13 slave_latch kQ='kQ'
x6_14 VDD VSS QA14 WE6CLK WE6CLKb RA6 RB6 QB14 N14 slave_latch kQ='kQ'
x6_15 VDD VSS QA15 WE6CLK WE6CLKb RA6 RB6 QB15 N15 slave_latch kQ='kQ'
x7_0 VDD VSS QA0 WE7CLK WE7CLKb RA7 RB7 QB0 N0 slave_latch kQ='kQ'
x7_1 VDD VSS QA1 WE7CLK WE7CLKb RA7 RB7 QB1 N1 slave_latch kQ='kQ'
x7_2 VDD VSS QA2 WE7CLK WE7CLKb RA7 RB7 QB2 N2 slave_latch kQ='kQ'
x7_3 VDD VSS QA3 WE7CLK WE7CLKb RA7 RB7 QB3 N3 slave_latch kQ='kQ'
x7_4 VDD VSS QA4 WE7CLK WE7CLKb RA7 RB7 QB4 N4 slave_latch kQ='kQ'
x7_5 VDD VSS QA5 WE7CLK WE7CLKb RA7 RB7 QB5 N5 slave_latch kQ='kQ'
x7_6 VDD VSS QA6 WE7CLK WE7CLKb RA7 RB7 QB6 N6 slave_latch kQ='kQ'
x7_7 VDD VSS QA7 WE7CLK WE7CLKb RA7 RB7 QB7 N7 slave_latch kQ='kQ'
x7_8 VDD VSS QA8 WE7CLK WE7CLKb RA7 RB7 QB8 N8 slave_latch kQ='kQ'
x7_9 VDD VSS QA9 WE7CLK WE7CLKb RA7 RB7 QB9 N9 slave_latch kQ='kQ'
x7_10 VDD VSS QA10 WE7CLK WE7CLKb RA7 RB7 QB10 N10 slave_latch kQ='kQ'
x7_11 VDD VSS QA11 WE7CLK WE7CLKb RA7 RB7 QB11 N11 slave_latch kQ='kQ'
x7_12 VDD VSS QA12 WE7CLK WE7CLKb RA7 RB7 QB12 N12 slave_latch kQ='kQ'
x7_13 VDD VSS QA13 WE7CLK WE7CLKb RA7 RB7 QB13 N13 slave_latch kQ='kQ'
x7_14 VDD VSS QA14 WE7CLK WE7CLKb RA7 RB7 QB14 N14 slave_latch kQ='kQ'
x7_15 VDD VSS QA15 WE7CLK WE7CLKb RA7 RB7 QB15 N15 slave_latch kQ='kQ'
x8_0 VDD VSS QA0 WE8CLK WE8CLKb RA8 RB8 QB0 N0 slave_latch kQ='kQ'
x8_1 VDD VSS QA1 WE8CLK WE8CLKb RA8 RB8 QB1 N1 slave_latch kQ='kQ'
x8_2 VDD VSS QA2 WE8CLK WE8CLKb RA8 RB8 QB2 N2 slave_latch kQ='kQ'
x8_3 VDD VSS QA3 WE8CLK WE8CLKb RA8 RB8 QB3 N3 slave_latch kQ='kQ'
x8_4 VDD VSS QA4 WE8CLK WE8CLKb RA8 RB8 QB4 N4 slave_latch kQ='kQ'
x8_5 VDD VSS QA5 WE8CLK WE8CLKb RA8 RB8 QB5 N5 slave_latch kQ='kQ'
x8_6 VDD VSS QA6 WE8CLK WE8CLKb RA8 RB8 QB6 N6 slave_latch kQ='kQ'
x8_7 VDD VSS QA7 WE8CLK WE8CLKb RA8 RB8 QB7 N7 slave_latch kQ='kQ'
x8_8 VDD VSS QA8 WE8CLK WE8CLKb RA8 RB8 QB8 N8 slave_latch kQ='kQ'
x8_9 VDD VSS QA9 WE8CLK WE8CLKb RA8 RB8 QB9 N9 slave_latch kQ='kQ'
x8_10 VDD VSS QA10 WE8CLK WE8CLKb RA8 RB8 QB10 N10 slave_latch kQ='kQ'
x8_11 VDD VSS QA11 WE8CLK WE8CLKb RA8 RB8 QB11 N11 slave_latch kQ='kQ'
x8_12 VDD VSS QA12 WE8CLK WE8CLKb RA8 RB8 QB12 N12 slave_latch kQ='kQ'
x8_13 VDD VSS QA13 WE8CLK WE8CLKb RA8 RB8 QB13 N13 slave_latch kQ='kQ'
x8_14 VDD VSS QA14 WE8CLK WE8CLKb RA8 RB8 QB14 N14 slave_latch kQ='kQ'
x8_15 VDD VSS QA15 WE8CLK WE8CLKb RA8 RB8 QB15 N15 slave_latch kQ='kQ'
x9_0 VDD VSS QA0 WE9CLK WE9CLKb RA9 RB9 QB0 N0 slave_latch kQ='kQ'
x9_1 VDD VSS QA1 WE9CLK WE9CLKb RA9 RB9 QB1 N1 slave_latch kQ='kQ'
x9_2 VDD VSS QA2 WE9CLK WE9CLKb RA9 RB9 QB2 N2 slave_latch kQ='kQ'
x9_3 VDD VSS QA3 WE9CLK WE9CLKb RA9 RB9 QB3 N3 slave_latch kQ='kQ'
x9_4 VDD VSS QA4 WE9CLK WE9CLKb RA9 RB9 QB4 N4 slave_latch kQ='kQ'
x9_5 VDD VSS QA5 WE9CLK WE9CLKb RA9 RB9 QB5 N5 slave_latch kQ='kQ'
x9_6 VDD VSS QA6 WE9CLK WE9CLKb RA9 RB9 QB6 N6 slave_latch kQ='kQ'
x9_7 VDD VSS QA7 WE9CLK WE9CLKb RA9 RB9 QB7 N7 slave_latch kQ='kQ'
x9_8 VDD VSS QA8 WE9CLK WE9CLKb RA9 RB9 QB8 N8 slave_latch kQ='kQ'
x9_9 VDD VSS QA9 WE9CLK WE9CLKb RA9 RB9 QB9 N9 slave_latch kQ='kQ'
x9_10 VDD VSS QA10 WE9CLK WE9CLKb RA9 RB9 QB10 N10 slave_latch kQ='kQ'
x9_11 VDD VSS QA11 WE9CLK WE9CLKb RA9 RB9 QB11 N11 slave_latch kQ='kQ'
x9_12 VDD VSS QA12 WE9CLK WE9CLKb RA9 RB9 QB12 N12 slave_latch kQ='kQ'
x9_13 VDD VSS QA13 WE9CLK WE9CLKb RA9 RB9 QB13 N13 slave_latch kQ='kQ'
x9_14 VDD VSS QA14 WE9CLK WE9CLKb RA9 RB9 QB14 N14 slave_latch kQ='kQ'
x9_15 VDD VSS QA15 WE9CLK WE9CLKb RA9 RB9 QB15 N15 slave_latch kQ='kQ'
x10_0 VDD VSS QA0 WE10CLK WE10CLKb RA10 RB10 QB0 N0 slave_latch kQ='kQ'
x10_1 VDD VSS QA1 WE10CLK WE10CLKb RA10 RB10 QB1 N1 slave_latch kQ='kQ'
x10_2 VDD VSS QA2 WE10CLK WE10CLKb RA10 RB10 QB2 N2 slave_latch kQ='kQ'
x10_3 VDD VSS QA3 WE10CLK WE10CLKb RA10 RB10 QB3 N3 slave_latch kQ='kQ'
x10_4 VDD VSS QA4 WE10CLK WE10CLKb RA10 RB10 QB4 N4 slave_latch kQ='kQ'
x10_5 VDD VSS QA5 WE10CLK WE10CLKb RA10 RB10 QB5 N5 slave_latch kQ='kQ'
x10_6 VDD VSS QA6 WE10CLK WE10CLKb RA10 RB10 QB6 N6 slave_latch kQ='kQ'
x10_7 VDD VSS QA7 WE10CLK WE10CLKb RA10 RB10 QB7 N7 slave_latch kQ='kQ'
x10_8 VDD VSS QA8 WE10CLK WE10CLKb RA10 RB10 QB8 N8 slave_latch kQ='kQ'
x10_9 VDD VSS QA9 WE10CLK WE10CLKb RA10 RB10 QB9 N9 slave_latch kQ='kQ'
x10_10 VDD VSS QA10 WE10CLK WE10CLKb RA10 RB10 QB10 N10 slave_latch kQ='kQ'
x10_11 VDD VSS QA11 WE10CLK WE10CLKb RA10 RB10 QB11 N11 slave_latch kQ='kQ'
x10_12 VDD VSS QA12 WE10CLK WE10CLKb RA10 RB10 QB12 N12 slave_latch kQ='kQ'
x10_13 VDD VSS QA13 WE10CLK WE10CLKb RA10 RB10 QB13 N13 slave_latch kQ='kQ'
x10_14 VDD VSS QA14 WE10CLK WE10CLKb RA10 RB10 QB14 N14 slave_latch kQ='kQ'
x10_15 VDD VSS QA15 WE10CLK WE10CLKb RA10 RB10 QB15 N15 slave_latch kQ='kQ'
x11_0 VDD VSS QA0 WE11CLK WE11CLKb RA11 RB11 QB0 N0 slave_latch kQ='kQ'
x11_1 VDD VSS QA1 WE11CLK WE11CLKb RA11 RB11 QB1 N1 slave_latch kQ='kQ'
x11_2 VDD VSS QA2 WE11CLK WE11CLKb RA11 RB11 QB2 N2 slave_latch kQ='kQ'
x11_3 VDD VSS QA3 WE11CLK WE11CLKb RA11 RB11 QB3 N3 slave_latch kQ='kQ'
x11_4 VDD VSS QA4 WE11CLK WE11CLKb RA11 RB11 QB4 N4 slave_latch kQ='kQ'
x11_5 VDD VSS QA5 WE11CLK WE11CLKb RA11 RB11 QB5 N5 slave_latch kQ='kQ'
x11_6 VDD VSS QA6 WE11CLK WE11CLKb RA11 RB11 QB6 N6 slave_latch kQ='kQ'
x11_7 VDD VSS QA7 WE11CLK WE11CLKb RA11 RB11 QB7 N7 slave_latch kQ='kQ'
x11_8 VDD VSS QA8 WE11CLK WE11CLKb RA11 RB11 QB8 N8 slave_latch kQ='kQ'
x11_9 VDD VSS QA9 WE11CLK WE11CLKb RA11 RB11 QB9 N9 slave_latch kQ='kQ'
x11_10 VDD VSS QA10 WE11CLK WE11CLKb RA11 RB11 QB10 N10 slave_latch kQ='kQ'
x11_11 VDD VSS QA11 WE11CLK WE11CLKb RA11 RB11 QB11 N11 slave_latch kQ='kQ'
x11_12 VDD VSS QA12 WE11CLK WE11CLKb RA11 RB11 QB12 N12 slave_latch kQ='kQ'
x11_13 VDD VSS QA13 WE11CLK WE11CLKb RA11 RB11 QB13 N13 slave_latch kQ='kQ'
x11_14 VDD VSS QA14 WE11CLK WE11CLKb RA11 RB11 QB14 N14 slave_latch kQ='kQ'
x11_15 VDD VSS QA15 WE11CLK WE11CLKb RA11 RB11 QB15 N15 slave_latch kQ='kQ'
x12_0 VDD VSS QA0 WE12CLK WE12CLKb RA12 RB12 QB0 N0 slave_latch kQ='kQ'
x12_1 VDD VSS QA1 WE12CLK WE12CLKb RA12 RB12 QB1 N1 slave_latch kQ='kQ'
x12_2 VDD VSS QA2 WE12CLK WE12CLKb RA12 RB12 QB2 N2 slave_latch kQ='kQ'
x12_3 VDD VSS QA3 WE12CLK WE12CLKb RA12 RB12 QB3 N3 slave_latch kQ='kQ'
x12_4 VDD VSS QA4 WE12CLK WE12CLKb RA12 RB12 QB4 N4 slave_latch kQ='kQ'
x12_5 VDD VSS QA5 WE12CLK WE12CLKb RA12 RB12 QB5 N5 slave_latch kQ='kQ'
x12_6 VDD VSS QA6 WE12CLK WE12CLKb RA12 RB12 QB6 N6 slave_latch kQ='kQ'
x12_7 VDD VSS QA7 WE12CLK WE12CLKb RA12 RB12 QB7 N7 slave_latch kQ='kQ'
x12_8 VDD VSS QA8 WE12CLK WE12CLKb RA12 RB12 QB8 N8 slave_latch kQ='kQ'
x12_9 VDD VSS QA9 WE12CLK WE12CLKb RA12 RB12 QB9 N9 slave_latch kQ='kQ'
x12_10 VDD VSS QA10 WE12CLK WE12CLKb RA12 RB12 QB10 N10 slave_latch kQ='kQ'
x12_11 VDD VSS QA11 WE12CLK WE12CLKb RA12 RB12 QB11 N11 slave_latch kQ='kQ'
x12_12 VDD VSS QA12 WE12CLK WE12CLKb RA12 RB12 QB12 N12 slave_latch kQ='kQ'
x12_13 VDD VSS QA13 WE12CLK WE12CLKb RA12 RB12 QB13 N13 slave_latch kQ='kQ'
x12_14 VDD VSS QA14 WE12CLK WE12CLKb RA12 RB12 QB14 N14 slave_latch kQ='kQ'
x12_15 VDD VSS QA15 WE12CLK WE12CLKb RA12 RB12 QB15 N15 slave_latch kQ='kQ'
x13_0 VDD VSS QA0 WE13CLK WE13CLKb RA13 RB13 QB0 N0 slave_latch kQ='kQ'
x13_1 VDD VSS QA1 WE13CLK WE13CLKb RA13 RB13 QB1 N1 slave_latch kQ='kQ'
x13_2 VDD VSS QA2 WE13CLK WE13CLKb RA13 RB13 QB2 N2 slave_latch kQ='kQ'
x13_3 VDD VSS QA3 WE13CLK WE13CLKb RA13 RB13 QB3 N3 slave_latch kQ='kQ'
x13_4 VDD VSS QA4 WE13CLK WE13CLKb RA13 RB13 QB4 N4 slave_latch kQ='kQ'
x13_5 VDD VSS QA5 WE13CLK WE13CLKb RA13 RB13 QB5 N5 slave_latch kQ='kQ'
x13_6 VDD VSS QA6 WE13CLK WE13CLKb RA13 RB13 QB6 N6 slave_latch kQ='kQ'
x13_7 VDD VSS QA7 WE13CLK WE13CLKb RA13 RB13 QB7 N7 slave_latch kQ='kQ'
x13_8 VDD VSS QA8 WE13CLK WE13CLKb RA13 RB13 QB8 N8 slave_latch kQ='kQ'
x13_9 VDD VSS QA9 WE13CLK WE13CLKb RA13 RB13 QB9 N9 slave_latch kQ='kQ'
x13_10 VDD VSS QA10 WE13CLK WE13CLKb RA13 RB13 QB10 N10 slave_latch kQ='kQ'
x13_11 VDD VSS QA11 WE13CLK WE13CLKb RA13 RB13 QB11 N11 slave_latch kQ='kQ'
x13_12 VDD VSS QA12 WE13CLK WE13CLKb RA13 RB13 QB12 N12 slave_latch kQ='kQ'
x13_13 VDD VSS QA13 WE13CLK WE13CLKb RA13 RB13 QB13 N13 slave_latch kQ='kQ'
x13_14 VDD VSS QA14 WE13CLK WE13CLKb RA13 RB13 QB14 N14 slave_latch kQ='kQ'
x13_15 VDD VSS QA15 WE13CLK WE13CLKb RA13 RB13 QB15 N15 slave_latch kQ='kQ'
x14_0 VDD VSS QA0 WE14CLK WE14CLKb RA14 RB14 QB0 N0 slave_latch kQ='kQ'
x14_1 VDD VSS QA1 WE14CLK WE14CLKb RA14 RB14 QB1 N1 slave_latch kQ='kQ'
x14_2 VDD VSS QA2 WE14CLK WE14CLKb RA14 RB14 QB2 N2 slave_latch kQ='kQ'
x14_3 VDD VSS QA3 WE14CLK WE14CLKb RA14 RB14 QB3 N3 slave_latch kQ='kQ'
x14_4 VDD VSS QA4 WE14CLK WE14CLKb RA14 RB14 QB4 N4 slave_latch kQ='kQ'
x14_5 VDD VSS QA5 WE14CLK WE14CLKb RA14 RB14 QB5 N5 slave_latch kQ='kQ'
x14_6 VDD VSS QA6 WE14CLK WE14CLKb RA14 RB14 QB6 N6 slave_latch kQ='kQ'
x14_7 VDD VSS QA7 WE14CLK WE14CLKb RA14 RB14 QB7 N7 slave_latch kQ='kQ'
x14_8 VDD VSS QA8 WE14CLK WE14CLKb RA14 RB14 QB8 N8 slave_latch kQ='kQ'
x14_9 VDD VSS QA9 WE14CLK WE14CLKb RA14 RB14 QB9 N9 slave_latch kQ='kQ'
x14_10 VDD VSS QA10 WE14CLK WE14CLKb RA14 RB14 QB10 N10 slave_latch kQ='kQ'
x14_11 VDD VSS QA11 WE14CLK WE14CLKb RA14 RB14 QB11 N11 slave_latch kQ='kQ'
x14_12 VDD VSS QA12 WE14CLK WE14CLKb RA14 RB14 QB12 N12 slave_latch kQ='kQ'
x14_13 VDD VSS QA13 WE14CLK WE14CLKb RA14 RB14 QB13 N13 slave_latch kQ='kQ'
x14_14 VDD VSS QA14 WE14CLK WE14CLKb RA14 RB14 QB14 N14 slave_latch kQ='kQ'
x14_15 VDD VSS QA15 WE14CLK WE14CLKb RA14 RB14 QB15 N15 slave_latch kQ='kQ'
x15_0 VDD VSS QA0 WE15CLK WE15CLKb RA15 RB15 QB0 N0 slave_latch kQ='kQ'
x15_1 VDD VSS QA1 WE15CLK WE15CLKb RA15 RB15 QB1 N1 slave_latch kQ='kQ'
x15_2 VDD VSS QA2 WE15CLK WE15CLKb RA15 RB15 QB2 N2 slave_latch kQ='kQ'
x15_3 VDD VSS QA3 WE15CLK WE15CLKb RA15 RB15 QB3 N3 slave_latch kQ='kQ'
x15_4 VDD VSS QA4 WE15CLK WE15CLKb RA15 RB15 QB4 N4 slave_latch kQ='kQ'
x15_5 VDD VSS QA5 WE15CLK WE15CLKb RA15 RB15 QB5 N5 slave_latch kQ='kQ'
x15_6 VDD VSS QA6 WE15CLK WE15CLKb RA15 RB15 QB6 N6 slave_latch kQ='kQ'
x15_7 VDD VSS QA7 WE15CLK WE15CLKb RA15 RB15 QB7 N7 slave_latch kQ='kQ'
x15_8 VDD VSS QA8 WE15CLK WE15CLKb RA15 RB15 QB8 N8 slave_latch kQ='kQ'
x15_9 VDD VSS QA9 WE15CLK WE15CLKb RA15 RB15 QB9 N9 slave_latch kQ='kQ'
x15_10 VDD VSS QA10 WE15CLK WE15CLKb RA15 RB15 QB10 N10 slave_latch kQ='kQ'
x15_11 VDD VSS QA11 WE15CLK WE15CLKb RA15 RB15 QB11 N11 slave_latch kQ='kQ'
x15_12 VDD VSS QA12 WE15CLK WE15CLKb RA15 RB15 QB12 N12 slave_latch kQ='kQ'
x15_13 VDD VSS QA13 WE15CLK WE15CLKb RA15 RB15 QB13 N13 slave_latch kQ='kQ'
x15_14 VDD VSS QA14 WE15CLK WE15CLKb RA15 RB15 QB14 N14 slave_latch kQ='kQ'
x15_15 VDD VSS QA15 WE15CLK WE15CLKb RA15 RB15 QB15 N15 slave_latch kQ='kQ'
x1 VDD VSS N0 WEM WEMb D0 master_latch kN='kN'
x2 VDD VSS N1 WEM WEMb D1 master_latch kN='kN'
x3 VDD VSS N2 WEM WEMb D2 master_latch kN='kN'
x4 VDD VSS N3 WEM WEMb D3 master_latch kN='kN'
x5 VDD VSS N4 WEM WEMb D4 master_latch kN='kN'
x6 VDD VSS N5 WEM WEMb D5 master_latch kN='kN'
x7 VDD VSS N6 WEM WEMb D6 master_latch kN='kN'
x8 VDD VSS N7 WEM WEMb D7 master_latch kN='kN'
x9 VDD VSS N8 WEM WEMb D8 master_latch kN='kN'
x10 VDD VSS N9 WEM WEMb D9 master_latch kN='kN'
x11 VDD VSS N10 WEM WEMb D10 master_latch kN='kN'
x12 VDD VSS N11 WEM WEMb D11 master_latch kN='kN'
x13 VDD VSS N12 WEM WEMb D12 master_latch kN='kN'
x14 VDD VSS N13 WEM WEMb D13 master_latch kN='kN'
x15 VDD VSS N14 WEM WEMb D14 master_latch kN='kN'
x16 VDD VSS N15 WEM WEMb D15 master_latch kN='kN'
x17 CLK WE15 WE15CLKb VDD VSS WE15CLK driver_cell kWECLK='kWECLK' kWECLKb='kWECLKb'
x18 CLK WE14 WE14CLKb VDD VSS WE14CLK driver_cell kWECLK='kWECLK' kWECLKb='kWECLKb'
x19 CLK WE13 WE13CLKb VDD VSS WE13CLK driver_cell kWECLK='kWECLK' kWECLKb='kWECLKb'
x20 CLK WE12 WE12CLKb VDD VSS WE12CLK driver_cell kWECLK='kWECLK' kWECLKb='kWECLKb'
x21 CLK WE11 WE11CLKb VDD VSS WE11CLK driver_cell kWECLK='kWECLK' kWECLKb='kWECLKb'
x22 CLK WE10 WE10CLKb VDD VSS WE10CLK driver_cell kWECLK='kWECLK' kWECLKb='kWECLKb'
x23 CLK WE9 WE9CLKb VDD VSS WE9CLK driver_cell kWECLK='kWECLK' kWECLKb='kWECLKb'
x24 CLK WE8 WE8CLKb VDD VSS WE8CLK driver_cell kWECLK='kWECLK' kWECLKb='kWECLKb'
x25 CLK WE7 WE7CLKb VDD VSS WE7CLK driver_cell kWECLK='kWECLK' kWECLKb='kWECLKb'
x26 CLK WE6 WE6CLKb VDD VSS WE6CLK driver_cell kWECLK='kWECLK' kWECLKb='kWECLKb'
x27 CLK WE5 WE5CLKb VDD VSS WE5CLK driver_cell kWECLK='kWECLK' kWECLKb='kWECLKb'
x28 CLK WE4 WE4CLKb VDD VSS WE4CLK driver_cell kWECLK='kWECLK' kWECLKb='kWECLKb'
x29 CLK WE3 WE3CLKb VDD VSS WE3CLK driver_cell kWECLK='kWECLK' kWECLKb='kWECLKb'
x30 CLK WE2 WE2CLKb VDD VSS WE2CLK driver_cell kWECLK='kWECLK' kWECLKb='kWECLKb'
x31 CLK WE1 WE1CLKb VDD VSS WE1CLK driver_cell kWECLK='kWECLK' kWECLKb='kWECLKb'
x32 CLK WE0 WE0CLKb VDD VSS WE0CLK driver_cell kWECLK='kWECLK' kWECLKb='kWECLKb'
x33 VDD VSS QA0b QA0 QB0 QB0b output_inverter
x34 VDD VSS QA1b QA1 QB1 QB1b output_inverter
x35 VDD VSS QA2b QA2 QB2 QB2b output_inverter
x36 VDD VSS QA3b QA3 QB3 QB3b output_inverter
x37 VDD VSS QA4b QA4 QB4 QB4b output_inverter
x38 VDD VSS QA5b QA5 QB5 QB5b output_inverter
x39 VDD VSS QA6b QA6 QB6 QB6b output_inverter
x40 VDD VSS QA7b QA7 QB7 QB7b output_inverter
x41 VDD VSS QA8b QA8 QB8 QB8b output_inverter
x42 VDD VSS QA9b QA9 QB9 QB9b output_inverter
x43 VDD VSS QA10b QA10 QB10 QB10b output_inverter
x44 VDD VSS QA11b QA11 QB11 QB11b output_inverter
x45 VDD VSS QA12b QA12 QB12 QB12b output_inverter
x46 VDD VSS QA13b QA13 QB13 QB13b output_inverter
x47 VDD VSS QA14b QA14 QB14 QB14b output_inverter
x48 VDD VSS QA15b QA15 QB15 QB15b output_inverter
x49 VDD WEM WEMb VSS wem_inverter kWEMb='kWEMb'
**** begin user architecture code

.param kWECLKb=1.34/0.36
.param kWECLK=1.27/0.36
.param kWEMb=1.26/0.36
.param kQ=0.36/0.36
.param kN=1.24/0.36

**** end user architecture code
.ends

* expanding   symbol:  engn1600-team1/CAD6/pc.sym # of pins=12
** sym_path: /foss/designs/engn1600-team1/CAD6/pc.sym
** sch_path: /foss/designs/engn1600-team1/CAD6/pc.sch
.subckt pc VDD VSS CLK RSTn BR DISP7 DISP6 DISP5 DISP4 DISP3 DISP2 DISP1 DISP0 JMP DEST15 DEST14 DEST13 DEST12 DEST11 DEST10 DEST9
+ DEST8 DEST7 DEST6 DEST5 DEST4 DEST3 DEST2 DEST1 DEST0 SI SE PC15 PC14 PC13 PC12 PC11 PC10 PC9 PC8 PC7 PC6 PC5 PC4 PC3 PC2 PC1 PC0
+ PC_NEXT15
*.PININFO JMP:I BR:I VDD:B DISP[7..0]:I PC[15..0]:O SI:I SE:I DEST[15..0]:I VSS:B CLK:I RSTn:I PC_NEXT15:O
x1 VDD VSS DISP_SE DISP7 sign_extend
x215 VSS BR BR15b B15 VDD VSS DISP_SE 2x1_mux
x214 VSS BR BR14b B14 VDD VSS DISP_SE 2x1_mux
x213 VSS BR BR13b B13 VDD VSS DISP_SE 2x1_mux
x212 VSS BR BR12b B12 VDD VSS DISP_SE 2x1_mux
x211 VSS BR BR11b B11 VDD VSS DISP_SE 2x1_mux
x210 VSS BR BR10b B10 VDD VSS DISP_SE 2x1_mux
x29 VSS BR BR9b B9 VDD VSS DISP_SE 2x1_mux
x28 VSS BR BR8b B8 VDD VSS DISP_SE 2x1_mux
x27 VSS BR BR7b B7 VDD VSS DISP_SE 2x1_mux
x26 VSS BR BR6b B6 VDD VSS DISP6 2x1_mux
x25 VSS BR BR5b B5 VDD VSS DISP5 2x1_mux
x24 VSS BR BR4b B4 VDD VSS DISP4 2x1_mux
x23 VSS BR BR3b B3 VDD VSS DISP3 2x1_mux
x22 VSS BR BR2b B2 VDD VSS DISP2 2x1_mux
x21 VDD BR BR1b B1 VDD VSS DISP1 2x1_mux
x20 VSS BR BR0b B0 VDD VSS DISP0 2x1_mux
x815 VDD BR BR15b VSS inv kINV=1
x814 VDD BR BR14b VSS inv kINV=1
x813 VDD BR BR13b VSS inv kINV=1
x812 VDD BR BR12b VSS inv kINV=1
x811 VDD BR BR11b VSS inv kINV=1
x810 VDD BR BR10b VSS inv kINV=1
x89 VDD BR BR9b VSS inv kINV=1
x88 VDD BR BR8b VSS inv kINV=1
x87 VDD BR BR7b VSS inv kINV=1
x86 VDD BR BR6b VSS inv kINV=1
x85 VDD BR BR5b VSS inv kINV=1
x84 VDD BR BR4b VSS inv kINV=1
x83 VDD BR BR3b VSS inv kINV=1
x82 VDD BR BR2b VSS inv kINV=1
x81 VDD BR BR1b VSS inv kINV=1
x80 VDD BR BR0b VSS inv kINV=1
x915 VDD JMP JMP15b VSS inv kINV=1
x914 VDD JMP JMP14b VSS inv kINV=1
x913 VDD JMP JMP13b VSS inv kINV=1
x912 VDD JMP JMP12b VSS inv kINV=1
x911 VDD JMP JMP11b VSS inv kINV=1
x910 VDD JMP JMP10b VSS inv kINV=1
x99 VDD JMP JMP9b VSS inv kINV=1
x98 VDD JMP JMP8b VSS inv kINV=1
x97 VDD JMP JMP7b VSS inv kINV=1
x96 VDD JMP JMP6b VSS inv kINV=1
x95 VDD JMP JMP5b VSS inv kINV=1
x94 VDD JMP JMP4b VSS inv kINV=1
x93 VDD JMP JMP3b VSS inv kINV=1
x92 VDD JMP JMP2b VSS inv kINV=1
x91 VDD JMP JMP1b VSS inv kINV=1
x90 VDD JMP JMP0b VSS inv kINV=1
x515 PCB15 JMP JMP15b PCJ15 VDD VSS DEST15 2x1_mux
x514 PCB14 JMP JMP14b PCJ14 VDD VSS DEST14 2x1_mux
x513 PCB13 JMP JMP13b PCJ13 VDD VSS DEST13 2x1_mux
x512 PCB12 JMP JMP12b PCJ12 VDD VSS DEST12 2x1_mux
x511 PCB11 JMP JMP11b PCJ11 VDD VSS DEST11 2x1_mux
x510 PCB10 JMP JMP10b PCJ10 VDD VSS DEST10 2x1_mux
x59 PCB9 JMP JMP9b PCJ9 VDD VSS DEST9 2x1_mux
x58 PCB8 JMP JMP8b PCJ8 VDD VSS DEST8 2x1_mux
x57 PCB7 JMP JMP7b PCJ7 VDD VSS DEST7 2x1_mux
x56 PCB6 JMP JMP6b PCJ6 VDD VSS DEST6 2x1_mux
x55 PCB5 JMP JMP5b PCJ5 VDD VSS DEST5 2x1_mux
x54 PCB4 JMP JMP4b PCJ4 VDD VSS DEST4 2x1_mux
x53 PCB3 JMP JMP3b PCJ3 VDD VSS DEST3 2x1_mux
x52 PCB2 JMP JMP2b PCJ2 VDD VSS DEST2 2x1_mux
x51 PCB1 JMP JMP1b PCJ1 VDD VSS DEST1 2x1_mux
x50 PCB0 JMP JMP0b PCJ0 VDD VSS DEST0 2x1_mux
x315 CLK15b PC_NEXT15 PC15 RSTn CLK VDD VSS dff
x314 CLK14b PC_NEXT14 PC14 RSTn CLK VDD VSS dff
x313 CLK13b PC_NEXT13 PC13 RSTn CLK VDD VSS dff
x312 CLK12b PC_NEXT12 PC12 RSTn CLK VDD VSS dff
x311 CLK11b PC_NEXT11 PC11 RSTn CLK VDD VSS dff
x310 CLK10b PC_NEXT10 PC10 RSTn CLK VDD VSS dff
x39 CLK9b PC_NEXT9 PC9 RSTn CLK VDD VSS dff
x38 CLK8b PC_NEXT8 PC8 RSTn CLK VDD VSS dff
x37 CLK7b PC_NEXT7 PC7 RSTn CLK VDD VSS dff
x36 CLK6b PC_NEXT6 PC6 RSTn CLK VDD VSS dff
x35 CLK5b PC_NEXT5 PC5 RSTn CLK VDD VSS dff
x34 CLK4b PC_NEXT4 PC4 RSTn CLK VDD VSS dff
x33 CLK3b PC_NEXT3 PC3 RSTn CLK VDD VSS dff
x32 CLK2b PC_NEXT2 PC2 RSTn CLK VDD VSS dff
x31 CLK1b PC_NEXT1 PC1 RSTn CLK VDD VSS dff
x30 CLK0b PC_NEXT0 PC0 RSTn CLK VDD VSS dff
x115 VDD CLK CLK15b VSS inv kINV=1
x114 VDD CLK CLK14b VSS inv kINV=1
x113 VDD CLK CLK13b VSS inv kINV=1
x112 VDD CLK CLK12b VSS inv kINV=1
x111 VDD CLK CLK11b VSS inv kINV=1
x110 VDD CLK CLK10b VSS inv kINV=1
x19 VDD CLK CLK9b VSS inv kINV=1
x18 VDD CLK CLK8b VSS inv kINV=1
x17 VDD CLK CLK7b VSS inv kINV=1
x16 VDD CLK CLK6b VSS inv kINV=1
x15 VDD CLK CLK5b VSS inv kINV=1
x14 VDD CLK CLK4b VSS inv kINV=1
x13 VDD CLK CLK3b VSS inv kINV=1
x12 VDD CLK CLK2b VSS inv kINV=1
x11 VDD CLK CLK1b VSS inv kINV=1
x10 VDD CLK CLK0b VSS inv kINV=1
x415 VDD VSS PC15 B15 COUT14 PCB15 COUT15 full_adder kSUMb=1 kTS=1
x414 VDD VSS PC14 B14 COUT13 PCB14 COUT14 full_adder kSUMb=1 kTS=1
x413 VDD VSS PC13 B13 COUT12 PCB13 COUT13 full_adder kSUMb=1 kTS=1
x412 VDD VSS PC12 B12 COUT11 PCB12 COUT12 full_adder kSUMb=1 kTS=1
x411 VDD VSS PC11 B11 COUT10 PCB11 COUT11 full_adder kSUMb=1 kTS=1
x410 VDD VSS PC10 B10 COUT9 PCB10 COUT10 full_adder kSUMb=1 kTS=1
x49 VDD VSS PC9 B9 COUT8 PCB9 COUT9 full_adder kSUMb=1 kTS=1
x48 VDD VSS PC8 B8 COUT7 PCB8 COUT8 full_adder kSUMb=1 kTS=1
x47 VDD VSS PC7 B7 COUT6 PCB7 COUT7 full_adder kSUMb=1 kTS=1
x46 VDD VSS PC6 B6 COUT5 PCB6 COUT6 full_adder kSUMb=1 kTS=1
x45 VDD VSS PC5 B5 COUT4 PCB5 COUT5 full_adder kSUMb=1 kTS=1
x44 VDD VSS PC4 B4 COUT3 PCB4 COUT4 full_adder kSUMb=1 kTS=1
x43 VDD VSS PC3 B3 COUT2 PCB3 COUT3 full_adder kSUMb=1 kTS=1
x42 VDD VSS PC2 B2 COUT1 PCB2 COUT2 full_adder kSUMb=1 kTS=1
x41 VDD VSS PC1 B1 COUT0 PCB1 COUT1 full_adder kSUMb=1 kTS=1
x40 VDD VSS PC0 B0 VSS PCB0 COUT0 full_adder kSUMb=1 kTS=1
x715 PCJ15 SE SE15b PC_NEXT15 VDD VSS PC14 2x1_mux
x714 PCJ14 SE SE14b PC_NEXT14 VDD VSS PC13 2x1_mux
x713 PCJ13 SE SE13b PC_NEXT13 VDD VSS PC12 2x1_mux
x712 PCJ12 SE SE12b PC_NEXT12 VDD VSS PC11 2x1_mux
x711 PCJ11 SE SE11b PC_NEXT11 VDD VSS PC10 2x1_mux
x710 PCJ10 SE SE10b PC_NEXT10 VDD VSS PC9 2x1_mux
x79 PCJ9 SE SE9b PC_NEXT9 VDD VSS PC8 2x1_mux
x78 PCJ8 SE SE8b PC_NEXT8 VDD VSS PC7 2x1_mux
x77 PCJ7 SE SE7b PC_NEXT7 VDD VSS PC6 2x1_mux
x76 PCJ6 SE SE6b PC_NEXT6 VDD VSS PC5 2x1_mux
x75 PCJ5 SE SE5b PC_NEXT5 VDD VSS PC4 2x1_mux
x74 PCJ4 SE SE4b PC_NEXT4 VDD VSS PC3 2x1_mux
x73 PCJ3 SE SE3b PC_NEXT3 VDD VSS PC2 2x1_mux
x72 PCJ2 SE SE2b PC_NEXT2 VDD VSS PC1 2x1_mux
x71 PCJ1 SE SE1b PC_NEXT1 VDD VSS PC0 2x1_mux
x70 PCJ0 SE SE0b PC_NEXT0 VDD VSS SI 2x1_mux
x1015 VDD SE SE15b VSS inv kINV=1
x1014 VDD SE SE14b VSS inv kINV=1
x1013 VDD SE SE13b VSS inv kINV=1
x1012 VDD SE SE12b VSS inv kINV=1
x1011 VDD SE SE11b VSS inv kINV=1
x1010 VDD SE SE10b VSS inv kINV=1
x109 VDD SE SE9b VSS inv kINV=1
x108 VDD SE SE8b VSS inv kINV=1
x107 VDD SE SE7b VSS inv kINV=1
x106 VDD SE SE6b VSS inv kINV=1
x105 VDD SE SE5b VSS inv kINV=1
x104 VDD SE SE4b VSS inv kINV=1
x103 VDD SE SE3b VSS inv kINV=1
x102 VDD SE SE2b VSS inv kINV=1
x101 VDD SE SE1b VSS inv kINV=1
x100 VDD SE SE0b VSS inv kINV=1
**** begin user architecture code

.param kINV=1
.param kSUMb=1
.param kTS=1
.param Kb=1

**** end user architecture code
.ends

* expanding   symbol:  engn1600-team1/CAD5/shifter.sym # of pins=7
** sym_path: /foss/designs/engn1600-team1/CAD5/shifter.sym
** sch_path: /foss/designs/engn1600-team1/CAD5/shifter.sch
.subckt shifter VDD VSS D15 D14 D13 D12 D11 D10 D9 D8 D7 D6 D5 D4 D3 D2 D1 D0 I3 I2 I1 I0 R3 R2 R1 R0 SEL Q15 Q14 Q13 Q12 Q11 Q10
+ Q9 Q8 Q7 Q6 Q5 Q4 Q3 Q2 Q1 Q0
*.PININFO VDD:B VSS:B D[15..0]:I Q[15..0]:O R[3..0]:I I[3..0]:I SEL:I
x115 D15b S0 S0b X15b VDD VSS D14b 2x1_mux
x114 D14b S0 S0b X14b VDD VSS D13b 2x1_mux
x113 D13b S0 S0b X13b VDD VSS D12b 2x1_mux
x112 D12b S0 S0b X12b VDD VSS D11b 2x1_mux
x111 D11b S0 S0b X11b VDD VSS D10b 2x1_mux
x110 D10b S0 S0b X10b VDD VSS D9b 2x1_mux
x19 D9b S0 S0b X9b VDD VSS D8b 2x1_mux
x18 D8b S0 S0b X8b VDD VSS D7b 2x1_mux
x17 D7b S0 S0b X7b VDD VSS D6b 2x1_mux
x16 D6b S0 S0b X6b VDD VSS D5b 2x1_mux
x15 D5b S0 S0b X5b VDD VSS D4b 2x1_mux
x14 D4b S0 S0b X4b VDD VSS D3b 2x1_mux
x13 D3b S0 S0b X3b VDD VSS D2b 2x1_mux
x12 D2b S0 S0b X2b VDD VSS D1b 2x1_mux
x11 D1b S0 S0b X1b VDD VSS D0b 2x1_mux
x10 D0b S0 S0b X0b VDD VSS VDD 2x1_mux
x23 R3 SEL SELb S3 VDD VSS I3 S3b 2x1_mux_cmos kI='kI' kYb='kYb' kY='kY'
x22 R2 SEL SELb S2 VDD VSS I2 S2b 2x1_mux_cmos kI='kI' kYb='kYb' kY='kY'
x21 R1 SEL SELb S1 VDD VSS I1 S1b 2x1_mux_cmos kI='kI' kYb='kYb' kY='kY'
x20 R0 SEL SELb S0 VDD VSS I0 S0b 2x1_mux_cmos kI='kI' kYb='kYb' kY='kY'
x1 VDD SEL SELb VSS inv kSELb='kSELb'
x315 X15b S1 S1b Y15b VDD VSS X13b 2x1_mux
x314 X14b S1 S1b Y14b VDD VSS X12b 2x1_mux
x313 X13b S1 S1b Y13b VDD VSS X11b 2x1_mux
x312 X12b S1 S1b Y12b VDD VSS X10b 2x1_mux
x311 X11b S1 S1b Y11b VDD VSS X9b 2x1_mux
x310 X10b S1 S1b Y10b VDD VSS X8b 2x1_mux
x39 X9b S1 S1b Y9b VDD VSS X7b 2x1_mux
x38 X8b S1 S1b Y8b VDD VSS X6b 2x1_mux
x37 X7b S1 S1b Y7b VDD VSS X5b 2x1_mux
x36 X6b S1 S1b Y6b VDD VSS X4b 2x1_mux
x35 X5b S1 S1b Y5b VDD VSS X3b 2x1_mux
x34 X4b S1 S1b Y4b VDD VSS X2b 2x1_mux
x33 X3b S1 S1b Y3b VDD VSS X1b 2x1_mux
x32 X2b S1 S1b Y2b VDD VSS X0b 2x1_mux
x31 X1b S1 S1b Y1b VDD VSS VDD 2x1_mux
x30 X0b S1 S1b Y0b VDD VSS VDD 2x1_mux
x1015 Y15b S2 S2b Z15b VDD VSS Y11b 2x1_mux
x1014 Y14b S2 S2b Z14b VDD VSS Y10b 2x1_mux
x1013 Y13b S2 S2b Z13b VDD VSS Y9b 2x1_mux
x1012 Y12b S2 S2b Z12b VDD VSS Y8b 2x1_mux
x1011 Y11b S2 S2b Z11b VDD VSS Y7b 2x1_mux
x1010 Y10b S2 S2b Z10b VDD VSS Y6b 2x1_mux
x109 Y9b S2 S2b Z9b VDD VSS Y5b 2x1_mux
x108 Y8b S2 S2b Z8b VDD VSS Y4b 2x1_mux
x107 Y7b S2 S2b Z7b VDD VSS Y3b 2x1_mux
x106 Y6b S2 S2b Z6b VDD VSS Y2b 2x1_mux
x105 Y5b S2 S2b Z5b VDD VSS Y1b 2x1_mux
x104 Y4b S2 S2b Z4b VDD VSS Y0b 2x1_mux
x103 Y3b S2 S2b Z3b VDD VSS VDD 2x1_mux
x102 Y2b S2 S2b Z2b VDD VSS VDD 2x1_mux
x101 Y1b S2 S2b Z1b VDD VSS VDD 2x1_mux
x100 Y0b S2 S2b Z0b VDD VSS VDD 2x1_mux
x415 Z15b S3 S3b Q15b VDD VSS Z7b 2x1_mux
x414 Z14b S3 S3b Q14b VDD VSS Z6b 2x1_mux
x413 Z13b S3 S3b Q13b VDD VSS Z5b 2x1_mux
x412 Z12b S3 S3b Q12b VDD VSS Z4b 2x1_mux
x411 Z11b S3 S3b Q11b VDD VSS Z3b 2x1_mux
x410 Z10b S3 S3b Q10b VDD VSS Z2b 2x1_mux
x49 Z9b S3 S3b Q9b VDD VSS Z1b 2x1_mux
x48 Z8b S3 S3b Q8b VDD VSS Z0b 2x1_mux
x47 Z7b S3 S3b Q7b VDD VSS VDD 2x1_mux
x46 Z6b S3 S3b Q6b VDD VSS VDD 2x1_mux
x45 Z5b S3 S3b Q5b VDD VSS VDD 2x1_mux
x44 Z4b S3 S3b Q4b VDD VSS VDD 2x1_mux
x43 Z3b S3 S3b Q3b VDD VSS VDD 2x1_mux
x42 Z2b S3 S3b Q2b VDD VSS VDD 2x1_mux
x41 Z1b S3 S3b Q1b VDD VSS VDD 2x1_mux
x40 Z0b S3 S3b Q0b VDD VSS VDD 2x1_mux
**** begin user architecture code

.param kI=6.958333
.param kYb=6.958333
.param kY=7.25
.param kSELb=6

**** end user architecture code
x515 VDD Q15b Q15 VSS unit_inv
x514 VDD Q14b Q14 VSS unit_inv
x513 VDD Q13b Q13 VSS unit_inv
x512 VDD Q12b Q12 VSS unit_inv
x511 VDD Q11b Q11 VSS unit_inv
x510 VDD Q10b Q10 VSS unit_inv
x59 VDD Q9b Q9 VSS unit_inv
x58 VDD Q8b Q8 VSS unit_inv
x57 VDD Q7b Q7 VSS unit_inv
x56 VDD Q6b Q6 VSS unit_inv
x55 VDD Q5b Q5 VSS unit_inv
x54 VDD Q4b Q4 VSS unit_inv
x53 VDD Q3b Q3 VSS unit_inv
x52 VDD Q2b Q2 VSS unit_inv
x51 VDD Q1b Q1 VSS unit_inv
x50 VDD Q0b Q0 VSS unit_inv
x915 VDD D15 D15b VSS unit_inv
x914 VDD D14 D14b VSS unit_inv
x913 VDD D13 D13b VSS unit_inv
x912 VDD D12 D12b VSS unit_inv
x911 VDD D11 D11b VSS unit_inv
x910 VDD D10 D10b VSS unit_inv
x99 VDD D9 D9b VSS unit_inv
x98 VDD D8 D8b VSS unit_inv
x97 VDD D7 D7b VSS unit_inv
x96 VDD D6 D6b VSS unit_inv
x95 VDD D5 D5b VSS unit_inv
x94 VDD D4 D4b VSS unit_inv
x93 VDD D3 D3b VSS unit_inv
x92 VDD D2 D2b VSS unit_inv
x91 VDD D1 D1b VSS unit_inv
x90 VDD D0 D0b VSS unit_inv
.ends

* expanding   symbol:  engn1600-team1/CAD4/4x1_mux.sym # of pins=10
** sym_path: /foss/designs/engn1600-team1/CAD4/4x1_mux.sym
** sch_path: /foss/designs/engn1600-team1/CAD4/4x1_mux.sch
.subckt 4x1_mux SA A SB B VSS Y SC C SD D
*.PININFO A:I B:I C:I D:I Y:O VSS:B SA:I SB:I SC:I SD:I
M1 Y SA A VSS nfet_03v3 L=0.28u W=0.36u nf=1 m=1
M2 Y SB B VSS nfet_03v3 L=0.28u W=0.36u nf=1 m=1
M3 Y SC C VSS nfet_03v3 L=0.28u W=0.36u nf=1 m=1
M4 Y SD D VSS nfet_03v3 L=0.28u W=0.36u nf=1 m=1
.ends

* expanding   symbol:  engn1600-team1/CAD7/inv.sym # of pins=4
** sym_path: /foss/designs/engn1600-team1/CAD7/inv.sym
** sch_path: /foss/designs/engn1600-team1/CAD7/inv.sch
.subckt inv VDD IN OUT VSS  kINV=1
*.PININFO IN:I OUT:O VDD:B VSS:B
M1 OUT IN VDD VDD pfet_03v3 L=0.28u W='kINV*0.72u' nf=1 m=1
M2 OUT IN VSS VSS nfet_03v3 L=0.28u W='kINV*0.36u' nf=1 m=1
**** begin user architecture code

.param kINV=1

**** end user architecture code
.ends

* expanding   symbol:  engn1600-team1/CAD7/2x1_mux.sym # of pins=7
** sym_path: /foss/designs/engn1600-team1/CAD7/2x1_mux.sym
** sch_path: /foss/designs/engn1600-team1/CAD7/2x1_mux.sch
.subckt 2x1_mux A SEL SELb Y VDD VSS B
*.PININFO A:I B:I SEL:I Y:O VDD:B VSS:B SELb:I
M1 Y SEL B VSS nfet_03v3 L=0.28u W=0.36u nf=1 m=1
M2 Y SELb B VDD pfet_03v3 L=0.28u W=0.36u nf=1 m=1
M3 Y SELb A VSS nfet_03v3 L=0.28u W=0.36u nf=1 m=1
M4 Y SEL A VDD pfet_03v3 L=0.28u W=0.36u nf=1 m=1
.ends

* expanding   symbol:  engn1600-team1/CAD7/2x1_mux_pass.sym # of pins=6
** sym_path: /foss/designs/engn1600-team1/CAD7/2x1_mux_pass.sym
** sch_path: /foss/designs/engn1600-team1/CAD7/2x1_mux_pass.sch
.subckt 2x1_mux_pass A SEL Y VDD VSS B
*.PININFO A:I B:I SEL:I Y:O VDD:B VSS:B
M1 Y SEL B VSS nfet_03v3 L=0.28u W=0.36u nf=1 m=1
M3 Y SELb A VSS nfet_03v3 L=0.28u W=0.36u nf=1 m=1
x1 VDD SEL SELb VSS inv kINV=1
.ends

* expanding   symbol:  engn1600-team1/CAD7/dff.sym # of pins=7
** sym_path: /foss/designs/engn1600-team1/CAD7/dff.sym
** sch_path: /foss/designs/engn1600-team1/CAD7/dff.sch
.subckt dff CLKb D Q RSTn CLK VDD VSS
*.PININFO D:I Q:O RSTn:I CLK:I CLKb:I VDD:B VSS:B
M7 net2 CLK VDD VDD pfet_03v3 L=0.28u W=0.36u nf=1 m=1
M8 net1 D net2 VDD pfet_03v3 L=0.28u W=0.36u nf=1 m=1
M9 net1 D net3 VSS nfet_03v3 L=0.28u W=0.36u nf=1 m=1
M10 net3 CLKb VSS VSS nfet_03v3 L=0.28u W=0.36u nf=1 m=1
M13 net4 net1 VDD VDD pfet_03v3 L=0.28u W=0.36u nf=1 m=1
M14 net4 net1 VSS VSS nfet_03v3 L=0.28u W=0.36u nf=1 m=1
M15 net1 CLKb net5 VDD pfet_03v3 L=0.28u W=0.36u nf=1 m=1
M16 net1 CLK net5 VSS nfet_03v3 L=0.28u W=0.36u nf=1 m=1
M25 net5 RSTn VDD VDD pfet_03v3 L=0.28u W=0.36u nf=1 m=1
M26 net5 net4 VDD VDD pfet_03v3 L=0.28u W=0.36u nf=1 m=1
M27 net6 net4 VSS VSS nfet_03v3 L=0.28u W=0.36u nf=1 m=1
M28 net5 RSTn net6 VSS nfet_03v3 L=0.28u W=0.36u nf=1 m=1
M29 net4 CLKb net7 VDD pfet_03v3 L=0.28u W=0.36u nf=1 m=1
M30 net4 CLK net7 VSS nfet_03v3 L=0.28u W=0.36u nf=1 m=1
M31 net8 net7 VDD VDD pfet_03v3 L=0.28u W=0.36u nf=1 m=1
M32 net8 RSTn VDD VDD pfet_03v3 L=0.28u W=0.36u nf=1 m=1
M33 net9 RSTn VSS VSS nfet_03v3 L=0.28u W=0.36u nf=1 m=1
M34 net8 net7 net9 VSS nfet_03v3 L=0.28u W=0.36u nf=1 m=1
M35 net10 CLK VDD VDD pfet_03v3 L=0.28u W=0.36u nf=1 m=1
M36 net7 net8 net10 VDD pfet_03v3 L=0.28u W=0.36u nf=1 m=1
M37 net7 net8 net11 VSS nfet_03v3 L=0.28u W=0.36u nf=1 m=1
M38 net11 CLKb VSS VSS nfet_03v3 L=0.28u W=0.36u nf=1 m=1
M43 Q net8 VDD VDD pfet_03v3 L=0.28u W=0.72u nf=1 m=1
M44 Q net8 VSS VSS nfet_03v3 L=0.28u W=0.36u nf=1 m=1
.ends

* expanding   symbol:  engn1600-team1/CAD7/sign_zero_extender.sym # of pins=5
** sym_path: /foss/designs/engn1600-team1/CAD7/sign_zero_extender.sym
** sch_path: /foss/designs/engn1600-team1/CAD7/sign_zero_extender.sch
.subckt sign_zero_extender EXTEND OUT IN VDD VSS
*.PININFO VDD:B VSS:B IN:I OUT:O EXTEND:I
M1 net1 net2 VDD VDD pfet_03v3 L=0.28u W='3*0.72u' nf=1 m=1
M2 net1 net2 VSS VSS nfet_03v3 L=0.28u W='3*0.36u' nf=1 m=1
M3 OUT net1 VDD VDD pfet_03v3 L=0.28u W='9*0.72u' nf=1 m=1
M4 OUT net1 VSS VSS nfet_03v3 L=0.28u W='9*0.36u' nf=1 m=1
x1 VDD net3 net2 VSS inv kINV=1
x1 VDD net3 EXTEND IN VSS nand2
.ends

* expanding   symbol:  engn1600-team1/CAD4/full_adder.sym # of pins=7
** sym_path: /foss/designs/engn1600-team1/CAD4/full_adder.sym
** sch_path: /foss/designs/engn1600-team1/CAD4/full_adder.sch
.subckt full_adder VDD VSS A B CIN SUMb COUT  kSUMb=1 kTS=1
*.PININFO VDD:B VSS:B A:I B:I CIN:I SUMb:O COUT:O
M1 net1 B VDD VDD pfet_03v3 L=0.28u W=0.72u nf=1 m=1
M2 net4 A net1 VDD pfet_03v3 L=0.28u W=0.72u nf=1 m=1
M3 net3 A VDD VDD pfet_03v3 L=0.28u W=0.72u nf=1 m=1
M4 net3 B VDD VDD pfet_03v3 L=0.28u W=0.72u nf=1 m=1
M5 net4 CIN net3 VDD pfet_03v3 L=0.28u W=0.72u nf=1 m=1
M6 net4 CIN net5 VSS nfet_03v3 L=0.28u W=0.36u nf=1 m=1
M7 net2 B VSS VSS nfet_03v3 L=0.28u W=0.36u nf=1 m=1
M8 net4 A net2 VSS nfet_03v3 L=0.28u W=0.36u nf=1 m=1
M9 net5 A VSS VSS nfet_03v3 L=0.28u W=0.36u nf=1 m=1
M10 net5 B VSS VSS nfet_03v3 L=0.28u W=0.36u nf=1 m=1
M11 SUMb net4 net7 VDD pfet_03v3 L=0.28u W='kSUMb*0.72u' nf=1 m=1
M12 net7 A VDD VDD pfet_03v3 L=0.28u W=0.72u nf=1 m=1
M13 net7 CIN VDD VDD pfet_03v3 L=0.28u W=0.72u nf=1 m=1
M14 net7 B VDD VDD pfet_03v3 L=0.28u W=0.72u nf=1 m=1
M15 net8 A net9 VDD pfet_03v3 L=0.28u W=0.72u nf=1 m=1
M16 SUMb CIN net8 VDD pfet_03v3 L=0.28u W='kTS*0.72u' nf=1 m=1
M17 net9 B VDD VDD pfet_03v3 L=0.28u W=0.72u nf=1 m=1
M18 SUMb net4 net6 VSS nfet_03v3 L=0.28u W='kSUMb*0.36u' nf=1 m=1
M19 net6 B VSS VSS nfet_03v3 L=0.28u W=0.36u nf=1 m=1
M20 net6 A VSS VSS nfet_03v3 L=0.28u W=0.36u nf=1 m=1
M21 net6 CIN VSS VSS nfet_03v3 L=0.28u W=0.36u nf=1 m=1
M22 SUMb CIN net11 VSS nfet_03v3 L=0.28u W='kTS*0.36u' nf=1 m=1
M23 net11 A net10 VSS nfet_03v3 L=0.28u W=0.36u nf=1 m=1
M24 net10 B VSS VSS nfet_03v3 L=0.28u W=0.36u nf=1 m=1
M25 COUT net4 VDD VDD pfet_03v3 L=0.28u W=0.72u nf=1 m=1
M26 COUT net4 VSS VSS nfet_03v3 L=0.28u W=0.36u nf=1 m=1
**** begin user architecture code

.param kSUMb=1
.param kTS=1

**** end user architecture code
.ends

* expanding   symbol:  engn1600-team1/CAD4/logic.sym # of pins=8
** sym_path: /foss/designs/engn1600-team1/CAD4/logic.sym
** sch_path: /foss/designs/engn1600-team1/CAD4/logic.sch
.subckt logic NOR VDD VSS XNOR A B NAND XOR
*.PININFO VSS:B VDD:B A:I B:I NAND:O NOR:O XNOR:O XOR:O
x1 VDD NAND A B VSS nand2
x3 VDD NOR net1 VSS inv
x2 VDD NOR A B VSS nor2
x4 VDD XNOR NAND net1 VSS nand2
x6 VDD XNOR XOR VSS inv
.ends

* expanding   symbol:  engn1600-team1/CAD4/logic_extended.sym # of pins=10
** sym_path: /foss/designs/engn1600-team1/CAD4/logic_extended.sym
** sch_path: /foss/designs/engn1600-team1/CAD4/logic_extended.sch
.subckt logic_extended AND XOR OR NOR VDD VSS XNOR A B NAND
*.PININFO VSS:B VDD:B A:I B:I NAND:O NOR:O XNOR:O OR:O AND:O XOR:O
x1 VDD NAND A B VSS nand2
x3 VDD NOR OR VSS inv
x2 VDD NOR A B VSS nor2
x4 VDD XNOR NAND OR VSS nand2
x5 VDD NAND AND VSS inv
x6 VDD XNOR XOR VSS inv
.ends

* expanding   symbol:  engn1600-team1/CAD4/2x1_mux_cmos.sym # of pins=8
** sym_path: /foss/designs/engn1600-team1/CAD4/2x1_mux_cmos.sym
** sch_path: /foss/designs/engn1600-team1/CAD4/2x1_mux_cmos.sch
.subckt 2x1_mux_cmos A SEL SELb Y VDD VSS B Yb  kI=1 kYb=1 kY=1
*.PININFO A:I B:I SEL:I Y:O VDD:B VSS:B SELb:I Yb:O
M1 VSS B net1 VSS nfet_03v3 L=0.28u W='kI*0.36u' nf=1 m=1
M2 net1 SEL Yb VSS nfet_03v3 L=0.28u W='kYb*0.36u' nf=1 m=1
M3 Yb SELb net2 VSS nfet_03v3 L=0.28u W='kYb*0.36u' nf=1 m=1
M4 net2 A VSS VSS nfet_03v3 L=0.28u W='kI*0.36u' nf=1 m=1
M5 net3 SELb Yb VDD pfet_03v3 L=0.28u W='kYb*0.72u' nf=1 m=1
M6 VDD B net3 VDD pfet_03v3 L=0.28u W='kI*0.72u' nf=1 m=1
M7 net4 A VDD VDD pfet_03v3 L=0.28u W='kI*0.72u' nf=1 m=1
M8 Yb SEL net4 VDD pfet_03v3 L=0.28u W='kYb*0.72u' nf=1 m=1
M9 VSS Yb Y VSS nfet_03v3 L=0.28u W='kY*0.36u' nf=1 m=1
M10 VDD Yb Y VDD pfet_03v3 L=0.28u W='kY*0.72u' nf=1 m=1
**** begin user architecture code

.param kI=2.5
.param kYb=1.875
.param kY=0.775/0.36

**** end user architecture code
.ends

* expanding   symbol:  engn1600-team1/CAD4/2x4_decoder.sym # of pins=8
** sym_path: /foss/designs/engn1600-team1/CAD4/2x4_decoder.sym
** sch_path: /foss/designs/engn1600-team1/CAD4/2x4_decoder.sch
.subckt 2x4_decoder VDD VSS S0 S1 SA SB SC SD
*.PININFO S0:I S1:I SA:O SB:O SC:O SD:O VSS:B VDD:B
M1 S1bar S1 VSS VSS nfet_03v3 L=0.28u W=0.36u nf=1 m=1
M2 S1bar S1 VDD VDD pfet_03v3 L=0.28u W=0.72u nf=1 m=1
M3 SA S0 VSS VSS nfet_03v3 L=0.28u W=0.36u nf=1 m=1
M4 SA S1 VSS VSS nfet_03v3 L=0.28u W=0.36u nf=1 m=1
M5 SA S0 S1bar VDD pfet_03v3 L=0.28u W=0.36u nf=1 m=1
M9 S0 S1 SB VDD pfet_03v3 L=0.28u W=0.36u nf=1 m=1
M10 S0 S1bar SB VSS nfet_03v3 L=0.28u W=0.36u nf=1 m=1
M11 VSS S1 SB VSS nfet_03v3 L=0.28u W=0.36u nf=1 m=1
M12 S0 S1bar SD VDD pfet_03v3 L=0.28u W=0.36u nf=1 m=1
M13 S0 S1 SD VSS nfet_03v3 L=0.28u W=0.36u nf=1 m=1
M14 VSS S1bar SD VSS nfet_03v3 L=0.28u W=0.36u nf=1 m=1
M6 SC S0 VSS VSS nfet_03v3 L=0.28u W=0.36u nf=1 m=1
M7 SC S1bar VSS VSS nfet_03v3 L=0.28u W=0.36u nf=1 m=1
M8 SC S0 S1 VDD pfet_03v3 L=0.28u W=0.36u nf=1 m=1
.ends

* expanding   symbol:  engn1600-team1/CAD4/and16.sym # of pins=4
** sym_path: /foss/designs/engn1600-team1/CAD4/and16.sym
** sch_path: /foss/designs/engn1600-team1/CAD4/and16.sch
.subckt and16 IN15 IN14 IN13 IN12 IN11 IN10 IN9 IN8 IN7 IN6 IN5 IN4 IN3 IN2 IN1 IN0 VDD OUT VSS
*.PININFO VSS:B VDD:B IN[15..0]:I OUT:O
x1 net4 VSS VDD IN0 IN1 IN2 IN3 nand4
x2 net1 VSS VDD IN4 IN5 IN6 IN7 nand4
x3 net2 VSS VDD IN8 IN9 IN10 IN11 nand4
x4 net3 VSS VDD IN12 IN13 IN14 IN15 nand4
x5 OUT VSS VDD net4 net1 net2 net3 nor4
.ends

* expanding   symbol:  engn1600-team1/CAD4/xor2.sym # of pins=5
** sym_path: /foss/designs/engn1600-team1/CAD4/xor2.sym
** sch_path: /foss/designs/engn1600-team1/CAD4/xor2.sch
.subckt xor2 VDD OUT IN0 IN1 VSS
*.PININFO VSS:B VDD:B IN0:I IN1:I OUT:O
M1 net3 IN1 VDD VDD pfet_03v3 L=0.28u W=1.44u nf=1 m=1
M2 net2 IN0 net3 VDD pfet_03v3 L=0.28u W=1.44u nf=1 m=1
M3 net2 IN0 VSS VSS nfet_03v3 L=0.28u W=0.72u nf=1 m=1
M5 OUT net2 VSS VSS nfet_03v3 L=0.28u W=0.72u nf=1 m=1
M6 net2 IN1 VSS VSS nfet_03v3 L=0.28u W=0.72u nf=1 m=1
M7 OUT IN0 net1 VDD pfet_03v3 L=0.28u W=1.44u nf=1 m=1
M8 OUT IN1 net1 VDD pfet_03v3 L=0.28u W=1.44u nf=1 m=1
M9 net1 net2 VDD VDD pfet_03v3 L=0.28u W=1.44u nf=1 m=1
M10 OUT IN1 net4 VSS nfet_03v3 L=0.28u W=0.72u nf=1 m=1
M11 net4 IN0 VSS VSS nfet_03v3 L=0.28u W=0.72u nf=1 m=1
.ends

* expanding   symbol:  engn1600-team1/CAD3/slave_latch.sym # of pins=9
** sym_path: /foss/designs/engn1600-team1/CAD3/slave_latch.sym
** sch_path: /foss/designs/engn1600-team1/CAD3/slave_latch.sch
.subckt slave_latch VDD VSS QA WECLK WECLKb RA RB QB D  kQ=1
*.PININFO D:I RA:I RB:I WECLKb:I WECLK:I QA:O QB:O VDD:B VSS:B
M1 net1 WECLKb net2 VDD pfet_03v3 L=0.28u W=0.36u nf=1 m=1
M2 net1 D VDD VDD pfet_03v3 L=0.28u W=0.72u nf=1 m=1
M3 net3 net2 VDD VDD pfet_03v3 L=0.28u W=0.72u nf=1 m=1
M4 net4 net2 VDD VDD pfet_03v3 L=0.28u W=0.36u nf=1 m=1
M5 VDD WECLK net8 VDD pfet_03v3 L=0.28u W=0.36u nf=1 m=1
M6 net8 net4 net2 VDD pfet_03v3 L=0.28u W=0.36u nf=1 m=1
M7 net1 D VSS VSS nfet_03v3 L=0.28u W=0.36u nf=1 m=1
M8 net1 WECLK net2 VSS nfet_03v3 L=0.28u W=0.36u nf=1 m=1
M9 net3 net2 VSS VSS nfet_03v3 L=0.28u W=0.36u nf=1 m=1
M10 net4 net2 VSS VSS nfet_03v3 L=0.28u W=0.36u nf=1 m=1
M11 net7 net4 net2 VSS nfet_03v3 L=0.28u W=0.36u nf=1 m=1
M12 VSS WECLKb net7 VSS nfet_03v3 L=0.28u W=0.36u nf=1 m=1
M13 net3 net5 QB VDD pfet_03v3 L=0.28u W='kQ*0.36u' nf=1 m=1
M14 net3 RB QB VSS nfet_03v3 L=0.28u W='kQ*0.36u' nf=1 m=1
M15 net5 RB VDD VDD pfet_03v3 L=0.28u W=0.72u nf=1 m=1
M16 net5 RB VSS VSS nfet_03v3 L=0.28u W=0.36u nf=1 m=1
M21 net3 net6 QA VDD pfet_03v3 L=0.28u W='kQ*0.36u' nf=1 m=1
M22 net3 RA QA VSS nfet_03v3 L=0.28u W='kQ*0.36u' nf=1 m=1
M23 net6 RA VDD VDD pfet_03v3 L=0.28u W=0.72u nf=1 m=1
M24 net6 RA VSS VSS nfet_03v3 L=0.28u W=0.36u nf=1 m=1
**** begin user architecture code

.param kQ=1

**** end user architecture code
.ends

* expanding   symbol:  engn1600-team1/CAD3/master_latch.sym # of pins=6
** sym_path: /foss/designs/engn1600-team1/CAD3/master_latch.sym
** sch_path: /foss/designs/engn1600-team1/CAD3/master_latch.sch
.subckt master_latch VDD VSS Q WEM WEMb D  kN=1
*.PININFO D:I WEMb:I WEM:I VSS:B VDD:B Q:O
M3 net1 WEMb net2 VDD pfet_03v3 L=0.28u W=0.36u nf=1 m=1
M7 net1 D VDD VDD pfet_03v3 L=0.28u W=0.72u nf=1 m=1
M8 Q net2 VDD VDD pfet_03v3 L=0.28u W='kN*0.72u' nf=1 m=1
M9 net3 net2 VDD VDD pfet_03v3 L=0.28u W=0.36u nf=1 m=1
M10 VDD WEM net5 VDD pfet_03v3 L=0.28u W=0.36u nf=1 m=1
M12 net5 net3 net2 VDD pfet_03v3 L=0.28u W=0.36u nf=1 m=1
M19 net1 D VSS VSS nfet_03v3 L=0.28u W=0.36u nf=1 m=1
M20 net1 WEM net2 VSS nfet_03v3 L=0.28u W=0.36u nf=1 m=1
M21 Q net2 VSS VSS nfet_03v3 L=0.28u W='kN*0.36u' nf=1 m=1
M22 net3 net2 VSS VSS nfet_03v3 L=0.28u W=0.36u nf=1 m=1
M23 net4 net3 net2 VSS nfet_03v3 L=0.28u W=0.36u nf=1 m=1
M24 VSS WEMb net4 VSS nfet_03v3 L=0.28u W=0.36u nf=1 m=1
**** begin user architecture code

.param kN=1

**** end user architecture code
.ends

* expanding   symbol:  engn1600-team1/CAD3/driver_cell.sym # of pins=6
** sym_path: /foss/designs/engn1600-team1/CAD3/driver_cell.sym
** sch_path: /foss/designs/engn1600-team1/CAD3/driver_cell.sch
.subckt driver_cell CLK WE WECLKb VDD VSS WECLK  kWECLK=1 kWECLKb=1
*.PININFO CLK:I WE:I VSS:B VDD:B WECLKb:O WECLK:O
M13 WECLK net1 VDD VDD pfet_03v3 L=0.28u W='kWECLK*0.72u' nf=1 m=1
M14 WECLK net1 VSS VSS nfet_03v3 L=0.28u W='kWECLK*0.36u' nf=1 m=1
M1 WECLKb WECLK VDD VDD pfet_03v3 L=0.28u W='kWECLKb*0.72u' nf=1 m=1
M2 WECLKb WECLK VSS VSS nfet_03v3 L=0.28u W='kWECLKb*0.36u' nf=1 m=1
M3 net1 CLK VDD VDD pfet_03v3 L=0.28u W=0.72u nf=1 m=1
M4 net1 WE VDD VDD pfet_03v3 L=0.28u W=0.72u nf=1 m=1
M5 net2 WE VSS VSS nfet_03v3 L=0.28u W=0.72u nf=1 m=1
M6 net1 CLK net2 VSS nfet_03v3 L=0.28u W=0.72u nf=1 m=1
**** begin user architecture code

.param kWECLKb=1
.param kWECLK=1

**** end user architecture code
.ends

* expanding   symbol:  engn1600-team1/CAD3/output_inverter.sym # of pins=6
** sym_path: /foss/designs/engn1600-team1/CAD3/output_inverter.sym
** sch_path: /foss/designs/engn1600-team1/CAD3/output_inverter.sch
.subckt output_inverter VDD VSS QAb QA QB QBb
*.PININFO QBb:O QAb:O VDD:B VSS:B QA:I QB:I
M3 QBb QB VDD VDD pfet_03v3 L=0.28u W=0.72u nf=1 m=1
M4 QBb QB VSS VSS nfet_03v3 L=0.28u W=0.36u nf=1 m=1
M35 QAb QA VDD VDD pfet_03v3 L=0.28u W=0.72u nf=1 m=1
M36 QAb QA VSS VSS nfet_03v3 L=0.28u W=0.36u nf=1 m=1
.ends

* expanding   symbol:  engn1600-team1/CAD3/wem_inverter.sym # of pins=4
** sym_path: /foss/designs/engn1600-team1/CAD3/wem_inverter.sym
** sch_path: /foss/designs/engn1600-team1/CAD3/wem_inverter.sch
.subckt wem_inverter VDD WEM WEMb VSS  kWEMb=1
*.PININFO WEM:I WEMb:O VDD:B VSS:B
M1 WEMb WEM VDD VDD pfet_03v3 L=0.28u W='kWEMb*0.72u' nf=1 m=1
M2 WEMb WEM VSS VSS nfet_03v3 L=0.28u W='kWEMb*0.36u' nf=1 m=1
**** begin user architecture code

.param kWEMb=1

**** end user architecture code
.ends

* expanding   symbol:  engn1600-team1/CAD6/sign_extend.sym # of pins=4
** sym_path: /foss/designs/engn1600-team1/CAD6/sign_extend.sym
** sch_path: /foss/designs/engn1600-team1/CAD6/sign_extend.sch
.subckt sign_extend VDD VSS OUT IN
*.PININFO VDD:B VSS:B IN:I OUT:O
M1 net1 IN VDD VDD pfet_03v3 L=0.28u W='3*0.72u' nf=1 m=1
M2 net1 IN VSS VSS nfet_03v3 L=0.28u W='3*0.36u' nf=1 m=1
M3 OUT net1 VDD VDD pfet_03v3 L=0.28u W='9*0.72u' nf=1 m=1
M4 OUT net1 VSS VSS nfet_03v3 L=0.28u W='9*0.36u' nf=1 m=1
.ends

* expanding   symbol:  engn1600-team1/CAD5/unit_inv.sym # of pins=4
** sym_path: /foss/designs/engn1600-team1/CAD5/unit_inv.sym
** sch_path: /foss/designs/engn1600-team1/CAD5/unit_inv.sch
.subckt unit_inv VDD IN OUT VSS
*.PININFO IN:I OUT:O VDD:B VSS:B
M1 OUT IN VDD VDD pfet_03v3 L=0.28u W=0.72u nf=1 m=1
M2 OUT IN VSS VSS nfet_03v3 L=0.28u W=0.36u nf=1 m=1
.ends

* expanding   symbol:  engn1600-team1/CAD7/nand2.sym # of pins=5
** sym_path: /foss/designs/engn1600-team1/CAD7/nand2.sym
** sch_path: /foss/designs/engn1600-team1/CAD7/nand2.sch
.subckt nand2 VDD OUT IN0 IN1 VSS
*.PININFO VSS:B VDD:B IN0:I IN1:I OUT:O
M1 net1 IN1 VSS VSS nfet_03v3 L=0.28u W=0.36u nf=1 m=1
M2 OUT IN0 net1 VSS nfet_03v3 L=0.28u W=0.36u nf=1 m=1
M3 OUT IN1 VDD VDD pfet_03v3 L=0.28u W=0.36u nf=1 m=1
M4 OUT IN0 VDD VDD pfet_03v3 L=0.28u W=0.36u nf=1 m=1
.ends

* expanding   symbol:  engn1600-team1/CAD4/nor2.sym # of pins=5
** sym_path: /foss/designs/engn1600-team1/CAD4/nor2.sym
** sch_path: /foss/designs/engn1600-team1/CAD4/nor2.sch
.subckt nor2 VDD OUT IN0 IN1 VSS
*.PININFO VSS:B VDD:B IN0:I IN1:I OUT:O
M1 OUT IN0 VSS VSS nfet_03v3 L=0.28u W=0.36u nf=1 m=1
M2 OUT IN1 VSS VSS nfet_03v3 L=0.28u W=0.36u nf=1 m=1
M3 net1 IN1 VDD VDD pfet_03v3 L=0.28u W=1.44u nf=1 m=1
M4 OUT IN0 net1 VDD pfet_03v3 L=0.28u W=1.44u nf=1 m=1
.ends

* expanding   symbol:  engn1600-team1/CAD4/nand4.sym # of pins=7
** sym_path: /foss/designs/engn1600-team1/CAD4/nand4.sym
** sch_path: /foss/designs/engn1600-team1/CAD4/nand4.sch
.subckt nand4 OUT VSS VDD IN0 IN1 IN2 IN3
*.PININFO VSS:B VDD:B IN0:I IN1:I OUT:O IN2:I IN3:I
M1 net1 IN2 net2 VSS nfet_03v3 L=0.28u W=1.44u nf=1 m=1
M2 OUT IN3 net1 VSS nfet_03v3 L=0.28u W=1.44u nf=1 m=1
M3 OUT IN1 VDD VDD pfet_03v3 L=0.28u W=0.72u nf=1 m=1
M4 OUT IN2 VDD VDD pfet_03v3 L=0.28u W=0.72u nf=1 m=1
M5 OUT IN0 VDD VDD pfet_03v3 L=0.28u W=0.72u nf=1 m=1
M6 OUT IN3 VDD VDD pfet_03v3 L=0.28u W=0.72u nf=1 m=1
M7 net3 IN0 VSS VSS nfet_03v3 L=0.28u W=1.44u nf=1 m=1
M8 net2 IN1 net3 VSS nfet_03v3 L=0.28u W=1.44u nf=1 m=1
.ends

* expanding   symbol:  engn1600-team1/CAD4/nor4.sym # of pins=7
** sym_path: /foss/designs/engn1600-team1/CAD4/nor4.sym
** sch_path: /foss/designs/engn1600-team1/CAD4/nor4.sch
.subckt nor4 OUT VSS VDD IN0 IN1 IN2 IN3
*.PININFO VSS:B VDD:B IN0:I IN1:I OUT:O IN2:I IN3:I
M1 net1 IN1 net2 VDD pfet_03v3 L=0.28u W=2.88u nf=1 m=1
M2 net2 IN0 VDD VDD pfet_03v3 L=0.28u W=2.88u nf=1 m=1
M3 OUT IN1 VSS VSS nfet_03v3 L=0.28u W=0.36u nf=1 m=1
M4 OUT IN2 VSS VSS nfet_03v3 L=0.28u W=0.36u nf=1 m=1
M5 OUT IN0 VSS VSS nfet_03v3 L=0.28u W=0.36u nf=1 m=1
M6 OUT IN3 VSS VSS nfet_03v3 L=0.28u W=0.36u nf=1 m=1
M7 OUT IN3 net3 VDD pfet_03v3 L=0.28u W=2.88u nf=1 m=1
M8 net3 IN2 net1 VDD pfet_03v3 L=0.28u W=2.88u nf=1 m=1
.ends

.GLOBAL GND
