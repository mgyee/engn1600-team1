** sch_path: /foss/designs/engn1600-team1/CAD7/processor_tb.sch
**.subckt processor_tb
x1 CLK RSTn SE SI VDD VSS processor
VCLK CLK GND 0
VRSTn RSTn GND 0
VSE SE GND 0
VSI SI GND 0
VVDD VDD GND 3.3
VVSS VSS GND 0
**** begin user architecture code

.include /foss/pdks/gf180mcuD/libs.tech/ngspice/design.ngspice
.lib /foss/pdks/gf180mcuD/libs.tech/ngspice/sm141064.ngspice typical
.include /foss/designs/engn1600-team1/CAD7/tb_tmp.spice

**** end user architecture code
**.ends

* expanding   symbol:  engn1600-team1/CAD7/processor.sym # of pins=6
** sym_path: /foss/designs/engn1600-team1/CAD7/processor.sym
** sch_path: /foss/designs/engn1600-team1/CAD7/processor.sch
.subckt processor CLK RSTn SE SI VDD VSS
*.ipin CLK
*.ipin RSTn
*.ipin SE
*.ipin SI
*.iopin VDD
*.iopin VSS
**** begin user architecture code

.include /foss/designs/engn1600-team1/CAD7/datapath_sim.spice
.include /foss/designs/engn1600-team1/CAD7/lib.spice

**** end user architecture code
.ends

.GLOBAL GND
.end
