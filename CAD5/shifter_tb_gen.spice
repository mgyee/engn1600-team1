** TEST SUMMARY
** 00: 0x5678 << (1 ? 03 : 12) = 0xB3C0
** 01: 0xFFFF << (0 ? 00 : 15) = 0x8000
** 02: 0x0001 << (1 ? 15 : 00) = 0x8000
** 03: 0x1357 << (0 ? 00 : 00) = 0x1357
** 04: 0x1357 << (0 ? 00 : 01) = 0x26AE
** 05: 0x1357 << (0 ? 00 : 02) = 0x4D5C
** 06: 0x1357 << (0 ? 00 : 03) = 0x9AB8
** 07: 0x1357 << (0 ? 00 : 04) = 0x3570
** 08: 0x1357 << (0 ? 00 : 05) = 0x6AE0
** 09: 0x1357 << (0 ? 00 : 06) = 0xD5C0
** 10: 0x1357 << (0 ? 00 : 07) = 0xAB80
** 11: 0x1357 << (0 ? 00 : 08) = 0x5700
** 12: 0x1357 << (0 ? 00 : 09) = 0xAE00
** 13: 0x1357 << (0 ? 00 : 10) = 0x5C00
** 14: 0x1357 << (0 ? 00 : 11) = 0xB800
** 15: 0x1357 << (0 ? 00 : 12) = 0x7000
** 16: 0x1357 << (0 ? 00 : 13) = 0xE000
** 17: 0x1357 << (0 ? 00 : 14) = 0xC000
** 18: 0x1357 << (0 ? 00 : 15) = 0x8000

.control
save all

** Define input signals

** D BUS
alter @VD15[PWL] = [ 0n 0.0 5n 0.0 5n 3.3 10n 3.3 10n 0.0 15n 0.0 15n 0.0 20n 0.0 20n 0.0 25n 0.0 25n 0.0 30n 0.0 30n 0.0 35n 0.0 35n 0.0 40n 0.0 40n 0.0 45n 0.0 45n 0.0 50n 0.0 50n 0.0 55n 0.0 55n 0.0 60n 0.0 60n 0.0 65n 0.0 65n 0.0 70n 0.0 70n 0.0 75n 0.0 75n 0.0 80n 0.0 80n 0.0 85n 0.0 85n 0.0 90n 0.0 90n 0.0 95n 0.0 ]
alter @VD14[PWL] = [ 0n 3.3 5n 3.3 5n 3.3 10n 3.3 10n 0.0 15n 0.0 15n 0.0 20n 0.0 20n 0.0 25n 0.0 25n 0.0 30n 0.0 30n 0.0 35n 0.0 35n 0.0 40n 0.0 40n 0.0 45n 0.0 45n 0.0 50n 0.0 50n 0.0 55n 0.0 55n 0.0 60n 0.0 60n 0.0 65n 0.0 65n 0.0 70n 0.0 70n 0.0 75n 0.0 75n 0.0 80n 0.0 80n 0.0 85n 0.0 85n 0.0 90n 0.0 90n 0.0 95n 0.0 ]
alter @VD13[PWL] = [ 0n 0.0 5n 0.0 5n 3.3 10n 3.3 10n 0.0 15n 0.0 15n 0.0 20n 0.0 20n 0.0 25n 0.0 25n 0.0 30n 0.0 30n 0.0 35n 0.0 35n 0.0 40n 0.0 40n 0.0 45n 0.0 45n 0.0 50n 0.0 50n 0.0 55n 0.0 55n 0.0 60n 0.0 60n 0.0 65n 0.0 65n 0.0 70n 0.0 70n 0.0 75n 0.0 75n 0.0 80n 0.0 80n 0.0 85n 0.0 85n 0.0 90n 0.0 90n 0.0 95n 0.0 ]
alter @VD12[PWL] = [ 0n 3.3 5n 3.3 5n 3.3 10n 3.3 10n 0.0 15n 0.0 15n 3.3 20n 3.3 20n 3.3 25n 3.3 25n 3.3 30n 3.3 30n 3.3 35n 3.3 35n 3.3 40n 3.3 40n 3.3 45n 3.3 45n 3.3 50n 3.3 50n 3.3 55n 3.3 55n 3.3 60n 3.3 60n 3.3 65n 3.3 65n 3.3 70n 3.3 70n 3.3 75n 3.3 75n 3.3 80n 3.3 80n 3.3 85n 3.3 85n 3.3 90n 3.3 90n 3.3 95n 3.3 ]
alter @VD11[PWL] = [ 0n 0.0 5n 0.0 5n 3.3 10n 3.3 10n 0.0 15n 0.0 15n 0.0 20n 0.0 20n 0.0 25n 0.0 25n 0.0 30n 0.0 30n 0.0 35n 0.0 35n 0.0 40n 0.0 40n 0.0 45n 0.0 45n 0.0 50n 0.0 50n 0.0 55n 0.0 55n 0.0 60n 0.0 60n 0.0 65n 0.0 65n 0.0 70n 0.0 70n 0.0 75n 0.0 75n 0.0 80n 0.0 80n 0.0 85n 0.0 85n 0.0 90n 0.0 90n 0.0 95n 0.0 ]
alter @VD10[PWL] = [ 0n 3.3 5n 3.3 5n 3.3 10n 3.3 10n 0.0 15n 0.0 15n 0.0 20n 0.0 20n 0.0 25n 0.0 25n 0.0 30n 0.0 30n 0.0 35n 0.0 35n 0.0 40n 0.0 40n 0.0 45n 0.0 45n 0.0 50n 0.0 50n 0.0 55n 0.0 55n 0.0 60n 0.0 60n 0.0 65n 0.0 65n 0.0 70n 0.0 70n 0.0 75n 0.0 75n 0.0 80n 0.0 80n 0.0 85n 0.0 85n 0.0 90n 0.0 90n 0.0 95n 0.0 ]
alter @VD9[PWL] = [ 0n 3.3 5n 3.3 5n 3.3 10n 3.3 10n 0.0 15n 0.0 15n 3.3 20n 3.3 20n 3.3 25n 3.3 25n 3.3 30n 3.3 30n 3.3 35n 3.3 35n 3.3 40n 3.3 40n 3.3 45n 3.3 45n 3.3 50n 3.3 50n 3.3 55n 3.3 55n 3.3 60n 3.3 60n 3.3 65n 3.3 65n 3.3 70n 3.3 70n 3.3 75n 3.3 75n 3.3 80n 3.3 80n 3.3 85n 3.3 85n 3.3 90n 3.3 90n 3.3 95n 3.3 ]
alter @VD8[PWL] = [ 0n 0.0 5n 0.0 5n 3.3 10n 3.3 10n 0.0 15n 0.0 15n 3.3 20n 3.3 20n 3.3 25n 3.3 25n 3.3 30n 3.3 30n 3.3 35n 3.3 35n 3.3 40n 3.3 40n 3.3 45n 3.3 45n 3.3 50n 3.3 50n 3.3 55n 3.3 55n 3.3 60n 3.3 60n 3.3 65n 3.3 65n 3.3 70n 3.3 70n 3.3 75n 3.3 75n 3.3 80n 3.3 80n 3.3 85n 3.3 85n 3.3 90n 3.3 90n 3.3 95n 3.3 ]
alter @VD7[PWL] = [ 0n 0.0 5n 0.0 5n 3.3 10n 3.3 10n 0.0 15n 0.0 15n 0.0 20n 0.0 20n 0.0 25n 0.0 25n 0.0 30n 0.0 30n 0.0 35n 0.0 35n 0.0 40n 0.0 40n 0.0 45n 0.0 45n 0.0 50n 0.0 50n 0.0 55n 0.0 55n 0.0 60n 0.0 60n 0.0 65n 0.0 65n 0.0 70n 0.0 70n 0.0 75n 0.0 75n 0.0 80n 0.0 80n 0.0 85n 0.0 85n 0.0 90n 0.0 90n 0.0 95n 0.0 ]
alter @VD6[PWL] = [ 0n 3.3 5n 3.3 5n 3.3 10n 3.3 10n 0.0 15n 0.0 15n 3.3 20n 3.3 20n 3.3 25n 3.3 25n 3.3 30n 3.3 30n 3.3 35n 3.3 35n 3.3 40n 3.3 40n 3.3 45n 3.3 45n 3.3 50n 3.3 50n 3.3 55n 3.3 55n 3.3 60n 3.3 60n 3.3 65n 3.3 65n 3.3 70n 3.3 70n 3.3 75n 3.3 75n 3.3 80n 3.3 80n 3.3 85n 3.3 85n 3.3 90n 3.3 90n 3.3 95n 3.3 ]
alter @VD5[PWL] = [ 0n 3.3 5n 3.3 5n 3.3 10n 3.3 10n 0.0 15n 0.0 15n 0.0 20n 0.0 20n 0.0 25n 0.0 25n 0.0 30n 0.0 30n 0.0 35n 0.0 35n 0.0 40n 0.0 40n 0.0 45n 0.0 45n 0.0 50n 0.0 50n 0.0 55n 0.0 55n 0.0 60n 0.0 60n 0.0 65n 0.0 65n 0.0 70n 0.0 70n 0.0 75n 0.0 75n 0.0 80n 0.0 80n 0.0 85n 0.0 85n 0.0 90n 0.0 90n 0.0 95n 0.0 ]
alter @VD4[PWL] = [ 0n 3.3 5n 3.3 5n 3.3 10n 3.3 10n 0.0 15n 0.0 15n 3.3 20n 3.3 20n 3.3 25n 3.3 25n 3.3 30n 3.3 30n 3.3 35n 3.3 35n 3.3 40n 3.3 40n 3.3 45n 3.3 45n 3.3 50n 3.3 50n 3.3 55n 3.3 55n 3.3 60n 3.3 60n 3.3 65n 3.3 65n 3.3 70n 3.3 70n 3.3 75n 3.3 75n 3.3 80n 3.3 80n 3.3 85n 3.3 85n 3.3 90n 3.3 90n 3.3 95n 3.3 ]
alter @VD3[PWL] = [ 0n 3.3 5n 3.3 5n 3.3 10n 3.3 10n 0.0 15n 0.0 15n 0.0 20n 0.0 20n 0.0 25n 0.0 25n 0.0 30n 0.0 30n 0.0 35n 0.0 35n 0.0 40n 0.0 40n 0.0 45n 0.0 45n 0.0 50n 0.0 50n 0.0 55n 0.0 55n 0.0 60n 0.0 60n 0.0 65n 0.0 65n 0.0 70n 0.0 70n 0.0 75n 0.0 75n 0.0 80n 0.0 80n 0.0 85n 0.0 85n 0.0 90n 0.0 90n 0.0 95n 0.0 ]
alter @VD2[PWL] = [ 0n 0.0 5n 0.0 5n 3.3 10n 3.3 10n 0.0 15n 0.0 15n 3.3 20n 3.3 20n 3.3 25n 3.3 25n 3.3 30n 3.3 30n 3.3 35n 3.3 35n 3.3 40n 3.3 40n 3.3 45n 3.3 45n 3.3 50n 3.3 50n 3.3 55n 3.3 55n 3.3 60n 3.3 60n 3.3 65n 3.3 65n 3.3 70n 3.3 70n 3.3 75n 3.3 75n 3.3 80n 3.3 80n 3.3 85n 3.3 85n 3.3 90n 3.3 90n 3.3 95n 3.3 ]
alter @VD1[PWL] = [ 0n 0.0 5n 0.0 5n 3.3 10n 3.3 10n 0.0 15n 0.0 15n 3.3 20n 3.3 20n 3.3 25n 3.3 25n 3.3 30n 3.3 30n 3.3 35n 3.3 35n 3.3 40n 3.3 40n 3.3 45n 3.3 45n 3.3 50n 3.3 50n 3.3 55n 3.3 55n 3.3 60n 3.3 60n 3.3 65n 3.3 65n 3.3 70n 3.3 70n 3.3 75n 3.3 75n 3.3 80n 3.3 80n 3.3 85n 3.3 85n 3.3 90n 3.3 90n 3.3 95n 3.3 ]
alter @VD0[PWL] = [ 0n 0.0 5n 0.0 5n 3.3 10n 3.3 10n 3.3 15n 3.3 15n 3.3 20n 3.3 20n 3.3 25n 3.3 25n 3.3 30n 3.3 30n 3.3 35n 3.3 35n 3.3 40n 3.3 40n 3.3 45n 3.3 45n 3.3 50n 3.3 50n 3.3 55n 3.3 55n 3.3 60n 3.3 60n 3.3 65n 3.3 65n 3.3 70n 3.3 70n 3.3 75n 3.3 75n 3.3 80n 3.3 80n 3.3 85n 3.3 85n 3.3 90n 3.3 90n 3.3 95n 3.3 ]

** R BUS
alter @VR3[PWL] = [ 0n 3.3 5n 3.3 5n 3.3 10n 3.3 10n 0.0 15n 0.0 15n 0.0 20n 0.0 20n 0.0 25n 0.0 25n 0.0 30n 0.0 30n 0.0 35n 0.0 35n 0.0 40n 0.0 40n 0.0 45n 0.0 45n 0.0 50n 0.0 50n 0.0 55n 0.0 55n 3.3 60n 3.3 60n 3.3 65n 3.3 65n 3.3 70n 3.3 70n 3.3 75n 3.3 75n 3.3 80n 3.3 80n 3.3 85n 3.3 85n 3.3 90n 3.3 90n 3.3 95n 3.3 ]
alter @VR2[PWL] = [ 0n 3.3 5n 3.3 5n 3.3 10n 3.3 10n 0.0 15n 0.0 15n 0.0 20n 0.0 20n 0.0 25n 0.0 25n 0.0 30n 0.0 30n 0.0 35n 0.0 35n 3.3 40n 3.3 40n 3.3 45n 3.3 45n 3.3 50n 3.3 50n 3.3 55n 3.3 55n 0.0 60n 0.0 60n 0.0 65n 0.0 65n 0.0 70n 0.0 70n 0.0 75n 0.0 75n 3.3 80n 3.3 80n 3.3 85n 3.3 85n 3.3 90n 3.3 90n 3.3 95n 3.3 ]
alter @VR1[PWL] = [ 0n 0.0 5n 0.0 5n 3.3 10n 3.3 10n 0.0 15n 0.0 15n 0.0 20n 0.0 20n 0.0 25n 0.0 25n 3.3 30n 3.3 30n 3.3 35n 3.3 35n 0.0 40n 0.0 40n 0.0 45n 0.0 45n 3.3 50n 3.3 50n 3.3 55n 3.3 55n 0.0 60n 0.0 60n 0.0 65n 0.0 65n 3.3 70n 3.3 70n 3.3 75n 3.3 75n 0.0 80n 0.0 80n 0.0 85n 0.0 85n 3.3 90n 3.3 90n 3.3 95n 3.3 ]
alter @VR0[PWL] = [ 0n 0.0 5n 0.0 5n 3.3 10n 3.3 10n 0.0 15n 0.0 15n 0.0 20n 0.0 20n 3.3 25n 3.3 25n 0.0 30n 0.0 30n 3.3 35n 3.3 35n 0.0 40n 0.0 40n 3.3 45n 3.3 45n 0.0 50n 0.0 50n 3.3 55n 3.3 55n 0.0 60n 0.0 60n 3.3 65n 3.3 65n 0.0 70n 0.0 70n 3.3 75n 3.3 75n 0.0 80n 0.0 80n 3.3 85n 3.3 85n 0.0 90n 0.0 90n 3.3 95n 3.3 ]

** I BUS
alter @VI3[PWL] = [ 0n 0.0 5n 0.0 5n 0.0 10n 0.0 10n 3.3 15n 3.3 15n 0.0 20n 0.0 20n 0.0 25n 0.0 25n 0.0 30n 0.0 30n 0.0 35n 0.0 35n 0.0 40n 0.0 40n 0.0 45n 0.0 45n 0.0 50n 0.0 50n 0.0 55n 0.0 55n 0.0 60n 0.0 60n 0.0 65n 0.0 65n 0.0 70n 0.0 70n 0.0 75n 0.0 75n 0.0 80n 0.0 80n 0.0 85n 0.0 85n 0.0 90n 0.0 90n 0.0 95n 0.0 ]
alter @VI2[PWL] = [ 0n 0.0 5n 0.0 5n 0.0 10n 0.0 10n 3.3 15n 3.3 15n 0.0 20n 0.0 20n 0.0 25n 0.0 25n 0.0 30n 0.0 30n 0.0 35n 0.0 35n 0.0 40n 0.0 40n 0.0 45n 0.0 45n 0.0 50n 0.0 50n 0.0 55n 0.0 55n 0.0 60n 0.0 60n 0.0 65n 0.0 65n 0.0 70n 0.0 70n 0.0 75n 0.0 75n 0.0 80n 0.0 80n 0.0 85n 0.0 85n 0.0 90n 0.0 90n 0.0 95n 0.0 ]
alter @VI1[PWL] = [ 0n 3.3 5n 3.3 5n 0.0 10n 0.0 10n 3.3 15n 3.3 15n 0.0 20n 0.0 20n 0.0 25n 0.0 25n 0.0 30n 0.0 30n 0.0 35n 0.0 35n 0.0 40n 0.0 40n 0.0 45n 0.0 45n 0.0 50n 0.0 50n 0.0 55n 0.0 55n 0.0 60n 0.0 60n 0.0 65n 0.0 65n 0.0 70n 0.0 70n 0.0 75n 0.0 75n 0.0 80n 0.0 80n 0.0 85n 0.0 85n 0.0 90n 0.0 90n 0.0 95n 0.0 ]
alter @VI0[PWL] = [ 0n 3.3 5n 3.3 5n 0.0 10n 0.0 10n 3.3 15n 3.3 15n 0.0 20n 0.0 20n 0.0 25n 0.0 25n 0.0 30n 0.0 30n 0.0 35n 0.0 35n 0.0 40n 0.0 40n 0.0 45n 0.0 45n 0.0 50n 0.0 50n 0.0 55n 0.0 55n 0.0 60n 0.0 60n 0.0 65n 0.0 65n 0.0 70n 0.0 70n 0.0 75n 0.0 75n 0.0 80n 0.0 80n 0.0 85n 0.0 85n 0.0 90n 0.0 90n 0.0 95n 0.0 ]

** CONTROL
alter @VSEL[PWL] = [ 0n 3.3 5n 3.3 5n 0.0 10n 0.0 10n 3.3 15n 3.3 15n 0.0 20n 0.0 20n 0.0 25n 0.0 25n 0.0 30n 0.0 30n 0.0 35n 0.0 35n 0.0 40n 0.0 40n 0.0 45n 0.0 45n 0.0 50n 0.0 50n 0.0 55n 0.0 55n 0.0 60n 0.0 60n 0.0 65n 0.0 65n 0.0 70n 0.0 70n 0.0 75n 0.0 75n 0.0 80n 0.0 80n 0.0 85n 0.0 85n 0.0 90n 0.0 90n 0.0 95n 0.0 ]

tran 0.005n 95n

write shifter_tb.raw

.endc
