** TEST SUMMARY
** 00: 0x00AA << (0 ? 00 : 00) = 0x00AA
** 01: 0x00AA << (1 ? 00 : 00) = 0x00AA
** 02: 0x00AA << (0 ? 00 : 01) = 0x0154
** 03: 0x00AA << (1 ? 00 : 01) = 0x00AA
** 04: 0x00AA << (0 ? 00 : 02) = 0x02A8
** 05: 0x00AA << (1 ? 00 : 02) = 0x00AA
** 06: 0x00AA << (0 ? 00 : 03) = 0x0550
** 07: 0x00AA << (1 ? 00 : 03) = 0x00AA
** 08: 0x00AA << (0 ? 00 : 04) = 0x0AA0
** 09: 0x00AA << (1 ? 00 : 04) = 0x00AA
** 10: 0x00AA << (0 ? 00 : 05) = 0x1540
** 11: 0x00AA << (1 ? 00 : 05) = 0x00AA
** 12: 0x00AA << (0 ? 00 : 06) = 0x2A80
** 13: 0x00AA << (1 ? 00 : 06) = 0x00AA
** 14: 0x00AA << (0 ? 00 : 07) = 0x5500
** 15: 0x00AA << (1 ? 00 : 07) = 0x00AA
** 16: 0x00AA << (0 ? 00 : 08) = 0xAA00
** 17: 0x00AA << (1 ? 00 : 08) = 0x00AA
** 18: 0x00AA << (0 ? 00 : 09) = 0x5400
** 19: 0x00AA << (1 ? 00 : 09) = 0x00AA
** 20: 0x00AA << (0 ? 00 : 10) = 0xA800
** 21: 0x00AA << (1 ? 00 : 10) = 0x00AA
** 22: 0x00AA << (0 ? 00 : 11) = 0x5000
** 23: 0x00AA << (1 ? 00 : 11) = 0x00AA
** 24: 0x00AA << (0 ? 00 : 12) = 0xA000
** 25: 0x00AA << (1 ? 00 : 12) = 0x00AA
** 26: 0x00AA << (0 ? 00 : 13) = 0x4000
** 27: 0x00AA << (1 ? 00 : 13) = 0x00AA
** 28: 0x00AA << (0 ? 00 : 14) = 0x8000
** 29: 0x00AA << (1 ? 00 : 14) = 0x00AA
** 30: 0x00AA << (0 ? 00 : 15) = 0x0000
** 31: 0x00AA << (1 ? 00 : 15) = 0x00AA

.control
save all

** Define input signals

** D BUS
alter @VD15[PWL] = [ 0n 0.0 5n 0.0 5n 0.0 10n 0.0 10n 0.0 15n 0.0 15n 0.0 20n 0.0 20n 0.0 25n 0.0 25n 0.0 30n 0.0 30n 0.0 35n 0.0 35n 0.0 40n 0.0 40n 0.0 45n 0.0 45n 0.0 50n 0.0 50n 0.0 55n 0.0 55n 0.0 60n 0.0 60n 0.0 65n 0.0 65n 0.0 70n 0.0 70n 0.0 75n 0.0 75n 0.0 80n 0.0 80n 0.0 85n 0.0 85n 0.0 90n 0.0 90n 0.0 95n 0.0 95n 0.0 100n 0.0 100n 0.0 105n 0.0 105n 0.0 110n 0.0 110n 0.0 115n 0.0 115n 0.0 120n 0.0 120n 0.0 125n 0.0 125n 0.0 130n 0.0 130n 0.0 135n 0.0 135n 0.0 140n 0.0 140n 0.0 145n 0.0 145n 0.0 150n 0.0 150n 0.0 155n 0.0 155n 0.0 160n 0.0 ]
alter @VD14[PWL] = [ 0n 0.0 5n 0.0 5n 0.0 10n 0.0 10n 0.0 15n 0.0 15n 0.0 20n 0.0 20n 0.0 25n 0.0 25n 0.0 30n 0.0 30n 0.0 35n 0.0 35n 0.0 40n 0.0 40n 0.0 45n 0.0 45n 0.0 50n 0.0 50n 0.0 55n 0.0 55n 0.0 60n 0.0 60n 0.0 65n 0.0 65n 0.0 70n 0.0 70n 0.0 75n 0.0 75n 0.0 80n 0.0 80n 0.0 85n 0.0 85n 0.0 90n 0.0 90n 0.0 95n 0.0 95n 0.0 100n 0.0 100n 0.0 105n 0.0 105n 0.0 110n 0.0 110n 0.0 115n 0.0 115n 0.0 120n 0.0 120n 0.0 125n 0.0 125n 0.0 130n 0.0 130n 0.0 135n 0.0 135n 0.0 140n 0.0 140n 0.0 145n 0.0 145n 0.0 150n 0.0 150n 0.0 155n 0.0 155n 0.0 160n 0.0 ]
alter @VD13[PWL] = [ 0n 0.0 5n 0.0 5n 0.0 10n 0.0 10n 0.0 15n 0.0 15n 0.0 20n 0.0 20n 0.0 25n 0.0 25n 0.0 30n 0.0 30n 0.0 35n 0.0 35n 0.0 40n 0.0 40n 0.0 45n 0.0 45n 0.0 50n 0.0 50n 0.0 55n 0.0 55n 0.0 60n 0.0 60n 0.0 65n 0.0 65n 0.0 70n 0.0 70n 0.0 75n 0.0 75n 0.0 80n 0.0 80n 0.0 85n 0.0 85n 0.0 90n 0.0 90n 0.0 95n 0.0 95n 0.0 100n 0.0 100n 0.0 105n 0.0 105n 0.0 110n 0.0 110n 0.0 115n 0.0 115n 0.0 120n 0.0 120n 0.0 125n 0.0 125n 0.0 130n 0.0 130n 0.0 135n 0.0 135n 0.0 140n 0.0 140n 0.0 145n 0.0 145n 0.0 150n 0.0 150n 0.0 155n 0.0 155n 0.0 160n 0.0 ]
alter @VD12[PWL] = [ 0n 0.0 5n 0.0 5n 0.0 10n 0.0 10n 0.0 15n 0.0 15n 0.0 20n 0.0 20n 0.0 25n 0.0 25n 0.0 30n 0.0 30n 0.0 35n 0.0 35n 0.0 40n 0.0 40n 0.0 45n 0.0 45n 0.0 50n 0.0 50n 0.0 55n 0.0 55n 0.0 60n 0.0 60n 0.0 65n 0.0 65n 0.0 70n 0.0 70n 0.0 75n 0.0 75n 0.0 80n 0.0 80n 0.0 85n 0.0 85n 0.0 90n 0.0 90n 0.0 95n 0.0 95n 0.0 100n 0.0 100n 0.0 105n 0.0 105n 0.0 110n 0.0 110n 0.0 115n 0.0 115n 0.0 120n 0.0 120n 0.0 125n 0.0 125n 0.0 130n 0.0 130n 0.0 135n 0.0 135n 0.0 140n 0.0 140n 0.0 145n 0.0 145n 0.0 150n 0.0 150n 0.0 155n 0.0 155n 0.0 160n 0.0 ]
alter @VD11[PWL] = [ 0n 0.0 5n 0.0 5n 0.0 10n 0.0 10n 0.0 15n 0.0 15n 0.0 20n 0.0 20n 0.0 25n 0.0 25n 0.0 30n 0.0 30n 0.0 35n 0.0 35n 0.0 40n 0.0 40n 0.0 45n 0.0 45n 0.0 50n 0.0 50n 0.0 55n 0.0 55n 0.0 60n 0.0 60n 0.0 65n 0.0 65n 0.0 70n 0.0 70n 0.0 75n 0.0 75n 0.0 80n 0.0 80n 0.0 85n 0.0 85n 0.0 90n 0.0 90n 0.0 95n 0.0 95n 0.0 100n 0.0 100n 0.0 105n 0.0 105n 0.0 110n 0.0 110n 0.0 115n 0.0 115n 0.0 120n 0.0 120n 0.0 125n 0.0 125n 0.0 130n 0.0 130n 0.0 135n 0.0 135n 0.0 140n 0.0 140n 0.0 145n 0.0 145n 0.0 150n 0.0 150n 0.0 155n 0.0 155n 0.0 160n 0.0 ]
alter @VD10[PWL] = [ 0n 0.0 5n 0.0 5n 0.0 10n 0.0 10n 0.0 15n 0.0 15n 0.0 20n 0.0 20n 0.0 25n 0.0 25n 0.0 30n 0.0 30n 0.0 35n 0.0 35n 0.0 40n 0.0 40n 0.0 45n 0.0 45n 0.0 50n 0.0 50n 0.0 55n 0.0 55n 0.0 60n 0.0 60n 0.0 65n 0.0 65n 0.0 70n 0.0 70n 0.0 75n 0.0 75n 0.0 80n 0.0 80n 0.0 85n 0.0 85n 0.0 90n 0.0 90n 0.0 95n 0.0 95n 0.0 100n 0.0 100n 0.0 105n 0.0 105n 0.0 110n 0.0 110n 0.0 115n 0.0 115n 0.0 120n 0.0 120n 0.0 125n 0.0 125n 0.0 130n 0.0 130n 0.0 135n 0.0 135n 0.0 140n 0.0 140n 0.0 145n 0.0 145n 0.0 150n 0.0 150n 0.0 155n 0.0 155n 0.0 160n 0.0 ]
alter @VD9[PWL] = [ 0n 0.0 5n 0.0 5n 0.0 10n 0.0 10n 0.0 15n 0.0 15n 0.0 20n 0.0 20n 0.0 25n 0.0 25n 0.0 30n 0.0 30n 0.0 35n 0.0 35n 0.0 40n 0.0 40n 0.0 45n 0.0 45n 0.0 50n 0.0 50n 0.0 55n 0.0 55n 0.0 60n 0.0 60n 0.0 65n 0.0 65n 0.0 70n 0.0 70n 0.0 75n 0.0 75n 0.0 80n 0.0 80n 0.0 85n 0.0 85n 0.0 90n 0.0 90n 0.0 95n 0.0 95n 0.0 100n 0.0 100n 0.0 105n 0.0 105n 0.0 110n 0.0 110n 0.0 115n 0.0 115n 0.0 120n 0.0 120n 0.0 125n 0.0 125n 0.0 130n 0.0 130n 0.0 135n 0.0 135n 0.0 140n 0.0 140n 0.0 145n 0.0 145n 0.0 150n 0.0 150n 0.0 155n 0.0 155n 0.0 160n 0.0 ]
alter @VD8[PWL] = [ 0n 0.0 5n 0.0 5n 0.0 10n 0.0 10n 0.0 15n 0.0 15n 0.0 20n 0.0 20n 0.0 25n 0.0 25n 0.0 30n 0.0 30n 0.0 35n 0.0 35n 0.0 40n 0.0 40n 0.0 45n 0.0 45n 0.0 50n 0.0 50n 0.0 55n 0.0 55n 0.0 60n 0.0 60n 0.0 65n 0.0 65n 0.0 70n 0.0 70n 0.0 75n 0.0 75n 0.0 80n 0.0 80n 0.0 85n 0.0 85n 0.0 90n 0.0 90n 0.0 95n 0.0 95n 0.0 100n 0.0 100n 0.0 105n 0.0 105n 0.0 110n 0.0 110n 0.0 115n 0.0 115n 0.0 120n 0.0 120n 0.0 125n 0.0 125n 0.0 130n 0.0 130n 0.0 135n 0.0 135n 0.0 140n 0.0 140n 0.0 145n 0.0 145n 0.0 150n 0.0 150n 0.0 155n 0.0 155n 0.0 160n 0.0 ]
alter @VD7[PWL] = [ 0n 3.3 5n 3.3 5n 3.3 10n 3.3 10n 3.3 15n 3.3 15n 3.3 20n 3.3 20n 3.3 25n 3.3 25n 3.3 30n 3.3 30n 3.3 35n 3.3 35n 3.3 40n 3.3 40n 3.3 45n 3.3 45n 3.3 50n 3.3 50n 3.3 55n 3.3 55n 3.3 60n 3.3 60n 3.3 65n 3.3 65n 3.3 70n 3.3 70n 3.3 75n 3.3 75n 3.3 80n 3.3 80n 3.3 85n 3.3 85n 3.3 90n 3.3 90n 3.3 95n 3.3 95n 3.3 100n 3.3 100n 3.3 105n 3.3 105n 3.3 110n 3.3 110n 3.3 115n 3.3 115n 3.3 120n 3.3 120n 3.3 125n 3.3 125n 3.3 130n 3.3 130n 3.3 135n 3.3 135n 3.3 140n 3.3 140n 3.3 145n 3.3 145n 3.3 150n 3.3 150n 3.3 155n 3.3 155n 3.3 160n 3.3 ]
alter @VD6[PWL] = [ 0n 0.0 5n 0.0 5n 0.0 10n 0.0 10n 0.0 15n 0.0 15n 0.0 20n 0.0 20n 0.0 25n 0.0 25n 0.0 30n 0.0 30n 0.0 35n 0.0 35n 0.0 40n 0.0 40n 0.0 45n 0.0 45n 0.0 50n 0.0 50n 0.0 55n 0.0 55n 0.0 60n 0.0 60n 0.0 65n 0.0 65n 0.0 70n 0.0 70n 0.0 75n 0.0 75n 0.0 80n 0.0 80n 0.0 85n 0.0 85n 0.0 90n 0.0 90n 0.0 95n 0.0 95n 0.0 100n 0.0 100n 0.0 105n 0.0 105n 0.0 110n 0.0 110n 0.0 115n 0.0 115n 0.0 120n 0.0 120n 0.0 125n 0.0 125n 0.0 130n 0.0 130n 0.0 135n 0.0 135n 0.0 140n 0.0 140n 0.0 145n 0.0 145n 0.0 150n 0.0 150n 0.0 155n 0.0 155n 0.0 160n 0.0 ]
alter @VD5[PWL] = [ 0n 3.3 5n 3.3 5n 3.3 10n 3.3 10n 3.3 15n 3.3 15n 3.3 20n 3.3 20n 3.3 25n 3.3 25n 3.3 30n 3.3 30n 3.3 35n 3.3 35n 3.3 40n 3.3 40n 3.3 45n 3.3 45n 3.3 50n 3.3 50n 3.3 55n 3.3 55n 3.3 60n 3.3 60n 3.3 65n 3.3 65n 3.3 70n 3.3 70n 3.3 75n 3.3 75n 3.3 80n 3.3 80n 3.3 85n 3.3 85n 3.3 90n 3.3 90n 3.3 95n 3.3 95n 3.3 100n 3.3 100n 3.3 105n 3.3 105n 3.3 110n 3.3 110n 3.3 115n 3.3 115n 3.3 120n 3.3 120n 3.3 125n 3.3 125n 3.3 130n 3.3 130n 3.3 135n 3.3 135n 3.3 140n 3.3 140n 3.3 145n 3.3 145n 3.3 150n 3.3 150n 3.3 155n 3.3 155n 3.3 160n 3.3 ]
alter @VD4[PWL] = [ 0n 0.0 5n 0.0 5n 0.0 10n 0.0 10n 0.0 15n 0.0 15n 0.0 20n 0.0 20n 0.0 25n 0.0 25n 0.0 30n 0.0 30n 0.0 35n 0.0 35n 0.0 40n 0.0 40n 0.0 45n 0.0 45n 0.0 50n 0.0 50n 0.0 55n 0.0 55n 0.0 60n 0.0 60n 0.0 65n 0.0 65n 0.0 70n 0.0 70n 0.0 75n 0.0 75n 0.0 80n 0.0 80n 0.0 85n 0.0 85n 0.0 90n 0.0 90n 0.0 95n 0.0 95n 0.0 100n 0.0 100n 0.0 105n 0.0 105n 0.0 110n 0.0 110n 0.0 115n 0.0 115n 0.0 120n 0.0 120n 0.0 125n 0.0 125n 0.0 130n 0.0 130n 0.0 135n 0.0 135n 0.0 140n 0.0 140n 0.0 145n 0.0 145n 0.0 150n 0.0 150n 0.0 155n 0.0 155n 0.0 160n 0.0 ]
alter @VD3[PWL] = [ 0n 3.3 5n 3.3 5n 3.3 10n 3.3 10n 3.3 15n 3.3 15n 3.3 20n 3.3 20n 3.3 25n 3.3 25n 3.3 30n 3.3 30n 3.3 35n 3.3 35n 3.3 40n 3.3 40n 3.3 45n 3.3 45n 3.3 50n 3.3 50n 3.3 55n 3.3 55n 3.3 60n 3.3 60n 3.3 65n 3.3 65n 3.3 70n 3.3 70n 3.3 75n 3.3 75n 3.3 80n 3.3 80n 3.3 85n 3.3 85n 3.3 90n 3.3 90n 3.3 95n 3.3 95n 3.3 100n 3.3 100n 3.3 105n 3.3 105n 3.3 110n 3.3 110n 3.3 115n 3.3 115n 3.3 120n 3.3 120n 3.3 125n 3.3 125n 3.3 130n 3.3 130n 3.3 135n 3.3 135n 3.3 140n 3.3 140n 3.3 145n 3.3 145n 3.3 150n 3.3 150n 3.3 155n 3.3 155n 3.3 160n 3.3 ]
alter @VD2[PWL] = [ 0n 0.0 5n 0.0 5n 0.0 10n 0.0 10n 0.0 15n 0.0 15n 0.0 20n 0.0 20n 0.0 25n 0.0 25n 0.0 30n 0.0 30n 0.0 35n 0.0 35n 0.0 40n 0.0 40n 0.0 45n 0.0 45n 0.0 50n 0.0 50n 0.0 55n 0.0 55n 0.0 60n 0.0 60n 0.0 65n 0.0 65n 0.0 70n 0.0 70n 0.0 75n 0.0 75n 0.0 80n 0.0 80n 0.0 85n 0.0 85n 0.0 90n 0.0 90n 0.0 95n 0.0 95n 0.0 100n 0.0 100n 0.0 105n 0.0 105n 0.0 110n 0.0 110n 0.0 115n 0.0 115n 0.0 120n 0.0 120n 0.0 125n 0.0 125n 0.0 130n 0.0 130n 0.0 135n 0.0 135n 0.0 140n 0.0 140n 0.0 145n 0.0 145n 0.0 150n 0.0 150n 0.0 155n 0.0 155n 0.0 160n 0.0 ]
alter @VD1[PWL] = [ 0n 3.3 5n 3.3 5n 3.3 10n 3.3 10n 3.3 15n 3.3 15n 3.3 20n 3.3 20n 3.3 25n 3.3 25n 3.3 30n 3.3 30n 3.3 35n 3.3 35n 3.3 40n 3.3 40n 3.3 45n 3.3 45n 3.3 50n 3.3 50n 3.3 55n 3.3 55n 3.3 60n 3.3 60n 3.3 65n 3.3 65n 3.3 70n 3.3 70n 3.3 75n 3.3 75n 3.3 80n 3.3 80n 3.3 85n 3.3 85n 3.3 90n 3.3 90n 3.3 95n 3.3 95n 3.3 100n 3.3 100n 3.3 105n 3.3 105n 3.3 110n 3.3 110n 3.3 115n 3.3 115n 3.3 120n 3.3 120n 3.3 125n 3.3 125n 3.3 130n 3.3 130n 3.3 135n 3.3 135n 3.3 140n 3.3 140n 3.3 145n 3.3 145n 3.3 150n 3.3 150n 3.3 155n 3.3 155n 3.3 160n 3.3 ]
alter @VD0[PWL] = [ 0n 0.0 5n 0.0 5n 0.0 10n 0.0 10n 0.0 15n 0.0 15n 0.0 20n 0.0 20n 0.0 25n 0.0 25n 0.0 30n 0.0 30n 0.0 35n 0.0 35n 0.0 40n 0.0 40n 0.0 45n 0.0 45n 0.0 50n 0.0 50n 0.0 55n 0.0 55n 0.0 60n 0.0 60n 0.0 65n 0.0 65n 0.0 70n 0.0 70n 0.0 75n 0.0 75n 0.0 80n 0.0 80n 0.0 85n 0.0 85n 0.0 90n 0.0 90n 0.0 95n 0.0 95n 0.0 100n 0.0 100n 0.0 105n 0.0 105n 0.0 110n 0.0 110n 0.0 115n 0.0 115n 0.0 120n 0.0 120n 0.0 125n 0.0 125n 0.0 130n 0.0 130n 0.0 135n 0.0 135n 0.0 140n 0.0 140n 0.0 145n 0.0 145n 0.0 150n 0.0 150n 0.0 155n 0.0 155n 0.0 160n 0.0 ]

** R BUS
alter @VR3[PWL] = [ 0n 0.0 5n 0.0 5n 0.0 10n 0.0 10n 0.0 15n 0.0 15n 0.0 20n 0.0 20n 0.0 25n 0.0 25n 0.0 30n 0.0 30n 0.0 35n 0.0 35n 0.0 40n 0.0 40n 0.0 45n 0.0 45n 0.0 50n 0.0 50n 0.0 55n 0.0 55n 0.0 60n 0.0 60n 0.0 65n 0.0 65n 0.0 70n 0.0 70n 0.0 75n 0.0 75n 0.0 80n 0.0 80n 3.3 85n 3.3 85n 3.3 90n 3.3 90n 3.3 95n 3.3 95n 3.3 100n 3.3 100n 3.3 105n 3.3 105n 3.3 110n 3.3 110n 3.3 115n 3.3 115n 3.3 120n 3.3 120n 3.3 125n 3.3 125n 3.3 130n 3.3 130n 3.3 135n 3.3 135n 3.3 140n 3.3 140n 3.3 145n 3.3 145n 3.3 150n 3.3 150n 3.3 155n 3.3 155n 3.3 160n 3.3 ]
alter @VR2[PWL] = [ 0n 0.0 5n 0.0 5n 0.0 10n 0.0 10n 0.0 15n 0.0 15n 0.0 20n 0.0 20n 0.0 25n 0.0 25n 0.0 30n 0.0 30n 0.0 35n 0.0 35n 0.0 40n 0.0 40n 3.3 45n 3.3 45n 3.3 50n 3.3 50n 3.3 55n 3.3 55n 3.3 60n 3.3 60n 3.3 65n 3.3 65n 3.3 70n 3.3 70n 3.3 75n 3.3 75n 3.3 80n 3.3 80n 0.0 85n 0.0 85n 0.0 90n 0.0 90n 0.0 95n 0.0 95n 0.0 100n 0.0 100n 0.0 105n 0.0 105n 0.0 110n 0.0 110n 0.0 115n 0.0 115n 0.0 120n 0.0 120n 3.3 125n 3.3 125n 3.3 130n 3.3 130n 3.3 135n 3.3 135n 3.3 140n 3.3 140n 3.3 145n 3.3 145n 3.3 150n 3.3 150n 3.3 155n 3.3 155n 3.3 160n 3.3 ]
alter @VR1[PWL] = [ 0n 0.0 5n 0.0 5n 0.0 10n 0.0 10n 0.0 15n 0.0 15n 0.0 20n 0.0 20n 3.3 25n 3.3 25n 3.3 30n 3.3 30n 3.3 35n 3.3 35n 3.3 40n 3.3 40n 0.0 45n 0.0 45n 0.0 50n 0.0 50n 0.0 55n 0.0 55n 0.0 60n 0.0 60n 3.3 65n 3.3 65n 3.3 70n 3.3 70n 3.3 75n 3.3 75n 3.3 80n 3.3 80n 0.0 85n 0.0 85n 0.0 90n 0.0 90n 0.0 95n 0.0 95n 0.0 100n 0.0 100n 3.3 105n 3.3 105n 3.3 110n 3.3 110n 3.3 115n 3.3 115n 3.3 120n 3.3 120n 0.0 125n 0.0 125n 0.0 130n 0.0 130n 0.0 135n 0.0 135n 0.0 140n 0.0 140n 3.3 145n 3.3 145n 3.3 150n 3.3 150n 3.3 155n 3.3 155n 3.3 160n 3.3 ]
alter @VR0[PWL] = [ 0n 0.0 5n 0.0 5n 0.0 10n 0.0 10n 3.3 15n 3.3 15n 3.3 20n 3.3 20n 0.0 25n 0.0 25n 0.0 30n 0.0 30n 3.3 35n 3.3 35n 3.3 40n 3.3 40n 0.0 45n 0.0 45n 0.0 50n 0.0 50n 3.3 55n 3.3 55n 3.3 60n 3.3 60n 0.0 65n 0.0 65n 0.0 70n 0.0 70n 3.3 75n 3.3 75n 3.3 80n 3.3 80n 0.0 85n 0.0 85n 0.0 90n 0.0 90n 3.3 95n 3.3 95n 3.3 100n 3.3 100n 0.0 105n 0.0 105n 0.0 110n 0.0 110n 3.3 115n 3.3 115n 3.3 120n 3.3 120n 0.0 125n 0.0 125n 0.0 130n 0.0 130n 3.3 135n 3.3 135n 3.3 140n 3.3 140n 0.0 145n 0.0 145n 0.0 150n 0.0 150n 3.3 155n 3.3 155n 3.3 160n 3.3 ]

** I BUS
alter @VI3[PWL] = [ 0n 0.0 5n 0.0 5n 0.0 10n 0.0 10n 0.0 15n 0.0 15n 0.0 20n 0.0 20n 0.0 25n 0.0 25n 0.0 30n 0.0 30n 0.0 35n 0.0 35n 0.0 40n 0.0 40n 0.0 45n 0.0 45n 0.0 50n 0.0 50n 0.0 55n 0.0 55n 0.0 60n 0.0 60n 0.0 65n 0.0 65n 0.0 70n 0.0 70n 0.0 75n 0.0 75n 0.0 80n 0.0 80n 0.0 85n 0.0 85n 0.0 90n 0.0 90n 0.0 95n 0.0 95n 0.0 100n 0.0 100n 0.0 105n 0.0 105n 0.0 110n 0.0 110n 0.0 115n 0.0 115n 0.0 120n 0.0 120n 0.0 125n 0.0 125n 0.0 130n 0.0 130n 0.0 135n 0.0 135n 0.0 140n 0.0 140n 0.0 145n 0.0 145n 0.0 150n 0.0 150n 0.0 155n 0.0 155n 0.0 160n 0.0 ]
alter @VI2[PWL] = [ 0n 0.0 5n 0.0 5n 0.0 10n 0.0 10n 0.0 15n 0.0 15n 0.0 20n 0.0 20n 0.0 25n 0.0 25n 0.0 30n 0.0 30n 0.0 35n 0.0 35n 0.0 40n 0.0 40n 0.0 45n 0.0 45n 0.0 50n 0.0 50n 0.0 55n 0.0 55n 0.0 60n 0.0 60n 0.0 65n 0.0 65n 0.0 70n 0.0 70n 0.0 75n 0.0 75n 0.0 80n 0.0 80n 0.0 85n 0.0 85n 0.0 90n 0.0 90n 0.0 95n 0.0 95n 0.0 100n 0.0 100n 0.0 105n 0.0 105n 0.0 110n 0.0 110n 0.0 115n 0.0 115n 0.0 120n 0.0 120n 0.0 125n 0.0 125n 0.0 130n 0.0 130n 0.0 135n 0.0 135n 0.0 140n 0.0 140n 0.0 145n 0.0 145n 0.0 150n 0.0 150n 0.0 155n 0.0 155n 0.0 160n 0.0 ]
alter @VI1[PWL] = [ 0n 0.0 5n 0.0 5n 0.0 10n 0.0 10n 0.0 15n 0.0 15n 0.0 20n 0.0 20n 0.0 25n 0.0 25n 0.0 30n 0.0 30n 0.0 35n 0.0 35n 0.0 40n 0.0 40n 0.0 45n 0.0 45n 0.0 50n 0.0 50n 0.0 55n 0.0 55n 0.0 60n 0.0 60n 0.0 65n 0.0 65n 0.0 70n 0.0 70n 0.0 75n 0.0 75n 0.0 80n 0.0 80n 0.0 85n 0.0 85n 0.0 90n 0.0 90n 0.0 95n 0.0 95n 0.0 100n 0.0 100n 0.0 105n 0.0 105n 0.0 110n 0.0 110n 0.0 115n 0.0 115n 0.0 120n 0.0 120n 0.0 125n 0.0 125n 0.0 130n 0.0 130n 0.0 135n 0.0 135n 0.0 140n 0.0 140n 0.0 145n 0.0 145n 0.0 150n 0.0 150n 0.0 155n 0.0 155n 0.0 160n 0.0 ]
alter @VI0[PWL] = [ 0n 0.0 5n 0.0 5n 0.0 10n 0.0 10n 0.0 15n 0.0 15n 0.0 20n 0.0 20n 0.0 25n 0.0 25n 0.0 30n 0.0 30n 0.0 35n 0.0 35n 0.0 40n 0.0 40n 0.0 45n 0.0 45n 0.0 50n 0.0 50n 0.0 55n 0.0 55n 0.0 60n 0.0 60n 0.0 65n 0.0 65n 0.0 70n 0.0 70n 0.0 75n 0.0 75n 0.0 80n 0.0 80n 0.0 85n 0.0 85n 0.0 90n 0.0 90n 0.0 95n 0.0 95n 0.0 100n 0.0 100n 0.0 105n 0.0 105n 0.0 110n 0.0 110n 0.0 115n 0.0 115n 0.0 120n 0.0 120n 0.0 125n 0.0 125n 0.0 130n 0.0 130n 0.0 135n 0.0 135n 0.0 140n 0.0 140n 0.0 145n 0.0 145n 0.0 150n 0.0 150n 0.0 155n 0.0 155n 0.0 160n 0.0 ]

** CONTROL
alter @VSEL[PWL] = [ 0n 0.0 5n 0.0 5n 3.3 10n 3.3 10n 0.0 15n 0.0 15n 3.3 20n 3.3 20n 0.0 25n 0.0 25n 3.3 30n 3.3 30n 0.0 35n 0.0 35n 3.3 40n 3.3 40n 0.0 45n 0.0 45n 3.3 50n 3.3 50n 0.0 55n 0.0 55n 3.3 60n 3.3 60n 0.0 65n 0.0 65n 3.3 70n 3.3 70n 0.0 75n 0.0 75n 3.3 80n 3.3 80n 0.0 85n 0.0 85n 3.3 90n 3.3 90n 0.0 95n 0.0 95n 3.3 100n 3.3 100n 0.0 105n 0.0 105n 3.3 110n 3.3 110n 0.0 115n 0.0 115n 3.3 120n 3.3 120n 0.0 125n 0.0 125n 3.3 130n 3.3 130n 0.0 135n 0.0 135n 3.3 140n 3.3 140n 0.0 145n 0.0 145n 3.3 150n 3.3 150n 0.0 155n 0.0 155n 3.3 160n 3.3 ]

tran 0.005n 160n

write shifter_tb.raw

.endc
