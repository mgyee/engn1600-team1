** sch_path: /foss/designs/engn1600-team1/CAD5/inv.sch
.subckt inv VDD IN OUT VSS
*.PININFO IN:I OUT:O VDD:B VSS:B
M1 OUT IN VDD VDD pfet_03v3 L=0.28u W='1*0.72u' nf=1 m=1
M2 OUT IN VSS VSS nfet_03v3 L=0.28u W='1*0.36u' nf=1 m=1
**** begin user architecture code

.param kSELb=1

**** end user architecture code
.ends
