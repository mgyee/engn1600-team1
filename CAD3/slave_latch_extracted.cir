* Extracted by KLayout with GF180MCU LVS runset on : 22/02/2026 01:42

.SUBCKT slave_latch VSS RB WECLK QAb QBb RA D VDD WECLKb
M$1 VDD RB \$14 VDD pfet_03v3 L=0.28U W=0.72U AS=0.3708P AD=0.3168P PS=2.47U
+ PD=2.32U
M$2 \$2 D VDD VDD pfet_03v3 L=0.28U W=0.72U AS=0.3168P AD=0.2097P PS=2.32U
+ PD=1.38U
M$3 \$3 WECLKb \$2 VDD pfet_03v3 L=0.28U W=0.36U AS=0.2097P AD=0.1278P PS=1.38U
+ PD=1.07U
M$4 \$25 \$4 \$3 VDD pfet_03v3 L=0.28U W=0.36U AS=0.1278P AD=0.0567P PS=1.07U
+ PD=0.675U
M$5 VDD WECLK \$25 VDD pfet_03v3 L=0.28U W=0.36U AS=0.0567P AD=0.1584P
+ PS=0.675U PD=1.6U
M$6 \$4 \$3 VDD VDD pfet_03v3 L=0.28U W=0.36U AS=0.1764P AD=0.1584P PS=1.26U
+ PD=1.6U
M$7 \$5 \$3 VDD VDD pfet_03v3 L=0.28U W=0.72U AS=0.1764P AD=0.36P PS=1.26U
+ PD=2.44U
M$8 \$11 RA VDD VDD pfet_03v3 L=0.28U W=0.72U AS=0.3312P AD=0.3888P PS=2.36U
+ PD=2.52U
M$9 \$5 \$11 QAb VDD pfet_03v3 L=0.28U W=0.36U AS=0.1584P AD=0.1152P PS=1.6U
+ PD=1U
M$10 QBb \$14 \$5 VDD pfet_03v3 L=0.28U W=0.36U AS=0.1152P AD=0.1584P PS=1U
+ PD=1.6U
M$11 VSS RB \$14 VSS nfet_03v3 L=0.28U W=0.36U AS=0.1854P AD=0.1584P PS=1.75U
+ PD=1.6U
M$12 \$2 D VSS VSS nfet_03v3 L=0.28U W=0.36U AS=0.1584P AD=0.1188P PS=1.6U
+ PD=1.02U
M$13 \$3 WECLK \$2 VSS nfet_03v3 L=0.28U W=0.36U AS=0.1188P AD=0.1278P PS=1.02U
+ PD=1.07U
M$14 \$7 \$4 \$3 VSS nfet_03v3 L=0.28U W=0.36U AS=0.1278P AD=0.0567P PS=1.07U
+ PD=0.675U
M$15 VSS WECLKb \$7 VSS nfet_03v3 L=0.28U W=0.36U AS=0.0567P AD=0.1584P
+ PS=0.675U PD=1.6U
M$16 \$5 RA QAb VSS nfet_03v3 L=0.28U W=0.36U AS=0.1584P AD=0.1152P PS=1.6U
+ PD=1U
M$17 QBb RB \$5 VSS nfet_03v3 L=0.28U W=0.36U AS=0.1152P AD=0.1584P PS=1U
+ PD=1.6U
M$18 VSS \$3 \$4 VSS nfet_03v3 L=0.28U W=0.36U AS=0.1584P AD=0.0972P PS=1.6U
+ PD=0.9U
M$19 \$5 \$3 VSS VSS nfet_03v3 L=0.28U W=0.36U AS=0.0972P AD=0.18P PS=0.9U
+ PD=1.72U
M$20 \$11 RA VSS VSS nfet_03v3 L=0.28U W=0.36U AS=0.1656P AD=0.1944P PS=1.64U
+ PD=1.8U
.ENDS slave_latch
