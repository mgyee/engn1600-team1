* Extracted by KLayout with GF180MCU LVS runset on : 26/02/2026 21:50

.SUBCKT rf VSS QB2 QB3 QB7 QB9 QB10 QB11 QB12 QB15 VDD QA0 QB0 QA1 QB1 QA2 QA3
+ QA4 QB4 QA5 QB5 QA6 QB6 QA7 QA8 QB8 QA9 QA10 QA11 QA12 QA13 QB13 QA14 QB14
+ QA15 WEM D0 D1 D2 D3 D4 D5 D6 D7 D8 D9 D10 D11 D12 D13 D14 D15 WE15 CLK RB15
+ RA15 WE14 RB14 RA14 WE13 RB13 RA13 WE12 RB12 RA12 WE11 RB11 RA11 WE10 RB10
+ RA10 WE9 RB9 RA9 WE8 RB8 RA8 WE7 RB7 RA7 WE6 RB6 RA6 WE5 RB5 RA5 WE4 RB4 RA4
+ WE3 RB3 RA3 WE2 RB2 RA2 WE1 RB1 RA1 WE0 RB0 RA0
M$1 VDD \$51 QA0 VDD pfet_03v3 L=0.28U W=0.72U AS=0.4104P AD=0.2484P PS=2.58U
+ PD=1.41U
M$2 QB0 \$52 VDD VDD pfet_03v3 L=0.28U W=0.72U AS=0.2484P AD=0.4104P PS=1.41U
+ PD=2.58U
M$3 VDD \$53 QA1 VDD pfet_03v3 L=0.28U W=0.72U AS=0.4104P AD=0.2484P PS=2.58U
+ PD=1.41U
M$4 QB1 \$54 VDD VDD pfet_03v3 L=0.28U W=0.72U AS=0.2484P AD=0.4104P PS=1.41U
+ PD=2.58U
M$5 VDD \$55 QA2 VDD pfet_03v3 L=0.28U W=0.72U AS=0.4104P AD=0.2484P PS=2.58U
+ PD=1.41U
M$6 QB2 \$56 VDD VDD pfet_03v3 L=0.28U W=0.72U AS=0.2484P AD=0.4104P PS=1.41U
+ PD=2.58U
M$7 VDD \$57 QA3 VDD pfet_03v3 L=0.28U W=0.72U AS=0.4104P AD=0.2484P PS=2.58U
+ PD=1.41U
M$8 QB3 \$58 VDD VDD pfet_03v3 L=0.28U W=0.72U AS=0.2484P AD=0.4104P PS=1.41U
+ PD=2.58U
M$9 VDD \$59 QA4 VDD pfet_03v3 L=0.28U W=0.72U AS=0.4104P AD=0.2484P PS=2.58U
+ PD=1.41U
M$10 QB4 \$60 VDD VDD pfet_03v3 L=0.28U W=0.72U AS=0.2484P AD=0.4104P PS=1.41U
+ PD=2.58U
M$11 VDD \$61 QA5 VDD pfet_03v3 L=0.28U W=0.72U AS=0.4104P AD=0.2484P PS=2.58U
+ PD=1.41U
M$12 QB5 \$62 VDD VDD pfet_03v3 L=0.28U W=0.72U AS=0.2484P AD=0.4104P PS=1.41U
+ PD=2.58U
M$13 VDD \$63 QA6 VDD pfet_03v3 L=0.28U W=0.72U AS=0.4104P AD=0.2484P PS=2.58U
+ PD=1.41U
M$14 QB6 \$64 VDD VDD pfet_03v3 L=0.28U W=0.72U AS=0.2484P AD=0.4104P PS=1.41U
+ PD=2.58U
M$15 VDD \$65 QA7 VDD pfet_03v3 L=0.28U W=0.72U AS=0.4104P AD=0.2484P PS=2.58U
+ PD=1.41U
M$16 QB7 \$66 VDD VDD pfet_03v3 L=0.28U W=0.72U AS=0.2484P AD=0.4104P PS=1.41U
+ PD=2.58U
M$17 VDD \$67 QA8 VDD pfet_03v3 L=0.28U W=0.72U AS=0.4104P AD=0.2484P PS=2.58U
+ PD=1.41U
M$18 QB8 \$68 VDD VDD pfet_03v3 L=0.28U W=0.72U AS=0.2484P AD=0.4104P PS=1.41U
+ PD=2.58U
M$19 VDD \$69 QA9 VDD pfet_03v3 L=0.28U W=0.72U AS=0.4104P AD=0.2484P PS=2.58U
+ PD=1.41U
M$20 QB9 \$70 VDD VDD pfet_03v3 L=0.28U W=0.72U AS=0.2484P AD=0.4104P PS=1.41U
+ PD=2.58U
M$21 VDD \$71 QA10 VDD pfet_03v3 L=0.28U W=0.72U AS=0.4104P AD=0.2484P PS=2.58U
+ PD=1.41U
M$22 QB10 \$72 VDD VDD pfet_03v3 L=0.28U W=0.72U AS=0.2484P AD=0.4104P PS=1.41U
+ PD=2.58U
M$23 VDD \$73 QA11 VDD pfet_03v3 L=0.28U W=0.72U AS=0.4104P AD=0.2484P PS=2.58U
+ PD=1.41U
M$24 QB11 \$74 VDD VDD pfet_03v3 L=0.28U W=0.72U AS=0.2484P AD=0.4104P PS=1.41U
+ PD=2.58U
M$25 VDD \$75 QA12 VDD pfet_03v3 L=0.28U W=0.72U AS=0.4104P AD=0.2484P PS=2.58U
+ PD=1.41U
M$26 QB12 \$76 VDD VDD pfet_03v3 L=0.28U W=0.72U AS=0.2484P AD=0.4104P PS=1.41U
+ PD=2.58U
M$27 VDD \$77 QA13 VDD pfet_03v3 L=0.28U W=0.72U AS=0.4104P AD=0.2484P PS=2.58U
+ PD=1.41U
M$28 QB13 \$78 VDD VDD pfet_03v3 L=0.28U W=0.72U AS=0.2484P AD=0.4104P PS=1.41U
+ PD=2.58U
M$29 VDD \$79 QA14 VDD pfet_03v3 L=0.28U W=0.72U AS=0.4104P AD=0.2484P PS=2.58U
+ PD=1.41U
M$30 QB14 \$80 VDD VDD pfet_03v3 L=0.28U W=0.72U AS=0.2484P AD=0.4104P PS=1.41U
+ PD=2.58U
M$31 VDD \$81 QA15 VDD pfet_03v3 L=0.28U W=0.72U AS=0.4104P AD=0.2484P PS=2.58U
+ PD=1.41U
M$32 QB15 \$82 VDD VDD pfet_03v3 L=0.28U W=0.72U AS=0.2484P AD=0.4104P PS=1.41U
+ PD=2.58U
M$33 \$105 WEM VDD VDD pfet_03v3 L=0.28U W=2.52U AS=0.9198P AD=0.9198P PS=5.24U
+ PD=5.24U
M$35 \$106 \$219 VDD VDD pfet_03v3 L=0.28U W=2.48U AS=0.868P AD=0.868P PS=5.12U
+ PD=5.12U
M$37 \$107 \$219 VDD VDD pfet_03v3 L=0.28U W=0.36U AS=0.1584P AD=0.1584P
+ PS=1.6U PD=1.6U
M$38 \$157 WEM VDD VDD pfet_03v3 L=0.28U W=0.36U AS=0.1584P AD=0.0567P PS=1.6U
+ PD=0.675U
M$39 \$219 \$107 \$157 VDD pfet_03v3 L=0.28U W=0.36U AS=0.0567P AD=0.1278P
+ PS=0.675U PD=1.07U
M$40 \$108 \$105 \$219 VDD pfet_03v3 L=0.28U W=0.36U AS=0.1278P AD=0.2097P
+ PS=1.07U PD=1.38U
M$41 VDD D0 \$108 VDD pfet_03v3 L=0.28U W=0.72U AS=0.2097P AD=0.3168P PS=1.38U
+ PD=2.32U
M$42 \$109 \$221 VDD VDD pfet_03v3 L=0.28U W=2.48U AS=0.868P AD=0.868P PS=5.12U
+ PD=5.12U
M$44 \$110 \$221 VDD VDD pfet_03v3 L=0.28U W=0.36U AS=0.1584P AD=0.1584P
+ PS=1.6U PD=1.6U
M$45 \$163 WEM VDD VDD pfet_03v3 L=0.28U W=0.36U AS=0.1584P AD=0.0567P PS=1.6U
+ PD=0.675U
M$46 \$221 \$110 \$163 VDD pfet_03v3 L=0.28U W=0.36U AS=0.0567P AD=0.1278P
+ PS=0.675U PD=1.07U
M$47 \$111 \$105 \$221 VDD pfet_03v3 L=0.28U W=0.36U AS=0.1278P AD=0.2097P
+ PS=1.07U PD=1.38U
M$48 VDD D1 \$111 VDD pfet_03v3 L=0.28U W=0.72U AS=0.2097P AD=0.3168P PS=1.38U
+ PD=2.32U
M$49 \$112 \$223 VDD VDD pfet_03v3 L=0.28U W=2.48U AS=0.868P AD=0.868P PS=5.12U
+ PD=5.12U
M$51 \$113 \$223 VDD VDD pfet_03v3 L=0.28U W=0.36U AS=0.1584P AD=0.1584P
+ PS=1.6U PD=1.6U
M$52 \$169 WEM VDD VDD pfet_03v3 L=0.28U W=0.36U AS=0.1584P AD=0.0567P PS=1.6U
+ PD=0.675U
M$53 \$223 \$113 \$169 VDD pfet_03v3 L=0.28U W=0.36U AS=0.0567P AD=0.1278P
+ PS=0.675U PD=1.07U
M$54 \$114 \$105 \$223 VDD pfet_03v3 L=0.28U W=0.36U AS=0.1278P AD=0.2097P
+ PS=1.07U PD=1.38U
M$55 VDD D2 \$114 VDD pfet_03v3 L=0.28U W=0.72U AS=0.2097P AD=0.3168P PS=1.38U
+ PD=2.32U
M$56 \$115 \$225 VDD VDD pfet_03v3 L=0.28U W=2.48U AS=0.868P AD=0.868P PS=5.12U
+ PD=5.12U
M$58 \$116 \$225 VDD VDD pfet_03v3 L=0.28U W=0.36U AS=0.1584P AD=0.1584P
+ PS=1.6U PD=1.6U
M$59 \$174 WEM VDD VDD pfet_03v3 L=0.28U W=0.36U AS=0.1584P AD=0.0567P PS=1.6U
+ PD=0.675U
M$60 \$225 \$116 \$174 VDD pfet_03v3 L=0.28U W=0.36U AS=0.0567P AD=0.1278P
+ PS=0.675U PD=1.07U
M$61 \$117 \$105 \$225 VDD pfet_03v3 L=0.28U W=0.36U AS=0.1278P AD=0.2097P
+ PS=1.07U PD=1.38U
M$62 VDD D3 \$117 VDD pfet_03v3 L=0.28U W=0.72U AS=0.2097P AD=0.3168P PS=1.38U
+ PD=2.32U
M$63 \$118 \$227 VDD VDD pfet_03v3 L=0.28U W=2.48U AS=0.868P AD=0.868P PS=5.12U
+ PD=5.12U
M$65 \$119 \$227 VDD VDD pfet_03v3 L=0.28U W=0.36U AS=0.1584P AD=0.1584P
+ PS=1.6U PD=1.6U
M$66 \$180 WEM VDD VDD pfet_03v3 L=0.28U W=0.36U AS=0.1584P AD=0.0567P PS=1.6U
+ PD=0.675U
M$67 \$227 \$119 \$180 VDD pfet_03v3 L=0.28U W=0.36U AS=0.0567P AD=0.1278P
+ PS=0.675U PD=1.07U
M$68 \$120 \$105 \$227 VDD pfet_03v3 L=0.28U W=0.36U AS=0.1278P AD=0.2097P
+ PS=1.07U PD=1.38U
M$69 VDD D4 \$120 VDD pfet_03v3 L=0.28U W=0.72U AS=0.2097P AD=0.3168P PS=1.38U
+ PD=2.32U
M$70 \$121 \$229 VDD VDD pfet_03v3 L=0.28U W=2.48U AS=0.868P AD=0.868P PS=5.12U
+ PD=5.12U
M$72 \$122 \$229 VDD VDD pfet_03v3 L=0.28U W=0.36U AS=0.1584P AD=0.1584P
+ PS=1.6U PD=1.6U
M$73 \$186 WEM VDD VDD pfet_03v3 L=0.28U W=0.36U AS=0.1584P AD=0.0567P PS=1.6U
+ PD=0.675U
M$74 \$229 \$122 \$186 VDD pfet_03v3 L=0.28U W=0.36U AS=0.0567P AD=0.1278P
+ PS=0.675U PD=1.07U
M$75 \$123 \$105 \$229 VDD pfet_03v3 L=0.28U W=0.36U AS=0.1278P AD=0.2097P
+ PS=1.07U PD=1.38U
M$76 VDD D5 \$123 VDD pfet_03v3 L=0.28U W=0.72U AS=0.2097P AD=0.3168P PS=1.38U
+ PD=2.32U
M$77 \$124 \$231 VDD VDD pfet_03v3 L=0.28U W=2.48U AS=0.868P AD=0.868P PS=5.12U
+ PD=5.12U
M$79 \$125 \$231 VDD VDD pfet_03v3 L=0.28U W=0.36U AS=0.1584P AD=0.1584P
+ PS=1.6U PD=1.6U
M$80 \$192 WEM VDD VDD pfet_03v3 L=0.28U W=0.36U AS=0.1584P AD=0.0567P PS=1.6U
+ PD=0.675U
M$81 \$231 \$125 \$192 VDD pfet_03v3 L=0.28U W=0.36U AS=0.0567P AD=0.1278P
+ PS=0.675U PD=1.07U
M$82 \$126 \$105 \$231 VDD pfet_03v3 L=0.28U W=0.36U AS=0.1278P AD=0.2097P
+ PS=1.07U PD=1.38U
M$83 VDD D6 \$126 VDD pfet_03v3 L=0.28U W=0.72U AS=0.2097P AD=0.3168P PS=1.38U
+ PD=2.32U
M$84 \$127 \$233 VDD VDD pfet_03v3 L=0.28U W=2.48U AS=0.868P AD=0.868P PS=5.12U
+ PD=5.12U
M$86 \$128 \$233 VDD VDD pfet_03v3 L=0.28U W=0.36U AS=0.1584P AD=0.1584P
+ PS=1.6U PD=1.6U
M$87 \$197 WEM VDD VDD pfet_03v3 L=0.28U W=0.36U AS=0.1584P AD=0.0567P PS=1.6U
+ PD=0.675U
M$88 \$233 \$128 \$197 VDD pfet_03v3 L=0.28U W=0.36U AS=0.0567P AD=0.1278P
+ PS=0.675U PD=1.07U
M$89 \$129 \$105 \$233 VDD pfet_03v3 L=0.28U W=0.36U AS=0.1278P AD=0.2097P
+ PS=1.07U PD=1.38U
M$90 VDD D7 \$129 VDD pfet_03v3 L=0.28U W=0.72U AS=0.2097P AD=0.3168P PS=1.38U
+ PD=2.32U
M$91 \$130 \$235 VDD VDD pfet_03v3 L=0.28U W=2.48U AS=0.868P AD=0.868P PS=5.12U
+ PD=5.12U
M$93 \$131 \$235 VDD VDD pfet_03v3 L=0.28U W=0.36U AS=0.1584P AD=0.1584P
+ PS=1.6U PD=1.6U
M$94 \$203 WEM VDD VDD pfet_03v3 L=0.28U W=0.36U AS=0.1584P AD=0.0567P PS=1.6U
+ PD=0.675U
M$95 \$235 \$131 \$203 VDD pfet_03v3 L=0.28U W=0.36U AS=0.0567P AD=0.1278P
+ PS=0.675U PD=1.07U
M$96 \$132 \$105 \$235 VDD pfet_03v3 L=0.28U W=0.36U AS=0.1278P AD=0.2097P
+ PS=1.07U PD=1.38U
M$97 VDD D8 \$132 VDD pfet_03v3 L=0.28U W=0.72U AS=0.2097P AD=0.3168P PS=1.38U
+ PD=2.32U
M$98 \$133 \$237 VDD VDD pfet_03v3 L=0.28U W=2.48U AS=0.868P AD=0.868P PS=5.12U
+ PD=5.12U
M$100 \$134 \$237 VDD VDD pfet_03v3 L=0.28U W=0.36U AS=0.1584P AD=0.1584P
+ PS=1.6U PD=1.6U
M$101 \$209 WEM VDD VDD pfet_03v3 L=0.28U W=0.36U AS=0.1584P AD=0.0567P PS=1.6U
+ PD=0.675U
M$102 \$237 \$134 \$209 VDD pfet_03v3 L=0.28U W=0.36U AS=0.0567P AD=0.1278P
+ PS=0.675U PD=1.07U
M$103 \$135 \$105 \$237 VDD pfet_03v3 L=0.28U W=0.36U AS=0.1278P AD=0.2097P
+ PS=1.07U PD=1.38U
M$104 VDD D9 \$135 VDD pfet_03v3 L=0.28U W=0.72U AS=0.2097P AD=0.3168P PS=1.38U
+ PD=2.32U
M$105 \$136 \$239 VDD VDD pfet_03v3 L=0.28U W=2.48U AS=0.868P AD=0.868P
+ PS=5.12U PD=5.12U
M$107 \$137 \$239 VDD VDD pfet_03v3 L=0.28U W=0.36U AS=0.1584P AD=0.1584P
+ PS=1.6U PD=1.6U
M$108 \$215 WEM VDD VDD pfet_03v3 L=0.28U W=0.36U AS=0.1584P AD=0.0567P PS=1.6U
+ PD=0.675U
M$109 \$239 \$137 \$215 VDD pfet_03v3 L=0.28U W=0.36U AS=0.0567P AD=0.1278P
+ PS=0.675U PD=1.07U
M$110 \$138 \$105 \$239 VDD pfet_03v3 L=0.28U W=0.36U AS=0.1278P AD=0.2097P
+ PS=1.07U PD=1.38U
M$111 VDD D10 \$138 VDD pfet_03v3 L=0.28U W=0.72U AS=0.2097P AD=0.3168P
+ PS=1.38U PD=2.32U
M$112 \$139 \$241 VDD VDD pfet_03v3 L=0.28U W=2.48U AS=0.868P AD=0.868P
+ PS=5.12U PD=5.12U
M$114 \$140 \$241 VDD VDD pfet_03v3 L=0.28U W=0.36U AS=0.1584P AD=0.1584P
+ PS=1.6U PD=1.6U
M$115 \$210 WEM VDD VDD pfet_03v3 L=0.28U W=0.36U AS=0.1584P AD=0.0567P PS=1.6U
+ PD=0.675U
M$116 \$241 \$140 \$210 VDD pfet_03v3 L=0.28U W=0.36U AS=0.0567P AD=0.1278P
+ PS=0.675U PD=1.07U
M$117 \$141 \$105 \$241 VDD pfet_03v3 L=0.28U W=0.36U AS=0.1278P AD=0.2097P
+ PS=1.07U PD=1.38U
M$118 VDD D11 \$141 VDD pfet_03v3 L=0.28U W=0.72U AS=0.2097P AD=0.3168P
+ PS=1.38U PD=2.32U
M$119 \$142 \$243 VDD VDD pfet_03v3 L=0.28U W=2.48U AS=0.868P AD=0.868P
+ PS=5.12U PD=5.12U
M$121 \$143 \$243 VDD VDD pfet_03v3 L=0.28U W=0.36U AS=0.1584P AD=0.1584P
+ PS=1.6U PD=1.6U
M$122 \$199 WEM VDD VDD pfet_03v3 L=0.28U W=0.36U AS=0.1584P AD=0.0567P PS=1.6U
+ PD=0.675U
M$123 \$243 \$143 \$199 VDD pfet_03v3 L=0.28U W=0.36U AS=0.0567P AD=0.1278P
+ PS=0.675U PD=1.07U
M$124 \$144 \$105 \$243 VDD pfet_03v3 L=0.28U W=0.36U AS=0.1278P AD=0.2097P
+ PS=1.07U PD=1.38U
M$125 VDD D12 \$144 VDD pfet_03v3 L=0.28U W=0.72U AS=0.2097P AD=0.3168P
+ PS=1.38U PD=2.32U
M$126 \$145 \$245 VDD VDD pfet_03v3 L=0.28U W=2.48U AS=0.868P AD=0.868P
+ PS=5.12U PD=5.12U
M$128 \$146 \$245 VDD VDD pfet_03v3 L=0.28U W=0.36U AS=0.1584P AD=0.1584P
+ PS=1.6U PD=1.6U
M$129 \$185 WEM VDD VDD pfet_03v3 L=0.28U W=0.36U AS=0.1584P AD=0.0567P PS=1.6U
+ PD=0.675U
M$130 \$245 \$146 \$185 VDD pfet_03v3 L=0.28U W=0.36U AS=0.0567P AD=0.1278P
+ PS=0.675U PD=1.07U
M$131 \$147 \$105 \$245 VDD pfet_03v3 L=0.28U W=0.36U AS=0.1278P AD=0.2097P
+ PS=1.07U PD=1.38U
M$132 VDD D13 \$147 VDD pfet_03v3 L=0.28U W=0.72U AS=0.2097P AD=0.3168P
+ PS=1.38U PD=2.32U
M$133 \$148 \$247 VDD VDD pfet_03v3 L=0.28U W=2.48U AS=0.868P AD=0.868P
+ PS=5.12U PD=5.12U
M$135 \$149 \$247 VDD VDD pfet_03v3 L=0.28U W=0.36U AS=0.1584P AD=0.1584P
+ PS=1.6U PD=1.6U
M$136 \$171 WEM VDD VDD pfet_03v3 L=0.28U W=0.36U AS=0.1584P AD=0.0567P PS=1.6U
+ PD=0.675U
M$137 \$247 \$149 \$171 VDD pfet_03v3 L=0.28U W=0.36U AS=0.0567P AD=0.1278P
+ PS=0.675U PD=1.07U
M$138 \$150 \$105 \$247 VDD pfet_03v3 L=0.28U W=0.36U AS=0.1278P AD=0.2097P
+ PS=1.07U PD=1.38U
M$139 VDD D14 \$150 VDD pfet_03v3 L=0.28U W=0.72U AS=0.2097P AD=0.3168P
+ PS=1.38U PD=2.32U
M$140 \$151 \$249 VDD VDD pfet_03v3 L=0.28U W=2.48U AS=0.868P AD=0.868P
+ PS=5.12U PD=5.12U
M$142 \$152 \$249 VDD VDD pfet_03v3 L=0.28U W=0.36U AS=0.1584P AD=0.1584P
+ PS=1.6U PD=1.6U
M$143 \$158 WEM VDD VDD pfet_03v3 L=0.28U W=0.36U AS=0.1584P AD=0.0567P PS=1.6U
+ PD=0.675U
M$144 \$249 \$152 \$158 VDD pfet_03v3 L=0.28U W=0.36U AS=0.0567P AD=0.1278P
+ PS=0.675U PD=1.07U
M$145 \$153 \$105 \$249 VDD pfet_03v3 L=0.28U W=0.36U AS=0.1278P AD=0.2097P
+ PS=1.07U PD=1.38U
M$146 VDD D15 \$153 VDD pfet_03v3 L=0.28U W=0.72U AS=0.2097P AD=0.3168P
+ PS=1.38U PD=2.32U
M$147 \$254 WE15 VDD VDD pfet_03v3 L=0.28U W=0.72U AS=0.3168P AD=0.1872P
+ PS=2.32U PD=1.24U
M$148 VDD CLK \$254 VDD pfet_03v3 L=0.28U W=0.72U AS=0.1872P AD=0.3168P
+ PS=1.24U PD=2.32U
M$149 \$416 \$254 VDD VDD pfet_03v3 L=0.28U W=2.54U AS=0.8974P AD=0.6604P
+ PS=5.28U PD=3.58U
M$151 \$523 \$416 VDD VDD pfet_03v3 L=0.28U W=2.68U AS=0.7272P AD=0.9782P
+ PS=3.78U PD=5.48U
M$153 \$255 \$106 VDD VDD pfet_03v3 L=0.28U W=0.72U AS=0.3168P AD=0.2097P
+ PS=2.32U PD=1.38U
M$154 \$256 \$523 \$255 VDD pfet_03v3 L=0.28U W=0.36U AS=0.2097P AD=0.1278P
+ PS=1.38U PD=1.07U
M$155 \$531 \$420 \$256 VDD pfet_03v3 L=0.28U W=0.36U AS=0.1278P AD=0.0567P
+ PS=1.07U PD=0.675U
M$156 VDD \$416 \$531 VDD pfet_03v3 L=0.28U W=0.36U AS=0.0567P AD=0.1584P
+ PS=0.675U PD=1.6U
M$157 \$420 \$256 VDD VDD pfet_03v3 L=0.28U W=0.36U AS=0.1764P AD=0.1584P
+ PS=1.26U PD=1.6U
M$158 \$257 \$256 VDD VDD pfet_03v3 L=0.28U W=0.72U AS=0.1764P AD=0.36P
+ PS=1.26U PD=2.44U
M$159 \$422 RA15 VDD VDD pfet_03v3 L=0.28U W=0.72U AS=0.3312P AD=0.3888P
+ PS=2.36U PD=2.52U
M$160 \$257 \$422 \$51 VDD pfet_03v3 L=0.28U W=0.36U AS=0.1584P AD=0.1152P
+ PS=1.6U PD=1U
M$161 \$52 \$423 \$257 VDD pfet_03v3 L=0.28U W=0.36U AS=0.1152P AD=0.1584P
+ PS=1U PD=1.6U
M$162 VDD RB15 \$423 VDD pfet_03v3 L=0.28U W=0.72U AS=0.3708P AD=0.3168P
+ PS=2.47U PD=2.32U
M$163 \$258 \$109 VDD VDD pfet_03v3 L=0.28U W=0.72U AS=0.3168P AD=0.2097P
+ PS=2.32U PD=1.38U
M$164 \$259 \$523 \$258 VDD pfet_03v3 L=0.28U W=0.36U AS=0.2097P AD=0.1278P
+ PS=1.38U PD=1.07U
M$165 \$543 \$424 \$259 VDD pfet_03v3 L=0.28U W=0.36U AS=0.1278P AD=0.0567P
+ PS=1.07U PD=0.675U
M$166 VDD \$416 \$543 VDD pfet_03v3 L=0.28U W=0.36U AS=0.0567P AD=0.1584P
+ PS=0.675U PD=1.6U
M$167 \$424 \$259 VDD VDD pfet_03v3 L=0.28U W=0.36U AS=0.1764P AD=0.1584P
+ PS=1.26U PD=1.6U
M$168 \$260 \$259 VDD VDD pfet_03v3 L=0.28U W=0.72U AS=0.1764P AD=0.36P
+ PS=1.26U PD=2.44U
M$169 \$425 RA15 VDD VDD pfet_03v3 L=0.28U W=0.72U AS=0.3312P AD=0.3888P
+ PS=2.36U PD=2.52U
M$170 \$260 \$425 \$53 VDD pfet_03v3 L=0.28U W=0.36U AS=0.1584P AD=0.1152P
+ PS=1.6U PD=1U
M$171 \$54 \$426 \$260 VDD pfet_03v3 L=0.28U W=0.36U AS=0.1152P AD=0.1584P
+ PS=1U PD=1.6U
M$172 VDD RB15 \$426 VDD pfet_03v3 L=0.28U W=0.72U AS=0.3708P AD=0.3168P
+ PS=2.47U PD=2.32U
M$173 \$261 \$112 VDD VDD pfet_03v3 L=0.28U W=0.72U AS=0.3168P AD=0.2097P
+ PS=2.32U PD=1.38U
M$174 \$262 \$523 \$261 VDD pfet_03v3 L=0.28U W=0.36U AS=0.2097P AD=0.1278P
+ PS=1.38U PD=1.07U
M$175 \$553 \$427 \$262 VDD pfet_03v3 L=0.28U W=0.36U AS=0.1278P AD=0.0567P
+ PS=1.07U PD=0.675U
M$176 VDD \$416 \$553 VDD pfet_03v3 L=0.28U W=0.36U AS=0.0567P AD=0.1584P
+ PS=0.675U PD=1.6U
M$177 \$427 \$262 VDD VDD pfet_03v3 L=0.28U W=0.36U AS=0.1764P AD=0.1584P
+ PS=1.26U PD=1.6U
M$178 \$263 \$262 VDD VDD pfet_03v3 L=0.28U W=0.72U AS=0.1764P AD=0.36P
+ PS=1.26U PD=2.44U
M$179 \$428 RA15 VDD VDD pfet_03v3 L=0.28U W=0.72U AS=0.3312P AD=0.3888P
+ PS=2.36U PD=2.52U
M$180 \$263 \$428 \$55 VDD pfet_03v3 L=0.28U W=0.36U AS=0.1584P AD=0.1152P
+ PS=1.6U PD=1U
M$181 \$56 \$429 \$263 VDD pfet_03v3 L=0.28U W=0.36U AS=0.1152P AD=0.1584P
+ PS=1U PD=1.6U
M$182 VDD RB15 \$429 VDD pfet_03v3 L=0.28U W=0.72U AS=0.3708P AD=0.3168P
+ PS=2.47U PD=2.32U
M$183 \$264 \$115 VDD VDD pfet_03v3 L=0.28U W=0.72U AS=0.3168P AD=0.2097P
+ PS=2.32U PD=1.38U
M$184 \$265 \$523 \$264 VDD pfet_03v3 L=0.28U W=0.36U AS=0.2097P AD=0.1278P
+ PS=1.38U PD=1.07U
M$185 \$563 \$430 \$265 VDD pfet_03v3 L=0.28U W=0.36U AS=0.1278P AD=0.0567P
+ PS=1.07U PD=0.675U
M$186 VDD \$416 \$563 VDD pfet_03v3 L=0.28U W=0.36U AS=0.0567P AD=0.1584P
+ PS=0.675U PD=1.6U
M$187 \$430 \$265 VDD VDD pfet_03v3 L=0.28U W=0.36U AS=0.1764P AD=0.1584P
+ PS=1.26U PD=1.6U
M$188 \$266 \$265 VDD VDD pfet_03v3 L=0.28U W=0.72U AS=0.1764P AD=0.36P
+ PS=1.26U PD=2.44U
M$189 \$432 RA15 VDD VDD pfet_03v3 L=0.28U W=0.72U AS=0.3312P AD=0.3888P
+ PS=2.36U PD=2.52U
M$190 \$266 \$432 \$57 VDD pfet_03v3 L=0.28U W=0.36U AS=0.1584P AD=0.1152P
+ PS=1.6U PD=1U
M$191 \$58 \$433 \$266 VDD pfet_03v3 L=0.28U W=0.36U AS=0.1152P AD=0.1584P
+ PS=1U PD=1.6U
M$192 VDD RB15 \$433 VDD pfet_03v3 L=0.28U W=0.72U AS=0.3708P AD=0.3168P
+ PS=2.47U PD=2.32U
M$193 \$267 \$118 VDD VDD pfet_03v3 L=0.28U W=0.72U AS=0.3168P AD=0.2097P
+ PS=2.32U PD=1.38U
M$194 \$268 \$523 \$267 VDD pfet_03v3 L=0.28U W=0.36U AS=0.2097P AD=0.1278P
+ PS=1.38U PD=1.07U
M$195 \$575 \$434 \$268 VDD pfet_03v3 L=0.28U W=0.36U AS=0.1278P AD=0.0567P
+ PS=1.07U PD=0.675U
M$196 VDD \$416 \$575 VDD pfet_03v3 L=0.28U W=0.36U AS=0.0567P AD=0.1584P
+ PS=0.675U PD=1.6U
M$197 \$434 \$268 VDD VDD pfet_03v3 L=0.28U W=0.36U AS=0.1764P AD=0.1584P
+ PS=1.26U PD=1.6U
M$198 \$269 \$268 VDD VDD pfet_03v3 L=0.28U W=0.72U AS=0.1764P AD=0.36P
+ PS=1.26U PD=2.44U
M$199 \$435 RA15 VDD VDD pfet_03v3 L=0.28U W=0.72U AS=0.3312P AD=0.3888P
+ PS=2.36U PD=2.52U
M$200 \$269 \$435 \$59 VDD pfet_03v3 L=0.28U W=0.36U AS=0.1584P AD=0.1152P
+ PS=1.6U PD=1U
M$201 \$60 \$436 \$269 VDD pfet_03v3 L=0.28U W=0.36U AS=0.1152P AD=0.1584P
+ PS=1U PD=1.6U
M$202 VDD RB15 \$436 VDD pfet_03v3 L=0.28U W=0.72U AS=0.3708P AD=0.3168P
+ PS=2.47U PD=2.32U
M$203 \$270 \$121 VDD VDD pfet_03v3 L=0.28U W=0.72U AS=0.3168P AD=0.2097P
+ PS=2.32U PD=1.38U
M$204 \$271 \$523 \$270 VDD pfet_03v3 L=0.28U W=0.36U AS=0.2097P AD=0.1278P
+ PS=1.38U PD=1.07U
M$205 \$587 \$437 \$271 VDD pfet_03v3 L=0.28U W=0.36U AS=0.1278P AD=0.0567P
+ PS=1.07U PD=0.675U
M$206 VDD \$416 \$587 VDD pfet_03v3 L=0.28U W=0.36U AS=0.0567P AD=0.1584P
+ PS=0.675U PD=1.6U
M$207 \$437 \$271 VDD VDD pfet_03v3 L=0.28U W=0.36U AS=0.1764P AD=0.1584P
+ PS=1.26U PD=1.6U
M$208 \$272 \$271 VDD VDD pfet_03v3 L=0.28U W=0.72U AS=0.1764P AD=0.36P
+ PS=1.26U PD=2.44U
M$209 \$438 RA15 VDD VDD pfet_03v3 L=0.28U W=0.72U AS=0.3312P AD=0.3888P
+ PS=2.36U PD=2.52U
M$210 \$272 \$438 \$61 VDD pfet_03v3 L=0.28U W=0.36U AS=0.1584P AD=0.1152P
+ PS=1.6U PD=1U
M$211 \$62 \$439 \$272 VDD pfet_03v3 L=0.28U W=0.36U AS=0.1152P AD=0.1584P
+ PS=1U PD=1.6U
M$212 VDD RB15 \$439 VDD pfet_03v3 L=0.28U W=0.72U AS=0.3708P AD=0.3168P
+ PS=2.47U PD=2.32U
M$213 \$273 \$124 VDD VDD pfet_03v3 L=0.28U W=0.72U AS=0.3168P AD=0.2097P
+ PS=2.32U PD=1.38U
M$214 \$274 \$523 \$273 VDD pfet_03v3 L=0.28U W=0.36U AS=0.2097P AD=0.1278P
+ PS=1.38U PD=1.07U
M$215 \$597 \$440 \$274 VDD pfet_03v3 L=0.28U W=0.36U AS=0.1278P AD=0.0567P
+ PS=1.07U PD=0.675U
M$216 VDD \$416 \$597 VDD pfet_03v3 L=0.28U W=0.36U AS=0.0567P AD=0.1584P
+ PS=0.675U PD=1.6U
M$217 \$440 \$274 VDD VDD pfet_03v3 L=0.28U W=0.36U AS=0.1764P AD=0.1584P
+ PS=1.26U PD=1.6U
M$218 \$275 \$274 VDD VDD pfet_03v3 L=0.28U W=0.72U AS=0.1764P AD=0.36P
+ PS=1.26U PD=2.44U
M$219 \$441 RA15 VDD VDD pfet_03v3 L=0.28U W=0.72U AS=0.3312P AD=0.3888P
+ PS=2.36U PD=2.52U
M$220 \$275 \$441 \$63 VDD pfet_03v3 L=0.28U W=0.36U AS=0.1584P AD=0.1152P
+ PS=1.6U PD=1U
M$221 \$64 \$442 \$275 VDD pfet_03v3 L=0.28U W=0.36U AS=0.1152P AD=0.1584P
+ PS=1U PD=1.6U
M$222 VDD RB15 \$442 VDD pfet_03v3 L=0.28U W=0.72U AS=0.3708P AD=0.3168P
+ PS=2.47U PD=2.32U
M$223 \$276 \$127 VDD VDD pfet_03v3 L=0.28U W=0.72U AS=0.3168P AD=0.2097P
+ PS=2.32U PD=1.38U
M$224 \$277 \$523 \$276 VDD pfet_03v3 L=0.28U W=0.36U AS=0.2097P AD=0.1278P
+ PS=1.38U PD=1.07U
M$225 \$606 \$443 \$277 VDD pfet_03v3 L=0.28U W=0.36U AS=0.1278P AD=0.0567P
+ PS=1.07U PD=0.675U
M$226 VDD \$416 \$606 VDD pfet_03v3 L=0.28U W=0.36U AS=0.0567P AD=0.1584P
+ PS=0.675U PD=1.6U
M$227 \$443 \$277 VDD VDD pfet_03v3 L=0.28U W=0.36U AS=0.1764P AD=0.1584P
+ PS=1.26U PD=1.6U
M$228 \$278 \$277 VDD VDD pfet_03v3 L=0.28U W=0.72U AS=0.1764P AD=0.36P
+ PS=1.26U PD=2.44U
M$229 \$444 RA15 VDD VDD pfet_03v3 L=0.28U W=0.72U AS=0.3312P AD=0.3888P
+ PS=2.36U PD=2.52U
M$230 \$278 \$444 \$65 VDD pfet_03v3 L=0.28U W=0.36U AS=0.1584P AD=0.1152P
+ PS=1.6U PD=1U
M$231 \$66 \$445 \$278 VDD pfet_03v3 L=0.28U W=0.36U AS=0.1152P AD=0.1584P
+ PS=1U PD=1.6U
M$232 VDD RB15 \$445 VDD pfet_03v3 L=0.28U W=0.72U AS=0.3708P AD=0.3168P
+ PS=2.47U PD=2.32U
M$233 \$279 \$130 VDD VDD pfet_03v3 L=0.28U W=0.72U AS=0.3168P AD=0.2097P
+ PS=2.32U PD=1.38U
M$234 \$280 \$523 \$279 VDD pfet_03v3 L=0.28U W=0.36U AS=0.2097P AD=0.1278P
+ PS=1.38U PD=1.07U
M$235 \$619 \$446 \$280 VDD pfet_03v3 L=0.28U W=0.36U AS=0.1278P AD=0.0567P
+ PS=1.07U PD=0.675U
M$236 VDD \$416 \$619 VDD pfet_03v3 L=0.28U W=0.36U AS=0.0567P AD=0.1584P
+ PS=0.675U PD=1.6U
M$237 \$446 \$280 VDD VDD pfet_03v3 L=0.28U W=0.36U AS=0.1764P AD=0.1584P
+ PS=1.26U PD=1.6U
M$238 \$281 \$280 VDD VDD pfet_03v3 L=0.28U W=0.72U AS=0.1764P AD=0.36P
+ PS=1.26U PD=2.44U
M$239 \$447 RA15 VDD VDD pfet_03v3 L=0.28U W=0.72U AS=0.3312P AD=0.3888P
+ PS=2.36U PD=2.52U
M$240 \$281 \$447 \$67 VDD pfet_03v3 L=0.28U W=0.36U AS=0.1584P AD=0.1152P
+ PS=1.6U PD=1U
M$241 \$68 \$448 \$281 VDD pfet_03v3 L=0.28U W=0.36U AS=0.1152P AD=0.1584P
+ PS=1U PD=1.6U
M$242 VDD RB15 \$448 VDD pfet_03v3 L=0.28U W=0.72U AS=0.3708P AD=0.3168P
+ PS=2.47U PD=2.32U
M$243 \$282 \$133 VDD VDD pfet_03v3 L=0.28U W=0.72U AS=0.3168P AD=0.2097P
+ PS=2.32U PD=1.38U
M$244 \$283 \$523 \$282 VDD pfet_03v3 L=0.28U W=0.36U AS=0.2097P AD=0.1278P
+ PS=1.38U PD=1.07U
M$245 \$625 \$449 \$283 VDD pfet_03v3 L=0.28U W=0.36U AS=0.1278P AD=0.0567P
+ PS=1.07U PD=0.675U
M$246 VDD \$416 \$625 VDD pfet_03v3 L=0.28U W=0.36U AS=0.0567P AD=0.1584P
+ PS=0.675U PD=1.6U
M$247 \$449 \$283 VDD VDD pfet_03v3 L=0.28U W=0.36U AS=0.1764P AD=0.1584P
+ PS=1.26U PD=1.6U
M$248 \$284 \$283 VDD VDD pfet_03v3 L=0.28U W=0.72U AS=0.1764P AD=0.36P
+ PS=1.26U PD=2.44U
M$249 \$450 RA15 VDD VDD pfet_03v3 L=0.28U W=0.72U AS=0.3312P AD=0.3888P
+ PS=2.36U PD=2.52U
M$250 \$284 \$450 \$69 VDD pfet_03v3 L=0.28U W=0.36U AS=0.1584P AD=0.1152P
+ PS=1.6U PD=1U
M$251 \$70 \$451 \$284 VDD pfet_03v3 L=0.28U W=0.36U AS=0.1152P AD=0.1584P
+ PS=1U PD=1.6U
M$252 VDD RB15 \$451 VDD pfet_03v3 L=0.28U W=0.72U AS=0.3708P AD=0.3168P
+ PS=2.47U PD=2.32U
M$253 \$285 \$136 VDD VDD pfet_03v3 L=0.28U W=0.72U AS=0.3168P AD=0.2097P
+ PS=2.32U PD=1.38U
M$254 \$286 \$523 \$285 VDD pfet_03v3 L=0.28U W=0.36U AS=0.2097P AD=0.1278P
+ PS=1.38U PD=1.07U
M$255 \$612 \$452 \$286 VDD pfet_03v3 L=0.28U W=0.36U AS=0.1278P AD=0.0567P
+ PS=1.07U PD=0.675U
M$256 VDD \$416 \$612 VDD pfet_03v3 L=0.28U W=0.36U AS=0.0567P AD=0.1584P
+ PS=0.675U PD=1.6U
M$257 \$452 \$286 VDD VDD pfet_03v3 L=0.28U W=0.36U AS=0.1764P AD=0.1584P
+ PS=1.26U PD=1.6U
M$258 \$287 \$286 VDD VDD pfet_03v3 L=0.28U W=0.72U AS=0.1764P AD=0.36P
+ PS=1.26U PD=2.44U
M$259 \$453 RA15 VDD VDD pfet_03v3 L=0.28U W=0.72U AS=0.3312P AD=0.3888P
+ PS=2.36U PD=2.52U
M$260 \$287 \$453 \$71 VDD pfet_03v3 L=0.28U W=0.36U AS=0.1584P AD=0.1152P
+ PS=1.6U PD=1U
M$261 \$72 \$454 \$287 VDD pfet_03v3 L=0.28U W=0.36U AS=0.1152P AD=0.1584P
+ PS=1U PD=1.6U
M$262 VDD RB15 \$454 VDD pfet_03v3 L=0.28U W=0.72U AS=0.3708P AD=0.3168P
+ PS=2.47U PD=2.32U
M$263 \$288 \$139 VDD VDD pfet_03v3 L=0.28U W=0.72U AS=0.3168P AD=0.2097P
+ PS=2.32U PD=1.38U
M$264 \$289 \$523 \$288 VDD pfet_03v3 L=0.28U W=0.36U AS=0.2097P AD=0.1278P
+ PS=1.38U PD=1.07U
M$265 \$594 \$455 \$289 VDD pfet_03v3 L=0.28U W=0.36U AS=0.1278P AD=0.0567P
+ PS=1.07U PD=0.675U
M$266 VDD \$416 \$594 VDD pfet_03v3 L=0.28U W=0.36U AS=0.0567P AD=0.1584P
+ PS=0.675U PD=1.6U
M$267 \$455 \$289 VDD VDD pfet_03v3 L=0.28U W=0.36U AS=0.1764P AD=0.1584P
+ PS=1.26U PD=1.6U
M$268 \$290 \$289 VDD VDD pfet_03v3 L=0.28U W=0.72U AS=0.1764P AD=0.36P
+ PS=1.26U PD=2.44U
M$269 \$456 RA15 VDD VDD pfet_03v3 L=0.28U W=0.72U AS=0.3312P AD=0.3888P
+ PS=2.36U PD=2.52U
M$270 \$290 \$456 \$73 VDD pfet_03v3 L=0.28U W=0.36U AS=0.1584P AD=0.1152P
+ PS=1.6U PD=1U
M$271 \$74 \$457 \$290 VDD pfet_03v3 L=0.28U W=0.36U AS=0.1152P AD=0.1584P
+ PS=1U PD=1.6U
M$272 VDD RB15 \$457 VDD pfet_03v3 L=0.28U W=0.72U AS=0.3708P AD=0.3168P
+ PS=2.47U PD=2.32U
M$273 \$291 \$142 VDD VDD pfet_03v3 L=0.28U W=0.72U AS=0.3168P AD=0.2097P
+ PS=2.32U PD=1.38U
M$274 \$292 \$523 \$291 VDD pfet_03v3 L=0.28U W=0.36U AS=0.2097P AD=0.1278P
+ PS=1.38U PD=1.07U
M$275 \$583 \$458 \$292 VDD pfet_03v3 L=0.28U W=0.36U AS=0.1278P AD=0.0567P
+ PS=1.07U PD=0.675U
M$276 VDD \$416 \$583 VDD pfet_03v3 L=0.28U W=0.36U AS=0.0567P AD=0.1584P
+ PS=0.675U PD=1.6U
M$277 \$458 \$292 VDD VDD pfet_03v3 L=0.28U W=0.36U AS=0.1764P AD=0.1584P
+ PS=1.26U PD=1.6U
M$278 \$293 \$292 VDD VDD pfet_03v3 L=0.28U W=0.72U AS=0.1764P AD=0.36P
+ PS=1.26U PD=2.44U
M$279 \$459 RA15 VDD VDD pfet_03v3 L=0.28U W=0.72U AS=0.3312P AD=0.3888P
+ PS=2.36U PD=2.52U
M$280 \$293 \$459 \$75 VDD pfet_03v3 L=0.28U W=0.36U AS=0.1584P AD=0.1152P
+ PS=1.6U PD=1U
M$281 \$76 \$460 \$293 VDD pfet_03v3 L=0.28U W=0.36U AS=0.1152P AD=0.1584P
+ PS=1U PD=1.6U
M$282 VDD RB15 \$460 VDD pfet_03v3 L=0.28U W=0.72U AS=0.3708P AD=0.3168P
+ PS=2.47U PD=2.32U
M$283 \$294 \$145 VDD VDD pfet_03v3 L=0.28U W=0.72U AS=0.3168P AD=0.2097P
+ PS=2.32U PD=1.38U
M$284 \$295 \$523 \$294 VDD pfet_03v3 L=0.28U W=0.36U AS=0.2097P AD=0.1278P
+ PS=1.38U PD=1.07U
M$285 \$566 \$461 \$295 VDD pfet_03v3 L=0.28U W=0.36U AS=0.1278P AD=0.0567P
+ PS=1.07U PD=0.675U
M$286 VDD \$416 \$566 VDD pfet_03v3 L=0.28U W=0.36U AS=0.0567P AD=0.1584P
+ PS=0.675U PD=1.6U
M$287 \$461 \$295 VDD VDD pfet_03v3 L=0.28U W=0.36U AS=0.1764P AD=0.1584P
+ PS=1.26U PD=1.6U
M$288 \$296 \$295 VDD VDD pfet_03v3 L=0.28U W=0.72U AS=0.1764P AD=0.36P
+ PS=1.26U PD=2.44U
M$289 \$462 RA15 VDD VDD pfet_03v3 L=0.28U W=0.72U AS=0.3312P AD=0.3888P
+ PS=2.36U PD=2.52U
M$290 \$296 \$462 \$77 VDD pfet_03v3 L=0.28U W=0.36U AS=0.1584P AD=0.1152P
+ PS=1.6U PD=1U
M$291 \$78 \$463 \$296 VDD pfet_03v3 L=0.28U W=0.36U AS=0.1152P AD=0.1584P
+ PS=1U PD=1.6U
M$292 VDD RB15 \$463 VDD pfet_03v3 L=0.28U W=0.72U AS=0.3708P AD=0.3168P
+ PS=2.47U PD=2.32U
M$293 \$297 \$148 VDD VDD pfet_03v3 L=0.28U W=0.72U AS=0.3168P AD=0.2097P
+ PS=2.32U PD=1.38U
M$294 \$298 \$523 \$297 VDD pfet_03v3 L=0.28U W=0.36U AS=0.2097P AD=0.1278P
+ PS=1.38U PD=1.07U
M$295 \$551 \$464 \$298 VDD pfet_03v3 L=0.28U W=0.36U AS=0.1278P AD=0.0567P
+ PS=1.07U PD=0.675U
M$296 VDD \$416 \$551 VDD pfet_03v3 L=0.28U W=0.36U AS=0.0567P AD=0.1584P
+ PS=0.675U PD=1.6U
M$297 \$464 \$298 VDD VDD pfet_03v3 L=0.28U W=0.36U AS=0.1764P AD=0.1584P
+ PS=1.26U PD=1.6U
M$298 \$299 \$298 VDD VDD pfet_03v3 L=0.28U W=0.72U AS=0.1764P AD=0.36P
+ PS=1.26U PD=2.44U
M$299 \$465 RA15 VDD VDD pfet_03v3 L=0.28U W=0.72U AS=0.3312P AD=0.3888P
+ PS=2.36U PD=2.52U
M$300 \$299 \$465 \$79 VDD pfet_03v3 L=0.28U W=0.36U AS=0.1584P AD=0.1152P
+ PS=1.6U PD=1U
M$301 \$80 \$466 \$299 VDD pfet_03v3 L=0.28U W=0.36U AS=0.1152P AD=0.1584P
+ PS=1U PD=1.6U
M$302 VDD RB15 \$466 VDD pfet_03v3 L=0.28U W=0.72U AS=0.3708P AD=0.3168P
+ PS=2.47U PD=2.32U
M$303 \$300 \$151 VDD VDD pfet_03v3 L=0.28U W=0.72U AS=0.3168P AD=0.2097P
+ PS=2.32U PD=1.38U
M$304 \$301 \$523 \$300 VDD pfet_03v3 L=0.28U W=0.36U AS=0.2097P AD=0.1278P
+ PS=1.38U PD=1.07U
M$305 \$533 \$467 \$301 VDD pfet_03v3 L=0.28U W=0.36U AS=0.1278P AD=0.0567P
+ PS=1.07U PD=0.675U
M$306 VDD \$416 \$533 VDD pfet_03v3 L=0.28U W=0.36U AS=0.0567P AD=0.1584P
+ PS=0.675U PD=1.6U
M$307 \$467 \$301 VDD VDD pfet_03v3 L=0.28U W=0.36U AS=0.1764P AD=0.1584P
+ PS=1.26U PD=1.6U
M$308 \$302 \$301 VDD VDD pfet_03v3 L=0.28U W=0.72U AS=0.1764P AD=0.36P
+ PS=1.26U PD=2.44U
M$309 \$468 RA15 VDD VDD pfet_03v3 L=0.28U W=0.72U AS=0.3312P AD=0.3888P
+ PS=2.36U PD=2.52U
M$310 \$302 \$468 \$81 VDD pfet_03v3 L=0.28U W=0.36U AS=0.1584P AD=0.1152P
+ PS=1.6U PD=1U
M$311 \$82 \$469 \$302 VDD pfet_03v3 L=0.28U W=0.36U AS=0.1152P AD=0.1584P
+ PS=1U PD=1.6U
M$312 VDD RB15 \$469 VDD pfet_03v3 L=0.28U W=0.72U AS=0.3708P AD=0.3168P
+ PS=2.47U PD=2.32U
M$313 \$629 WE14 VDD VDD pfet_03v3 L=0.28U W=0.72U AS=0.3168P AD=0.1872P
+ PS=2.32U PD=1.24U
M$314 VDD CLK \$629 VDD pfet_03v3 L=0.28U W=0.72U AS=0.1872P AD=0.3168P
+ PS=1.24U PD=2.32U
M$315 \$630 \$629 VDD VDD pfet_03v3 L=0.28U W=2.54U AS=0.889P AD=0.6688P
+ PS=5.21U PD=3.65U
M$317 \$631 \$630 VDD VDD pfet_03v3 L=0.28U W=2.68U AS=0.7272P AD=0.9782P
+ PS=3.78U PD=5.48U
M$319 \$633 \$631 \$632 VDD pfet_03v3 L=0.28U W=0.36U AS=0.2097P AD=0.1278P
+ PS=1.38U PD=1.07U
M$320 \$734 \$634 \$633 VDD pfet_03v3 L=0.28U W=0.36U AS=0.1278P AD=0.0567P
+ PS=1.07U PD=0.675U
M$321 VDD \$630 \$734 VDD pfet_03v3 L=0.28U W=0.36U AS=0.0567P AD=0.1584P
+ PS=0.675U PD=1.6U
M$322 \$632 \$106 VDD VDD pfet_03v3 L=0.28U W=0.72U AS=0.3168P AD=0.2097P
+ PS=2.32U PD=1.38U
M$323 VDD \$633 \$634 VDD pfet_03v3 L=0.28U W=0.36U AS=0.1584P AD=0.1764P
+ PS=1.6U PD=1.26U
M$324 \$635 \$633 VDD VDD pfet_03v3 L=0.28U W=0.72U AS=0.1764P AD=0.36P
+ PS=1.26U PD=2.44U
M$325 \$637 RB14 VDD VDD pfet_03v3 L=0.28U W=0.72U AS=0.3312P AD=0.3888P
+ PS=2.36U PD=2.52U
M$326 \$635 \$637 \$51 VDD pfet_03v3 L=0.28U W=0.36U AS=0.1584P AD=0.1152P
+ PS=1.6U PD=1U
M$327 \$52 \$638 \$635 VDD pfet_03v3 L=0.28U W=0.36U AS=0.1152P AD=0.1584P
+ PS=1U PD=1.6U
M$328 VDD RA14 \$638 VDD pfet_03v3 L=0.28U W=0.72U AS=0.3708P AD=0.3168P
+ PS=2.47U PD=2.32U
M$329 \$640 \$631 \$639 VDD pfet_03v3 L=0.28U W=0.36U AS=0.2097P AD=0.1278P
+ PS=1.38U PD=1.07U
M$330 \$743 \$641 \$640 VDD pfet_03v3 L=0.28U W=0.36U AS=0.1278P AD=0.0567P
+ PS=1.07U PD=0.675U
M$331 VDD \$630 \$743 VDD pfet_03v3 L=0.28U W=0.36U AS=0.0567P AD=0.1584P
+ PS=0.675U PD=1.6U
M$332 \$639 \$109 VDD VDD pfet_03v3 L=0.28U W=0.72U AS=0.3168P AD=0.2097P
+ PS=2.32U PD=1.38U
M$333 VDD \$640 \$641 VDD pfet_03v3 L=0.28U W=0.36U AS=0.1584P AD=0.1764P
+ PS=1.6U PD=1.26U
M$334 \$642 \$640 VDD VDD pfet_03v3 L=0.28U W=0.72U AS=0.1764P AD=0.36P
+ PS=1.26U PD=2.44U
M$335 \$643 RB14 VDD VDD pfet_03v3 L=0.28U W=0.72U AS=0.3312P AD=0.3888P
+ PS=2.36U PD=2.52U
M$336 \$642 \$643 \$53 VDD pfet_03v3 L=0.28U W=0.36U AS=0.1584P AD=0.1152P
+ PS=1.6U PD=1U
M$337 \$54 \$644 \$642 VDD pfet_03v3 L=0.28U W=0.36U AS=0.1152P AD=0.1584P
+ PS=1U PD=1.6U
M$338 VDD RA14 \$644 VDD pfet_03v3 L=0.28U W=0.72U AS=0.3708P AD=0.3168P
+ PS=2.47U PD=2.32U
M$339 \$646 \$631 \$645 VDD pfet_03v3 L=0.28U W=0.36U AS=0.2097P AD=0.1278P
+ PS=1.38U PD=1.07U
M$340 \$754 \$647 \$646 VDD pfet_03v3 L=0.28U W=0.36U AS=0.1278P AD=0.0567P
+ PS=1.07U PD=0.675U
M$341 VDD \$630 \$754 VDD pfet_03v3 L=0.28U W=0.36U AS=0.0567P AD=0.1584P
+ PS=0.675U PD=1.6U
M$342 \$645 \$112 VDD VDD pfet_03v3 L=0.28U W=0.72U AS=0.3168P AD=0.2097P
+ PS=2.32U PD=1.38U
M$343 VDD \$646 \$647 VDD pfet_03v3 L=0.28U W=0.36U AS=0.1584P AD=0.1764P
+ PS=1.6U PD=1.26U
M$344 \$648 \$646 VDD VDD pfet_03v3 L=0.28U W=0.72U AS=0.1764P AD=0.36P
+ PS=1.26U PD=2.44U
M$345 \$649 RB14 VDD VDD pfet_03v3 L=0.28U W=0.72U AS=0.3312P AD=0.3888P
+ PS=2.36U PD=2.52U
M$346 \$648 \$649 \$55 VDD pfet_03v3 L=0.28U W=0.36U AS=0.1584P AD=0.1152P
+ PS=1.6U PD=1U
M$347 \$56 \$650 \$648 VDD pfet_03v3 L=0.28U W=0.36U AS=0.1152P AD=0.1584P
+ PS=1U PD=1.6U
M$348 VDD RA14 \$650 VDD pfet_03v3 L=0.28U W=0.72U AS=0.3708P AD=0.3168P
+ PS=2.47U PD=2.32U
M$349 \$652 \$631 \$651 VDD pfet_03v3 L=0.28U W=0.36U AS=0.2097P AD=0.1278P
+ PS=1.38U PD=1.07U
M$350 \$764 \$653 \$652 VDD pfet_03v3 L=0.28U W=0.36U AS=0.1278P AD=0.0567P
+ PS=1.07U PD=0.675U
M$351 VDD \$630 \$764 VDD pfet_03v3 L=0.28U W=0.36U AS=0.0567P AD=0.1584P
+ PS=0.675U PD=1.6U
M$352 \$651 \$115 VDD VDD pfet_03v3 L=0.28U W=0.72U AS=0.3168P AD=0.2097P
+ PS=2.32U PD=1.38U
M$353 VDD \$652 \$653 VDD pfet_03v3 L=0.28U W=0.36U AS=0.1584P AD=0.1764P
+ PS=1.6U PD=1.26U
M$354 \$654 \$652 VDD VDD pfet_03v3 L=0.28U W=0.72U AS=0.1764P AD=0.36P
+ PS=1.26U PD=2.44U
M$355 \$655 RB14 VDD VDD pfet_03v3 L=0.28U W=0.72U AS=0.3312P AD=0.3888P
+ PS=2.36U PD=2.52U
M$356 \$654 \$655 \$57 VDD pfet_03v3 L=0.28U W=0.36U AS=0.1584P AD=0.1152P
+ PS=1.6U PD=1U
M$357 \$58 \$656 \$654 VDD pfet_03v3 L=0.28U W=0.36U AS=0.1152P AD=0.1584P
+ PS=1U PD=1.6U
M$358 VDD RA14 \$656 VDD pfet_03v3 L=0.28U W=0.72U AS=0.3708P AD=0.3168P
+ PS=2.47U PD=2.32U
M$359 \$658 \$631 \$657 VDD pfet_03v3 L=0.28U W=0.36U AS=0.2097P AD=0.1278P
+ PS=1.38U PD=1.07U
M$360 \$775 \$659 \$658 VDD pfet_03v3 L=0.28U W=0.36U AS=0.1278P AD=0.0567P
+ PS=1.07U PD=0.675U
M$361 VDD \$630 \$775 VDD pfet_03v3 L=0.28U W=0.36U AS=0.0567P AD=0.1584P
+ PS=0.675U PD=1.6U
M$362 \$657 \$118 VDD VDD pfet_03v3 L=0.28U W=0.72U AS=0.3168P AD=0.2097P
+ PS=2.32U PD=1.38U
M$363 VDD \$658 \$659 VDD pfet_03v3 L=0.28U W=0.36U AS=0.1584P AD=0.1764P
+ PS=1.6U PD=1.26U
M$364 \$660 \$658 VDD VDD pfet_03v3 L=0.28U W=0.72U AS=0.1764P AD=0.36P
+ PS=1.26U PD=2.44U
M$365 \$661 RB14 VDD VDD pfet_03v3 L=0.28U W=0.72U AS=0.3312P AD=0.3888P
+ PS=2.36U PD=2.52U
M$366 \$660 \$661 \$59 VDD pfet_03v3 L=0.28U W=0.36U AS=0.1584P AD=0.1152P
+ PS=1.6U PD=1U
M$367 \$60 \$662 \$660 VDD pfet_03v3 L=0.28U W=0.36U AS=0.1152P AD=0.1584P
+ PS=1U PD=1.6U
M$368 VDD RA14 \$662 VDD pfet_03v3 L=0.28U W=0.72U AS=0.3708P AD=0.3168P
+ PS=2.47U PD=2.32U
M$369 \$664 \$631 \$663 VDD pfet_03v3 L=0.28U W=0.36U AS=0.2097P AD=0.1278P
+ PS=1.38U PD=1.07U
M$370 \$784 \$665 \$664 VDD pfet_03v3 L=0.28U W=0.36U AS=0.1278P AD=0.0567P
+ PS=1.07U PD=0.675U
M$371 VDD \$630 \$784 VDD pfet_03v3 L=0.28U W=0.36U AS=0.0567P AD=0.1584P
+ PS=0.675U PD=1.6U
M$372 \$663 \$121 VDD VDD pfet_03v3 L=0.28U W=0.72U AS=0.3168P AD=0.2097P
+ PS=2.32U PD=1.38U
M$373 VDD \$664 \$665 VDD pfet_03v3 L=0.28U W=0.36U AS=0.1584P AD=0.1764P
+ PS=1.6U PD=1.26U
M$374 \$666 \$664 VDD VDD pfet_03v3 L=0.28U W=0.72U AS=0.1764P AD=0.36P
+ PS=1.26U PD=2.44U
M$375 \$667 RB14 VDD VDD pfet_03v3 L=0.28U W=0.72U AS=0.3312P AD=0.3888P
+ PS=2.36U PD=2.52U
M$376 \$666 \$667 \$61 VDD pfet_03v3 L=0.28U W=0.36U AS=0.1584P AD=0.1152P
+ PS=1.6U PD=1U
M$377 \$62 \$668 \$666 VDD pfet_03v3 L=0.28U W=0.36U AS=0.1152P AD=0.1584P
+ PS=1U PD=1.6U
M$378 VDD RA14 \$668 VDD pfet_03v3 L=0.28U W=0.72U AS=0.3708P AD=0.3168P
+ PS=2.47U PD=2.32U
M$379 \$670 \$631 \$669 VDD pfet_03v3 L=0.28U W=0.36U AS=0.2097P AD=0.1278P
+ PS=1.38U PD=1.07U
M$380 \$794 \$671 \$670 VDD pfet_03v3 L=0.28U W=0.36U AS=0.1278P AD=0.0567P
+ PS=1.07U PD=0.675U
M$381 VDD \$630 \$794 VDD pfet_03v3 L=0.28U W=0.36U AS=0.0567P AD=0.1584P
+ PS=0.675U PD=1.6U
M$382 \$669 \$124 VDD VDD pfet_03v3 L=0.28U W=0.72U AS=0.3168P AD=0.2097P
+ PS=2.32U PD=1.38U
M$383 VDD \$670 \$671 VDD pfet_03v3 L=0.28U W=0.36U AS=0.1584P AD=0.1764P
+ PS=1.6U PD=1.26U
M$384 \$672 \$670 VDD VDD pfet_03v3 L=0.28U W=0.72U AS=0.1764P AD=0.36P
+ PS=1.26U PD=2.44U
M$385 \$673 RB14 VDD VDD pfet_03v3 L=0.28U W=0.72U AS=0.3312P AD=0.3888P
+ PS=2.36U PD=2.52U
M$386 \$672 \$673 \$63 VDD pfet_03v3 L=0.28U W=0.36U AS=0.1584P AD=0.1152P
+ PS=1.6U PD=1U
M$387 \$64 \$674 \$672 VDD pfet_03v3 L=0.28U W=0.36U AS=0.1152P AD=0.1584P
+ PS=1U PD=1.6U
M$388 VDD RA14 \$674 VDD pfet_03v3 L=0.28U W=0.72U AS=0.3708P AD=0.3168P
+ PS=2.47U PD=2.32U
M$389 \$676 \$631 \$675 VDD pfet_03v3 L=0.28U W=0.36U AS=0.2097P AD=0.1278P
+ PS=1.38U PD=1.07U
M$390 \$804 \$677 \$676 VDD pfet_03v3 L=0.28U W=0.36U AS=0.1278P AD=0.0567P
+ PS=1.07U PD=0.675U
M$391 VDD \$630 \$804 VDD pfet_03v3 L=0.28U W=0.36U AS=0.0567P AD=0.1584P
+ PS=0.675U PD=1.6U
M$392 \$675 \$127 VDD VDD pfet_03v3 L=0.28U W=0.72U AS=0.3168P AD=0.2097P
+ PS=2.32U PD=1.38U
M$393 VDD \$676 \$677 VDD pfet_03v3 L=0.28U W=0.36U AS=0.1584P AD=0.1764P
+ PS=1.6U PD=1.26U
M$394 \$678 \$676 VDD VDD pfet_03v3 L=0.28U W=0.72U AS=0.1764P AD=0.36P
+ PS=1.26U PD=2.44U
M$395 \$679 RB14 VDD VDD pfet_03v3 L=0.28U W=0.72U AS=0.3312P AD=0.3888P
+ PS=2.36U PD=2.52U
M$396 \$678 \$679 \$65 VDD pfet_03v3 L=0.28U W=0.36U AS=0.1584P AD=0.1152P
+ PS=1.6U PD=1U
M$397 \$66 \$680 \$678 VDD pfet_03v3 L=0.28U W=0.36U AS=0.1152P AD=0.1584P
+ PS=1U PD=1.6U
M$398 VDD RA14 \$680 VDD pfet_03v3 L=0.28U W=0.72U AS=0.3708P AD=0.3168P
+ PS=2.47U PD=2.32U
M$399 \$682 \$631 \$681 VDD pfet_03v3 L=0.28U W=0.36U AS=0.2097P AD=0.1278P
+ PS=1.38U PD=1.07U
M$400 \$814 \$683 \$682 VDD pfet_03v3 L=0.28U W=0.36U AS=0.1278P AD=0.0567P
+ PS=1.07U PD=0.675U
M$401 VDD \$630 \$814 VDD pfet_03v3 L=0.28U W=0.36U AS=0.0567P AD=0.1584P
+ PS=0.675U PD=1.6U
M$402 \$681 \$130 VDD VDD pfet_03v3 L=0.28U W=0.72U AS=0.3168P AD=0.2097P
+ PS=2.32U PD=1.38U
M$403 VDD \$682 \$683 VDD pfet_03v3 L=0.28U W=0.36U AS=0.1584P AD=0.1764P
+ PS=1.6U PD=1.26U
M$404 \$684 \$682 VDD VDD pfet_03v3 L=0.28U W=0.72U AS=0.1764P AD=0.36P
+ PS=1.26U PD=2.44U
M$405 \$685 RB14 VDD VDD pfet_03v3 L=0.28U W=0.72U AS=0.3312P AD=0.3888P
+ PS=2.36U PD=2.52U
M$406 \$684 \$685 \$67 VDD pfet_03v3 L=0.28U W=0.36U AS=0.1584P AD=0.1152P
+ PS=1.6U PD=1U
M$407 \$68 \$686 \$684 VDD pfet_03v3 L=0.28U W=0.36U AS=0.1152P AD=0.1584P
+ PS=1U PD=1.6U
M$408 VDD RA14 \$686 VDD pfet_03v3 L=0.28U W=0.72U AS=0.3708P AD=0.3168P
+ PS=2.47U PD=2.32U
M$409 \$688 \$631 \$687 VDD pfet_03v3 L=0.28U W=0.36U AS=0.2097P AD=0.1278P
+ PS=1.38U PD=1.07U
M$410 \$824 \$689 \$688 VDD pfet_03v3 L=0.28U W=0.36U AS=0.1278P AD=0.0567P
+ PS=1.07U PD=0.675U
M$411 VDD \$630 \$824 VDD pfet_03v3 L=0.28U W=0.36U AS=0.0567P AD=0.1584P
+ PS=0.675U PD=1.6U
M$412 \$687 \$133 VDD VDD pfet_03v3 L=0.28U W=0.72U AS=0.3168P AD=0.2097P
+ PS=2.32U PD=1.38U
M$413 VDD \$688 \$689 VDD pfet_03v3 L=0.28U W=0.36U AS=0.1584P AD=0.1764P
+ PS=1.6U PD=1.26U
M$414 \$690 \$688 VDD VDD pfet_03v3 L=0.28U W=0.72U AS=0.1764P AD=0.36P
+ PS=1.26U PD=2.44U
M$415 \$691 RB14 VDD VDD pfet_03v3 L=0.28U W=0.72U AS=0.3312P AD=0.3888P
+ PS=2.36U PD=2.52U
M$416 \$690 \$691 \$69 VDD pfet_03v3 L=0.28U W=0.36U AS=0.1584P AD=0.1152P
+ PS=1.6U PD=1U
M$417 \$70 \$692 \$690 VDD pfet_03v3 L=0.28U W=0.36U AS=0.1152P AD=0.1584P
+ PS=1U PD=1.6U
M$418 VDD RA14 \$692 VDD pfet_03v3 L=0.28U W=0.72U AS=0.3708P AD=0.3168P
+ PS=2.47U PD=2.32U
M$419 \$694 \$631 \$693 VDD pfet_03v3 L=0.28U W=0.36U AS=0.2097P AD=0.1278P
+ PS=1.38U PD=1.07U
M$420 \$810 \$695 \$694 VDD pfet_03v3 L=0.28U W=0.36U AS=0.1278P AD=0.0567P
+ PS=1.07U PD=0.675U
M$421 VDD \$630 \$810 VDD pfet_03v3 L=0.28U W=0.36U AS=0.0567P AD=0.1584P
+ PS=0.675U PD=1.6U
M$422 \$693 \$136 VDD VDD pfet_03v3 L=0.28U W=0.72U AS=0.3168P AD=0.2097P
+ PS=2.32U PD=1.38U
M$423 VDD \$694 \$695 VDD pfet_03v3 L=0.28U W=0.36U AS=0.1584P AD=0.1764P
+ PS=1.6U PD=1.26U
M$424 \$696 \$694 VDD VDD pfet_03v3 L=0.28U W=0.72U AS=0.1764P AD=0.36P
+ PS=1.26U PD=2.44U
M$425 \$697 RB14 VDD VDD pfet_03v3 L=0.28U W=0.72U AS=0.3312P AD=0.3888P
+ PS=2.36U PD=2.52U
M$426 \$696 \$697 \$71 VDD pfet_03v3 L=0.28U W=0.36U AS=0.1584P AD=0.1152P
+ PS=1.6U PD=1U
M$427 \$72 \$698 \$696 VDD pfet_03v3 L=0.28U W=0.36U AS=0.1152P AD=0.1584P
+ PS=1U PD=1.6U
M$428 VDD RA14 \$698 VDD pfet_03v3 L=0.28U W=0.72U AS=0.3708P AD=0.3168P
+ PS=2.47U PD=2.32U
M$429 \$700 \$631 \$699 VDD pfet_03v3 L=0.28U W=0.36U AS=0.2097P AD=0.1278P
+ PS=1.38U PD=1.07U
M$430 \$796 \$701 \$700 VDD pfet_03v3 L=0.28U W=0.36U AS=0.1278P AD=0.0567P
+ PS=1.07U PD=0.675U
M$431 VDD \$630 \$796 VDD pfet_03v3 L=0.28U W=0.36U AS=0.0567P AD=0.1584P
+ PS=0.675U PD=1.6U
M$432 \$699 \$139 VDD VDD pfet_03v3 L=0.28U W=0.72U AS=0.3168P AD=0.2097P
+ PS=2.32U PD=1.38U
M$433 VDD \$700 \$701 VDD pfet_03v3 L=0.28U W=0.36U AS=0.1584P AD=0.1764P
+ PS=1.6U PD=1.26U
M$434 \$702 \$700 VDD VDD pfet_03v3 L=0.28U W=0.72U AS=0.1764P AD=0.36P
+ PS=1.26U PD=2.44U
M$435 \$703 RB14 VDD VDD pfet_03v3 L=0.28U W=0.72U AS=0.3312P AD=0.3888P
+ PS=2.36U PD=2.52U
M$436 \$702 \$703 \$73 VDD pfet_03v3 L=0.28U W=0.36U AS=0.1584P AD=0.1152P
+ PS=1.6U PD=1U
M$437 \$74 \$704 \$702 VDD pfet_03v3 L=0.28U W=0.36U AS=0.1152P AD=0.1584P
+ PS=1U PD=1.6U
M$438 VDD RA14 \$704 VDD pfet_03v3 L=0.28U W=0.72U AS=0.3708P AD=0.3168P
+ PS=2.47U PD=2.32U
M$439 \$706 \$631 \$705 VDD pfet_03v3 L=0.28U W=0.36U AS=0.2097P AD=0.1278P
+ PS=1.38U PD=1.07U
M$440 \$780 \$707 \$706 VDD pfet_03v3 L=0.28U W=0.36U AS=0.1278P AD=0.0567P
+ PS=1.07U PD=0.675U
M$441 VDD \$630 \$780 VDD pfet_03v3 L=0.28U W=0.36U AS=0.0567P AD=0.1584P
+ PS=0.675U PD=1.6U
M$442 \$705 \$142 VDD VDD pfet_03v3 L=0.28U W=0.72U AS=0.3168P AD=0.2097P
+ PS=2.32U PD=1.38U
M$443 VDD \$706 \$707 VDD pfet_03v3 L=0.28U W=0.36U AS=0.1584P AD=0.1764P
+ PS=1.6U PD=1.26U
M$444 \$708 \$706 VDD VDD pfet_03v3 L=0.28U W=0.72U AS=0.1764P AD=0.36P
+ PS=1.26U PD=2.44U
M$445 \$709 RB14 VDD VDD pfet_03v3 L=0.28U W=0.72U AS=0.3312P AD=0.3888P
+ PS=2.36U PD=2.52U
M$446 \$708 \$709 \$75 VDD pfet_03v3 L=0.28U W=0.36U AS=0.1584P AD=0.1152P
+ PS=1.6U PD=1U
M$447 \$76 \$710 \$708 VDD pfet_03v3 L=0.28U W=0.36U AS=0.1152P AD=0.1584P
+ PS=1U PD=1.6U
M$448 VDD RA14 \$710 VDD pfet_03v3 L=0.28U W=0.72U AS=0.3708P AD=0.3168P
+ PS=2.47U PD=2.32U
M$449 \$712 \$631 \$711 VDD pfet_03v3 L=0.28U W=0.36U AS=0.2097P AD=0.1278P
+ PS=1.38U PD=1.07U
M$450 \$769 \$713 \$712 VDD pfet_03v3 L=0.28U W=0.36U AS=0.1278P AD=0.0567P
+ PS=1.07U PD=0.675U
M$451 VDD \$630 \$769 VDD pfet_03v3 L=0.28U W=0.36U AS=0.0567P AD=0.1584P
+ PS=0.675U PD=1.6U
M$452 \$711 \$145 VDD VDD pfet_03v3 L=0.28U W=0.72U AS=0.3168P AD=0.2097P
+ PS=2.32U PD=1.38U
M$453 VDD \$712 \$713 VDD pfet_03v3 L=0.28U W=0.36U AS=0.1584P AD=0.1764P
+ PS=1.6U PD=1.26U
M$454 \$714 \$712 VDD VDD pfet_03v3 L=0.28U W=0.72U AS=0.1764P AD=0.36P
+ PS=1.26U PD=2.44U
M$455 \$715 RB14 VDD VDD pfet_03v3 L=0.28U W=0.72U AS=0.3312P AD=0.3888P
+ PS=2.36U PD=2.52U
M$456 \$714 \$715 \$77 VDD pfet_03v3 L=0.28U W=0.36U AS=0.1584P AD=0.1152P
+ PS=1.6U PD=1U
M$457 \$78 \$716 \$714 VDD pfet_03v3 L=0.28U W=0.36U AS=0.1152P AD=0.1584P
+ PS=1U PD=1.6U
M$458 VDD RA14 \$716 VDD pfet_03v3 L=0.28U W=0.72U AS=0.3708P AD=0.3168P
+ PS=2.47U PD=2.32U
M$459 \$718 \$631 \$717 VDD pfet_03v3 L=0.28U W=0.36U AS=0.2097P AD=0.1278P
+ PS=1.38U PD=1.07U
M$460 \$753 \$719 \$718 VDD pfet_03v3 L=0.28U W=0.36U AS=0.1278P AD=0.0567P
+ PS=1.07U PD=0.675U
M$461 VDD \$630 \$753 VDD pfet_03v3 L=0.28U W=0.36U AS=0.0567P AD=0.1584P
+ PS=0.675U PD=1.6U
M$462 \$717 \$148 VDD VDD pfet_03v3 L=0.28U W=0.72U AS=0.3168P AD=0.2097P
+ PS=2.32U PD=1.38U
M$463 VDD \$718 \$719 VDD pfet_03v3 L=0.28U W=0.36U AS=0.1584P AD=0.1764P
+ PS=1.6U PD=1.26U
M$464 \$720 \$718 VDD VDD pfet_03v3 L=0.28U W=0.72U AS=0.1764P AD=0.36P
+ PS=1.26U PD=2.44U
M$465 \$721 RB14 VDD VDD pfet_03v3 L=0.28U W=0.72U AS=0.3312P AD=0.3888P
+ PS=2.36U PD=2.52U
M$466 \$720 \$721 \$79 VDD pfet_03v3 L=0.28U W=0.36U AS=0.1584P AD=0.1152P
+ PS=1.6U PD=1U
M$467 \$80 \$722 \$720 VDD pfet_03v3 L=0.28U W=0.36U AS=0.1152P AD=0.1584P
+ PS=1U PD=1.6U
M$468 VDD RA14 \$722 VDD pfet_03v3 L=0.28U W=0.72U AS=0.3708P AD=0.3168P
+ PS=2.47U PD=2.32U
M$469 \$724 \$631 \$723 VDD pfet_03v3 L=0.28U W=0.36U AS=0.2097P AD=0.1278P
+ PS=1.38U PD=1.07U
M$470 \$739 \$725 \$724 VDD pfet_03v3 L=0.28U W=0.36U AS=0.1278P AD=0.0567P
+ PS=1.07U PD=0.675U
M$471 VDD \$630 \$739 VDD pfet_03v3 L=0.28U W=0.36U AS=0.0567P AD=0.1584P
+ PS=0.675U PD=1.6U
M$472 \$723 \$151 VDD VDD pfet_03v3 L=0.28U W=0.72U AS=0.3168P AD=0.2097P
+ PS=2.32U PD=1.38U
M$473 VDD \$724 \$725 VDD pfet_03v3 L=0.28U W=0.36U AS=0.1584P AD=0.1764P
+ PS=1.6U PD=1.26U
M$474 \$726 \$724 VDD VDD pfet_03v3 L=0.28U W=0.72U AS=0.1764P AD=0.36P
+ PS=1.26U PD=2.44U
M$475 \$727 RB14 VDD VDD pfet_03v3 L=0.28U W=0.72U AS=0.3312P AD=0.3888P
+ PS=2.36U PD=2.52U
M$476 \$726 \$727 \$81 VDD pfet_03v3 L=0.28U W=0.36U AS=0.1584P AD=0.1152P
+ PS=1.6U PD=1U
M$477 \$82 \$728 \$726 VDD pfet_03v3 L=0.28U W=0.36U AS=0.1152P AD=0.1584P
+ PS=1U PD=1.6U
M$478 VDD RA14 \$728 VDD pfet_03v3 L=0.28U W=0.72U AS=0.3708P AD=0.3168P
+ PS=2.47U PD=2.32U
M$479 \$948 WE13 VDD VDD pfet_03v3 L=0.28U W=0.72U AS=0.3168P AD=0.1872P
+ PS=2.32U PD=1.24U
M$480 VDD CLK \$948 VDD pfet_03v3 L=0.28U W=0.72U AS=0.1872P AD=0.3168P
+ PS=1.24U PD=2.32U
M$481 \$949 \$948 VDD VDD pfet_03v3 L=0.28U W=2.54U AS=0.8974P AD=0.6604P
+ PS=5.28U PD=3.58U
M$483 \$1142 \$949 VDD VDD pfet_03v3 L=0.28U W=2.68U AS=0.7272P AD=0.9782P
+ PS=3.78U PD=5.48U
M$485 \$950 \$106 VDD VDD pfet_03v3 L=0.28U W=0.72U AS=0.3168P AD=0.2097P
+ PS=2.32U PD=1.38U
M$486 \$951 \$1142 \$950 VDD pfet_03v3 L=0.28U W=0.36U AS=0.2097P AD=0.1278P
+ PS=1.38U PD=1.07U
M$487 \$1148 \$1040 \$951 VDD pfet_03v3 L=0.28U W=0.36U AS=0.1278P AD=0.0567P
+ PS=1.07U PD=0.675U
M$488 VDD \$949 \$1148 VDD pfet_03v3 L=0.28U W=0.36U AS=0.0567P AD=0.1584P
+ PS=0.675U PD=1.6U
M$489 \$1040 \$951 VDD VDD pfet_03v3 L=0.28U W=0.36U AS=0.1764P AD=0.1584P
+ PS=1.26U PD=1.6U
M$490 \$932 \$951 VDD VDD pfet_03v3 L=0.28U W=0.72U AS=0.1764P AD=0.36P
+ PS=1.26U PD=2.44U
M$491 \$1042 RA13 VDD VDD pfet_03v3 L=0.28U W=0.72U AS=0.3312P AD=0.3888P
+ PS=2.36U PD=2.52U
M$492 \$932 \$1042 \$51 VDD pfet_03v3 L=0.28U W=0.36U AS=0.1584P AD=0.1152P
+ PS=1.6U PD=1U
M$493 \$52 \$1043 \$932 VDD pfet_03v3 L=0.28U W=0.36U AS=0.1152P AD=0.1584P
+ PS=1U PD=1.6U
M$494 VDD RB13 \$1043 VDD pfet_03v3 L=0.28U W=0.72U AS=0.3708P AD=0.3168P
+ PS=2.47U PD=2.32U
M$495 \$952 \$109 VDD VDD pfet_03v3 L=0.28U W=0.72U AS=0.3168P AD=0.2097P
+ PS=2.32U PD=1.38U
M$496 \$953 \$1142 \$952 VDD pfet_03v3 L=0.28U W=0.36U AS=0.2097P AD=0.1278P
+ PS=1.38U PD=1.07U
M$497 \$1160 \$1044 \$953 VDD pfet_03v3 L=0.28U W=0.36U AS=0.1278P AD=0.0567P
+ PS=1.07U PD=0.675U
M$498 VDD \$949 \$1160 VDD pfet_03v3 L=0.28U W=0.36U AS=0.0567P AD=0.1584P
+ PS=0.675U PD=1.6U
M$499 \$1044 \$953 VDD VDD pfet_03v3 L=0.28U W=0.36U AS=0.1764P AD=0.1584P
+ PS=1.26U PD=1.6U
M$500 \$933 \$953 VDD VDD pfet_03v3 L=0.28U W=0.72U AS=0.1764P AD=0.36P
+ PS=1.26U PD=2.44U
M$501 \$1045 RA13 VDD VDD pfet_03v3 L=0.28U W=0.72U AS=0.3312P AD=0.3888P
+ PS=2.36U PD=2.52U
M$502 \$933 \$1045 \$53 VDD pfet_03v3 L=0.28U W=0.36U AS=0.1584P AD=0.1152P
+ PS=1.6U PD=1U
M$503 \$54 \$1046 \$933 VDD pfet_03v3 L=0.28U W=0.36U AS=0.1152P AD=0.1584P
+ PS=1U PD=1.6U
M$504 VDD RB13 \$1046 VDD pfet_03v3 L=0.28U W=0.72U AS=0.3708P AD=0.3168P
+ PS=2.47U PD=2.32U
M$505 \$954 \$112 VDD VDD pfet_03v3 L=0.28U W=0.72U AS=0.3168P AD=0.2097P
+ PS=2.32U PD=1.38U
M$506 \$955 \$1142 \$954 VDD pfet_03v3 L=0.28U W=0.36U AS=0.2097P AD=0.1278P
+ PS=1.38U PD=1.07U
M$507 \$1169 \$1047 \$955 VDD pfet_03v3 L=0.28U W=0.36U AS=0.1278P AD=0.0567P
+ PS=1.07U PD=0.675U
M$508 VDD \$949 \$1169 VDD pfet_03v3 L=0.28U W=0.36U AS=0.0567P AD=0.1584P
+ PS=0.675U PD=1.6U
M$509 \$1047 \$955 VDD VDD pfet_03v3 L=0.28U W=0.36U AS=0.1764P AD=0.1584P
+ PS=1.26U PD=1.6U
M$510 \$934 \$955 VDD VDD pfet_03v3 L=0.28U W=0.72U AS=0.1764P AD=0.36P
+ PS=1.26U PD=2.44U
M$511 \$1048 RA13 VDD VDD pfet_03v3 L=0.28U W=0.72U AS=0.3312P AD=0.3888P
+ PS=2.36U PD=2.52U
M$512 \$934 \$1048 \$55 VDD pfet_03v3 L=0.28U W=0.36U AS=0.1584P AD=0.1152P
+ PS=1.6U PD=1U
M$513 \$56 \$1049 \$934 VDD pfet_03v3 L=0.28U W=0.36U AS=0.1152P AD=0.1584P
+ PS=1U PD=1.6U
M$514 VDD RB13 \$1049 VDD pfet_03v3 L=0.28U W=0.72U AS=0.3708P AD=0.3168P
+ PS=2.47U PD=2.32U
M$515 \$956 \$115 VDD VDD pfet_03v3 L=0.28U W=0.72U AS=0.3168P AD=0.2097P
+ PS=2.32U PD=1.38U
M$516 \$957 \$1142 \$956 VDD pfet_03v3 L=0.28U W=0.36U AS=0.2097P AD=0.1278P
+ PS=1.38U PD=1.07U
M$517 \$1180 \$1050 \$957 VDD pfet_03v3 L=0.28U W=0.36U AS=0.1278P AD=0.0567P
+ PS=1.07U PD=0.675U
M$518 VDD \$949 \$1180 VDD pfet_03v3 L=0.28U W=0.36U AS=0.0567P AD=0.1584P
+ PS=0.675U PD=1.6U
M$519 \$1050 \$957 VDD VDD pfet_03v3 L=0.28U W=0.36U AS=0.1764P AD=0.1584P
+ PS=1.26U PD=1.6U
M$520 \$935 \$957 VDD VDD pfet_03v3 L=0.28U W=0.72U AS=0.1764P AD=0.36P
+ PS=1.26U PD=2.44U
M$521 \$1051 RA13 VDD VDD pfet_03v3 L=0.28U W=0.72U AS=0.3312P AD=0.3888P
+ PS=2.36U PD=2.52U
M$522 \$935 \$1051 \$57 VDD pfet_03v3 L=0.28U W=0.36U AS=0.1584P AD=0.1152P
+ PS=1.6U PD=1U
M$523 \$58 \$1052 \$935 VDD pfet_03v3 L=0.28U W=0.36U AS=0.1152P AD=0.1584P
+ PS=1U PD=1.6U
M$524 VDD RB13 \$1052 VDD pfet_03v3 L=0.28U W=0.72U AS=0.3708P AD=0.3168P
+ PS=2.47U PD=2.32U
M$525 \$958 \$118 VDD VDD pfet_03v3 L=0.28U W=0.72U AS=0.3168P AD=0.2097P
+ PS=2.32U PD=1.38U
M$526 \$959 \$1142 \$958 VDD pfet_03v3 L=0.28U W=0.36U AS=0.2097P AD=0.1278P
+ PS=1.38U PD=1.07U
M$527 \$1189 \$1053 \$959 VDD pfet_03v3 L=0.28U W=0.36U AS=0.1278P AD=0.0567P
+ PS=1.07U PD=0.675U
M$528 VDD \$949 \$1189 VDD pfet_03v3 L=0.28U W=0.36U AS=0.0567P AD=0.1584P
+ PS=0.675U PD=1.6U
M$529 \$1053 \$959 VDD VDD pfet_03v3 L=0.28U W=0.36U AS=0.1764P AD=0.1584P
+ PS=1.26U PD=1.6U
M$530 \$936 \$959 VDD VDD pfet_03v3 L=0.28U W=0.72U AS=0.1764P AD=0.36P
+ PS=1.26U PD=2.44U
M$531 \$1054 RA13 VDD VDD pfet_03v3 L=0.28U W=0.72U AS=0.3312P AD=0.3888P
+ PS=2.36U PD=2.52U
M$532 \$936 \$1054 \$59 VDD pfet_03v3 L=0.28U W=0.36U AS=0.1584P AD=0.1152P
+ PS=1.6U PD=1U
M$533 \$60 \$1055 \$936 VDD pfet_03v3 L=0.28U W=0.36U AS=0.1152P AD=0.1584P
+ PS=1U PD=1.6U
M$534 VDD RB13 \$1055 VDD pfet_03v3 L=0.28U W=0.72U AS=0.3708P AD=0.3168P
+ PS=2.47U PD=2.32U
M$535 \$960 \$121 VDD VDD pfet_03v3 L=0.28U W=0.72U AS=0.3168P AD=0.2097P
+ PS=2.32U PD=1.38U
M$536 \$961 \$1142 \$960 VDD pfet_03v3 L=0.28U W=0.36U AS=0.2097P AD=0.1278P
+ PS=1.38U PD=1.07U
M$537 \$1199 \$1056 \$961 VDD pfet_03v3 L=0.28U W=0.36U AS=0.1278P AD=0.0567P
+ PS=1.07U PD=0.675U
M$538 VDD \$949 \$1199 VDD pfet_03v3 L=0.28U W=0.36U AS=0.0567P AD=0.1584P
+ PS=0.675U PD=1.6U
M$539 \$1056 \$961 VDD VDD pfet_03v3 L=0.28U W=0.36U AS=0.1764P AD=0.1584P
+ PS=1.26U PD=1.6U
M$540 \$937 \$961 VDD VDD pfet_03v3 L=0.28U W=0.72U AS=0.1764P AD=0.36P
+ PS=1.26U PD=2.44U
M$541 \$1057 RA13 VDD VDD pfet_03v3 L=0.28U W=0.72U AS=0.3312P AD=0.3888P
+ PS=2.36U PD=2.52U
M$542 \$937 \$1057 \$61 VDD pfet_03v3 L=0.28U W=0.36U AS=0.1584P AD=0.1152P
+ PS=1.6U PD=1U
M$543 \$62 \$1058 \$937 VDD pfet_03v3 L=0.28U W=0.36U AS=0.1152P AD=0.1584P
+ PS=1U PD=1.6U
M$544 VDD RB13 \$1058 VDD pfet_03v3 L=0.28U W=0.72U AS=0.3708P AD=0.3168P
+ PS=2.47U PD=2.32U
M$545 \$962 \$124 VDD VDD pfet_03v3 L=0.28U W=0.72U AS=0.3168P AD=0.2097P
+ PS=2.32U PD=1.38U
M$546 \$963 \$1142 \$962 VDD pfet_03v3 L=0.28U W=0.36U AS=0.2097P AD=0.1278P
+ PS=1.38U PD=1.07U
M$547 \$1210 \$1059 \$963 VDD pfet_03v3 L=0.28U W=0.36U AS=0.1278P AD=0.0567P
+ PS=1.07U PD=0.675U
M$548 VDD \$949 \$1210 VDD pfet_03v3 L=0.28U W=0.36U AS=0.0567P AD=0.1584P
+ PS=0.675U PD=1.6U
M$549 \$1059 \$963 VDD VDD pfet_03v3 L=0.28U W=0.36U AS=0.1764P AD=0.1584P
+ PS=1.26U PD=1.6U
M$550 \$938 \$963 VDD VDD pfet_03v3 L=0.28U W=0.72U AS=0.1764P AD=0.36P
+ PS=1.26U PD=2.44U
M$551 \$1060 RA13 VDD VDD pfet_03v3 L=0.28U W=0.72U AS=0.3312P AD=0.3888P
+ PS=2.36U PD=2.52U
M$552 \$938 \$1060 \$63 VDD pfet_03v3 L=0.28U W=0.36U AS=0.1584P AD=0.1152P
+ PS=1.6U PD=1U
M$553 \$64 \$1061 \$938 VDD pfet_03v3 L=0.28U W=0.36U AS=0.1152P AD=0.1584P
+ PS=1U PD=1.6U
M$554 VDD RB13 \$1061 VDD pfet_03v3 L=0.28U W=0.72U AS=0.3708P AD=0.3168P
+ PS=2.47U PD=2.32U
M$555 \$964 \$127 VDD VDD pfet_03v3 L=0.28U W=0.72U AS=0.3168P AD=0.2097P
+ PS=2.32U PD=1.38U
M$556 \$965 \$1142 \$964 VDD pfet_03v3 L=0.28U W=0.36U AS=0.2097P AD=0.1278P
+ PS=1.38U PD=1.07U
M$557 \$1221 \$1062 \$965 VDD pfet_03v3 L=0.28U W=0.36U AS=0.1278P AD=0.0567P
+ PS=1.07U PD=0.675U
M$558 VDD \$949 \$1221 VDD pfet_03v3 L=0.28U W=0.36U AS=0.0567P AD=0.1584P
+ PS=0.675U PD=1.6U
M$559 \$1062 \$965 VDD VDD pfet_03v3 L=0.28U W=0.36U AS=0.1764P AD=0.1584P
+ PS=1.26U PD=1.6U
M$560 \$939 \$965 VDD VDD pfet_03v3 L=0.28U W=0.72U AS=0.1764P AD=0.36P
+ PS=1.26U PD=2.44U
M$561 \$1063 RA13 VDD VDD pfet_03v3 L=0.28U W=0.72U AS=0.3312P AD=0.3888P
+ PS=2.36U PD=2.52U
M$562 \$939 \$1063 \$65 VDD pfet_03v3 L=0.28U W=0.36U AS=0.1584P AD=0.1152P
+ PS=1.6U PD=1U
M$563 \$66 \$1064 \$939 VDD pfet_03v3 L=0.28U W=0.36U AS=0.1152P AD=0.1584P
+ PS=1U PD=1.6U
M$564 VDD RB13 \$1064 VDD pfet_03v3 L=0.28U W=0.72U AS=0.3708P AD=0.3168P
+ PS=2.47U PD=2.32U
M$565 \$966 \$130 VDD VDD pfet_03v3 L=0.28U W=0.72U AS=0.3168P AD=0.2097P
+ PS=2.32U PD=1.38U
M$566 \$967 \$1142 \$966 VDD pfet_03v3 L=0.28U W=0.36U AS=0.2097P AD=0.1278P
+ PS=1.38U PD=1.07U
M$567 \$1230 \$1065 \$967 VDD pfet_03v3 L=0.28U W=0.36U AS=0.1278P AD=0.0567P
+ PS=1.07U PD=0.675U
M$568 VDD \$949 \$1230 VDD pfet_03v3 L=0.28U W=0.36U AS=0.0567P AD=0.1584P
+ PS=0.675U PD=1.6U
M$569 \$1065 \$967 VDD VDD pfet_03v3 L=0.28U W=0.36U AS=0.1764P AD=0.1584P
+ PS=1.26U PD=1.6U
M$570 \$940 \$967 VDD VDD pfet_03v3 L=0.28U W=0.72U AS=0.1764P AD=0.36P
+ PS=1.26U PD=2.44U
M$571 \$1066 RA13 VDD VDD pfet_03v3 L=0.28U W=0.72U AS=0.3312P AD=0.3888P
+ PS=2.36U PD=2.52U
M$572 \$940 \$1066 \$67 VDD pfet_03v3 L=0.28U W=0.36U AS=0.1584P AD=0.1152P
+ PS=1.6U PD=1U
M$573 \$68 \$1067 \$940 VDD pfet_03v3 L=0.28U W=0.36U AS=0.1152P AD=0.1584P
+ PS=1U PD=1.6U
M$574 VDD RB13 \$1067 VDD pfet_03v3 L=0.28U W=0.72U AS=0.3708P AD=0.3168P
+ PS=2.47U PD=2.32U
M$575 \$968 \$133 VDD VDD pfet_03v3 L=0.28U W=0.72U AS=0.3168P AD=0.2097P
+ PS=2.32U PD=1.38U
M$576 \$969 \$1142 \$968 VDD pfet_03v3 L=0.28U W=0.36U AS=0.2097P AD=0.1278P
+ PS=1.38U PD=1.07U
M$577 \$1240 \$1068 \$969 VDD pfet_03v3 L=0.28U W=0.36U AS=0.1278P AD=0.0567P
+ PS=1.07U PD=0.675U
M$578 VDD \$949 \$1240 VDD pfet_03v3 L=0.28U W=0.36U AS=0.0567P AD=0.1584P
+ PS=0.675U PD=1.6U
M$579 \$1068 \$969 VDD VDD pfet_03v3 L=0.28U W=0.36U AS=0.1764P AD=0.1584P
+ PS=1.26U PD=1.6U
M$580 \$941 \$969 VDD VDD pfet_03v3 L=0.28U W=0.72U AS=0.1764P AD=0.36P
+ PS=1.26U PD=2.44U
M$581 \$1069 RA13 VDD VDD pfet_03v3 L=0.28U W=0.72U AS=0.3312P AD=0.3888P
+ PS=2.36U PD=2.52U
M$582 \$941 \$1069 \$69 VDD pfet_03v3 L=0.28U W=0.36U AS=0.1584P AD=0.1152P
+ PS=1.6U PD=1U
M$583 \$70 \$1070 \$941 VDD pfet_03v3 L=0.28U W=0.36U AS=0.1152P AD=0.1584P
+ PS=1U PD=1.6U
M$584 VDD RB13 \$1070 VDD pfet_03v3 L=0.28U W=0.72U AS=0.3708P AD=0.3168P
+ PS=2.47U PD=2.32U
M$585 \$970 \$136 VDD VDD pfet_03v3 L=0.28U W=0.72U AS=0.3168P AD=0.2097P
+ PS=2.32U PD=1.38U
M$586 \$971 \$1142 \$970 VDD pfet_03v3 L=0.28U W=0.36U AS=0.2097P AD=0.1278P
+ PS=1.38U PD=1.07U
M$587 \$1241 \$1071 \$971 VDD pfet_03v3 L=0.28U W=0.36U AS=0.1278P AD=0.0567P
+ PS=1.07U PD=0.675U
M$588 VDD \$949 \$1241 VDD pfet_03v3 L=0.28U W=0.36U AS=0.0567P AD=0.1584P
+ PS=0.675U PD=1.6U
M$589 \$1071 \$971 VDD VDD pfet_03v3 L=0.28U W=0.36U AS=0.1764P AD=0.1584P
+ PS=1.26U PD=1.6U
M$590 \$942 \$971 VDD VDD pfet_03v3 L=0.28U W=0.72U AS=0.1764P AD=0.36P
+ PS=1.26U PD=2.44U
M$591 \$1072 RA13 VDD VDD pfet_03v3 L=0.28U W=0.72U AS=0.3312P AD=0.3888P
+ PS=2.36U PD=2.52U
M$592 \$942 \$1072 \$71 VDD pfet_03v3 L=0.28U W=0.36U AS=0.1584P AD=0.1152P
+ PS=1.6U PD=1U
M$593 \$72 \$1073 \$942 VDD pfet_03v3 L=0.28U W=0.36U AS=0.1152P AD=0.1584P
+ PS=1U PD=1.6U
M$594 VDD RB13 \$1073 VDD pfet_03v3 L=0.28U W=0.72U AS=0.3708P AD=0.3168P
+ PS=2.47U PD=2.32U
M$595 \$972 \$139 VDD VDD pfet_03v3 L=0.28U W=0.72U AS=0.3168P AD=0.2097P
+ PS=2.32U PD=1.38U
M$596 \$973 \$1142 \$972 VDD pfet_03v3 L=0.28U W=0.36U AS=0.2097P AD=0.1278P
+ PS=1.38U PD=1.07U
M$597 \$1222 \$1074 \$973 VDD pfet_03v3 L=0.28U W=0.36U AS=0.1278P AD=0.0567P
+ PS=1.07U PD=0.675U
M$598 VDD \$949 \$1222 VDD pfet_03v3 L=0.28U W=0.36U AS=0.0567P AD=0.1584P
+ PS=0.675U PD=1.6U
M$599 \$1074 \$973 VDD VDD pfet_03v3 L=0.28U W=0.36U AS=0.1764P AD=0.1584P
+ PS=1.26U PD=1.6U
M$600 \$943 \$973 VDD VDD pfet_03v3 L=0.28U W=0.72U AS=0.1764P AD=0.36P
+ PS=1.26U PD=2.44U
M$601 \$1075 RA13 VDD VDD pfet_03v3 L=0.28U W=0.72U AS=0.3312P AD=0.3888P
+ PS=2.36U PD=2.52U
M$602 \$943 \$1075 \$73 VDD pfet_03v3 L=0.28U W=0.36U AS=0.1584P AD=0.1152P
+ PS=1.6U PD=1U
M$603 \$74 \$1076 \$943 VDD pfet_03v3 L=0.28U W=0.36U AS=0.1152P AD=0.1584P
+ PS=1U PD=1.6U
M$604 VDD RB13 \$1076 VDD pfet_03v3 L=0.28U W=0.72U AS=0.3708P AD=0.3168P
+ PS=2.47U PD=2.32U
M$605 \$974 \$142 VDD VDD pfet_03v3 L=0.28U W=0.72U AS=0.3168P AD=0.2097P
+ PS=2.32U PD=1.38U
M$606 \$975 \$1142 \$974 VDD pfet_03v3 L=0.28U W=0.36U AS=0.2097P AD=0.1278P
+ PS=1.38U PD=1.07U
M$607 \$1207 \$1077 \$975 VDD pfet_03v3 L=0.28U W=0.36U AS=0.1278P AD=0.0567P
+ PS=1.07U PD=0.675U
M$608 VDD \$949 \$1207 VDD pfet_03v3 L=0.28U W=0.36U AS=0.0567P AD=0.1584P
+ PS=0.675U PD=1.6U
M$609 \$1077 \$975 VDD VDD pfet_03v3 L=0.28U W=0.36U AS=0.1764P AD=0.1584P
+ PS=1.26U PD=1.6U
M$610 \$944 \$975 VDD VDD pfet_03v3 L=0.28U W=0.72U AS=0.1764P AD=0.36P
+ PS=1.26U PD=2.44U
M$611 \$1078 RA13 VDD VDD pfet_03v3 L=0.28U W=0.72U AS=0.3312P AD=0.3888P
+ PS=2.36U PD=2.52U
M$612 \$944 \$1078 \$75 VDD pfet_03v3 L=0.28U W=0.36U AS=0.1584P AD=0.1152P
+ PS=1.6U PD=1U
M$613 \$76 \$1079 \$944 VDD pfet_03v3 L=0.28U W=0.36U AS=0.1152P AD=0.1584P
+ PS=1U PD=1.6U
M$614 VDD RB13 \$1079 VDD pfet_03v3 L=0.28U W=0.72U AS=0.3708P AD=0.3168P
+ PS=2.47U PD=2.32U
M$615 \$976 \$145 VDD VDD pfet_03v3 L=0.28U W=0.72U AS=0.3168P AD=0.2097P
+ PS=2.32U PD=1.38U
M$616 \$977 \$1142 \$976 VDD pfet_03v3 L=0.28U W=0.36U AS=0.2097P AD=0.1278P
+ PS=1.38U PD=1.07U
M$617 \$1190 \$1080 \$977 VDD pfet_03v3 L=0.28U W=0.36U AS=0.1278P AD=0.0567P
+ PS=1.07U PD=0.675U
M$618 VDD \$949 \$1190 VDD pfet_03v3 L=0.28U W=0.36U AS=0.0567P AD=0.1584P
+ PS=0.675U PD=1.6U
M$619 \$1080 \$977 VDD VDD pfet_03v3 L=0.28U W=0.36U AS=0.1764P AD=0.1584P
+ PS=1.26U PD=1.6U
M$620 \$945 \$977 VDD VDD pfet_03v3 L=0.28U W=0.72U AS=0.1764P AD=0.36P
+ PS=1.26U PD=2.44U
M$621 \$1081 RA13 VDD VDD pfet_03v3 L=0.28U W=0.72U AS=0.3312P AD=0.3888P
+ PS=2.36U PD=2.52U
M$622 \$945 \$1081 \$77 VDD pfet_03v3 L=0.28U W=0.36U AS=0.1584P AD=0.1152P
+ PS=1.6U PD=1U
M$623 \$78 \$1082 \$945 VDD pfet_03v3 L=0.28U W=0.36U AS=0.1152P AD=0.1584P
+ PS=1U PD=1.6U
M$624 VDD RB13 \$1082 VDD pfet_03v3 L=0.28U W=0.72U AS=0.3708P AD=0.3168P
+ PS=2.47U PD=2.32U
M$625 \$978 \$148 VDD VDD pfet_03v3 L=0.28U W=0.72U AS=0.3168P AD=0.2097P
+ PS=2.32U PD=1.38U
M$626 \$979 \$1142 \$978 VDD pfet_03v3 L=0.28U W=0.36U AS=0.2097P AD=0.1278P
+ PS=1.38U PD=1.07U
M$627 \$1171 \$1083 \$979 VDD pfet_03v3 L=0.28U W=0.36U AS=0.1278P AD=0.0567P
+ PS=1.07U PD=0.675U
M$628 VDD \$949 \$1171 VDD pfet_03v3 L=0.28U W=0.36U AS=0.0567P AD=0.1584P
+ PS=0.675U PD=1.6U
M$629 \$1083 \$979 VDD VDD pfet_03v3 L=0.28U W=0.36U AS=0.1764P AD=0.1584P
+ PS=1.26U PD=1.6U
M$630 \$946 \$979 VDD VDD pfet_03v3 L=0.28U W=0.72U AS=0.1764P AD=0.36P
+ PS=1.26U PD=2.44U
M$631 \$1084 RA13 VDD VDD pfet_03v3 L=0.28U W=0.72U AS=0.3312P AD=0.3888P
+ PS=2.36U PD=2.52U
M$632 \$946 \$1084 \$79 VDD pfet_03v3 L=0.28U W=0.36U AS=0.1584P AD=0.1152P
+ PS=1.6U PD=1U
M$633 \$80 \$1085 \$946 VDD pfet_03v3 L=0.28U W=0.36U AS=0.1152P AD=0.1584P
+ PS=1U PD=1.6U
M$634 VDD RB13 \$1085 VDD pfet_03v3 L=0.28U W=0.72U AS=0.3708P AD=0.3168P
+ PS=2.47U PD=2.32U
M$635 \$980 \$151 VDD VDD pfet_03v3 L=0.28U W=0.72U AS=0.3168P AD=0.2097P
+ PS=2.32U PD=1.38U
M$636 \$981 \$1142 \$980 VDD pfet_03v3 L=0.28U W=0.36U AS=0.2097P AD=0.1278P
+ PS=1.38U PD=1.07U
M$637 \$1152 \$1086 \$981 VDD pfet_03v3 L=0.28U W=0.36U AS=0.1278P AD=0.0567P
+ PS=1.07U PD=0.675U
M$638 VDD \$949 \$1152 VDD pfet_03v3 L=0.28U W=0.36U AS=0.0567P AD=0.1584P
+ PS=0.675U PD=1.6U
M$639 \$1086 \$981 VDD VDD pfet_03v3 L=0.28U W=0.36U AS=0.1764P AD=0.1584P
+ PS=1.26U PD=1.6U
M$640 \$947 \$981 VDD VDD pfet_03v3 L=0.28U W=0.72U AS=0.1764P AD=0.36P
+ PS=1.26U PD=2.44U
M$641 \$1087 RA13 VDD VDD pfet_03v3 L=0.28U W=0.72U AS=0.3312P AD=0.3888P
+ PS=2.36U PD=2.52U
M$642 \$947 \$1087 \$81 VDD pfet_03v3 L=0.28U W=0.36U AS=0.1584P AD=0.1152P
+ PS=1.6U PD=1U
M$643 \$82 \$1088 \$947 VDD pfet_03v3 L=0.28U W=0.36U AS=0.1152P AD=0.1584P
+ PS=1U PD=1.6U
M$644 VDD RB13 \$1088 VDD pfet_03v3 L=0.28U W=0.72U AS=0.3708P AD=0.3168P
+ PS=2.47U PD=2.32U
M$645 \$1248 WE12 VDD VDD pfet_03v3 L=0.28U W=0.72U AS=0.3168P AD=0.1872P
+ PS=2.32U PD=1.24U
M$646 VDD CLK \$1248 VDD pfet_03v3 L=0.28U W=0.72U AS=0.1872P AD=0.3168P
+ PS=1.24U PD=2.32U
M$647 \$1249 \$1248 VDD VDD pfet_03v3 L=0.28U W=2.54U AS=0.889P AD=0.6688P
+ PS=5.21U PD=3.65U
M$649 \$1250 \$1249 VDD VDD pfet_03v3 L=0.28U W=2.68U AS=0.7272P AD=0.9782P
+ PS=3.78U PD=5.48U
M$651 \$1252 \$1250 \$1251 VDD pfet_03v3 L=0.28U W=0.36U AS=0.2097P AD=0.1278P
+ PS=1.38U PD=1.07U
M$652 \$1353 \$1253 \$1252 VDD pfet_03v3 L=0.28U W=0.36U AS=0.1278P AD=0.0567P
+ PS=1.07U PD=0.675U
M$653 VDD \$1249 \$1353 VDD pfet_03v3 L=0.28U W=0.36U AS=0.0567P AD=0.1584P
+ PS=0.675U PD=1.6U
M$654 \$1251 \$106 VDD VDD pfet_03v3 L=0.28U W=0.72U AS=0.3168P AD=0.2097P
+ PS=2.32U PD=1.38U
M$655 VDD \$1252 \$1253 VDD pfet_03v3 L=0.28U W=0.36U AS=0.1584P AD=0.1764P
+ PS=1.6U PD=1.26U
M$656 \$1254 \$1252 VDD VDD pfet_03v3 L=0.28U W=0.72U AS=0.1764P AD=0.36P
+ PS=1.26U PD=2.44U
M$657 \$1256 RB12 VDD VDD pfet_03v3 L=0.28U W=0.72U AS=0.3312P AD=0.3888P
+ PS=2.36U PD=2.52U
M$658 \$1254 \$1256 \$51 VDD pfet_03v3 L=0.28U W=0.36U AS=0.1584P AD=0.1152P
+ PS=1.6U PD=1U
M$659 \$52 \$1257 \$1254 VDD pfet_03v3 L=0.28U W=0.36U AS=0.1152P AD=0.1584P
+ PS=1U PD=1.6U
M$660 VDD RA12 \$1257 VDD pfet_03v3 L=0.28U W=0.72U AS=0.3708P AD=0.3168P
+ PS=2.47U PD=2.32U
M$661 \$1259 \$1250 \$1258 VDD pfet_03v3 L=0.28U W=0.36U AS=0.2097P AD=0.1278P
+ PS=1.38U PD=1.07U
M$662 \$1362 \$1260 \$1259 VDD pfet_03v3 L=0.28U W=0.36U AS=0.1278P AD=0.0567P
+ PS=1.07U PD=0.675U
M$663 VDD \$1249 \$1362 VDD pfet_03v3 L=0.28U W=0.36U AS=0.0567P AD=0.1584P
+ PS=0.675U PD=1.6U
M$664 \$1258 \$109 VDD VDD pfet_03v3 L=0.28U W=0.72U AS=0.3168P AD=0.2097P
+ PS=2.32U PD=1.38U
M$665 VDD \$1259 \$1260 VDD pfet_03v3 L=0.28U W=0.36U AS=0.1584P AD=0.1764P
+ PS=1.6U PD=1.26U
M$666 \$1261 \$1259 VDD VDD pfet_03v3 L=0.28U W=0.72U AS=0.1764P AD=0.36P
+ PS=1.26U PD=2.44U
M$667 \$1262 RB12 VDD VDD pfet_03v3 L=0.28U W=0.72U AS=0.3312P AD=0.3888P
+ PS=2.36U PD=2.52U
M$668 \$1261 \$1262 \$53 VDD pfet_03v3 L=0.28U W=0.36U AS=0.1584P AD=0.1152P
+ PS=1.6U PD=1U
M$669 \$54 \$1263 \$1261 VDD pfet_03v3 L=0.28U W=0.36U AS=0.1152P AD=0.1584P
+ PS=1U PD=1.6U
M$670 VDD RA12 \$1263 VDD pfet_03v3 L=0.28U W=0.72U AS=0.3708P AD=0.3168P
+ PS=2.47U PD=2.32U
M$671 \$1265 \$1250 \$1264 VDD pfet_03v3 L=0.28U W=0.36U AS=0.2097P AD=0.1278P
+ PS=1.38U PD=1.07U
M$672 \$1373 \$1266 \$1265 VDD pfet_03v3 L=0.28U W=0.36U AS=0.1278P AD=0.0567P
+ PS=1.07U PD=0.675U
M$673 VDD \$1249 \$1373 VDD pfet_03v3 L=0.28U W=0.36U AS=0.0567P AD=0.1584P
+ PS=0.675U PD=1.6U
M$674 \$1264 \$112 VDD VDD pfet_03v3 L=0.28U W=0.72U AS=0.3168P AD=0.2097P
+ PS=2.32U PD=1.38U
M$675 VDD \$1265 \$1266 VDD pfet_03v3 L=0.28U W=0.36U AS=0.1584P AD=0.1764P
+ PS=1.6U PD=1.26U
M$676 \$1267 \$1265 VDD VDD pfet_03v3 L=0.28U W=0.72U AS=0.1764P AD=0.36P
+ PS=1.26U PD=2.44U
M$677 \$1268 RB12 VDD VDD pfet_03v3 L=0.28U W=0.72U AS=0.3312P AD=0.3888P
+ PS=2.36U PD=2.52U
M$678 \$1267 \$1268 \$55 VDD pfet_03v3 L=0.28U W=0.36U AS=0.1584P AD=0.1152P
+ PS=1.6U PD=1U
M$679 \$56 \$1269 \$1267 VDD pfet_03v3 L=0.28U W=0.36U AS=0.1152P AD=0.1584P
+ PS=1U PD=1.6U
M$680 VDD RA12 \$1269 VDD pfet_03v3 L=0.28U W=0.72U AS=0.3708P AD=0.3168P
+ PS=2.47U PD=2.32U
M$681 \$1271 \$1250 \$1270 VDD pfet_03v3 L=0.28U W=0.36U AS=0.2097P AD=0.1278P
+ PS=1.38U PD=1.07U
M$682 \$1383 \$1272 \$1271 VDD pfet_03v3 L=0.28U W=0.36U AS=0.1278P AD=0.0567P
+ PS=1.07U PD=0.675U
M$683 VDD \$1249 \$1383 VDD pfet_03v3 L=0.28U W=0.36U AS=0.0567P AD=0.1584P
+ PS=0.675U PD=1.6U
M$684 \$1270 \$115 VDD VDD pfet_03v3 L=0.28U W=0.72U AS=0.3168P AD=0.2097P
+ PS=2.32U PD=1.38U
M$685 VDD \$1271 \$1272 VDD pfet_03v3 L=0.28U W=0.36U AS=0.1584P AD=0.1764P
+ PS=1.6U PD=1.26U
M$686 \$1273 \$1271 VDD VDD pfet_03v3 L=0.28U W=0.72U AS=0.1764P AD=0.36P
+ PS=1.26U PD=2.44U
M$687 \$1274 RB12 VDD VDD pfet_03v3 L=0.28U W=0.72U AS=0.3312P AD=0.3888P
+ PS=2.36U PD=2.52U
M$688 \$1273 \$1274 \$57 VDD pfet_03v3 L=0.28U W=0.36U AS=0.1584P AD=0.1152P
+ PS=1.6U PD=1U
M$689 \$58 \$1275 \$1273 VDD pfet_03v3 L=0.28U W=0.36U AS=0.1152P AD=0.1584P
+ PS=1U PD=1.6U
M$690 VDD RA12 \$1275 VDD pfet_03v3 L=0.28U W=0.72U AS=0.3708P AD=0.3168P
+ PS=2.47U PD=2.32U
M$691 \$1277 \$1250 \$1276 VDD pfet_03v3 L=0.28U W=0.36U AS=0.2097P AD=0.1278P
+ PS=1.38U PD=1.07U
M$692 \$1394 \$1278 \$1277 VDD pfet_03v3 L=0.28U W=0.36U AS=0.1278P AD=0.0567P
+ PS=1.07U PD=0.675U
M$693 VDD \$1249 \$1394 VDD pfet_03v3 L=0.28U W=0.36U AS=0.0567P AD=0.1584P
+ PS=0.675U PD=1.6U
M$694 \$1276 \$118 VDD VDD pfet_03v3 L=0.28U W=0.72U AS=0.3168P AD=0.2097P
+ PS=2.32U PD=1.38U
M$695 VDD \$1277 \$1278 VDD pfet_03v3 L=0.28U W=0.36U AS=0.1584P AD=0.1764P
+ PS=1.6U PD=1.26U
M$696 \$1279 \$1277 VDD VDD pfet_03v3 L=0.28U W=0.72U AS=0.1764P AD=0.36P
+ PS=1.26U PD=2.44U
M$697 \$1280 RB12 VDD VDD pfet_03v3 L=0.28U W=0.72U AS=0.3312P AD=0.3888P
+ PS=2.36U PD=2.52U
M$698 \$1279 \$1280 \$59 VDD pfet_03v3 L=0.28U W=0.36U AS=0.1584P AD=0.1152P
+ PS=1.6U PD=1U
M$699 \$60 \$1281 \$1279 VDD pfet_03v3 L=0.28U W=0.36U AS=0.1152P AD=0.1584P
+ PS=1U PD=1.6U
M$700 VDD RA12 \$1281 VDD pfet_03v3 L=0.28U W=0.72U AS=0.3708P AD=0.3168P
+ PS=2.47U PD=2.32U
M$701 \$1283 \$1250 \$1282 VDD pfet_03v3 L=0.28U W=0.36U AS=0.2097P AD=0.1278P
+ PS=1.38U PD=1.07U
M$702 \$1403 \$1284 \$1283 VDD pfet_03v3 L=0.28U W=0.36U AS=0.1278P AD=0.0567P
+ PS=1.07U PD=0.675U
M$703 VDD \$1249 \$1403 VDD pfet_03v3 L=0.28U W=0.36U AS=0.0567P AD=0.1584P
+ PS=0.675U PD=1.6U
M$704 \$1282 \$121 VDD VDD pfet_03v3 L=0.28U W=0.72U AS=0.3168P AD=0.2097P
+ PS=2.32U PD=1.38U
M$705 VDD \$1283 \$1284 VDD pfet_03v3 L=0.28U W=0.36U AS=0.1584P AD=0.1764P
+ PS=1.6U PD=1.26U
M$706 \$1285 \$1283 VDD VDD pfet_03v3 L=0.28U W=0.72U AS=0.1764P AD=0.36P
+ PS=1.26U PD=2.44U
M$707 \$1286 RB12 VDD VDD pfet_03v3 L=0.28U W=0.72U AS=0.3312P AD=0.3888P
+ PS=2.36U PD=2.52U
M$708 \$1285 \$1286 \$61 VDD pfet_03v3 L=0.28U W=0.36U AS=0.1584P AD=0.1152P
+ PS=1.6U PD=1U
M$709 \$62 \$1287 \$1285 VDD pfet_03v3 L=0.28U W=0.36U AS=0.1152P AD=0.1584P
+ PS=1U PD=1.6U
M$710 VDD RA12 \$1287 VDD pfet_03v3 L=0.28U W=0.72U AS=0.3708P AD=0.3168P
+ PS=2.47U PD=2.32U
M$711 \$1289 \$1250 \$1288 VDD pfet_03v3 L=0.28U W=0.36U AS=0.2097P AD=0.1278P
+ PS=1.38U PD=1.07U
M$712 \$1413 \$1290 \$1289 VDD pfet_03v3 L=0.28U W=0.36U AS=0.1278P AD=0.0567P
+ PS=1.07U PD=0.675U
M$713 VDD \$1249 \$1413 VDD pfet_03v3 L=0.28U W=0.36U AS=0.0567P AD=0.1584P
+ PS=0.675U PD=1.6U
M$714 \$1288 \$124 VDD VDD pfet_03v3 L=0.28U W=0.72U AS=0.3168P AD=0.2097P
+ PS=2.32U PD=1.38U
M$715 VDD \$1289 \$1290 VDD pfet_03v3 L=0.28U W=0.36U AS=0.1584P AD=0.1764P
+ PS=1.6U PD=1.26U
M$716 \$1291 \$1289 VDD VDD pfet_03v3 L=0.28U W=0.72U AS=0.1764P AD=0.36P
+ PS=1.26U PD=2.44U
M$717 \$1292 RB12 VDD VDD pfet_03v3 L=0.28U W=0.72U AS=0.3312P AD=0.3888P
+ PS=2.36U PD=2.52U
M$718 \$1291 \$1292 \$63 VDD pfet_03v3 L=0.28U W=0.36U AS=0.1584P AD=0.1152P
+ PS=1.6U PD=1U
M$719 \$64 \$1293 \$1291 VDD pfet_03v3 L=0.28U W=0.36U AS=0.1152P AD=0.1584P
+ PS=1U PD=1.6U
M$720 VDD RA12 \$1293 VDD pfet_03v3 L=0.28U W=0.72U AS=0.3708P AD=0.3168P
+ PS=2.47U PD=2.32U
M$721 \$1295 \$1250 \$1294 VDD pfet_03v3 L=0.28U W=0.36U AS=0.2097P AD=0.1278P
+ PS=1.38U PD=1.07U
M$722 \$1423 \$1296 \$1295 VDD pfet_03v3 L=0.28U W=0.36U AS=0.1278P AD=0.0567P
+ PS=1.07U PD=0.675U
M$723 VDD \$1249 \$1423 VDD pfet_03v3 L=0.28U W=0.36U AS=0.0567P AD=0.1584P
+ PS=0.675U PD=1.6U
M$724 \$1294 \$127 VDD VDD pfet_03v3 L=0.28U W=0.72U AS=0.3168P AD=0.2097P
+ PS=2.32U PD=1.38U
M$725 VDD \$1295 \$1296 VDD pfet_03v3 L=0.28U W=0.36U AS=0.1584P AD=0.1764P
+ PS=1.6U PD=1.26U
M$726 \$1297 \$1295 VDD VDD pfet_03v3 L=0.28U W=0.72U AS=0.1764P AD=0.36P
+ PS=1.26U PD=2.44U
M$727 \$1298 RB12 VDD VDD pfet_03v3 L=0.28U W=0.72U AS=0.3312P AD=0.3888P
+ PS=2.36U PD=2.52U
M$728 \$1297 \$1298 \$65 VDD pfet_03v3 L=0.28U W=0.36U AS=0.1584P AD=0.1152P
+ PS=1.6U PD=1U
M$729 \$66 \$1299 \$1297 VDD pfet_03v3 L=0.28U W=0.36U AS=0.1152P AD=0.1584P
+ PS=1U PD=1.6U
M$730 VDD RA12 \$1299 VDD pfet_03v3 L=0.28U W=0.72U AS=0.3708P AD=0.3168P
+ PS=2.47U PD=2.32U
M$731 \$1301 \$1250 \$1300 VDD pfet_03v3 L=0.28U W=0.36U AS=0.2097P AD=0.1278P
+ PS=1.38U PD=1.07U
M$732 \$1433 \$1302 \$1301 VDD pfet_03v3 L=0.28U W=0.36U AS=0.1278P AD=0.0567P
+ PS=1.07U PD=0.675U
M$733 VDD \$1249 \$1433 VDD pfet_03v3 L=0.28U W=0.36U AS=0.0567P AD=0.1584P
+ PS=0.675U PD=1.6U
M$734 \$1300 \$130 VDD VDD pfet_03v3 L=0.28U W=0.72U AS=0.3168P AD=0.2097P
+ PS=2.32U PD=1.38U
M$735 VDD \$1301 \$1302 VDD pfet_03v3 L=0.28U W=0.36U AS=0.1584P AD=0.1764P
+ PS=1.6U PD=1.26U
M$736 \$1303 \$1301 VDD VDD pfet_03v3 L=0.28U W=0.72U AS=0.1764P AD=0.36P
+ PS=1.26U PD=2.44U
M$737 \$1304 RB12 VDD VDD pfet_03v3 L=0.28U W=0.72U AS=0.3312P AD=0.3888P
+ PS=2.36U PD=2.52U
M$738 \$1303 \$1304 \$67 VDD pfet_03v3 L=0.28U W=0.36U AS=0.1584P AD=0.1152P
+ PS=1.6U PD=1U
M$739 \$68 \$1305 \$1303 VDD pfet_03v3 L=0.28U W=0.36U AS=0.1152P AD=0.1584P
+ PS=1U PD=1.6U
M$740 VDD RA12 \$1305 VDD pfet_03v3 L=0.28U W=0.72U AS=0.3708P AD=0.3168P
+ PS=2.47U PD=2.32U
M$741 \$1307 \$1250 \$1306 VDD pfet_03v3 L=0.28U W=0.36U AS=0.2097P AD=0.1278P
+ PS=1.38U PD=1.07U
M$742 \$1443 \$1308 \$1307 VDD pfet_03v3 L=0.28U W=0.36U AS=0.1278P AD=0.0567P
+ PS=1.07U PD=0.675U
M$743 VDD \$1249 \$1443 VDD pfet_03v3 L=0.28U W=0.36U AS=0.0567P AD=0.1584P
+ PS=0.675U PD=1.6U
M$744 \$1306 \$133 VDD VDD pfet_03v3 L=0.28U W=0.72U AS=0.3168P AD=0.2097P
+ PS=2.32U PD=1.38U
M$745 VDD \$1307 \$1308 VDD pfet_03v3 L=0.28U W=0.36U AS=0.1584P AD=0.1764P
+ PS=1.6U PD=1.26U
M$746 \$1309 \$1307 VDD VDD pfet_03v3 L=0.28U W=0.72U AS=0.1764P AD=0.36P
+ PS=1.26U PD=2.44U
M$747 \$1310 RB12 VDD VDD pfet_03v3 L=0.28U W=0.72U AS=0.3312P AD=0.3888P
+ PS=2.36U PD=2.52U
M$748 \$1309 \$1310 \$69 VDD pfet_03v3 L=0.28U W=0.36U AS=0.1584P AD=0.1152P
+ PS=1.6U PD=1U
M$749 \$70 \$1311 \$1309 VDD pfet_03v3 L=0.28U W=0.36U AS=0.1152P AD=0.1584P
+ PS=1U PD=1.6U
M$750 VDD RA12 \$1311 VDD pfet_03v3 L=0.28U W=0.72U AS=0.3708P AD=0.3168P
+ PS=2.47U PD=2.32U
M$751 \$1313 \$1250 \$1312 VDD pfet_03v3 L=0.28U W=0.36U AS=0.2097P AD=0.1278P
+ PS=1.38U PD=1.07U
M$752 \$1429 \$1314 \$1313 VDD pfet_03v3 L=0.28U W=0.36U AS=0.1278P AD=0.0567P
+ PS=1.07U PD=0.675U
M$753 VDD \$1249 \$1429 VDD pfet_03v3 L=0.28U W=0.36U AS=0.0567P AD=0.1584P
+ PS=0.675U PD=1.6U
M$754 \$1312 \$136 VDD VDD pfet_03v3 L=0.28U W=0.72U AS=0.3168P AD=0.2097P
+ PS=2.32U PD=1.38U
M$755 VDD \$1313 \$1314 VDD pfet_03v3 L=0.28U W=0.36U AS=0.1584P AD=0.1764P
+ PS=1.6U PD=1.26U
M$756 \$1315 \$1313 VDD VDD pfet_03v3 L=0.28U W=0.72U AS=0.1764P AD=0.36P
+ PS=1.26U PD=2.44U
M$757 \$1316 RB12 VDD VDD pfet_03v3 L=0.28U W=0.72U AS=0.3312P AD=0.3888P
+ PS=2.36U PD=2.52U
M$758 \$1315 \$1316 \$71 VDD pfet_03v3 L=0.28U W=0.36U AS=0.1584P AD=0.1152P
+ PS=1.6U PD=1U
M$759 \$72 \$1317 \$1315 VDD pfet_03v3 L=0.28U W=0.36U AS=0.1152P AD=0.1584P
+ PS=1U PD=1.6U
M$760 VDD RA12 \$1317 VDD pfet_03v3 L=0.28U W=0.72U AS=0.3708P AD=0.3168P
+ PS=2.47U PD=2.32U
M$761 \$1319 \$1250 \$1318 VDD pfet_03v3 L=0.28U W=0.36U AS=0.2097P AD=0.1278P
+ PS=1.38U PD=1.07U
M$762 \$1415 \$1320 \$1319 VDD pfet_03v3 L=0.28U W=0.36U AS=0.1278P AD=0.0567P
+ PS=1.07U PD=0.675U
M$763 VDD \$1249 \$1415 VDD pfet_03v3 L=0.28U W=0.36U AS=0.0567P AD=0.1584P
+ PS=0.675U PD=1.6U
M$764 \$1318 \$139 VDD VDD pfet_03v3 L=0.28U W=0.72U AS=0.3168P AD=0.2097P
+ PS=2.32U PD=1.38U
M$765 VDD \$1319 \$1320 VDD pfet_03v3 L=0.28U W=0.36U AS=0.1584P AD=0.1764P
+ PS=1.6U PD=1.26U
M$766 \$1321 \$1319 VDD VDD pfet_03v3 L=0.28U W=0.72U AS=0.1764P AD=0.36P
+ PS=1.26U PD=2.44U
M$767 \$1322 RB12 VDD VDD pfet_03v3 L=0.28U W=0.72U AS=0.3312P AD=0.3888P
+ PS=2.36U PD=2.52U
M$768 \$1321 \$1322 \$73 VDD pfet_03v3 L=0.28U W=0.36U AS=0.1584P AD=0.1152P
+ PS=1.6U PD=1U
M$769 \$74 \$1323 \$1321 VDD pfet_03v3 L=0.28U W=0.36U AS=0.1152P AD=0.1584P
+ PS=1U PD=1.6U
M$770 VDD RA12 \$1323 VDD pfet_03v3 L=0.28U W=0.72U AS=0.3708P AD=0.3168P
+ PS=2.47U PD=2.32U
M$771 \$1325 \$1250 \$1324 VDD pfet_03v3 L=0.28U W=0.36U AS=0.2097P AD=0.1278P
+ PS=1.38U PD=1.07U
M$772 \$1399 \$1326 \$1325 VDD pfet_03v3 L=0.28U W=0.36U AS=0.1278P AD=0.0567P
+ PS=1.07U PD=0.675U
M$773 VDD \$1249 \$1399 VDD pfet_03v3 L=0.28U W=0.36U AS=0.0567P AD=0.1584P
+ PS=0.675U PD=1.6U
M$774 \$1324 \$142 VDD VDD pfet_03v3 L=0.28U W=0.72U AS=0.3168P AD=0.2097P
+ PS=2.32U PD=1.38U
M$775 VDD \$1325 \$1326 VDD pfet_03v3 L=0.28U W=0.36U AS=0.1584P AD=0.1764P
+ PS=1.6U PD=1.26U
M$776 \$1327 \$1325 VDD VDD pfet_03v3 L=0.28U W=0.72U AS=0.1764P AD=0.36P
+ PS=1.26U PD=2.44U
M$777 \$1328 RB12 VDD VDD pfet_03v3 L=0.28U W=0.72U AS=0.3312P AD=0.3888P
+ PS=2.36U PD=2.52U
M$778 \$1327 \$1328 \$75 VDD pfet_03v3 L=0.28U W=0.36U AS=0.1584P AD=0.1152P
+ PS=1.6U PD=1U
M$779 \$76 \$1329 \$1327 VDD pfet_03v3 L=0.28U W=0.36U AS=0.1152P AD=0.1584P
+ PS=1U PD=1.6U
M$780 VDD RA12 \$1329 VDD pfet_03v3 L=0.28U W=0.72U AS=0.3708P AD=0.3168P
+ PS=2.47U PD=2.32U
M$781 \$1331 \$1250 \$1330 VDD pfet_03v3 L=0.28U W=0.36U AS=0.2097P AD=0.1278P
+ PS=1.38U PD=1.07U
M$782 \$1388 \$1332 \$1331 VDD pfet_03v3 L=0.28U W=0.36U AS=0.1278P AD=0.0567P
+ PS=1.07U PD=0.675U
M$783 VDD \$1249 \$1388 VDD pfet_03v3 L=0.28U W=0.36U AS=0.0567P AD=0.1584P
+ PS=0.675U PD=1.6U
M$784 \$1330 \$145 VDD VDD pfet_03v3 L=0.28U W=0.72U AS=0.3168P AD=0.2097P
+ PS=2.32U PD=1.38U
M$785 VDD \$1331 \$1332 VDD pfet_03v3 L=0.28U W=0.36U AS=0.1584P AD=0.1764P
+ PS=1.6U PD=1.26U
M$786 \$1333 \$1331 VDD VDD pfet_03v3 L=0.28U W=0.72U AS=0.1764P AD=0.36P
+ PS=1.26U PD=2.44U
M$787 \$1334 RB12 VDD VDD pfet_03v3 L=0.28U W=0.72U AS=0.3312P AD=0.3888P
+ PS=2.36U PD=2.52U
M$788 \$1333 \$1334 \$77 VDD pfet_03v3 L=0.28U W=0.36U AS=0.1584P AD=0.1152P
+ PS=1.6U PD=1U
M$789 \$78 \$1335 \$1333 VDD pfet_03v3 L=0.28U W=0.36U AS=0.1152P AD=0.1584P
+ PS=1U PD=1.6U
M$790 VDD RA12 \$1335 VDD pfet_03v3 L=0.28U W=0.72U AS=0.3708P AD=0.3168P
+ PS=2.47U PD=2.32U
M$791 \$1337 \$1250 \$1336 VDD pfet_03v3 L=0.28U W=0.36U AS=0.2097P AD=0.1278P
+ PS=1.38U PD=1.07U
M$792 \$1372 \$1338 \$1337 VDD pfet_03v3 L=0.28U W=0.36U AS=0.1278P AD=0.0567P
+ PS=1.07U PD=0.675U
M$793 VDD \$1249 \$1372 VDD pfet_03v3 L=0.28U W=0.36U AS=0.0567P AD=0.1584P
+ PS=0.675U PD=1.6U
M$794 \$1336 \$148 VDD VDD pfet_03v3 L=0.28U W=0.72U AS=0.3168P AD=0.2097P
+ PS=2.32U PD=1.38U
M$795 VDD \$1337 \$1338 VDD pfet_03v3 L=0.28U W=0.36U AS=0.1584P AD=0.1764P
+ PS=1.6U PD=1.26U
M$796 \$1339 \$1337 VDD VDD pfet_03v3 L=0.28U W=0.72U AS=0.1764P AD=0.36P
+ PS=1.26U PD=2.44U
M$797 \$1340 RB12 VDD VDD pfet_03v3 L=0.28U W=0.72U AS=0.3312P AD=0.3888P
+ PS=2.36U PD=2.52U
M$798 \$1339 \$1340 \$79 VDD pfet_03v3 L=0.28U W=0.36U AS=0.1584P AD=0.1152P
+ PS=1.6U PD=1U
M$799 \$80 \$1341 \$1339 VDD pfet_03v3 L=0.28U W=0.36U AS=0.1152P AD=0.1584P
+ PS=1U PD=1.6U
M$800 VDD RA12 \$1341 VDD pfet_03v3 L=0.28U W=0.72U AS=0.3708P AD=0.3168P
+ PS=2.47U PD=2.32U
M$801 \$1343 \$1250 \$1342 VDD pfet_03v3 L=0.28U W=0.36U AS=0.2097P AD=0.1278P
+ PS=1.38U PD=1.07U
M$802 \$1358 \$1344 \$1343 VDD pfet_03v3 L=0.28U W=0.36U AS=0.1278P AD=0.0567P
+ PS=1.07U PD=0.675U
M$803 VDD \$1249 \$1358 VDD pfet_03v3 L=0.28U W=0.36U AS=0.0567P AD=0.1584P
+ PS=0.675U PD=1.6U
M$804 \$1342 \$151 VDD VDD pfet_03v3 L=0.28U W=0.72U AS=0.3168P AD=0.2097P
+ PS=2.32U PD=1.38U
M$805 VDD \$1343 \$1344 VDD pfet_03v3 L=0.28U W=0.36U AS=0.1584P AD=0.1764P
+ PS=1.6U PD=1.26U
M$806 \$1345 \$1343 VDD VDD pfet_03v3 L=0.28U W=0.72U AS=0.1764P AD=0.36P
+ PS=1.26U PD=2.44U
M$807 \$1346 RB12 VDD VDD pfet_03v3 L=0.28U W=0.72U AS=0.3312P AD=0.3888P
+ PS=2.36U PD=2.52U
M$808 \$1345 \$1346 \$81 VDD pfet_03v3 L=0.28U W=0.36U AS=0.1584P AD=0.1152P
+ PS=1.6U PD=1U
M$809 \$82 \$1347 \$1345 VDD pfet_03v3 L=0.28U W=0.36U AS=0.1152P AD=0.1584P
+ PS=1U PD=1.6U
M$810 VDD RA12 \$1347 VDD pfet_03v3 L=0.28U W=0.72U AS=0.3708P AD=0.3168P
+ PS=2.47U PD=2.32U
M$811 \$1567 WE11 VDD VDD pfet_03v3 L=0.28U W=0.72U AS=0.3168P AD=0.1872P
+ PS=2.32U PD=1.24U
M$812 VDD CLK \$1567 VDD pfet_03v3 L=0.28U W=0.72U AS=0.1872P AD=0.3168P
+ PS=1.24U PD=2.32U
M$813 \$1568 \$1567 VDD VDD pfet_03v3 L=0.28U W=2.54U AS=0.8974P AD=0.6604P
+ PS=5.28U PD=3.58U
M$815 \$1755 \$1568 VDD VDD pfet_03v3 L=0.28U W=2.68U AS=0.7272P AD=0.9782P
+ PS=3.78U PD=5.48U
M$817 \$1569 \$106 VDD VDD pfet_03v3 L=0.28U W=0.72U AS=0.3168P AD=0.2097P
+ PS=2.32U PD=1.38U
M$818 \$1570 \$1755 \$1569 VDD pfet_03v3 L=0.28U W=0.36U AS=0.2097P AD=0.1278P
+ PS=1.38U PD=1.07U
M$819 \$1761 \$1653 \$1570 VDD pfet_03v3 L=0.28U W=0.36U AS=0.1278P AD=0.0567P
+ PS=1.07U PD=0.675U
M$820 VDD \$1568 \$1761 VDD pfet_03v3 L=0.28U W=0.36U AS=0.0567P AD=0.1584P
+ PS=0.675U PD=1.6U
M$821 \$1653 \$1570 VDD VDD pfet_03v3 L=0.28U W=0.36U AS=0.1764P AD=0.1584P
+ PS=1.26U PD=1.6U
M$822 \$1551 \$1570 VDD VDD pfet_03v3 L=0.28U W=0.72U AS=0.1764P AD=0.36P
+ PS=1.26U PD=2.44U
M$823 \$1655 RA11 VDD VDD pfet_03v3 L=0.28U W=0.72U AS=0.3312P AD=0.3888P
+ PS=2.36U PD=2.52U
M$824 \$1551 \$1655 \$51 VDD pfet_03v3 L=0.28U W=0.36U AS=0.1584P AD=0.1152P
+ PS=1.6U PD=1U
M$825 \$52 \$1656 \$1551 VDD pfet_03v3 L=0.28U W=0.36U AS=0.1152P AD=0.1584P
+ PS=1U PD=1.6U
M$826 VDD RB11 \$1656 VDD pfet_03v3 L=0.28U W=0.72U AS=0.3708P AD=0.3168P
+ PS=2.47U PD=2.32U
M$827 \$1571 \$109 VDD VDD pfet_03v3 L=0.28U W=0.72U AS=0.3168P AD=0.2097P
+ PS=2.32U PD=1.38U
M$828 \$1572 \$1755 \$1571 VDD pfet_03v3 L=0.28U W=0.36U AS=0.2097P AD=0.1278P
+ PS=1.38U PD=1.07U
M$829 \$1773 \$1657 \$1572 VDD pfet_03v3 L=0.28U W=0.36U AS=0.1278P AD=0.0567P
+ PS=1.07U PD=0.675U
M$830 VDD \$1568 \$1773 VDD pfet_03v3 L=0.28U W=0.36U AS=0.0567P AD=0.1584P
+ PS=0.675U PD=1.6U
M$831 \$1657 \$1572 VDD VDD pfet_03v3 L=0.28U W=0.36U AS=0.1764P AD=0.1584P
+ PS=1.26U PD=1.6U
M$832 \$1552 \$1572 VDD VDD pfet_03v3 L=0.28U W=0.72U AS=0.1764P AD=0.36P
+ PS=1.26U PD=2.44U
M$833 \$1658 RA11 VDD VDD pfet_03v3 L=0.28U W=0.72U AS=0.3312P AD=0.3888P
+ PS=2.36U PD=2.52U
M$834 \$1552 \$1658 \$53 VDD pfet_03v3 L=0.28U W=0.36U AS=0.1584P AD=0.1152P
+ PS=1.6U PD=1U
M$835 \$54 \$1659 \$1552 VDD pfet_03v3 L=0.28U W=0.36U AS=0.1152P AD=0.1584P
+ PS=1U PD=1.6U
M$836 VDD RB11 \$1659 VDD pfet_03v3 L=0.28U W=0.72U AS=0.3708P AD=0.3168P
+ PS=2.47U PD=2.32U
M$837 \$1573 \$112 VDD VDD pfet_03v3 L=0.28U W=0.72U AS=0.3168P AD=0.2097P
+ PS=2.32U PD=1.38U
M$838 \$1574 \$1755 \$1573 VDD pfet_03v3 L=0.28U W=0.36U AS=0.2097P AD=0.1278P
+ PS=1.38U PD=1.07U
M$839 \$1782 \$1660 \$1574 VDD pfet_03v3 L=0.28U W=0.36U AS=0.1278P AD=0.0567P
+ PS=1.07U PD=0.675U
M$840 VDD \$1568 \$1782 VDD pfet_03v3 L=0.28U W=0.36U AS=0.0567P AD=0.1584P
+ PS=0.675U PD=1.6U
M$841 \$1660 \$1574 VDD VDD pfet_03v3 L=0.28U W=0.36U AS=0.1764P AD=0.1584P
+ PS=1.26U PD=1.6U
M$842 \$1553 \$1574 VDD VDD pfet_03v3 L=0.28U W=0.72U AS=0.1764P AD=0.36P
+ PS=1.26U PD=2.44U
M$843 \$1661 RA11 VDD VDD pfet_03v3 L=0.28U W=0.72U AS=0.3312P AD=0.3888P
+ PS=2.36U PD=2.52U
M$844 \$1553 \$1661 \$55 VDD pfet_03v3 L=0.28U W=0.36U AS=0.1584P AD=0.1152P
+ PS=1.6U PD=1U
M$845 \$56 \$1662 \$1553 VDD pfet_03v3 L=0.28U W=0.36U AS=0.1152P AD=0.1584P
+ PS=1U PD=1.6U
M$846 VDD RB11 \$1662 VDD pfet_03v3 L=0.28U W=0.72U AS=0.3708P AD=0.3168P
+ PS=2.47U PD=2.32U
M$847 \$1575 \$115 VDD VDD pfet_03v3 L=0.28U W=0.72U AS=0.3168P AD=0.2097P
+ PS=2.32U PD=1.38U
M$848 \$1576 \$1755 \$1575 VDD pfet_03v3 L=0.28U W=0.36U AS=0.2097P AD=0.1278P
+ PS=1.38U PD=1.07U
M$849 \$1793 \$1663 \$1576 VDD pfet_03v3 L=0.28U W=0.36U AS=0.1278P AD=0.0567P
+ PS=1.07U PD=0.675U
M$850 VDD \$1568 \$1793 VDD pfet_03v3 L=0.28U W=0.36U AS=0.0567P AD=0.1584P
+ PS=0.675U PD=1.6U
M$851 \$1663 \$1576 VDD VDD pfet_03v3 L=0.28U W=0.36U AS=0.1764P AD=0.1584P
+ PS=1.26U PD=1.6U
M$852 \$1554 \$1576 VDD VDD pfet_03v3 L=0.28U W=0.72U AS=0.1764P AD=0.36P
+ PS=1.26U PD=2.44U
M$853 \$1664 RA11 VDD VDD pfet_03v3 L=0.28U W=0.72U AS=0.3312P AD=0.3888P
+ PS=2.36U PD=2.52U
M$854 \$1554 \$1664 \$57 VDD pfet_03v3 L=0.28U W=0.36U AS=0.1584P AD=0.1152P
+ PS=1.6U PD=1U
M$855 \$58 \$1665 \$1554 VDD pfet_03v3 L=0.28U W=0.36U AS=0.1152P AD=0.1584P
+ PS=1U PD=1.6U
M$856 VDD RB11 \$1665 VDD pfet_03v3 L=0.28U W=0.72U AS=0.3708P AD=0.3168P
+ PS=2.47U PD=2.32U
M$857 \$1577 \$118 VDD VDD pfet_03v3 L=0.28U W=0.72U AS=0.3168P AD=0.2097P
+ PS=2.32U PD=1.38U
M$858 \$1578 \$1755 \$1577 VDD pfet_03v3 L=0.28U W=0.36U AS=0.2097P AD=0.1278P
+ PS=1.38U PD=1.07U
M$859 \$1802 \$1666 \$1578 VDD pfet_03v3 L=0.28U W=0.36U AS=0.1278P AD=0.0567P
+ PS=1.07U PD=0.675U
M$860 VDD \$1568 \$1802 VDD pfet_03v3 L=0.28U W=0.36U AS=0.0567P AD=0.1584P
+ PS=0.675U PD=1.6U
M$861 \$1666 \$1578 VDD VDD pfet_03v3 L=0.28U W=0.36U AS=0.1764P AD=0.1584P
+ PS=1.26U PD=1.6U
M$862 \$1555 \$1578 VDD VDD pfet_03v3 L=0.28U W=0.72U AS=0.1764P AD=0.36P
+ PS=1.26U PD=2.44U
M$863 \$1667 RA11 VDD VDD pfet_03v3 L=0.28U W=0.72U AS=0.3312P AD=0.3888P
+ PS=2.36U PD=2.52U
M$864 \$1555 \$1667 \$59 VDD pfet_03v3 L=0.28U W=0.36U AS=0.1584P AD=0.1152P
+ PS=1.6U PD=1U
M$865 \$60 \$1668 \$1555 VDD pfet_03v3 L=0.28U W=0.36U AS=0.1152P AD=0.1584P
+ PS=1U PD=1.6U
M$866 VDD RB11 \$1668 VDD pfet_03v3 L=0.28U W=0.72U AS=0.3708P AD=0.3168P
+ PS=2.47U PD=2.32U
M$867 \$1579 \$121 VDD VDD pfet_03v3 L=0.28U W=0.72U AS=0.3168P AD=0.2097P
+ PS=2.32U PD=1.38U
M$868 \$1580 \$1755 \$1579 VDD pfet_03v3 L=0.28U W=0.36U AS=0.2097P AD=0.1278P
+ PS=1.38U PD=1.07U
M$869 \$1812 \$1669 \$1580 VDD pfet_03v3 L=0.28U W=0.36U AS=0.1278P AD=0.0567P
+ PS=1.07U PD=0.675U
M$870 VDD \$1568 \$1812 VDD pfet_03v3 L=0.28U W=0.36U AS=0.0567P AD=0.1584P
+ PS=0.675U PD=1.6U
M$871 \$1669 \$1580 VDD VDD pfet_03v3 L=0.28U W=0.36U AS=0.1764P AD=0.1584P
+ PS=1.26U PD=1.6U
M$872 \$1556 \$1580 VDD VDD pfet_03v3 L=0.28U W=0.72U AS=0.1764P AD=0.36P
+ PS=1.26U PD=2.44U
M$873 \$1670 RA11 VDD VDD pfet_03v3 L=0.28U W=0.72U AS=0.3312P AD=0.3888P
+ PS=2.36U PD=2.52U
M$874 \$1556 \$1670 \$61 VDD pfet_03v3 L=0.28U W=0.36U AS=0.1584P AD=0.1152P
+ PS=1.6U PD=1U
M$875 \$62 \$1671 \$1556 VDD pfet_03v3 L=0.28U W=0.36U AS=0.1152P AD=0.1584P
+ PS=1U PD=1.6U
M$876 VDD RB11 \$1671 VDD pfet_03v3 L=0.28U W=0.72U AS=0.3708P AD=0.3168P
+ PS=2.47U PD=2.32U
M$877 \$1581 \$124 VDD VDD pfet_03v3 L=0.28U W=0.72U AS=0.3168P AD=0.2097P
+ PS=2.32U PD=1.38U
M$878 \$1582 \$1755 \$1581 VDD pfet_03v3 L=0.28U W=0.36U AS=0.2097P AD=0.1278P
+ PS=1.38U PD=1.07U
M$879 \$1823 \$1672 \$1582 VDD pfet_03v3 L=0.28U W=0.36U AS=0.1278P AD=0.0567P
+ PS=1.07U PD=0.675U
M$880 VDD \$1568 \$1823 VDD pfet_03v3 L=0.28U W=0.36U AS=0.0567P AD=0.1584P
+ PS=0.675U PD=1.6U
M$881 \$1672 \$1582 VDD VDD pfet_03v3 L=0.28U W=0.36U AS=0.1764P AD=0.1584P
+ PS=1.26U PD=1.6U
M$882 \$1557 \$1582 VDD VDD pfet_03v3 L=0.28U W=0.72U AS=0.1764P AD=0.36P
+ PS=1.26U PD=2.44U
M$883 \$1673 RA11 VDD VDD pfet_03v3 L=0.28U W=0.72U AS=0.3312P AD=0.3888P
+ PS=2.36U PD=2.52U
M$884 \$1557 \$1673 \$63 VDD pfet_03v3 L=0.28U W=0.36U AS=0.1584P AD=0.1152P
+ PS=1.6U PD=1U
M$885 \$64 \$1674 \$1557 VDD pfet_03v3 L=0.28U W=0.36U AS=0.1152P AD=0.1584P
+ PS=1U PD=1.6U
M$886 VDD RB11 \$1674 VDD pfet_03v3 L=0.28U W=0.72U AS=0.3708P AD=0.3168P
+ PS=2.47U PD=2.32U
M$887 \$1583 \$127 VDD VDD pfet_03v3 L=0.28U W=0.72U AS=0.3168P AD=0.2097P
+ PS=2.32U PD=1.38U
M$888 \$1584 \$1755 \$1583 VDD pfet_03v3 L=0.28U W=0.36U AS=0.2097P AD=0.1278P
+ PS=1.38U PD=1.07U
M$889 \$1834 \$1675 \$1584 VDD pfet_03v3 L=0.28U W=0.36U AS=0.1278P AD=0.0567P
+ PS=1.07U PD=0.675U
M$890 VDD \$1568 \$1834 VDD pfet_03v3 L=0.28U W=0.36U AS=0.0567P AD=0.1584P
+ PS=0.675U PD=1.6U
M$891 \$1675 \$1584 VDD VDD pfet_03v3 L=0.28U W=0.36U AS=0.1764P AD=0.1584P
+ PS=1.26U PD=1.6U
M$892 \$1558 \$1584 VDD VDD pfet_03v3 L=0.28U W=0.72U AS=0.1764P AD=0.36P
+ PS=1.26U PD=2.44U
M$893 \$1676 RA11 VDD VDD pfet_03v3 L=0.28U W=0.72U AS=0.3312P AD=0.3888P
+ PS=2.36U PD=2.52U
M$894 \$1558 \$1676 \$65 VDD pfet_03v3 L=0.28U W=0.36U AS=0.1584P AD=0.1152P
+ PS=1.6U PD=1U
M$895 \$66 \$1677 \$1558 VDD pfet_03v3 L=0.28U W=0.36U AS=0.1152P AD=0.1584P
+ PS=1U PD=1.6U
M$896 VDD RB11 \$1677 VDD pfet_03v3 L=0.28U W=0.72U AS=0.3708P AD=0.3168P
+ PS=2.47U PD=2.32U
M$897 \$1585 \$130 VDD VDD pfet_03v3 L=0.28U W=0.72U AS=0.3168P AD=0.2097P
+ PS=2.32U PD=1.38U
M$898 \$1586 \$1755 \$1585 VDD pfet_03v3 L=0.28U W=0.36U AS=0.2097P AD=0.1278P
+ PS=1.38U PD=1.07U
M$899 \$1843 \$1678 \$1586 VDD pfet_03v3 L=0.28U W=0.36U AS=0.1278P AD=0.0567P
+ PS=1.07U PD=0.675U
M$900 VDD \$1568 \$1843 VDD pfet_03v3 L=0.28U W=0.36U AS=0.0567P AD=0.1584P
+ PS=0.675U PD=1.6U
M$901 \$1678 \$1586 VDD VDD pfet_03v3 L=0.28U W=0.36U AS=0.1764P AD=0.1584P
+ PS=1.26U PD=1.6U
M$902 \$1559 \$1586 VDD VDD pfet_03v3 L=0.28U W=0.72U AS=0.1764P AD=0.36P
+ PS=1.26U PD=2.44U
M$903 \$1679 RA11 VDD VDD pfet_03v3 L=0.28U W=0.72U AS=0.3312P AD=0.3888P
+ PS=2.36U PD=2.52U
M$904 \$1559 \$1679 \$67 VDD pfet_03v3 L=0.28U W=0.36U AS=0.1584P AD=0.1152P
+ PS=1.6U PD=1U
M$905 \$68 \$1680 \$1559 VDD pfet_03v3 L=0.28U W=0.36U AS=0.1152P AD=0.1584P
+ PS=1U PD=1.6U
M$906 VDD RB11 \$1680 VDD pfet_03v3 L=0.28U W=0.72U AS=0.3708P AD=0.3168P
+ PS=2.47U PD=2.32U
M$907 \$1587 \$133 VDD VDD pfet_03v3 L=0.28U W=0.72U AS=0.3168P AD=0.2097P
+ PS=2.32U PD=1.38U
M$908 \$1588 \$1755 \$1587 VDD pfet_03v3 L=0.28U W=0.36U AS=0.2097P AD=0.1278P
+ PS=1.38U PD=1.07U
M$909 \$1853 \$1681 \$1588 VDD pfet_03v3 L=0.28U W=0.36U AS=0.1278P AD=0.0567P
+ PS=1.07U PD=0.675U
M$910 VDD \$1568 \$1853 VDD pfet_03v3 L=0.28U W=0.36U AS=0.0567P AD=0.1584P
+ PS=0.675U PD=1.6U
M$911 \$1681 \$1588 VDD VDD pfet_03v3 L=0.28U W=0.36U AS=0.1764P AD=0.1584P
+ PS=1.26U PD=1.6U
M$912 \$1560 \$1588 VDD VDD pfet_03v3 L=0.28U W=0.72U AS=0.1764P AD=0.36P
+ PS=1.26U PD=2.44U
M$913 \$1682 RA11 VDD VDD pfet_03v3 L=0.28U W=0.72U AS=0.3312P AD=0.3888P
+ PS=2.36U PD=2.52U
M$914 \$1560 \$1682 \$69 VDD pfet_03v3 L=0.28U W=0.36U AS=0.1584P AD=0.1152P
+ PS=1.6U PD=1U
M$915 \$70 \$1683 \$1560 VDD pfet_03v3 L=0.28U W=0.36U AS=0.1152P AD=0.1584P
+ PS=1U PD=1.6U
M$916 VDD RB11 \$1683 VDD pfet_03v3 L=0.28U W=0.72U AS=0.3708P AD=0.3168P
+ PS=2.47U PD=2.32U
M$917 \$1589 \$136 VDD VDD pfet_03v3 L=0.28U W=0.72U AS=0.3168P AD=0.2097P
+ PS=2.32U PD=1.38U
M$918 \$1590 \$1755 \$1589 VDD pfet_03v3 L=0.28U W=0.36U AS=0.2097P AD=0.1278P
+ PS=1.38U PD=1.07U
M$919 \$1854 \$1684 \$1590 VDD pfet_03v3 L=0.28U W=0.36U AS=0.1278P AD=0.0567P
+ PS=1.07U PD=0.675U
M$920 VDD \$1568 \$1854 VDD pfet_03v3 L=0.28U W=0.36U AS=0.0567P AD=0.1584P
+ PS=0.675U PD=1.6U
M$921 \$1684 \$1590 VDD VDD pfet_03v3 L=0.28U W=0.36U AS=0.1764P AD=0.1584P
+ PS=1.26U PD=1.6U
M$922 \$1561 \$1590 VDD VDD pfet_03v3 L=0.28U W=0.72U AS=0.1764P AD=0.36P
+ PS=1.26U PD=2.44U
M$923 \$1685 RA11 VDD VDD pfet_03v3 L=0.28U W=0.72U AS=0.3312P AD=0.3888P
+ PS=2.36U PD=2.52U
M$924 \$1561 \$1685 \$71 VDD pfet_03v3 L=0.28U W=0.36U AS=0.1584P AD=0.1152P
+ PS=1.6U PD=1U
M$925 \$72 \$1686 \$1561 VDD pfet_03v3 L=0.28U W=0.36U AS=0.1152P AD=0.1584P
+ PS=1U PD=1.6U
M$926 VDD RB11 \$1686 VDD pfet_03v3 L=0.28U W=0.72U AS=0.3708P AD=0.3168P
+ PS=2.47U PD=2.32U
M$927 \$1591 \$139 VDD VDD pfet_03v3 L=0.28U W=0.72U AS=0.3168P AD=0.2097P
+ PS=2.32U PD=1.38U
M$928 \$1592 \$1755 \$1591 VDD pfet_03v3 L=0.28U W=0.36U AS=0.2097P AD=0.1278P
+ PS=1.38U PD=1.07U
M$929 \$1835 \$1687 \$1592 VDD pfet_03v3 L=0.28U W=0.36U AS=0.1278P AD=0.0567P
+ PS=1.07U PD=0.675U
M$930 VDD \$1568 \$1835 VDD pfet_03v3 L=0.28U W=0.36U AS=0.0567P AD=0.1584P
+ PS=0.675U PD=1.6U
M$931 \$1687 \$1592 VDD VDD pfet_03v3 L=0.28U W=0.36U AS=0.1764P AD=0.1584P
+ PS=1.26U PD=1.6U
M$932 \$1562 \$1592 VDD VDD pfet_03v3 L=0.28U W=0.72U AS=0.1764P AD=0.36P
+ PS=1.26U PD=2.44U
M$933 \$1688 RA11 VDD VDD pfet_03v3 L=0.28U W=0.72U AS=0.3312P AD=0.3888P
+ PS=2.36U PD=2.52U
M$934 \$1562 \$1688 \$73 VDD pfet_03v3 L=0.28U W=0.36U AS=0.1584P AD=0.1152P
+ PS=1.6U PD=1U
M$935 \$74 \$1689 \$1562 VDD pfet_03v3 L=0.28U W=0.36U AS=0.1152P AD=0.1584P
+ PS=1U PD=1.6U
M$936 VDD RB11 \$1689 VDD pfet_03v3 L=0.28U W=0.72U AS=0.3708P AD=0.3168P
+ PS=2.47U PD=2.32U
M$937 \$1593 \$142 VDD VDD pfet_03v3 L=0.28U W=0.72U AS=0.3168P AD=0.2097P
+ PS=2.32U PD=1.38U
M$938 \$1594 \$1755 \$1593 VDD pfet_03v3 L=0.28U W=0.36U AS=0.2097P AD=0.1278P
+ PS=1.38U PD=1.07U
M$939 \$1821 \$1690 \$1594 VDD pfet_03v3 L=0.28U W=0.36U AS=0.1278P AD=0.0567P
+ PS=1.07U PD=0.675U
M$940 VDD \$1568 \$1821 VDD pfet_03v3 L=0.28U W=0.36U AS=0.0567P AD=0.1584P
+ PS=0.675U PD=1.6U
M$941 \$1690 \$1594 VDD VDD pfet_03v3 L=0.28U W=0.36U AS=0.1764P AD=0.1584P
+ PS=1.26U PD=1.6U
M$942 \$1563 \$1594 VDD VDD pfet_03v3 L=0.28U W=0.72U AS=0.1764P AD=0.36P
+ PS=1.26U PD=2.44U
M$943 \$1691 RA11 VDD VDD pfet_03v3 L=0.28U W=0.72U AS=0.3312P AD=0.3888P
+ PS=2.36U PD=2.52U
M$944 \$1563 \$1691 \$75 VDD pfet_03v3 L=0.28U W=0.36U AS=0.1584P AD=0.1152P
+ PS=1.6U PD=1U
M$945 \$76 \$1692 \$1563 VDD pfet_03v3 L=0.28U W=0.36U AS=0.1152P AD=0.1584P
+ PS=1U PD=1.6U
M$946 VDD RB11 \$1692 VDD pfet_03v3 L=0.28U W=0.72U AS=0.3708P AD=0.3168P
+ PS=2.47U PD=2.32U
M$947 \$1595 \$145 VDD VDD pfet_03v3 L=0.28U W=0.72U AS=0.3168P AD=0.2097P
+ PS=2.32U PD=1.38U
M$948 \$1596 \$1755 \$1595 VDD pfet_03v3 L=0.28U W=0.36U AS=0.2097P AD=0.1278P
+ PS=1.38U PD=1.07U
M$949 \$1803 \$1693 \$1596 VDD pfet_03v3 L=0.28U W=0.36U AS=0.1278P AD=0.0567P
+ PS=1.07U PD=0.675U
M$950 VDD \$1568 \$1803 VDD pfet_03v3 L=0.28U W=0.36U AS=0.0567P AD=0.1584P
+ PS=0.675U PD=1.6U
M$951 \$1693 \$1596 VDD VDD pfet_03v3 L=0.28U W=0.36U AS=0.1764P AD=0.1584P
+ PS=1.26U PD=1.6U
M$952 \$1564 \$1596 VDD VDD pfet_03v3 L=0.28U W=0.72U AS=0.1764P AD=0.36P
+ PS=1.26U PD=2.44U
M$953 \$1694 RA11 VDD VDD pfet_03v3 L=0.28U W=0.72U AS=0.3312P AD=0.3888P
+ PS=2.36U PD=2.52U
M$954 \$1564 \$1694 \$77 VDD pfet_03v3 L=0.28U W=0.36U AS=0.1584P AD=0.1152P
+ PS=1.6U PD=1U
M$955 \$78 \$1695 \$1564 VDD pfet_03v3 L=0.28U W=0.36U AS=0.1152P AD=0.1584P
+ PS=1U PD=1.6U
M$956 VDD RB11 \$1695 VDD pfet_03v3 L=0.28U W=0.72U AS=0.3708P AD=0.3168P
+ PS=2.47U PD=2.32U
M$957 \$1597 \$148 VDD VDD pfet_03v3 L=0.28U W=0.72U AS=0.3168P AD=0.2097P
+ PS=2.32U PD=1.38U
M$958 \$1598 \$1755 \$1597 VDD pfet_03v3 L=0.28U W=0.36U AS=0.2097P AD=0.1278P
+ PS=1.38U PD=1.07U
M$959 \$1784 \$1696 \$1598 VDD pfet_03v3 L=0.28U W=0.36U AS=0.1278P AD=0.0567P
+ PS=1.07U PD=0.675U
M$960 VDD \$1568 \$1784 VDD pfet_03v3 L=0.28U W=0.36U AS=0.0567P AD=0.1584P
+ PS=0.675U PD=1.6U
M$961 \$1696 \$1598 VDD VDD pfet_03v3 L=0.28U W=0.36U AS=0.1764P AD=0.1584P
+ PS=1.26U PD=1.6U
M$962 \$1565 \$1598 VDD VDD pfet_03v3 L=0.28U W=0.72U AS=0.1764P AD=0.36P
+ PS=1.26U PD=2.44U
M$963 \$1697 RA11 VDD VDD pfet_03v3 L=0.28U W=0.72U AS=0.3312P AD=0.3888P
+ PS=2.36U PD=2.52U
M$964 \$1565 \$1697 \$79 VDD pfet_03v3 L=0.28U W=0.36U AS=0.1584P AD=0.1152P
+ PS=1.6U PD=1U
M$965 \$80 \$1698 \$1565 VDD pfet_03v3 L=0.28U W=0.36U AS=0.1152P AD=0.1584P
+ PS=1U PD=1.6U
M$966 VDD RB11 \$1698 VDD pfet_03v3 L=0.28U W=0.72U AS=0.3708P AD=0.3168P
+ PS=2.47U PD=2.32U
M$967 \$1599 \$151 VDD VDD pfet_03v3 L=0.28U W=0.72U AS=0.3168P AD=0.2097P
+ PS=2.32U PD=1.38U
M$968 \$1600 \$1755 \$1599 VDD pfet_03v3 L=0.28U W=0.36U AS=0.2097P AD=0.1278P
+ PS=1.38U PD=1.07U
M$969 \$1766 \$1699 \$1600 VDD pfet_03v3 L=0.28U W=0.36U AS=0.1278P AD=0.0567P
+ PS=1.07U PD=0.675U
M$970 VDD \$1568 \$1766 VDD pfet_03v3 L=0.28U W=0.36U AS=0.0567P AD=0.1584P
+ PS=0.675U PD=1.6U
M$971 \$1699 \$1600 VDD VDD pfet_03v3 L=0.28U W=0.36U AS=0.1764P AD=0.1584P
+ PS=1.26U PD=1.6U
M$972 \$1566 \$1600 VDD VDD pfet_03v3 L=0.28U W=0.72U AS=0.1764P AD=0.36P
+ PS=1.26U PD=2.44U
M$973 \$1700 RA11 VDD VDD pfet_03v3 L=0.28U W=0.72U AS=0.3312P AD=0.3888P
+ PS=2.36U PD=2.52U
M$974 \$1566 \$1700 \$81 VDD pfet_03v3 L=0.28U W=0.36U AS=0.1584P AD=0.1152P
+ PS=1.6U PD=1U
M$975 \$82 \$1701 \$1566 VDD pfet_03v3 L=0.28U W=0.36U AS=0.1152P AD=0.1584P
+ PS=1U PD=1.6U
M$976 VDD RB11 \$1701 VDD pfet_03v3 L=0.28U W=0.72U AS=0.3708P AD=0.3168P
+ PS=2.47U PD=2.32U
M$977 \$1861 WE10 VDD VDD pfet_03v3 L=0.28U W=0.72U AS=0.3168P AD=0.1872P
+ PS=2.32U PD=1.24U
M$978 VDD CLK \$1861 VDD pfet_03v3 L=0.28U W=0.72U AS=0.1872P AD=0.3168P
+ PS=1.24U PD=2.32U
M$979 \$1862 \$1861 VDD VDD pfet_03v3 L=0.28U W=2.54U AS=0.889P AD=0.6688P
+ PS=5.21U PD=3.65U
M$981 \$1863 \$1862 VDD VDD pfet_03v3 L=0.28U W=2.68U AS=0.7272P AD=0.9782P
+ PS=3.78U PD=5.48U
M$983 \$1865 \$1863 \$1864 VDD pfet_03v3 L=0.28U W=0.36U AS=0.2097P AD=0.1278P
+ PS=1.38U PD=1.07U
M$984 \$1966 \$1866 \$1865 VDD pfet_03v3 L=0.28U W=0.36U AS=0.1278P AD=0.0567P
+ PS=1.07U PD=0.675U
M$985 VDD \$1862 \$1966 VDD pfet_03v3 L=0.28U W=0.36U AS=0.0567P AD=0.1584P
+ PS=0.675U PD=1.6U
M$986 \$1864 \$106 VDD VDD pfet_03v3 L=0.28U W=0.72U AS=0.3168P AD=0.2097P
+ PS=2.32U PD=1.38U
M$987 VDD \$1865 \$1866 VDD pfet_03v3 L=0.28U W=0.36U AS=0.1584P AD=0.1764P
+ PS=1.6U PD=1.26U
M$988 \$1867 \$1865 VDD VDD pfet_03v3 L=0.28U W=0.72U AS=0.1764P AD=0.36P
+ PS=1.26U PD=2.44U
M$989 \$1869 RB10 VDD VDD pfet_03v3 L=0.28U W=0.72U AS=0.3312P AD=0.3888P
+ PS=2.36U PD=2.52U
M$990 \$1867 \$1869 \$51 VDD pfet_03v3 L=0.28U W=0.36U AS=0.1584P AD=0.1152P
+ PS=1.6U PD=1U
M$991 \$52 \$1870 \$1867 VDD pfet_03v3 L=0.28U W=0.36U AS=0.1152P AD=0.1584P
+ PS=1U PD=1.6U
M$992 VDD RA10 \$1870 VDD pfet_03v3 L=0.28U W=0.72U AS=0.3708P AD=0.3168P
+ PS=2.47U PD=2.32U
M$993 \$1872 \$1863 \$1871 VDD pfet_03v3 L=0.28U W=0.36U AS=0.2097P AD=0.1278P
+ PS=1.38U PD=1.07U
M$994 \$1975 \$1873 \$1872 VDD pfet_03v3 L=0.28U W=0.36U AS=0.1278P AD=0.0567P
+ PS=1.07U PD=0.675U
M$995 VDD \$1862 \$1975 VDD pfet_03v3 L=0.28U W=0.36U AS=0.0567P AD=0.1584P
+ PS=0.675U PD=1.6U
M$996 \$1871 \$109 VDD VDD pfet_03v3 L=0.28U W=0.72U AS=0.3168P AD=0.2097P
+ PS=2.32U PD=1.38U
M$997 VDD \$1872 \$1873 VDD pfet_03v3 L=0.28U W=0.36U AS=0.1584P AD=0.1764P
+ PS=1.6U PD=1.26U
M$998 \$1874 \$1872 VDD VDD pfet_03v3 L=0.28U W=0.72U AS=0.1764P AD=0.36P
+ PS=1.26U PD=2.44U
M$999 \$1875 RB10 VDD VDD pfet_03v3 L=0.28U W=0.72U AS=0.3312P AD=0.3888P
+ PS=2.36U PD=2.52U
M$1000 \$1874 \$1875 \$53 VDD pfet_03v3 L=0.28U W=0.36U AS=0.1584P AD=0.1152P
+ PS=1.6U PD=1U
M$1001 \$54 \$1876 \$1874 VDD pfet_03v3 L=0.28U W=0.36U AS=0.1152P AD=0.1584P
+ PS=1U PD=1.6U
M$1002 VDD RA10 \$1876 VDD pfet_03v3 L=0.28U W=0.72U AS=0.3708P AD=0.3168P
+ PS=2.47U PD=2.32U
M$1003 \$1878 \$1863 \$1877 VDD pfet_03v3 L=0.28U W=0.36U AS=0.2097P AD=0.1278P
+ PS=1.38U PD=1.07U
M$1004 \$1986 \$1879 \$1878 VDD pfet_03v3 L=0.28U W=0.36U AS=0.1278P AD=0.0567P
+ PS=1.07U PD=0.675U
M$1005 VDD \$1862 \$1986 VDD pfet_03v3 L=0.28U W=0.36U AS=0.0567P AD=0.1584P
+ PS=0.675U PD=1.6U
M$1006 \$1877 \$112 VDD VDD pfet_03v3 L=0.28U W=0.72U AS=0.3168P AD=0.2097P
+ PS=2.32U PD=1.38U
M$1007 VDD \$1878 \$1879 VDD pfet_03v3 L=0.28U W=0.36U AS=0.1584P AD=0.1764P
+ PS=1.6U PD=1.26U
M$1008 \$1880 \$1878 VDD VDD pfet_03v3 L=0.28U W=0.72U AS=0.1764P AD=0.36P
+ PS=1.26U PD=2.44U
M$1009 \$1881 RB10 VDD VDD pfet_03v3 L=0.28U W=0.72U AS=0.3312P AD=0.3888P
+ PS=2.36U PD=2.52U
M$1010 \$1880 \$1881 \$55 VDD pfet_03v3 L=0.28U W=0.36U AS=0.1584P AD=0.1152P
+ PS=1.6U PD=1U
M$1011 \$56 \$1882 \$1880 VDD pfet_03v3 L=0.28U W=0.36U AS=0.1152P AD=0.1584P
+ PS=1U PD=1.6U
M$1012 VDD RA10 \$1882 VDD pfet_03v3 L=0.28U W=0.72U AS=0.3708P AD=0.3168P
+ PS=2.47U PD=2.32U
M$1013 \$1884 \$1863 \$1883 VDD pfet_03v3 L=0.28U W=0.36U AS=0.2097P AD=0.1278P
+ PS=1.38U PD=1.07U
M$1014 \$1996 \$1885 \$1884 VDD pfet_03v3 L=0.28U W=0.36U AS=0.1278P AD=0.0567P
+ PS=1.07U PD=0.675U
M$1015 VDD \$1862 \$1996 VDD pfet_03v3 L=0.28U W=0.36U AS=0.0567P AD=0.1584P
+ PS=0.675U PD=1.6U
M$1016 \$1883 \$115 VDD VDD pfet_03v3 L=0.28U W=0.72U AS=0.3168P AD=0.2097P
+ PS=2.32U PD=1.38U
M$1017 VDD \$1884 \$1885 VDD pfet_03v3 L=0.28U W=0.36U AS=0.1584P AD=0.1764P
+ PS=1.6U PD=1.26U
M$1018 \$1886 \$1884 VDD VDD pfet_03v3 L=0.28U W=0.72U AS=0.1764P AD=0.36P
+ PS=1.26U PD=2.44U
M$1019 \$1887 RB10 VDD VDD pfet_03v3 L=0.28U W=0.72U AS=0.3312P AD=0.3888P
+ PS=2.36U PD=2.52U
M$1020 \$1886 \$1887 \$57 VDD pfet_03v3 L=0.28U W=0.36U AS=0.1584P AD=0.1152P
+ PS=1.6U PD=1U
M$1021 \$58 \$1888 \$1886 VDD pfet_03v3 L=0.28U W=0.36U AS=0.1152P AD=0.1584P
+ PS=1U PD=1.6U
M$1022 VDD RA10 \$1888 VDD pfet_03v3 L=0.28U W=0.72U AS=0.3708P AD=0.3168P
+ PS=2.47U PD=2.32U
M$1023 \$1890 \$1863 \$1889 VDD pfet_03v3 L=0.28U W=0.36U AS=0.2097P AD=0.1278P
+ PS=1.38U PD=1.07U
M$1024 \$2007 \$1891 \$1890 VDD pfet_03v3 L=0.28U W=0.36U AS=0.1278P AD=0.0567P
+ PS=1.07U PD=0.675U
M$1025 VDD \$1862 \$2007 VDD pfet_03v3 L=0.28U W=0.36U AS=0.0567P AD=0.1584P
+ PS=0.675U PD=1.6U
M$1026 \$1889 \$118 VDD VDD pfet_03v3 L=0.28U W=0.72U AS=0.3168P AD=0.2097P
+ PS=2.32U PD=1.38U
M$1027 VDD \$1890 \$1891 VDD pfet_03v3 L=0.28U W=0.36U AS=0.1584P AD=0.1764P
+ PS=1.6U PD=1.26U
M$1028 \$1892 \$1890 VDD VDD pfet_03v3 L=0.28U W=0.72U AS=0.1764P AD=0.36P
+ PS=1.26U PD=2.44U
M$1029 \$1893 RB10 VDD VDD pfet_03v3 L=0.28U W=0.72U AS=0.3312P AD=0.3888P
+ PS=2.36U PD=2.52U
M$1030 \$1892 \$1893 \$59 VDD pfet_03v3 L=0.28U W=0.36U AS=0.1584P AD=0.1152P
+ PS=1.6U PD=1U
M$1031 \$60 \$1894 \$1892 VDD pfet_03v3 L=0.28U W=0.36U AS=0.1152P AD=0.1584P
+ PS=1U PD=1.6U
M$1032 VDD RA10 \$1894 VDD pfet_03v3 L=0.28U W=0.72U AS=0.3708P AD=0.3168P
+ PS=2.47U PD=2.32U
M$1033 \$1896 \$1863 \$1895 VDD pfet_03v3 L=0.28U W=0.36U AS=0.2097P AD=0.1278P
+ PS=1.38U PD=1.07U
M$1034 \$2016 \$1897 \$1896 VDD pfet_03v3 L=0.28U W=0.36U AS=0.1278P AD=0.0567P
+ PS=1.07U PD=0.675U
M$1035 VDD \$1862 \$2016 VDD pfet_03v3 L=0.28U W=0.36U AS=0.0567P AD=0.1584P
+ PS=0.675U PD=1.6U
M$1036 \$1895 \$121 VDD VDD pfet_03v3 L=0.28U W=0.72U AS=0.3168P AD=0.2097P
+ PS=2.32U PD=1.38U
M$1037 VDD \$1896 \$1897 VDD pfet_03v3 L=0.28U W=0.36U AS=0.1584P AD=0.1764P
+ PS=1.6U PD=1.26U
M$1038 \$1898 \$1896 VDD VDD pfet_03v3 L=0.28U W=0.72U AS=0.1764P AD=0.36P
+ PS=1.26U PD=2.44U
M$1039 \$1899 RB10 VDD VDD pfet_03v3 L=0.28U W=0.72U AS=0.3312P AD=0.3888P
+ PS=2.36U PD=2.52U
M$1040 \$1898 \$1899 \$61 VDD pfet_03v3 L=0.28U W=0.36U AS=0.1584P AD=0.1152P
+ PS=1.6U PD=1U
M$1041 \$62 \$1900 \$1898 VDD pfet_03v3 L=0.28U W=0.36U AS=0.1152P AD=0.1584P
+ PS=1U PD=1.6U
M$1042 VDD RA10 \$1900 VDD pfet_03v3 L=0.28U W=0.72U AS=0.3708P AD=0.3168P
+ PS=2.47U PD=2.32U
M$1043 \$1902 \$1863 \$1901 VDD pfet_03v3 L=0.28U W=0.36U AS=0.2097P AD=0.1278P
+ PS=1.38U PD=1.07U
M$1044 \$2026 \$1903 \$1902 VDD pfet_03v3 L=0.28U W=0.36U AS=0.1278P AD=0.0567P
+ PS=1.07U PD=0.675U
M$1045 VDD \$1862 \$2026 VDD pfet_03v3 L=0.28U W=0.36U AS=0.0567P AD=0.1584P
+ PS=0.675U PD=1.6U
M$1046 \$1901 \$124 VDD VDD pfet_03v3 L=0.28U W=0.72U AS=0.3168P AD=0.2097P
+ PS=2.32U PD=1.38U
M$1047 VDD \$1902 \$1903 VDD pfet_03v3 L=0.28U W=0.36U AS=0.1584P AD=0.1764P
+ PS=1.6U PD=1.26U
M$1048 \$1904 \$1902 VDD VDD pfet_03v3 L=0.28U W=0.72U AS=0.1764P AD=0.36P
+ PS=1.26U PD=2.44U
M$1049 \$1905 RB10 VDD VDD pfet_03v3 L=0.28U W=0.72U AS=0.3312P AD=0.3888P
+ PS=2.36U PD=2.52U
M$1050 \$1904 \$1905 \$63 VDD pfet_03v3 L=0.28U W=0.36U AS=0.1584P AD=0.1152P
+ PS=1.6U PD=1U
M$1051 \$64 \$1906 \$1904 VDD pfet_03v3 L=0.28U W=0.36U AS=0.1152P AD=0.1584P
+ PS=1U PD=1.6U
M$1052 VDD RA10 \$1906 VDD pfet_03v3 L=0.28U W=0.72U AS=0.3708P AD=0.3168P
+ PS=2.47U PD=2.32U
M$1053 \$1908 \$1863 \$1907 VDD pfet_03v3 L=0.28U W=0.36U AS=0.2097P AD=0.1278P
+ PS=1.38U PD=1.07U
M$1054 \$2036 \$1909 \$1908 VDD pfet_03v3 L=0.28U W=0.36U AS=0.1278P AD=0.0567P
+ PS=1.07U PD=0.675U
M$1055 VDD \$1862 \$2036 VDD pfet_03v3 L=0.28U W=0.36U AS=0.0567P AD=0.1584P
+ PS=0.675U PD=1.6U
M$1056 \$1907 \$127 VDD VDD pfet_03v3 L=0.28U W=0.72U AS=0.3168P AD=0.2097P
+ PS=2.32U PD=1.38U
M$1057 VDD \$1908 \$1909 VDD pfet_03v3 L=0.28U W=0.36U AS=0.1584P AD=0.1764P
+ PS=1.6U PD=1.26U
M$1058 \$1910 \$1908 VDD VDD pfet_03v3 L=0.28U W=0.72U AS=0.1764P AD=0.36P
+ PS=1.26U PD=2.44U
M$1059 \$1911 RB10 VDD VDD pfet_03v3 L=0.28U W=0.72U AS=0.3312P AD=0.3888P
+ PS=2.36U PD=2.52U
M$1060 \$1910 \$1911 \$65 VDD pfet_03v3 L=0.28U W=0.36U AS=0.1584P AD=0.1152P
+ PS=1.6U PD=1U
M$1061 \$66 \$1912 \$1910 VDD pfet_03v3 L=0.28U W=0.36U AS=0.1152P AD=0.1584P
+ PS=1U PD=1.6U
M$1062 VDD RA10 \$1912 VDD pfet_03v3 L=0.28U W=0.72U AS=0.3708P AD=0.3168P
+ PS=2.47U PD=2.32U
M$1063 \$1914 \$1863 \$1913 VDD pfet_03v3 L=0.28U W=0.36U AS=0.2097P AD=0.1278P
+ PS=1.38U PD=1.07U
M$1064 \$2046 \$1915 \$1914 VDD pfet_03v3 L=0.28U W=0.36U AS=0.1278P AD=0.0567P
+ PS=1.07U PD=0.675U
M$1065 VDD \$1862 \$2046 VDD pfet_03v3 L=0.28U W=0.36U AS=0.0567P AD=0.1584P
+ PS=0.675U PD=1.6U
M$1066 \$1913 \$130 VDD VDD pfet_03v3 L=0.28U W=0.72U AS=0.3168P AD=0.2097P
+ PS=2.32U PD=1.38U
M$1067 VDD \$1914 \$1915 VDD pfet_03v3 L=0.28U W=0.36U AS=0.1584P AD=0.1764P
+ PS=1.6U PD=1.26U
M$1068 \$1916 \$1914 VDD VDD pfet_03v3 L=0.28U W=0.72U AS=0.1764P AD=0.36P
+ PS=1.26U PD=2.44U
M$1069 \$1917 RB10 VDD VDD pfet_03v3 L=0.28U W=0.72U AS=0.3312P AD=0.3888P
+ PS=2.36U PD=2.52U
M$1070 \$1916 \$1917 \$67 VDD pfet_03v3 L=0.28U W=0.36U AS=0.1584P AD=0.1152P
+ PS=1.6U PD=1U
M$1071 \$68 \$1918 \$1916 VDD pfet_03v3 L=0.28U W=0.36U AS=0.1152P AD=0.1584P
+ PS=1U PD=1.6U
M$1072 VDD RA10 \$1918 VDD pfet_03v3 L=0.28U W=0.72U AS=0.3708P AD=0.3168P
+ PS=2.47U PD=2.32U
M$1073 \$1920 \$1863 \$1919 VDD pfet_03v3 L=0.28U W=0.36U AS=0.2097P AD=0.1278P
+ PS=1.38U PD=1.07U
M$1074 \$2056 \$1921 \$1920 VDD pfet_03v3 L=0.28U W=0.36U AS=0.1278P AD=0.0567P
+ PS=1.07U PD=0.675U
M$1075 VDD \$1862 \$2056 VDD pfet_03v3 L=0.28U W=0.36U AS=0.0567P AD=0.1584P
+ PS=0.675U PD=1.6U
M$1076 \$1919 \$133 VDD VDD pfet_03v3 L=0.28U W=0.72U AS=0.3168P AD=0.2097P
+ PS=2.32U PD=1.38U
M$1077 VDD \$1920 \$1921 VDD pfet_03v3 L=0.28U W=0.36U AS=0.1584P AD=0.1764P
+ PS=1.6U PD=1.26U
M$1078 \$1922 \$1920 VDD VDD pfet_03v3 L=0.28U W=0.72U AS=0.1764P AD=0.36P
+ PS=1.26U PD=2.44U
M$1079 \$1923 RB10 VDD VDD pfet_03v3 L=0.28U W=0.72U AS=0.3312P AD=0.3888P
+ PS=2.36U PD=2.52U
M$1080 \$1922 \$1923 \$69 VDD pfet_03v3 L=0.28U W=0.36U AS=0.1584P AD=0.1152P
+ PS=1.6U PD=1U
M$1081 \$70 \$1924 \$1922 VDD pfet_03v3 L=0.28U W=0.36U AS=0.1152P AD=0.1584P
+ PS=1U PD=1.6U
M$1082 VDD RA10 \$1924 VDD pfet_03v3 L=0.28U W=0.72U AS=0.3708P AD=0.3168P
+ PS=2.47U PD=2.32U
M$1083 \$1926 \$1863 \$1925 VDD pfet_03v3 L=0.28U W=0.36U AS=0.2097P AD=0.1278P
+ PS=1.38U PD=1.07U
M$1084 \$2042 \$1927 \$1926 VDD pfet_03v3 L=0.28U W=0.36U AS=0.1278P AD=0.0567P
+ PS=1.07U PD=0.675U
M$1085 VDD \$1862 \$2042 VDD pfet_03v3 L=0.28U W=0.36U AS=0.0567P AD=0.1584P
+ PS=0.675U PD=1.6U
M$1086 \$1925 \$136 VDD VDD pfet_03v3 L=0.28U W=0.72U AS=0.3168P AD=0.2097P
+ PS=2.32U PD=1.38U
M$1087 VDD \$1926 \$1927 VDD pfet_03v3 L=0.28U W=0.36U AS=0.1584P AD=0.1764P
+ PS=1.6U PD=1.26U
M$1088 \$1928 \$1926 VDD VDD pfet_03v3 L=0.28U W=0.72U AS=0.1764P AD=0.36P
+ PS=1.26U PD=2.44U
M$1089 \$1929 RB10 VDD VDD pfet_03v3 L=0.28U W=0.72U AS=0.3312P AD=0.3888P
+ PS=2.36U PD=2.52U
M$1090 \$1928 \$1929 \$71 VDD pfet_03v3 L=0.28U W=0.36U AS=0.1584P AD=0.1152P
+ PS=1.6U PD=1U
M$1091 \$72 \$1930 \$1928 VDD pfet_03v3 L=0.28U W=0.36U AS=0.1152P AD=0.1584P
+ PS=1U PD=1.6U
M$1092 VDD RA10 \$1930 VDD pfet_03v3 L=0.28U W=0.72U AS=0.3708P AD=0.3168P
+ PS=2.47U PD=2.32U
M$1093 \$1932 \$1863 \$1931 VDD pfet_03v3 L=0.28U W=0.36U AS=0.2097P AD=0.1278P
+ PS=1.38U PD=1.07U
M$1094 \$2028 \$1933 \$1932 VDD pfet_03v3 L=0.28U W=0.36U AS=0.1278P AD=0.0567P
+ PS=1.07U PD=0.675U
M$1095 VDD \$1862 \$2028 VDD pfet_03v3 L=0.28U W=0.36U AS=0.0567P AD=0.1584P
+ PS=0.675U PD=1.6U
M$1096 \$1931 \$139 VDD VDD pfet_03v3 L=0.28U W=0.72U AS=0.3168P AD=0.2097P
+ PS=2.32U PD=1.38U
M$1097 VDD \$1932 \$1933 VDD pfet_03v3 L=0.28U W=0.36U AS=0.1584P AD=0.1764P
+ PS=1.6U PD=1.26U
M$1098 \$1934 \$1932 VDD VDD pfet_03v3 L=0.28U W=0.72U AS=0.1764P AD=0.36P
+ PS=1.26U PD=2.44U
M$1099 \$1935 RB10 VDD VDD pfet_03v3 L=0.28U W=0.72U AS=0.3312P AD=0.3888P
+ PS=2.36U PD=2.52U
M$1100 \$1934 \$1935 \$73 VDD pfet_03v3 L=0.28U W=0.36U AS=0.1584P AD=0.1152P
+ PS=1.6U PD=1U
M$1101 \$74 \$1936 \$1934 VDD pfet_03v3 L=0.28U W=0.36U AS=0.1152P AD=0.1584P
+ PS=1U PD=1.6U
M$1102 VDD RA10 \$1936 VDD pfet_03v3 L=0.28U W=0.72U AS=0.3708P AD=0.3168P
+ PS=2.47U PD=2.32U
M$1103 \$1938 \$1863 \$1937 VDD pfet_03v3 L=0.28U W=0.36U AS=0.2097P AD=0.1278P
+ PS=1.38U PD=1.07U
M$1104 \$2012 \$1939 \$1938 VDD pfet_03v3 L=0.28U W=0.36U AS=0.1278P AD=0.0567P
+ PS=1.07U PD=0.675U
M$1105 VDD \$1862 \$2012 VDD pfet_03v3 L=0.28U W=0.36U AS=0.0567P AD=0.1584P
+ PS=0.675U PD=1.6U
M$1106 \$1937 \$142 VDD VDD pfet_03v3 L=0.28U W=0.72U AS=0.3168P AD=0.2097P
+ PS=2.32U PD=1.38U
M$1107 VDD \$1938 \$1939 VDD pfet_03v3 L=0.28U W=0.36U AS=0.1584P AD=0.1764P
+ PS=1.6U PD=1.26U
M$1108 \$1940 \$1938 VDD VDD pfet_03v3 L=0.28U W=0.72U AS=0.1764P AD=0.36P
+ PS=1.26U PD=2.44U
M$1109 \$1941 RB10 VDD VDD pfet_03v3 L=0.28U W=0.72U AS=0.3312P AD=0.3888P
+ PS=2.36U PD=2.52U
M$1110 \$1940 \$1941 \$75 VDD pfet_03v3 L=0.28U W=0.36U AS=0.1584P AD=0.1152P
+ PS=1.6U PD=1U
M$1111 \$76 \$1942 \$1940 VDD pfet_03v3 L=0.28U W=0.36U AS=0.1152P AD=0.1584P
+ PS=1U PD=1.6U
M$1112 VDD RA10 \$1942 VDD pfet_03v3 L=0.28U W=0.72U AS=0.3708P AD=0.3168P
+ PS=2.47U PD=2.32U
M$1113 \$1944 \$1863 \$1943 VDD pfet_03v3 L=0.28U W=0.36U AS=0.2097P AD=0.1278P
+ PS=1.38U PD=1.07U
M$1114 \$2001 \$1945 \$1944 VDD pfet_03v3 L=0.28U W=0.36U AS=0.1278P AD=0.0567P
+ PS=1.07U PD=0.675U
M$1115 VDD \$1862 \$2001 VDD pfet_03v3 L=0.28U W=0.36U AS=0.0567P AD=0.1584P
+ PS=0.675U PD=1.6U
M$1116 \$1943 \$145 VDD VDD pfet_03v3 L=0.28U W=0.72U AS=0.3168P AD=0.2097P
+ PS=2.32U PD=1.38U
M$1117 VDD \$1944 \$1945 VDD pfet_03v3 L=0.28U W=0.36U AS=0.1584P AD=0.1764P
+ PS=1.6U PD=1.26U
M$1118 \$1946 \$1944 VDD VDD pfet_03v3 L=0.28U W=0.72U AS=0.1764P AD=0.36P
+ PS=1.26U PD=2.44U
M$1119 \$1947 RB10 VDD VDD pfet_03v3 L=0.28U W=0.72U AS=0.3312P AD=0.3888P
+ PS=2.36U PD=2.52U
M$1120 \$1946 \$1947 \$77 VDD pfet_03v3 L=0.28U W=0.36U AS=0.1584P AD=0.1152P
+ PS=1.6U PD=1U
M$1121 \$78 \$1948 \$1946 VDD pfet_03v3 L=0.28U W=0.36U AS=0.1152P AD=0.1584P
+ PS=1U PD=1.6U
M$1122 VDD RA10 \$1948 VDD pfet_03v3 L=0.28U W=0.72U AS=0.3708P AD=0.3168P
+ PS=2.47U PD=2.32U
M$1123 \$1950 \$1863 \$1949 VDD pfet_03v3 L=0.28U W=0.36U AS=0.2097P AD=0.1278P
+ PS=1.38U PD=1.07U
M$1124 \$1985 \$1951 \$1950 VDD pfet_03v3 L=0.28U W=0.36U AS=0.1278P AD=0.0567P
+ PS=1.07U PD=0.675U
M$1125 VDD \$1862 \$1985 VDD pfet_03v3 L=0.28U W=0.36U AS=0.0567P AD=0.1584P
+ PS=0.675U PD=1.6U
M$1126 \$1949 \$148 VDD VDD pfet_03v3 L=0.28U W=0.72U AS=0.3168P AD=0.2097P
+ PS=2.32U PD=1.38U
M$1127 VDD \$1950 \$1951 VDD pfet_03v3 L=0.28U W=0.36U AS=0.1584P AD=0.1764P
+ PS=1.6U PD=1.26U
M$1128 \$1952 \$1950 VDD VDD pfet_03v3 L=0.28U W=0.72U AS=0.1764P AD=0.36P
+ PS=1.26U PD=2.44U
M$1129 \$1953 RB10 VDD VDD pfet_03v3 L=0.28U W=0.72U AS=0.3312P AD=0.3888P
+ PS=2.36U PD=2.52U
M$1130 \$1952 \$1953 \$79 VDD pfet_03v3 L=0.28U W=0.36U AS=0.1584P AD=0.1152P
+ PS=1.6U PD=1U
M$1131 \$80 \$1954 \$1952 VDD pfet_03v3 L=0.28U W=0.36U AS=0.1152P AD=0.1584P
+ PS=1U PD=1.6U
M$1132 VDD RA10 \$1954 VDD pfet_03v3 L=0.28U W=0.72U AS=0.3708P AD=0.3168P
+ PS=2.47U PD=2.32U
M$1133 \$1956 \$1863 \$1955 VDD pfet_03v3 L=0.28U W=0.36U AS=0.2097P AD=0.1278P
+ PS=1.38U PD=1.07U
M$1134 \$1971 \$1957 \$1956 VDD pfet_03v3 L=0.28U W=0.36U AS=0.1278P AD=0.0567P
+ PS=1.07U PD=0.675U
M$1135 VDD \$1862 \$1971 VDD pfet_03v3 L=0.28U W=0.36U AS=0.0567P AD=0.1584P
+ PS=0.675U PD=1.6U
M$1136 \$1955 \$151 VDD VDD pfet_03v3 L=0.28U W=0.72U AS=0.3168P AD=0.2097P
+ PS=2.32U PD=1.38U
M$1137 VDD \$1956 \$1957 VDD pfet_03v3 L=0.28U W=0.36U AS=0.1584P AD=0.1764P
+ PS=1.6U PD=1.26U
M$1138 \$1958 \$1956 VDD VDD pfet_03v3 L=0.28U W=0.72U AS=0.1764P AD=0.36P
+ PS=1.26U PD=2.44U
M$1139 \$1959 RB10 VDD VDD pfet_03v3 L=0.28U W=0.72U AS=0.3312P AD=0.3888P
+ PS=2.36U PD=2.52U
M$1140 \$1958 \$1959 \$81 VDD pfet_03v3 L=0.28U W=0.36U AS=0.1584P AD=0.1152P
+ PS=1.6U PD=1U
M$1141 \$82 \$1960 \$1958 VDD pfet_03v3 L=0.28U W=0.36U AS=0.1152P AD=0.1584P
+ PS=1U PD=1.6U
M$1142 VDD RA10 \$1960 VDD pfet_03v3 L=0.28U W=0.72U AS=0.3708P AD=0.3168P
+ PS=2.47U PD=2.32U
M$1143 \$2180 WE9 VDD VDD pfet_03v3 L=0.28U W=0.72U AS=0.3168P AD=0.1872P
+ PS=2.32U PD=1.24U
M$1144 VDD CLK \$2180 VDD pfet_03v3 L=0.28U W=0.72U AS=0.1872P AD=0.3168P
+ PS=1.24U PD=2.32U
M$1145 \$2181 \$2180 VDD VDD pfet_03v3 L=0.28U W=2.54U AS=0.8974P AD=0.6604P
+ PS=5.28U PD=3.58U
M$1147 \$2368 \$2181 VDD VDD pfet_03v3 L=0.28U W=2.68U AS=0.7272P AD=0.9782P
+ PS=3.78U PD=5.48U
M$1149 \$2182 \$106 VDD VDD pfet_03v3 L=0.28U W=0.72U AS=0.3168P AD=0.2097P
+ PS=2.32U PD=1.38U
M$1150 \$2183 \$2368 \$2182 VDD pfet_03v3 L=0.28U W=0.36U AS=0.2097P AD=0.1278P
+ PS=1.38U PD=1.07U
M$1151 \$2374 \$2266 \$2183 VDD pfet_03v3 L=0.28U W=0.36U AS=0.1278P AD=0.0567P
+ PS=1.07U PD=0.675U
M$1152 VDD \$2181 \$2374 VDD pfet_03v3 L=0.28U W=0.36U AS=0.0567P AD=0.1584P
+ PS=0.675U PD=1.6U
M$1153 \$2266 \$2183 VDD VDD pfet_03v3 L=0.28U W=0.36U AS=0.1764P AD=0.1584P
+ PS=1.26U PD=1.6U
M$1154 \$2164 \$2183 VDD VDD pfet_03v3 L=0.28U W=0.72U AS=0.1764P AD=0.36P
+ PS=1.26U PD=2.44U
M$1155 \$2268 RA9 VDD VDD pfet_03v3 L=0.28U W=0.72U AS=0.3312P AD=0.3888P
+ PS=2.36U PD=2.52U
M$1156 \$2164 \$2268 \$51 VDD pfet_03v3 L=0.28U W=0.36U AS=0.1584P AD=0.1152P
+ PS=1.6U PD=1U
M$1157 \$52 \$2269 \$2164 VDD pfet_03v3 L=0.28U W=0.36U AS=0.1152P AD=0.1584P
+ PS=1U PD=1.6U
M$1158 VDD RB9 \$2269 VDD pfet_03v3 L=0.28U W=0.72U AS=0.3708P AD=0.3168P
+ PS=2.47U PD=2.32U
M$1159 \$2184 \$109 VDD VDD pfet_03v3 L=0.28U W=0.72U AS=0.3168P AD=0.2097P
+ PS=2.32U PD=1.38U
M$1160 \$2185 \$2368 \$2184 VDD pfet_03v3 L=0.28U W=0.36U AS=0.2097P AD=0.1278P
+ PS=1.38U PD=1.07U
M$1161 \$2386 \$2270 \$2185 VDD pfet_03v3 L=0.28U W=0.36U AS=0.1278P AD=0.0567P
+ PS=1.07U PD=0.675U
M$1162 VDD \$2181 \$2386 VDD pfet_03v3 L=0.28U W=0.36U AS=0.0567P AD=0.1584P
+ PS=0.675U PD=1.6U
M$1163 \$2270 \$2185 VDD VDD pfet_03v3 L=0.28U W=0.36U AS=0.1764P AD=0.1584P
+ PS=1.26U PD=1.6U
M$1164 \$2165 \$2185 VDD VDD pfet_03v3 L=0.28U W=0.72U AS=0.1764P AD=0.36P
+ PS=1.26U PD=2.44U
M$1165 \$2271 RA9 VDD VDD pfet_03v3 L=0.28U W=0.72U AS=0.3312P AD=0.3888P
+ PS=2.36U PD=2.52U
M$1166 \$2165 \$2271 \$53 VDD pfet_03v3 L=0.28U W=0.36U AS=0.1584P AD=0.1152P
+ PS=1.6U PD=1U
M$1167 \$54 \$2272 \$2165 VDD pfet_03v3 L=0.28U W=0.36U AS=0.1152P AD=0.1584P
+ PS=1U PD=1.6U
M$1168 VDD RB9 \$2272 VDD pfet_03v3 L=0.28U W=0.72U AS=0.3708P AD=0.3168P
+ PS=2.47U PD=2.32U
M$1169 \$2186 \$112 VDD VDD pfet_03v3 L=0.28U W=0.72U AS=0.3168P AD=0.2097P
+ PS=2.32U PD=1.38U
M$1170 \$2187 \$2368 \$2186 VDD pfet_03v3 L=0.28U W=0.36U AS=0.2097P AD=0.1278P
+ PS=1.38U PD=1.07U
M$1171 \$2395 \$2273 \$2187 VDD pfet_03v3 L=0.28U W=0.36U AS=0.1278P AD=0.0567P
+ PS=1.07U PD=0.675U
M$1172 VDD \$2181 \$2395 VDD pfet_03v3 L=0.28U W=0.36U AS=0.0567P AD=0.1584P
+ PS=0.675U PD=1.6U
M$1173 \$2273 \$2187 VDD VDD pfet_03v3 L=0.28U W=0.36U AS=0.1764P AD=0.1584P
+ PS=1.26U PD=1.6U
M$1174 \$2166 \$2187 VDD VDD pfet_03v3 L=0.28U W=0.72U AS=0.1764P AD=0.36P
+ PS=1.26U PD=2.44U
M$1175 \$2274 RA9 VDD VDD pfet_03v3 L=0.28U W=0.72U AS=0.3312P AD=0.3888P
+ PS=2.36U PD=2.52U
M$1176 \$2166 \$2274 \$55 VDD pfet_03v3 L=0.28U W=0.36U AS=0.1584P AD=0.1152P
+ PS=1.6U PD=1U
M$1177 \$56 \$2275 \$2166 VDD pfet_03v3 L=0.28U W=0.36U AS=0.1152P AD=0.1584P
+ PS=1U PD=1.6U
M$1178 VDD RB9 \$2275 VDD pfet_03v3 L=0.28U W=0.72U AS=0.3708P AD=0.3168P
+ PS=2.47U PD=2.32U
M$1179 \$2188 \$115 VDD VDD pfet_03v3 L=0.28U W=0.72U AS=0.3168P AD=0.2097P
+ PS=2.32U PD=1.38U
M$1180 \$2189 \$2368 \$2188 VDD pfet_03v3 L=0.28U W=0.36U AS=0.2097P AD=0.1278P
+ PS=1.38U PD=1.07U
M$1181 \$2406 \$2276 \$2189 VDD pfet_03v3 L=0.28U W=0.36U AS=0.1278P AD=0.0567P
+ PS=1.07U PD=0.675U
M$1182 VDD \$2181 \$2406 VDD pfet_03v3 L=0.28U W=0.36U AS=0.0567P AD=0.1584P
+ PS=0.675U PD=1.6U
M$1183 \$2276 \$2189 VDD VDD pfet_03v3 L=0.28U W=0.36U AS=0.1764P AD=0.1584P
+ PS=1.26U PD=1.6U
M$1184 \$2167 \$2189 VDD VDD pfet_03v3 L=0.28U W=0.72U AS=0.1764P AD=0.36P
+ PS=1.26U PD=2.44U
M$1185 \$2277 RA9 VDD VDD pfet_03v3 L=0.28U W=0.72U AS=0.3312P AD=0.3888P
+ PS=2.36U PD=2.52U
M$1186 \$2167 \$2277 \$57 VDD pfet_03v3 L=0.28U W=0.36U AS=0.1584P AD=0.1152P
+ PS=1.6U PD=1U
M$1187 \$58 \$2278 \$2167 VDD pfet_03v3 L=0.28U W=0.36U AS=0.1152P AD=0.1584P
+ PS=1U PD=1.6U
M$1188 VDD RB9 \$2278 VDD pfet_03v3 L=0.28U W=0.72U AS=0.3708P AD=0.3168P
+ PS=2.47U PD=2.32U
M$1189 \$2190 \$118 VDD VDD pfet_03v3 L=0.28U W=0.72U AS=0.3168P AD=0.2097P
+ PS=2.32U PD=1.38U
M$1190 \$2191 \$2368 \$2190 VDD pfet_03v3 L=0.28U W=0.36U AS=0.2097P AD=0.1278P
+ PS=1.38U PD=1.07U
M$1191 \$2415 \$2279 \$2191 VDD pfet_03v3 L=0.28U W=0.36U AS=0.1278P AD=0.0567P
+ PS=1.07U PD=0.675U
M$1192 VDD \$2181 \$2415 VDD pfet_03v3 L=0.28U W=0.36U AS=0.0567P AD=0.1584P
+ PS=0.675U PD=1.6U
M$1193 \$2279 \$2191 VDD VDD pfet_03v3 L=0.28U W=0.36U AS=0.1764P AD=0.1584P
+ PS=1.26U PD=1.6U
M$1194 \$2168 \$2191 VDD VDD pfet_03v3 L=0.28U W=0.72U AS=0.1764P AD=0.36P
+ PS=1.26U PD=2.44U
M$1195 \$2280 RA9 VDD VDD pfet_03v3 L=0.28U W=0.72U AS=0.3312P AD=0.3888P
+ PS=2.36U PD=2.52U
M$1196 \$2168 \$2280 \$59 VDD pfet_03v3 L=0.28U W=0.36U AS=0.1584P AD=0.1152P
+ PS=1.6U PD=1U
M$1197 \$60 \$2281 \$2168 VDD pfet_03v3 L=0.28U W=0.36U AS=0.1152P AD=0.1584P
+ PS=1U PD=1.6U
M$1198 VDD RB9 \$2281 VDD pfet_03v3 L=0.28U W=0.72U AS=0.3708P AD=0.3168P
+ PS=2.47U PD=2.32U
M$1199 \$2192 \$121 VDD VDD pfet_03v3 L=0.28U W=0.72U AS=0.3168P AD=0.2097P
+ PS=2.32U PD=1.38U
M$1200 \$2193 \$2368 \$2192 VDD pfet_03v3 L=0.28U W=0.36U AS=0.2097P AD=0.1278P
+ PS=1.38U PD=1.07U
M$1201 \$2425 \$2282 \$2193 VDD pfet_03v3 L=0.28U W=0.36U AS=0.1278P AD=0.0567P
+ PS=1.07U PD=0.675U
M$1202 VDD \$2181 \$2425 VDD pfet_03v3 L=0.28U W=0.36U AS=0.0567P AD=0.1584P
+ PS=0.675U PD=1.6U
M$1203 \$2282 \$2193 VDD VDD pfet_03v3 L=0.28U W=0.36U AS=0.1764P AD=0.1584P
+ PS=1.26U PD=1.6U
M$1204 \$2169 \$2193 VDD VDD pfet_03v3 L=0.28U W=0.72U AS=0.1764P AD=0.36P
+ PS=1.26U PD=2.44U
M$1205 \$2283 RA9 VDD VDD pfet_03v3 L=0.28U W=0.72U AS=0.3312P AD=0.3888P
+ PS=2.36U PD=2.52U
M$1206 \$2169 \$2283 \$61 VDD pfet_03v3 L=0.28U W=0.36U AS=0.1584P AD=0.1152P
+ PS=1.6U PD=1U
M$1207 \$62 \$2284 \$2169 VDD pfet_03v3 L=0.28U W=0.36U AS=0.1152P AD=0.1584P
+ PS=1U PD=1.6U
M$1208 VDD RB9 \$2284 VDD pfet_03v3 L=0.28U W=0.72U AS=0.3708P AD=0.3168P
+ PS=2.47U PD=2.32U
M$1209 \$2194 \$124 VDD VDD pfet_03v3 L=0.28U W=0.72U AS=0.3168P AD=0.2097P
+ PS=2.32U PD=1.38U
M$1210 \$2195 \$2368 \$2194 VDD pfet_03v3 L=0.28U W=0.36U AS=0.2097P AD=0.1278P
+ PS=1.38U PD=1.07U
M$1211 \$2436 \$2285 \$2195 VDD pfet_03v3 L=0.28U W=0.36U AS=0.1278P AD=0.0567P
+ PS=1.07U PD=0.675U
M$1212 VDD \$2181 \$2436 VDD pfet_03v3 L=0.28U W=0.36U AS=0.0567P AD=0.1584P
+ PS=0.675U PD=1.6U
M$1213 \$2285 \$2195 VDD VDD pfet_03v3 L=0.28U W=0.36U AS=0.1764P AD=0.1584P
+ PS=1.26U PD=1.6U
M$1214 \$2170 \$2195 VDD VDD pfet_03v3 L=0.28U W=0.72U AS=0.1764P AD=0.36P
+ PS=1.26U PD=2.44U
M$1215 \$2286 RA9 VDD VDD pfet_03v3 L=0.28U W=0.72U AS=0.3312P AD=0.3888P
+ PS=2.36U PD=2.52U
M$1216 \$2170 \$2286 \$63 VDD pfet_03v3 L=0.28U W=0.36U AS=0.1584P AD=0.1152P
+ PS=1.6U PD=1U
M$1217 \$64 \$2287 \$2170 VDD pfet_03v3 L=0.28U W=0.36U AS=0.1152P AD=0.1584P
+ PS=1U PD=1.6U
M$1218 VDD RB9 \$2287 VDD pfet_03v3 L=0.28U W=0.72U AS=0.3708P AD=0.3168P
+ PS=2.47U PD=2.32U
M$1219 \$2196 \$127 VDD VDD pfet_03v3 L=0.28U W=0.72U AS=0.3168P AD=0.2097P
+ PS=2.32U PD=1.38U
M$1220 \$2197 \$2368 \$2196 VDD pfet_03v3 L=0.28U W=0.36U AS=0.2097P AD=0.1278P
+ PS=1.38U PD=1.07U
M$1221 \$2447 \$2288 \$2197 VDD pfet_03v3 L=0.28U W=0.36U AS=0.1278P AD=0.0567P
+ PS=1.07U PD=0.675U
M$1222 VDD \$2181 \$2447 VDD pfet_03v3 L=0.28U W=0.36U AS=0.0567P AD=0.1584P
+ PS=0.675U PD=1.6U
M$1223 \$2288 \$2197 VDD VDD pfet_03v3 L=0.28U W=0.36U AS=0.1764P AD=0.1584P
+ PS=1.26U PD=1.6U
M$1224 \$2171 \$2197 VDD VDD pfet_03v3 L=0.28U W=0.72U AS=0.1764P AD=0.36P
+ PS=1.26U PD=2.44U
M$1225 \$2289 RA9 VDD VDD pfet_03v3 L=0.28U W=0.72U AS=0.3312P AD=0.3888P
+ PS=2.36U PD=2.52U
M$1226 \$2171 \$2289 \$65 VDD pfet_03v3 L=0.28U W=0.36U AS=0.1584P AD=0.1152P
+ PS=1.6U PD=1U
M$1227 \$66 \$2290 \$2171 VDD pfet_03v3 L=0.28U W=0.36U AS=0.1152P AD=0.1584P
+ PS=1U PD=1.6U
M$1228 VDD RB9 \$2290 VDD pfet_03v3 L=0.28U W=0.72U AS=0.3708P AD=0.3168P
+ PS=2.47U PD=2.32U
M$1229 \$2198 \$130 VDD VDD pfet_03v3 L=0.28U W=0.72U AS=0.3168P AD=0.2097P
+ PS=2.32U PD=1.38U
M$1230 \$2199 \$2368 \$2198 VDD pfet_03v3 L=0.28U W=0.36U AS=0.2097P AD=0.1278P
+ PS=1.38U PD=1.07U
M$1231 \$2456 \$2291 \$2199 VDD pfet_03v3 L=0.28U W=0.36U AS=0.1278P AD=0.0567P
+ PS=1.07U PD=0.675U
M$1232 VDD \$2181 \$2456 VDD pfet_03v3 L=0.28U W=0.36U AS=0.0567P AD=0.1584P
+ PS=0.675U PD=1.6U
M$1233 \$2291 \$2199 VDD VDD pfet_03v3 L=0.28U W=0.36U AS=0.1764P AD=0.1584P
+ PS=1.26U PD=1.6U
M$1234 \$2172 \$2199 VDD VDD pfet_03v3 L=0.28U W=0.72U AS=0.1764P AD=0.36P
+ PS=1.26U PD=2.44U
M$1235 \$2292 RA9 VDD VDD pfet_03v3 L=0.28U W=0.72U AS=0.3312P AD=0.3888P
+ PS=2.36U PD=2.52U
M$1236 \$2172 \$2292 \$67 VDD pfet_03v3 L=0.28U W=0.36U AS=0.1584P AD=0.1152P
+ PS=1.6U PD=1U
M$1237 \$68 \$2293 \$2172 VDD pfet_03v3 L=0.28U W=0.36U AS=0.1152P AD=0.1584P
+ PS=1U PD=1.6U
M$1238 VDD RB9 \$2293 VDD pfet_03v3 L=0.28U W=0.72U AS=0.3708P AD=0.3168P
+ PS=2.47U PD=2.32U
M$1239 \$2200 \$133 VDD VDD pfet_03v3 L=0.28U W=0.72U AS=0.3168P AD=0.2097P
+ PS=2.32U PD=1.38U
M$1240 \$2201 \$2368 \$2200 VDD pfet_03v3 L=0.28U W=0.36U AS=0.2097P AD=0.1278P
+ PS=1.38U PD=1.07U
M$1241 \$2466 \$2294 \$2201 VDD pfet_03v3 L=0.28U W=0.36U AS=0.1278P AD=0.0567P
+ PS=1.07U PD=0.675U
M$1242 VDD \$2181 \$2466 VDD pfet_03v3 L=0.28U W=0.36U AS=0.0567P AD=0.1584P
+ PS=0.675U PD=1.6U
M$1243 \$2294 \$2201 VDD VDD pfet_03v3 L=0.28U W=0.36U AS=0.1764P AD=0.1584P
+ PS=1.26U PD=1.6U
M$1244 \$2173 \$2201 VDD VDD pfet_03v3 L=0.28U W=0.72U AS=0.1764P AD=0.36P
+ PS=1.26U PD=2.44U
M$1245 \$2295 RA9 VDD VDD pfet_03v3 L=0.28U W=0.72U AS=0.3312P AD=0.3888P
+ PS=2.36U PD=2.52U
M$1246 \$2173 \$2295 \$69 VDD pfet_03v3 L=0.28U W=0.36U AS=0.1584P AD=0.1152P
+ PS=1.6U PD=1U
M$1247 \$70 \$2296 \$2173 VDD pfet_03v3 L=0.28U W=0.36U AS=0.1152P AD=0.1584P
+ PS=1U PD=1.6U
M$1248 VDD RB9 \$2296 VDD pfet_03v3 L=0.28U W=0.72U AS=0.3708P AD=0.3168P
+ PS=2.47U PD=2.32U
M$1249 \$2202 \$136 VDD VDD pfet_03v3 L=0.28U W=0.72U AS=0.3168P AD=0.2097P
+ PS=2.32U PD=1.38U
M$1250 \$2203 \$2368 \$2202 VDD pfet_03v3 L=0.28U W=0.36U AS=0.2097P AD=0.1278P
+ PS=1.38U PD=1.07U
M$1251 \$2467 \$2297 \$2203 VDD pfet_03v3 L=0.28U W=0.36U AS=0.1278P AD=0.0567P
+ PS=1.07U PD=0.675U
M$1252 VDD \$2181 \$2467 VDD pfet_03v3 L=0.28U W=0.36U AS=0.0567P AD=0.1584P
+ PS=0.675U PD=1.6U
M$1253 \$2297 \$2203 VDD VDD pfet_03v3 L=0.28U W=0.36U AS=0.1764P AD=0.1584P
+ PS=1.26U PD=1.6U
M$1254 \$2174 \$2203 VDD VDD pfet_03v3 L=0.28U W=0.72U AS=0.1764P AD=0.36P
+ PS=1.26U PD=2.44U
M$1255 \$2298 RA9 VDD VDD pfet_03v3 L=0.28U W=0.72U AS=0.3312P AD=0.3888P
+ PS=2.36U PD=2.52U
M$1256 \$2174 \$2298 \$71 VDD pfet_03v3 L=0.28U W=0.36U AS=0.1584P AD=0.1152P
+ PS=1.6U PD=1U
M$1257 \$72 \$2299 \$2174 VDD pfet_03v3 L=0.28U W=0.36U AS=0.1152P AD=0.1584P
+ PS=1U PD=1.6U
M$1258 VDD RB9 \$2299 VDD pfet_03v3 L=0.28U W=0.72U AS=0.3708P AD=0.3168P
+ PS=2.47U PD=2.32U
M$1259 \$2204 \$139 VDD VDD pfet_03v3 L=0.28U W=0.72U AS=0.3168P AD=0.2097P
+ PS=2.32U PD=1.38U
M$1260 \$2205 \$2368 \$2204 VDD pfet_03v3 L=0.28U W=0.36U AS=0.2097P AD=0.1278P
+ PS=1.38U PD=1.07U
M$1261 \$2448 \$2300 \$2205 VDD pfet_03v3 L=0.28U W=0.36U AS=0.1278P AD=0.0567P
+ PS=1.07U PD=0.675U
M$1262 VDD \$2181 \$2448 VDD pfet_03v3 L=0.28U W=0.36U AS=0.0567P AD=0.1584P
+ PS=0.675U PD=1.6U
M$1263 \$2300 \$2205 VDD VDD pfet_03v3 L=0.28U W=0.36U AS=0.1764P AD=0.1584P
+ PS=1.26U PD=1.6U
M$1264 \$2175 \$2205 VDD VDD pfet_03v3 L=0.28U W=0.72U AS=0.1764P AD=0.36P
+ PS=1.26U PD=2.44U
M$1265 \$2301 RA9 VDD VDD pfet_03v3 L=0.28U W=0.72U AS=0.3312P AD=0.3888P
+ PS=2.36U PD=2.52U
M$1266 \$2175 \$2301 \$73 VDD pfet_03v3 L=0.28U W=0.36U AS=0.1584P AD=0.1152P
+ PS=1.6U PD=1U
M$1267 \$74 \$2302 \$2175 VDD pfet_03v3 L=0.28U W=0.36U AS=0.1152P AD=0.1584P
+ PS=1U PD=1.6U
M$1268 VDD RB9 \$2302 VDD pfet_03v3 L=0.28U W=0.72U AS=0.3708P AD=0.3168P
+ PS=2.47U PD=2.32U
M$1269 \$2206 \$142 VDD VDD pfet_03v3 L=0.28U W=0.72U AS=0.3168P AD=0.2097P
+ PS=2.32U PD=1.38U
M$1270 \$2207 \$2368 \$2206 VDD pfet_03v3 L=0.28U W=0.36U AS=0.2097P AD=0.1278P
+ PS=1.38U PD=1.07U
M$1271 \$2434 \$2303 \$2207 VDD pfet_03v3 L=0.28U W=0.36U AS=0.1278P AD=0.0567P
+ PS=1.07U PD=0.675U
M$1272 VDD \$2181 \$2434 VDD pfet_03v3 L=0.28U W=0.36U AS=0.0567P AD=0.1584P
+ PS=0.675U PD=1.6U
M$1273 \$2303 \$2207 VDD VDD pfet_03v3 L=0.28U W=0.36U AS=0.1764P AD=0.1584P
+ PS=1.26U PD=1.6U
M$1274 \$2176 \$2207 VDD VDD pfet_03v3 L=0.28U W=0.72U AS=0.1764P AD=0.36P
+ PS=1.26U PD=2.44U
M$1275 \$2304 RA9 VDD VDD pfet_03v3 L=0.28U W=0.72U AS=0.3312P AD=0.3888P
+ PS=2.36U PD=2.52U
M$1276 \$2176 \$2304 \$75 VDD pfet_03v3 L=0.28U W=0.36U AS=0.1584P AD=0.1152P
+ PS=1.6U PD=1U
M$1277 \$76 \$2305 \$2176 VDD pfet_03v3 L=0.28U W=0.36U AS=0.1152P AD=0.1584P
+ PS=1U PD=1.6U
M$1278 VDD RB9 \$2305 VDD pfet_03v3 L=0.28U W=0.72U AS=0.3708P AD=0.3168P
+ PS=2.47U PD=2.32U
M$1279 \$2208 \$145 VDD VDD pfet_03v3 L=0.28U W=0.72U AS=0.3168P AD=0.2097P
+ PS=2.32U PD=1.38U
M$1280 \$2209 \$2368 \$2208 VDD pfet_03v3 L=0.28U W=0.36U AS=0.2097P AD=0.1278P
+ PS=1.38U PD=1.07U
M$1281 \$2416 \$2306 \$2209 VDD pfet_03v3 L=0.28U W=0.36U AS=0.1278P AD=0.0567P
+ PS=1.07U PD=0.675U
M$1282 VDD \$2181 \$2416 VDD pfet_03v3 L=0.28U W=0.36U AS=0.0567P AD=0.1584P
+ PS=0.675U PD=1.6U
M$1283 \$2306 \$2209 VDD VDD pfet_03v3 L=0.28U W=0.36U AS=0.1764P AD=0.1584P
+ PS=1.26U PD=1.6U
M$1284 \$2177 \$2209 VDD VDD pfet_03v3 L=0.28U W=0.72U AS=0.1764P AD=0.36P
+ PS=1.26U PD=2.44U
M$1285 \$2307 RA9 VDD VDD pfet_03v3 L=0.28U W=0.72U AS=0.3312P AD=0.3888P
+ PS=2.36U PD=2.52U
M$1286 \$2177 \$2307 \$77 VDD pfet_03v3 L=0.28U W=0.36U AS=0.1584P AD=0.1152P
+ PS=1.6U PD=1U
M$1287 \$78 \$2308 \$2177 VDD pfet_03v3 L=0.28U W=0.36U AS=0.1152P AD=0.1584P
+ PS=1U PD=1.6U
M$1288 VDD RB9 \$2308 VDD pfet_03v3 L=0.28U W=0.72U AS=0.3708P AD=0.3168P
+ PS=2.47U PD=2.32U
M$1289 \$2210 \$148 VDD VDD pfet_03v3 L=0.28U W=0.72U AS=0.3168P AD=0.2097P
+ PS=2.32U PD=1.38U
M$1290 \$2211 \$2368 \$2210 VDD pfet_03v3 L=0.28U W=0.36U AS=0.2097P AD=0.1278P
+ PS=1.38U PD=1.07U
M$1291 \$2397 \$2309 \$2211 VDD pfet_03v3 L=0.28U W=0.36U AS=0.1278P AD=0.0567P
+ PS=1.07U PD=0.675U
M$1292 VDD \$2181 \$2397 VDD pfet_03v3 L=0.28U W=0.36U AS=0.0567P AD=0.1584P
+ PS=0.675U PD=1.6U
M$1293 \$2309 \$2211 VDD VDD pfet_03v3 L=0.28U W=0.36U AS=0.1764P AD=0.1584P
+ PS=1.26U PD=1.6U
M$1294 \$2178 \$2211 VDD VDD pfet_03v3 L=0.28U W=0.72U AS=0.1764P AD=0.36P
+ PS=1.26U PD=2.44U
M$1295 \$2310 RA9 VDD VDD pfet_03v3 L=0.28U W=0.72U AS=0.3312P AD=0.3888P
+ PS=2.36U PD=2.52U
M$1296 \$2178 \$2310 \$79 VDD pfet_03v3 L=0.28U W=0.36U AS=0.1584P AD=0.1152P
+ PS=1.6U PD=1U
M$1297 \$80 \$2311 \$2178 VDD pfet_03v3 L=0.28U W=0.36U AS=0.1152P AD=0.1584P
+ PS=1U PD=1.6U
M$1298 VDD RB9 \$2311 VDD pfet_03v3 L=0.28U W=0.72U AS=0.3708P AD=0.3168P
+ PS=2.47U PD=2.32U
M$1299 \$2212 \$151 VDD VDD pfet_03v3 L=0.28U W=0.72U AS=0.3168P AD=0.2097P
+ PS=2.32U PD=1.38U
M$1300 \$2213 \$2368 \$2212 VDD pfet_03v3 L=0.28U W=0.36U AS=0.2097P AD=0.1278P
+ PS=1.38U PD=1.07U
M$1301 \$2378 \$2312 \$2213 VDD pfet_03v3 L=0.28U W=0.36U AS=0.1278P AD=0.0567P
+ PS=1.07U PD=0.675U
M$1302 VDD \$2181 \$2378 VDD pfet_03v3 L=0.28U W=0.36U AS=0.0567P AD=0.1584P
+ PS=0.675U PD=1.6U
M$1303 \$2312 \$2213 VDD VDD pfet_03v3 L=0.28U W=0.36U AS=0.1764P AD=0.1584P
+ PS=1.26U PD=1.6U
M$1304 \$2179 \$2213 VDD VDD pfet_03v3 L=0.28U W=0.72U AS=0.1764P AD=0.36P
+ PS=1.26U PD=2.44U
M$1305 \$2313 RA9 VDD VDD pfet_03v3 L=0.28U W=0.72U AS=0.3312P AD=0.3888P
+ PS=2.36U PD=2.52U
M$1306 \$2179 \$2313 \$81 VDD pfet_03v3 L=0.28U W=0.36U AS=0.1584P AD=0.1152P
+ PS=1.6U PD=1U
M$1307 \$82 \$2314 \$2179 VDD pfet_03v3 L=0.28U W=0.36U AS=0.1152P AD=0.1584P
+ PS=1U PD=1.6U
M$1308 VDD RB9 \$2314 VDD pfet_03v3 L=0.28U W=0.72U AS=0.3708P AD=0.3168P
+ PS=2.47U PD=2.32U
M$1309 \$2474 WE8 VDD VDD pfet_03v3 L=0.28U W=0.72U AS=0.3168P AD=0.1872P
+ PS=2.32U PD=1.24U
M$1310 VDD CLK \$2474 VDD pfet_03v3 L=0.28U W=0.72U AS=0.1872P AD=0.3168P
+ PS=1.24U PD=2.32U
M$1311 \$2475 \$2474 VDD VDD pfet_03v3 L=0.28U W=2.54U AS=0.889P AD=0.6688P
+ PS=5.21U PD=3.65U
M$1313 \$2476 \$2475 VDD VDD pfet_03v3 L=0.28U W=2.68U AS=0.7272P AD=0.9782P
+ PS=3.78U PD=5.48U
M$1315 \$2478 \$2476 \$2477 VDD pfet_03v3 L=0.28U W=0.36U AS=0.2097P AD=0.1278P
+ PS=1.38U PD=1.07U
M$1316 \$2579 \$2479 \$2478 VDD pfet_03v3 L=0.28U W=0.36U AS=0.1278P AD=0.0567P
+ PS=1.07U PD=0.675U
M$1317 VDD \$2475 \$2579 VDD pfet_03v3 L=0.28U W=0.36U AS=0.0567P AD=0.1584P
+ PS=0.675U PD=1.6U
M$1318 \$2477 \$106 VDD VDD pfet_03v3 L=0.28U W=0.72U AS=0.3168P AD=0.2097P
+ PS=2.32U PD=1.38U
M$1319 VDD \$2478 \$2479 VDD pfet_03v3 L=0.28U W=0.36U AS=0.1584P AD=0.1764P
+ PS=1.6U PD=1.26U
M$1320 \$2480 \$2478 VDD VDD pfet_03v3 L=0.28U W=0.72U AS=0.1764P AD=0.36P
+ PS=1.26U PD=2.44U
M$1321 \$2482 RB8 VDD VDD pfet_03v3 L=0.28U W=0.72U AS=0.3312P AD=0.3888P
+ PS=2.36U PD=2.52U
M$1322 \$2480 \$2482 \$51 VDD pfet_03v3 L=0.28U W=0.36U AS=0.1584P AD=0.1152P
+ PS=1.6U PD=1U
M$1323 \$52 \$2483 \$2480 VDD pfet_03v3 L=0.28U W=0.36U AS=0.1152P AD=0.1584P
+ PS=1U PD=1.6U
M$1324 VDD RA8 \$2483 VDD pfet_03v3 L=0.28U W=0.72U AS=0.3708P AD=0.3168P
+ PS=2.47U PD=2.32U
M$1325 \$2485 \$2476 \$2484 VDD pfet_03v3 L=0.28U W=0.36U AS=0.2097P AD=0.1278P
+ PS=1.38U PD=1.07U
M$1326 \$2588 \$2486 \$2485 VDD pfet_03v3 L=0.28U W=0.36U AS=0.1278P AD=0.0567P
+ PS=1.07U PD=0.675U
M$1327 VDD \$2475 \$2588 VDD pfet_03v3 L=0.28U W=0.36U AS=0.0567P AD=0.1584P
+ PS=0.675U PD=1.6U
M$1328 \$2484 \$109 VDD VDD pfet_03v3 L=0.28U W=0.72U AS=0.3168P AD=0.2097P
+ PS=2.32U PD=1.38U
M$1329 VDD \$2485 \$2486 VDD pfet_03v3 L=0.28U W=0.36U AS=0.1584P AD=0.1764P
+ PS=1.6U PD=1.26U
M$1330 \$2487 \$2485 VDD VDD pfet_03v3 L=0.28U W=0.72U AS=0.1764P AD=0.36P
+ PS=1.26U PD=2.44U
M$1331 \$2488 RB8 VDD VDD pfet_03v3 L=0.28U W=0.72U AS=0.3312P AD=0.3888P
+ PS=2.36U PD=2.52U
M$1332 \$2487 \$2488 \$53 VDD pfet_03v3 L=0.28U W=0.36U AS=0.1584P AD=0.1152P
+ PS=1.6U PD=1U
M$1333 \$54 \$2489 \$2487 VDD pfet_03v3 L=0.28U W=0.36U AS=0.1152P AD=0.1584P
+ PS=1U PD=1.6U
M$1334 VDD RA8 \$2489 VDD pfet_03v3 L=0.28U W=0.72U AS=0.3708P AD=0.3168P
+ PS=2.47U PD=2.32U
M$1335 \$2491 \$2476 \$2490 VDD pfet_03v3 L=0.28U W=0.36U AS=0.2097P AD=0.1278P
+ PS=1.38U PD=1.07U
M$1336 \$2599 \$2492 \$2491 VDD pfet_03v3 L=0.28U W=0.36U AS=0.1278P AD=0.0567P
+ PS=1.07U PD=0.675U
M$1337 VDD \$2475 \$2599 VDD pfet_03v3 L=0.28U W=0.36U AS=0.0567P AD=0.1584P
+ PS=0.675U PD=1.6U
M$1338 \$2490 \$112 VDD VDD pfet_03v3 L=0.28U W=0.72U AS=0.3168P AD=0.2097P
+ PS=2.32U PD=1.38U
M$1339 VDD \$2491 \$2492 VDD pfet_03v3 L=0.28U W=0.36U AS=0.1584P AD=0.1764P
+ PS=1.6U PD=1.26U
M$1340 \$2493 \$2491 VDD VDD pfet_03v3 L=0.28U W=0.72U AS=0.1764P AD=0.36P
+ PS=1.26U PD=2.44U
M$1341 \$2494 RB8 VDD VDD pfet_03v3 L=0.28U W=0.72U AS=0.3312P AD=0.3888P
+ PS=2.36U PD=2.52U
M$1342 \$2493 \$2494 \$55 VDD pfet_03v3 L=0.28U W=0.36U AS=0.1584P AD=0.1152P
+ PS=1.6U PD=1U
M$1343 \$56 \$2495 \$2493 VDD pfet_03v3 L=0.28U W=0.36U AS=0.1152P AD=0.1584P
+ PS=1U PD=1.6U
M$1344 VDD RA8 \$2495 VDD pfet_03v3 L=0.28U W=0.72U AS=0.3708P AD=0.3168P
+ PS=2.47U PD=2.32U
M$1345 \$2497 \$2476 \$2496 VDD pfet_03v3 L=0.28U W=0.36U AS=0.2097P AD=0.1278P
+ PS=1.38U PD=1.07U
M$1346 \$2609 \$2498 \$2497 VDD pfet_03v3 L=0.28U W=0.36U AS=0.1278P AD=0.0567P
+ PS=1.07U PD=0.675U
M$1347 VDD \$2475 \$2609 VDD pfet_03v3 L=0.28U W=0.36U AS=0.0567P AD=0.1584P
+ PS=0.675U PD=1.6U
M$1348 \$2496 \$115 VDD VDD pfet_03v3 L=0.28U W=0.72U AS=0.3168P AD=0.2097P
+ PS=2.32U PD=1.38U
M$1349 VDD \$2497 \$2498 VDD pfet_03v3 L=0.28U W=0.36U AS=0.1584P AD=0.1764P
+ PS=1.6U PD=1.26U
M$1350 \$2499 \$2497 VDD VDD pfet_03v3 L=0.28U W=0.72U AS=0.1764P AD=0.36P
+ PS=1.26U PD=2.44U
M$1351 \$2500 RB8 VDD VDD pfet_03v3 L=0.28U W=0.72U AS=0.3312P AD=0.3888P
+ PS=2.36U PD=2.52U
M$1352 \$2499 \$2500 \$57 VDD pfet_03v3 L=0.28U W=0.36U AS=0.1584P AD=0.1152P
+ PS=1.6U PD=1U
M$1353 \$58 \$2501 \$2499 VDD pfet_03v3 L=0.28U W=0.36U AS=0.1152P AD=0.1584P
+ PS=1U PD=1.6U
M$1354 VDD RA8 \$2501 VDD pfet_03v3 L=0.28U W=0.72U AS=0.3708P AD=0.3168P
+ PS=2.47U PD=2.32U
M$1355 \$2503 \$2476 \$2502 VDD pfet_03v3 L=0.28U W=0.36U AS=0.2097P AD=0.1278P
+ PS=1.38U PD=1.07U
M$1356 \$2620 \$2504 \$2503 VDD pfet_03v3 L=0.28U W=0.36U AS=0.1278P AD=0.0567P
+ PS=1.07U PD=0.675U
M$1357 VDD \$2475 \$2620 VDD pfet_03v3 L=0.28U W=0.36U AS=0.0567P AD=0.1584P
+ PS=0.675U PD=1.6U
M$1358 \$2502 \$118 VDD VDD pfet_03v3 L=0.28U W=0.72U AS=0.3168P AD=0.2097P
+ PS=2.32U PD=1.38U
M$1359 VDD \$2503 \$2504 VDD pfet_03v3 L=0.28U W=0.36U AS=0.1584P AD=0.1764P
+ PS=1.6U PD=1.26U
M$1360 \$2505 \$2503 VDD VDD pfet_03v3 L=0.28U W=0.72U AS=0.1764P AD=0.36P
+ PS=1.26U PD=2.44U
M$1361 \$2506 RB8 VDD VDD pfet_03v3 L=0.28U W=0.72U AS=0.3312P AD=0.3888P
+ PS=2.36U PD=2.52U
M$1362 \$2505 \$2506 \$59 VDD pfet_03v3 L=0.28U W=0.36U AS=0.1584P AD=0.1152P
+ PS=1.6U PD=1U
M$1363 \$60 \$2507 \$2505 VDD pfet_03v3 L=0.28U W=0.36U AS=0.1152P AD=0.1584P
+ PS=1U PD=1.6U
M$1364 VDD RA8 \$2507 VDD pfet_03v3 L=0.28U W=0.72U AS=0.3708P AD=0.3168P
+ PS=2.47U PD=2.32U
M$1365 \$2509 \$2476 \$2508 VDD pfet_03v3 L=0.28U W=0.36U AS=0.2097P AD=0.1278P
+ PS=1.38U PD=1.07U
M$1366 \$2629 \$2510 \$2509 VDD pfet_03v3 L=0.28U W=0.36U AS=0.1278P AD=0.0567P
+ PS=1.07U PD=0.675U
M$1367 VDD \$2475 \$2629 VDD pfet_03v3 L=0.28U W=0.36U AS=0.0567P AD=0.1584P
+ PS=0.675U PD=1.6U
M$1368 \$2508 \$121 VDD VDD pfet_03v3 L=0.28U W=0.72U AS=0.3168P AD=0.2097P
+ PS=2.32U PD=1.38U
M$1369 VDD \$2509 \$2510 VDD pfet_03v3 L=0.28U W=0.36U AS=0.1584P AD=0.1764P
+ PS=1.6U PD=1.26U
M$1370 \$2511 \$2509 VDD VDD pfet_03v3 L=0.28U W=0.72U AS=0.1764P AD=0.36P
+ PS=1.26U PD=2.44U
M$1371 \$2512 RB8 VDD VDD pfet_03v3 L=0.28U W=0.72U AS=0.3312P AD=0.3888P
+ PS=2.36U PD=2.52U
M$1372 \$2511 \$2512 \$61 VDD pfet_03v3 L=0.28U W=0.36U AS=0.1584P AD=0.1152P
+ PS=1.6U PD=1U
M$1373 \$62 \$2513 \$2511 VDD pfet_03v3 L=0.28U W=0.36U AS=0.1152P AD=0.1584P
+ PS=1U PD=1.6U
M$1374 VDD RA8 \$2513 VDD pfet_03v3 L=0.28U W=0.72U AS=0.3708P AD=0.3168P
+ PS=2.47U PD=2.32U
M$1375 \$2515 \$2476 \$2514 VDD pfet_03v3 L=0.28U W=0.36U AS=0.2097P AD=0.1278P
+ PS=1.38U PD=1.07U
M$1376 \$2639 \$2516 \$2515 VDD pfet_03v3 L=0.28U W=0.36U AS=0.1278P AD=0.0567P
+ PS=1.07U PD=0.675U
M$1377 VDD \$2475 \$2639 VDD pfet_03v3 L=0.28U W=0.36U AS=0.0567P AD=0.1584P
+ PS=0.675U PD=1.6U
M$1378 \$2514 \$124 VDD VDD pfet_03v3 L=0.28U W=0.72U AS=0.3168P AD=0.2097P
+ PS=2.32U PD=1.38U
M$1379 VDD \$2515 \$2516 VDD pfet_03v3 L=0.28U W=0.36U AS=0.1584P AD=0.1764P
+ PS=1.6U PD=1.26U
M$1380 \$2517 \$2515 VDD VDD pfet_03v3 L=0.28U W=0.72U AS=0.1764P AD=0.36P
+ PS=1.26U PD=2.44U
M$1381 \$2518 RB8 VDD VDD pfet_03v3 L=0.28U W=0.72U AS=0.3312P AD=0.3888P
+ PS=2.36U PD=2.52U
M$1382 \$2517 \$2518 \$63 VDD pfet_03v3 L=0.28U W=0.36U AS=0.1584P AD=0.1152P
+ PS=1.6U PD=1U
M$1383 \$64 \$2519 \$2517 VDD pfet_03v3 L=0.28U W=0.36U AS=0.1152P AD=0.1584P
+ PS=1U PD=1.6U
M$1384 VDD RA8 \$2519 VDD pfet_03v3 L=0.28U W=0.72U AS=0.3708P AD=0.3168P
+ PS=2.47U PD=2.32U
M$1385 \$2521 \$2476 \$2520 VDD pfet_03v3 L=0.28U W=0.36U AS=0.2097P AD=0.1278P
+ PS=1.38U PD=1.07U
M$1386 \$2649 \$2522 \$2521 VDD pfet_03v3 L=0.28U W=0.36U AS=0.1278P AD=0.0567P
+ PS=1.07U PD=0.675U
M$1387 VDD \$2475 \$2649 VDD pfet_03v3 L=0.28U W=0.36U AS=0.0567P AD=0.1584P
+ PS=0.675U PD=1.6U
M$1388 \$2520 \$127 VDD VDD pfet_03v3 L=0.28U W=0.72U AS=0.3168P AD=0.2097P
+ PS=2.32U PD=1.38U
M$1389 VDD \$2521 \$2522 VDD pfet_03v3 L=0.28U W=0.36U AS=0.1584P AD=0.1764P
+ PS=1.6U PD=1.26U
M$1390 \$2523 \$2521 VDD VDD pfet_03v3 L=0.28U W=0.72U AS=0.1764P AD=0.36P
+ PS=1.26U PD=2.44U
M$1391 \$2524 RB8 VDD VDD pfet_03v3 L=0.28U W=0.72U AS=0.3312P AD=0.3888P
+ PS=2.36U PD=2.52U
M$1392 \$2523 \$2524 \$65 VDD pfet_03v3 L=0.28U W=0.36U AS=0.1584P AD=0.1152P
+ PS=1.6U PD=1U
M$1393 \$66 \$2525 \$2523 VDD pfet_03v3 L=0.28U W=0.36U AS=0.1152P AD=0.1584P
+ PS=1U PD=1.6U
M$1394 VDD RA8 \$2525 VDD pfet_03v3 L=0.28U W=0.72U AS=0.3708P AD=0.3168P
+ PS=2.47U PD=2.32U
M$1395 \$2527 \$2476 \$2526 VDD pfet_03v3 L=0.28U W=0.36U AS=0.2097P AD=0.1278P
+ PS=1.38U PD=1.07U
M$1396 \$2659 \$2528 \$2527 VDD pfet_03v3 L=0.28U W=0.36U AS=0.1278P AD=0.0567P
+ PS=1.07U PD=0.675U
M$1397 VDD \$2475 \$2659 VDD pfet_03v3 L=0.28U W=0.36U AS=0.0567P AD=0.1584P
+ PS=0.675U PD=1.6U
M$1398 \$2526 \$130 VDD VDD pfet_03v3 L=0.28U W=0.72U AS=0.3168P AD=0.2097P
+ PS=2.32U PD=1.38U
M$1399 VDD \$2527 \$2528 VDD pfet_03v3 L=0.28U W=0.36U AS=0.1584P AD=0.1764P
+ PS=1.6U PD=1.26U
M$1400 \$2529 \$2527 VDD VDD pfet_03v3 L=0.28U W=0.72U AS=0.1764P AD=0.36P
+ PS=1.26U PD=2.44U
M$1401 \$2530 RB8 VDD VDD pfet_03v3 L=0.28U W=0.72U AS=0.3312P AD=0.3888P
+ PS=2.36U PD=2.52U
M$1402 \$2529 \$2530 \$67 VDD pfet_03v3 L=0.28U W=0.36U AS=0.1584P AD=0.1152P
+ PS=1.6U PD=1U
M$1403 \$68 \$2531 \$2529 VDD pfet_03v3 L=0.28U W=0.36U AS=0.1152P AD=0.1584P
+ PS=1U PD=1.6U
M$1404 VDD RA8 \$2531 VDD pfet_03v3 L=0.28U W=0.72U AS=0.3708P AD=0.3168P
+ PS=2.47U PD=2.32U
M$1405 \$2533 \$2476 \$2532 VDD pfet_03v3 L=0.28U W=0.36U AS=0.2097P AD=0.1278P
+ PS=1.38U PD=1.07U
M$1406 \$2669 \$2534 \$2533 VDD pfet_03v3 L=0.28U W=0.36U AS=0.1278P AD=0.0567P
+ PS=1.07U PD=0.675U
M$1407 VDD \$2475 \$2669 VDD pfet_03v3 L=0.28U W=0.36U AS=0.0567P AD=0.1584P
+ PS=0.675U PD=1.6U
M$1408 \$2532 \$133 VDD VDD pfet_03v3 L=0.28U W=0.72U AS=0.3168P AD=0.2097P
+ PS=2.32U PD=1.38U
M$1409 VDD \$2533 \$2534 VDD pfet_03v3 L=0.28U W=0.36U AS=0.1584P AD=0.1764P
+ PS=1.6U PD=1.26U
M$1410 \$2535 \$2533 VDD VDD pfet_03v3 L=0.28U W=0.72U AS=0.1764P AD=0.36P
+ PS=1.26U PD=2.44U
M$1411 \$2536 RB8 VDD VDD pfet_03v3 L=0.28U W=0.72U AS=0.3312P AD=0.3888P
+ PS=2.36U PD=2.52U
M$1412 \$2535 \$2536 \$69 VDD pfet_03v3 L=0.28U W=0.36U AS=0.1584P AD=0.1152P
+ PS=1.6U PD=1U
M$1413 \$70 \$2537 \$2535 VDD pfet_03v3 L=0.28U W=0.36U AS=0.1152P AD=0.1584P
+ PS=1U PD=1.6U
M$1414 VDD RA8 \$2537 VDD pfet_03v3 L=0.28U W=0.72U AS=0.3708P AD=0.3168P
+ PS=2.47U PD=2.32U
M$1415 \$2539 \$2476 \$2538 VDD pfet_03v3 L=0.28U W=0.36U AS=0.2097P AD=0.1278P
+ PS=1.38U PD=1.07U
M$1416 \$2655 \$2540 \$2539 VDD pfet_03v3 L=0.28U W=0.36U AS=0.1278P AD=0.0567P
+ PS=1.07U PD=0.675U
M$1417 VDD \$2475 \$2655 VDD pfet_03v3 L=0.28U W=0.36U AS=0.0567P AD=0.1584P
+ PS=0.675U PD=1.6U
M$1418 \$2538 \$136 VDD VDD pfet_03v3 L=0.28U W=0.72U AS=0.3168P AD=0.2097P
+ PS=2.32U PD=1.38U
M$1419 VDD \$2539 \$2540 VDD pfet_03v3 L=0.28U W=0.36U AS=0.1584P AD=0.1764P
+ PS=1.6U PD=1.26U
M$1420 \$2541 \$2539 VDD VDD pfet_03v3 L=0.28U W=0.72U AS=0.1764P AD=0.36P
+ PS=1.26U PD=2.44U
M$1421 \$2542 RB8 VDD VDD pfet_03v3 L=0.28U W=0.72U AS=0.3312P AD=0.3888P
+ PS=2.36U PD=2.52U
M$1422 \$2541 \$2542 \$71 VDD pfet_03v3 L=0.28U W=0.36U AS=0.1584P AD=0.1152P
+ PS=1.6U PD=1U
M$1423 \$72 \$2543 \$2541 VDD pfet_03v3 L=0.28U W=0.36U AS=0.1152P AD=0.1584P
+ PS=1U PD=1.6U
M$1424 VDD RA8 \$2543 VDD pfet_03v3 L=0.28U W=0.72U AS=0.3708P AD=0.3168P
+ PS=2.47U PD=2.32U
M$1425 \$2545 \$2476 \$2544 VDD pfet_03v3 L=0.28U W=0.36U AS=0.2097P AD=0.1278P
+ PS=1.38U PD=1.07U
M$1426 \$2641 \$2546 \$2545 VDD pfet_03v3 L=0.28U W=0.36U AS=0.1278P AD=0.0567P
+ PS=1.07U PD=0.675U
M$1427 VDD \$2475 \$2641 VDD pfet_03v3 L=0.28U W=0.36U AS=0.0567P AD=0.1584P
+ PS=0.675U PD=1.6U
M$1428 \$2544 \$139 VDD VDD pfet_03v3 L=0.28U W=0.72U AS=0.3168P AD=0.2097P
+ PS=2.32U PD=1.38U
M$1429 VDD \$2545 \$2546 VDD pfet_03v3 L=0.28U W=0.36U AS=0.1584P AD=0.1764P
+ PS=1.6U PD=1.26U
M$1430 \$2547 \$2545 VDD VDD pfet_03v3 L=0.28U W=0.72U AS=0.1764P AD=0.36P
+ PS=1.26U PD=2.44U
M$1431 \$2548 RB8 VDD VDD pfet_03v3 L=0.28U W=0.72U AS=0.3312P AD=0.3888P
+ PS=2.36U PD=2.52U
M$1432 \$2547 \$2548 \$73 VDD pfet_03v3 L=0.28U W=0.36U AS=0.1584P AD=0.1152P
+ PS=1.6U PD=1U
M$1433 \$74 \$2549 \$2547 VDD pfet_03v3 L=0.28U W=0.36U AS=0.1152P AD=0.1584P
+ PS=1U PD=1.6U
M$1434 VDD RA8 \$2549 VDD pfet_03v3 L=0.28U W=0.72U AS=0.3708P AD=0.3168P
+ PS=2.47U PD=2.32U
M$1435 \$2551 \$2476 \$2550 VDD pfet_03v3 L=0.28U W=0.36U AS=0.2097P AD=0.1278P
+ PS=1.38U PD=1.07U
M$1436 \$2625 \$2552 \$2551 VDD pfet_03v3 L=0.28U W=0.36U AS=0.1278P AD=0.0567P
+ PS=1.07U PD=0.675U
M$1437 VDD \$2475 \$2625 VDD pfet_03v3 L=0.28U W=0.36U AS=0.0567P AD=0.1584P
+ PS=0.675U PD=1.6U
M$1438 \$2550 \$142 VDD VDD pfet_03v3 L=0.28U W=0.72U AS=0.3168P AD=0.2097P
+ PS=2.32U PD=1.38U
M$1439 VDD \$2551 \$2552 VDD pfet_03v3 L=0.28U W=0.36U AS=0.1584P AD=0.1764P
+ PS=1.6U PD=1.26U
M$1440 \$2553 \$2551 VDD VDD pfet_03v3 L=0.28U W=0.72U AS=0.1764P AD=0.36P
+ PS=1.26U PD=2.44U
M$1441 \$2554 RB8 VDD VDD pfet_03v3 L=0.28U W=0.72U AS=0.3312P AD=0.3888P
+ PS=2.36U PD=2.52U
M$1442 \$2553 \$2554 \$75 VDD pfet_03v3 L=0.28U W=0.36U AS=0.1584P AD=0.1152P
+ PS=1.6U PD=1U
M$1443 \$76 \$2555 \$2553 VDD pfet_03v3 L=0.28U W=0.36U AS=0.1152P AD=0.1584P
+ PS=1U PD=1.6U
M$1444 VDD RA8 \$2555 VDD pfet_03v3 L=0.28U W=0.72U AS=0.3708P AD=0.3168P
+ PS=2.47U PD=2.32U
M$1445 \$2557 \$2476 \$2556 VDD pfet_03v3 L=0.28U W=0.36U AS=0.2097P AD=0.1278P
+ PS=1.38U PD=1.07U
M$1446 \$2614 \$2558 \$2557 VDD pfet_03v3 L=0.28U W=0.36U AS=0.1278P AD=0.0567P
+ PS=1.07U PD=0.675U
M$1447 VDD \$2475 \$2614 VDD pfet_03v3 L=0.28U W=0.36U AS=0.0567P AD=0.1584P
+ PS=0.675U PD=1.6U
M$1448 \$2556 \$145 VDD VDD pfet_03v3 L=0.28U W=0.72U AS=0.3168P AD=0.2097P
+ PS=2.32U PD=1.38U
M$1449 VDD \$2557 \$2558 VDD pfet_03v3 L=0.28U W=0.36U AS=0.1584P AD=0.1764P
+ PS=1.6U PD=1.26U
M$1450 \$2559 \$2557 VDD VDD pfet_03v3 L=0.28U W=0.72U AS=0.1764P AD=0.36P
+ PS=1.26U PD=2.44U
M$1451 \$2560 RB8 VDD VDD pfet_03v3 L=0.28U W=0.72U AS=0.3312P AD=0.3888P
+ PS=2.36U PD=2.52U
M$1452 \$2559 \$2560 \$77 VDD pfet_03v3 L=0.28U W=0.36U AS=0.1584P AD=0.1152P
+ PS=1.6U PD=1U
M$1453 \$78 \$2561 \$2559 VDD pfet_03v3 L=0.28U W=0.36U AS=0.1152P AD=0.1584P
+ PS=1U PD=1.6U
M$1454 VDD RA8 \$2561 VDD pfet_03v3 L=0.28U W=0.72U AS=0.3708P AD=0.3168P
+ PS=2.47U PD=2.32U
M$1455 \$2563 \$2476 \$2562 VDD pfet_03v3 L=0.28U W=0.36U AS=0.2097P AD=0.1278P
+ PS=1.38U PD=1.07U
M$1456 \$2598 \$2564 \$2563 VDD pfet_03v3 L=0.28U W=0.36U AS=0.1278P AD=0.0567P
+ PS=1.07U PD=0.675U
M$1457 VDD \$2475 \$2598 VDD pfet_03v3 L=0.28U W=0.36U AS=0.0567P AD=0.1584P
+ PS=0.675U PD=1.6U
M$1458 \$2562 \$148 VDD VDD pfet_03v3 L=0.28U W=0.72U AS=0.3168P AD=0.2097P
+ PS=2.32U PD=1.38U
M$1459 VDD \$2563 \$2564 VDD pfet_03v3 L=0.28U W=0.36U AS=0.1584P AD=0.1764P
+ PS=1.6U PD=1.26U
M$1460 \$2565 \$2563 VDD VDD pfet_03v3 L=0.28U W=0.72U AS=0.1764P AD=0.36P
+ PS=1.26U PD=2.44U
M$1461 \$2566 RB8 VDD VDD pfet_03v3 L=0.28U W=0.72U AS=0.3312P AD=0.3888P
+ PS=2.36U PD=2.52U
M$1462 \$2565 \$2566 \$79 VDD pfet_03v3 L=0.28U W=0.36U AS=0.1584P AD=0.1152P
+ PS=1.6U PD=1U
M$1463 \$80 \$2567 \$2565 VDD pfet_03v3 L=0.28U W=0.36U AS=0.1152P AD=0.1584P
+ PS=1U PD=1.6U
M$1464 VDD RA8 \$2567 VDD pfet_03v3 L=0.28U W=0.72U AS=0.3708P AD=0.3168P
+ PS=2.47U PD=2.32U
M$1465 \$2569 \$2476 \$2568 VDD pfet_03v3 L=0.28U W=0.36U AS=0.2097P AD=0.1278P
+ PS=1.38U PD=1.07U
M$1466 \$2584 \$2570 \$2569 VDD pfet_03v3 L=0.28U W=0.36U AS=0.1278P AD=0.0567P
+ PS=1.07U PD=0.675U
M$1467 VDD \$2475 \$2584 VDD pfet_03v3 L=0.28U W=0.36U AS=0.0567P AD=0.1584P
+ PS=0.675U PD=1.6U
M$1468 \$2568 \$151 VDD VDD pfet_03v3 L=0.28U W=0.72U AS=0.3168P AD=0.2097P
+ PS=2.32U PD=1.38U
M$1469 VDD \$2569 \$2570 VDD pfet_03v3 L=0.28U W=0.36U AS=0.1584P AD=0.1764P
+ PS=1.6U PD=1.26U
M$1470 \$2571 \$2569 VDD VDD pfet_03v3 L=0.28U W=0.72U AS=0.1764P AD=0.36P
+ PS=1.26U PD=2.44U
M$1471 \$2572 RB8 VDD VDD pfet_03v3 L=0.28U W=0.72U AS=0.3312P AD=0.3888P
+ PS=2.36U PD=2.52U
M$1472 \$2571 \$2572 \$81 VDD pfet_03v3 L=0.28U W=0.36U AS=0.1584P AD=0.1152P
+ PS=1.6U PD=1U
M$1473 \$82 \$2573 \$2571 VDD pfet_03v3 L=0.28U W=0.36U AS=0.1152P AD=0.1584P
+ PS=1U PD=1.6U
M$1474 VDD RA8 \$2573 VDD pfet_03v3 L=0.28U W=0.72U AS=0.3708P AD=0.3168P
+ PS=2.47U PD=2.32U
M$1475 \$2793 WE7 VDD VDD pfet_03v3 L=0.28U W=0.72U AS=0.3168P AD=0.1872P
+ PS=2.32U PD=1.24U
M$1476 VDD CLK \$2793 VDD pfet_03v3 L=0.28U W=0.72U AS=0.1872P AD=0.3168P
+ PS=1.24U PD=2.32U
M$1477 \$2794 \$2793 VDD VDD pfet_03v3 L=0.28U W=2.54U AS=0.8974P AD=0.6604P
+ PS=5.28U PD=3.58U
M$1479 \$2987 \$2794 VDD VDD pfet_03v3 L=0.28U W=2.68U AS=0.7272P AD=0.9782P
+ PS=3.78U PD=5.48U
M$1481 \$2795 \$106 VDD VDD pfet_03v3 L=0.28U W=0.72U AS=0.3168P AD=0.2097P
+ PS=2.32U PD=1.38U
M$1482 \$2796 \$2987 \$2795 VDD pfet_03v3 L=0.28U W=0.36U AS=0.2097P AD=0.1278P
+ PS=1.38U PD=1.07U
M$1483 \$2993 \$2885 \$2796 VDD pfet_03v3 L=0.28U W=0.36U AS=0.1278P AD=0.0567P
+ PS=1.07U PD=0.675U
M$1484 VDD \$2794 \$2993 VDD pfet_03v3 L=0.28U W=0.36U AS=0.0567P AD=0.1584P
+ PS=0.675U PD=1.6U
M$1485 \$2885 \$2796 VDD VDD pfet_03v3 L=0.28U W=0.36U AS=0.1764P AD=0.1584P
+ PS=1.26U PD=1.6U
M$1486 \$2777 \$2796 VDD VDD pfet_03v3 L=0.28U W=0.72U AS=0.1764P AD=0.36P
+ PS=1.26U PD=2.44U
M$1487 \$2887 RA7 VDD VDD pfet_03v3 L=0.28U W=0.72U AS=0.3312P AD=0.3888P
+ PS=2.36U PD=2.52U
M$1488 \$2777 \$2887 \$51 VDD pfet_03v3 L=0.28U W=0.36U AS=0.1584P AD=0.1152P
+ PS=1.6U PD=1U
M$1489 \$52 \$2888 \$2777 VDD pfet_03v3 L=0.28U W=0.36U AS=0.1152P AD=0.1584P
+ PS=1U PD=1.6U
M$1490 VDD RB7 \$2888 VDD pfet_03v3 L=0.28U W=0.72U AS=0.3708P AD=0.3168P
+ PS=2.47U PD=2.32U
M$1491 \$2797 \$109 VDD VDD pfet_03v3 L=0.28U W=0.72U AS=0.3168P AD=0.2097P
+ PS=2.32U PD=1.38U
M$1492 \$2798 \$2987 \$2797 VDD pfet_03v3 L=0.28U W=0.36U AS=0.2097P AD=0.1278P
+ PS=1.38U PD=1.07U
M$1493 \$3005 \$2889 \$2798 VDD pfet_03v3 L=0.28U W=0.36U AS=0.1278P AD=0.0567P
+ PS=1.07U PD=0.675U
M$1494 VDD \$2794 \$3005 VDD pfet_03v3 L=0.28U W=0.36U AS=0.0567P AD=0.1584P
+ PS=0.675U PD=1.6U
M$1495 \$2889 \$2798 VDD VDD pfet_03v3 L=0.28U W=0.36U AS=0.1764P AD=0.1584P
+ PS=1.26U PD=1.6U
M$1496 \$2778 \$2798 VDD VDD pfet_03v3 L=0.28U W=0.72U AS=0.1764P AD=0.36P
+ PS=1.26U PD=2.44U
M$1497 \$2890 RA7 VDD VDD pfet_03v3 L=0.28U W=0.72U AS=0.3312P AD=0.3888P
+ PS=2.36U PD=2.52U
M$1498 \$2778 \$2890 \$53 VDD pfet_03v3 L=0.28U W=0.36U AS=0.1584P AD=0.1152P
+ PS=1.6U PD=1U
M$1499 \$54 \$2891 \$2778 VDD pfet_03v3 L=0.28U W=0.36U AS=0.1152P AD=0.1584P
+ PS=1U PD=1.6U
M$1500 VDD RB7 \$2891 VDD pfet_03v3 L=0.28U W=0.72U AS=0.3708P AD=0.3168P
+ PS=2.47U PD=2.32U
M$1501 \$2799 \$112 VDD VDD pfet_03v3 L=0.28U W=0.72U AS=0.3168P AD=0.2097P
+ PS=2.32U PD=1.38U
M$1502 \$2800 \$2987 \$2799 VDD pfet_03v3 L=0.28U W=0.36U AS=0.2097P AD=0.1278P
+ PS=1.38U PD=1.07U
M$1503 \$3014 \$2892 \$2800 VDD pfet_03v3 L=0.28U W=0.36U AS=0.1278P AD=0.0567P
+ PS=1.07U PD=0.675U
M$1504 VDD \$2794 \$3014 VDD pfet_03v3 L=0.28U W=0.36U AS=0.0567P AD=0.1584P
+ PS=0.675U PD=1.6U
M$1505 \$2892 \$2800 VDD VDD pfet_03v3 L=0.28U W=0.36U AS=0.1764P AD=0.1584P
+ PS=1.26U PD=1.6U
M$1506 \$2779 \$2800 VDD VDD pfet_03v3 L=0.28U W=0.72U AS=0.1764P AD=0.36P
+ PS=1.26U PD=2.44U
M$1507 \$2893 RA7 VDD VDD pfet_03v3 L=0.28U W=0.72U AS=0.3312P AD=0.3888P
+ PS=2.36U PD=2.52U
M$1508 \$2779 \$2893 \$55 VDD pfet_03v3 L=0.28U W=0.36U AS=0.1584P AD=0.1152P
+ PS=1.6U PD=1U
M$1509 \$56 \$2894 \$2779 VDD pfet_03v3 L=0.28U W=0.36U AS=0.1152P AD=0.1584P
+ PS=1U PD=1.6U
M$1510 VDD RB7 \$2894 VDD pfet_03v3 L=0.28U W=0.72U AS=0.3708P AD=0.3168P
+ PS=2.47U PD=2.32U
M$1511 \$2801 \$115 VDD VDD pfet_03v3 L=0.28U W=0.72U AS=0.3168P AD=0.2097P
+ PS=2.32U PD=1.38U
M$1512 \$2802 \$2987 \$2801 VDD pfet_03v3 L=0.28U W=0.36U AS=0.2097P AD=0.1278P
+ PS=1.38U PD=1.07U
M$1513 \$3025 \$2895 \$2802 VDD pfet_03v3 L=0.28U W=0.36U AS=0.1278P AD=0.0567P
+ PS=1.07U PD=0.675U
M$1514 VDD \$2794 \$3025 VDD pfet_03v3 L=0.28U W=0.36U AS=0.0567P AD=0.1584P
+ PS=0.675U PD=1.6U
M$1515 \$2895 \$2802 VDD VDD pfet_03v3 L=0.28U W=0.36U AS=0.1764P AD=0.1584P
+ PS=1.26U PD=1.6U
M$1516 \$2780 \$2802 VDD VDD pfet_03v3 L=0.28U W=0.72U AS=0.1764P AD=0.36P
+ PS=1.26U PD=2.44U
M$1517 \$2896 RA7 VDD VDD pfet_03v3 L=0.28U W=0.72U AS=0.3312P AD=0.3888P
+ PS=2.36U PD=2.52U
M$1518 \$2780 \$2896 \$57 VDD pfet_03v3 L=0.28U W=0.36U AS=0.1584P AD=0.1152P
+ PS=1.6U PD=1U
M$1519 \$58 \$2897 \$2780 VDD pfet_03v3 L=0.28U W=0.36U AS=0.1152P AD=0.1584P
+ PS=1U PD=1.6U
M$1520 VDD RB7 \$2897 VDD pfet_03v3 L=0.28U W=0.72U AS=0.3708P AD=0.3168P
+ PS=2.47U PD=2.32U
M$1521 \$2803 \$118 VDD VDD pfet_03v3 L=0.28U W=0.72U AS=0.3168P AD=0.2097P
+ PS=2.32U PD=1.38U
M$1522 \$2804 \$2987 \$2803 VDD pfet_03v3 L=0.28U W=0.36U AS=0.2097P AD=0.1278P
+ PS=1.38U PD=1.07U
M$1523 \$3034 \$2898 \$2804 VDD pfet_03v3 L=0.28U W=0.36U AS=0.1278P AD=0.0567P
+ PS=1.07U PD=0.675U
M$1524 VDD \$2794 \$3034 VDD pfet_03v3 L=0.28U W=0.36U AS=0.0567P AD=0.1584P
+ PS=0.675U PD=1.6U
M$1525 \$2898 \$2804 VDD VDD pfet_03v3 L=0.28U W=0.36U AS=0.1764P AD=0.1584P
+ PS=1.26U PD=1.6U
M$1526 \$2781 \$2804 VDD VDD pfet_03v3 L=0.28U W=0.72U AS=0.1764P AD=0.36P
+ PS=1.26U PD=2.44U
M$1527 \$2899 RA7 VDD VDD pfet_03v3 L=0.28U W=0.72U AS=0.3312P AD=0.3888P
+ PS=2.36U PD=2.52U
M$1528 \$2781 \$2899 \$59 VDD pfet_03v3 L=0.28U W=0.36U AS=0.1584P AD=0.1152P
+ PS=1.6U PD=1U
M$1529 \$60 \$2900 \$2781 VDD pfet_03v3 L=0.28U W=0.36U AS=0.1152P AD=0.1584P
+ PS=1U PD=1.6U
M$1530 VDD RB7 \$2900 VDD pfet_03v3 L=0.28U W=0.72U AS=0.3708P AD=0.3168P
+ PS=2.47U PD=2.32U
M$1531 \$2805 \$121 VDD VDD pfet_03v3 L=0.28U W=0.72U AS=0.3168P AD=0.2097P
+ PS=2.32U PD=1.38U
M$1532 \$2806 \$2987 \$2805 VDD pfet_03v3 L=0.28U W=0.36U AS=0.2097P AD=0.1278P
+ PS=1.38U PD=1.07U
M$1533 \$3044 \$2901 \$2806 VDD pfet_03v3 L=0.28U W=0.36U AS=0.1278P AD=0.0567P
+ PS=1.07U PD=0.675U
M$1534 VDD \$2794 \$3044 VDD pfet_03v3 L=0.28U W=0.36U AS=0.0567P AD=0.1584P
+ PS=0.675U PD=1.6U
M$1535 \$2901 \$2806 VDD VDD pfet_03v3 L=0.28U W=0.36U AS=0.1764P AD=0.1584P
+ PS=1.26U PD=1.6U
M$1536 \$2782 \$2806 VDD VDD pfet_03v3 L=0.28U W=0.72U AS=0.1764P AD=0.36P
+ PS=1.26U PD=2.44U
M$1537 \$2902 RA7 VDD VDD pfet_03v3 L=0.28U W=0.72U AS=0.3312P AD=0.3888P
+ PS=2.36U PD=2.52U
M$1538 \$2782 \$2902 \$61 VDD pfet_03v3 L=0.28U W=0.36U AS=0.1584P AD=0.1152P
+ PS=1.6U PD=1U
M$1539 \$62 \$2903 \$2782 VDD pfet_03v3 L=0.28U W=0.36U AS=0.1152P AD=0.1584P
+ PS=1U PD=1.6U
M$1540 VDD RB7 \$2903 VDD pfet_03v3 L=0.28U W=0.72U AS=0.3708P AD=0.3168P
+ PS=2.47U PD=2.32U
M$1541 \$2807 \$124 VDD VDD pfet_03v3 L=0.28U W=0.72U AS=0.3168P AD=0.2097P
+ PS=2.32U PD=1.38U
M$1542 \$2808 \$2987 \$2807 VDD pfet_03v3 L=0.28U W=0.36U AS=0.2097P AD=0.1278P
+ PS=1.38U PD=1.07U
M$1543 \$3055 \$2904 \$2808 VDD pfet_03v3 L=0.28U W=0.36U AS=0.1278P AD=0.0567P
+ PS=1.07U PD=0.675U
M$1544 VDD \$2794 \$3055 VDD pfet_03v3 L=0.28U W=0.36U AS=0.0567P AD=0.1584P
+ PS=0.675U PD=1.6U
M$1545 \$2904 \$2808 VDD VDD pfet_03v3 L=0.28U W=0.36U AS=0.1764P AD=0.1584P
+ PS=1.26U PD=1.6U
M$1546 \$2783 \$2808 VDD VDD pfet_03v3 L=0.28U W=0.72U AS=0.1764P AD=0.36P
+ PS=1.26U PD=2.44U
M$1547 \$2905 RA7 VDD VDD pfet_03v3 L=0.28U W=0.72U AS=0.3312P AD=0.3888P
+ PS=2.36U PD=2.52U
M$1548 \$2783 \$2905 \$63 VDD pfet_03v3 L=0.28U W=0.36U AS=0.1584P AD=0.1152P
+ PS=1.6U PD=1U
M$1549 \$64 \$2906 \$2783 VDD pfet_03v3 L=0.28U W=0.36U AS=0.1152P AD=0.1584P
+ PS=1U PD=1.6U
M$1550 VDD RB7 \$2906 VDD pfet_03v3 L=0.28U W=0.72U AS=0.3708P AD=0.3168P
+ PS=2.47U PD=2.32U
M$1551 \$2809 \$127 VDD VDD pfet_03v3 L=0.28U W=0.72U AS=0.3168P AD=0.2097P
+ PS=2.32U PD=1.38U
M$1552 \$2810 \$2987 \$2809 VDD pfet_03v3 L=0.28U W=0.36U AS=0.2097P AD=0.1278P
+ PS=1.38U PD=1.07U
M$1553 \$3066 \$2907 \$2810 VDD pfet_03v3 L=0.28U W=0.36U AS=0.1278P AD=0.0567P
+ PS=1.07U PD=0.675U
M$1554 VDD \$2794 \$3066 VDD pfet_03v3 L=0.28U W=0.36U AS=0.0567P AD=0.1584P
+ PS=0.675U PD=1.6U
M$1555 \$2907 \$2810 VDD VDD pfet_03v3 L=0.28U W=0.36U AS=0.1764P AD=0.1584P
+ PS=1.26U PD=1.6U
M$1556 \$2784 \$2810 VDD VDD pfet_03v3 L=0.28U W=0.72U AS=0.1764P AD=0.36P
+ PS=1.26U PD=2.44U
M$1557 \$2908 RA7 VDD VDD pfet_03v3 L=0.28U W=0.72U AS=0.3312P AD=0.3888P
+ PS=2.36U PD=2.52U
M$1558 \$2784 \$2908 \$65 VDD pfet_03v3 L=0.28U W=0.36U AS=0.1584P AD=0.1152P
+ PS=1.6U PD=1U
M$1559 \$66 \$2909 \$2784 VDD pfet_03v3 L=0.28U W=0.36U AS=0.1152P AD=0.1584P
+ PS=1U PD=1.6U
M$1560 VDD RB7 \$2909 VDD pfet_03v3 L=0.28U W=0.72U AS=0.3708P AD=0.3168P
+ PS=2.47U PD=2.32U
M$1561 \$2811 \$130 VDD VDD pfet_03v3 L=0.28U W=0.72U AS=0.3168P AD=0.2097P
+ PS=2.32U PD=1.38U
M$1562 \$2812 \$2987 \$2811 VDD pfet_03v3 L=0.28U W=0.36U AS=0.2097P AD=0.1278P
+ PS=1.38U PD=1.07U
M$1563 \$3075 \$2910 \$2812 VDD pfet_03v3 L=0.28U W=0.36U AS=0.1278P AD=0.0567P
+ PS=1.07U PD=0.675U
M$1564 VDD \$2794 \$3075 VDD pfet_03v3 L=0.28U W=0.36U AS=0.0567P AD=0.1584P
+ PS=0.675U PD=1.6U
M$1565 \$2910 \$2812 VDD VDD pfet_03v3 L=0.28U W=0.36U AS=0.1764P AD=0.1584P
+ PS=1.26U PD=1.6U
M$1566 \$2785 \$2812 VDD VDD pfet_03v3 L=0.28U W=0.72U AS=0.1764P AD=0.36P
+ PS=1.26U PD=2.44U
M$1567 \$2911 RA7 VDD VDD pfet_03v3 L=0.28U W=0.72U AS=0.3312P AD=0.3888P
+ PS=2.36U PD=2.52U
M$1568 \$2785 \$2911 \$67 VDD pfet_03v3 L=0.28U W=0.36U AS=0.1584P AD=0.1152P
+ PS=1.6U PD=1U
M$1569 \$68 \$2912 \$2785 VDD pfet_03v3 L=0.28U W=0.36U AS=0.1152P AD=0.1584P
+ PS=1U PD=1.6U
M$1570 VDD RB7 \$2912 VDD pfet_03v3 L=0.28U W=0.72U AS=0.3708P AD=0.3168P
+ PS=2.47U PD=2.32U
M$1571 \$2813 \$133 VDD VDD pfet_03v3 L=0.28U W=0.72U AS=0.3168P AD=0.2097P
+ PS=2.32U PD=1.38U
M$1572 \$2814 \$2987 \$2813 VDD pfet_03v3 L=0.28U W=0.36U AS=0.2097P AD=0.1278P
+ PS=1.38U PD=1.07U
M$1573 \$3085 \$2913 \$2814 VDD pfet_03v3 L=0.28U W=0.36U AS=0.1278P AD=0.0567P
+ PS=1.07U PD=0.675U
M$1574 VDD \$2794 \$3085 VDD pfet_03v3 L=0.28U W=0.36U AS=0.0567P AD=0.1584P
+ PS=0.675U PD=1.6U
M$1575 \$2913 \$2814 VDD VDD pfet_03v3 L=0.28U W=0.36U AS=0.1764P AD=0.1584P
+ PS=1.26U PD=1.6U
M$1576 \$2786 \$2814 VDD VDD pfet_03v3 L=0.28U W=0.72U AS=0.1764P AD=0.36P
+ PS=1.26U PD=2.44U
M$1577 \$2914 RA7 VDD VDD pfet_03v3 L=0.28U W=0.72U AS=0.3312P AD=0.3888P
+ PS=2.36U PD=2.52U
M$1578 \$2786 \$2914 \$69 VDD pfet_03v3 L=0.28U W=0.36U AS=0.1584P AD=0.1152P
+ PS=1.6U PD=1U
M$1579 \$70 \$2915 \$2786 VDD pfet_03v3 L=0.28U W=0.36U AS=0.1152P AD=0.1584P
+ PS=1U PD=1.6U
M$1580 VDD RB7 \$2915 VDD pfet_03v3 L=0.28U W=0.72U AS=0.3708P AD=0.3168P
+ PS=2.47U PD=2.32U
M$1581 \$2815 \$136 VDD VDD pfet_03v3 L=0.28U W=0.72U AS=0.3168P AD=0.2097P
+ PS=2.32U PD=1.38U
M$1582 \$2816 \$2987 \$2815 VDD pfet_03v3 L=0.28U W=0.36U AS=0.2097P AD=0.1278P
+ PS=1.38U PD=1.07U
M$1583 \$3086 \$2916 \$2816 VDD pfet_03v3 L=0.28U W=0.36U AS=0.1278P AD=0.0567P
+ PS=1.07U PD=0.675U
M$1584 VDD \$2794 \$3086 VDD pfet_03v3 L=0.28U W=0.36U AS=0.0567P AD=0.1584P
+ PS=0.675U PD=1.6U
M$1585 \$2916 \$2816 VDD VDD pfet_03v3 L=0.28U W=0.36U AS=0.1764P AD=0.1584P
+ PS=1.26U PD=1.6U
M$1586 \$2787 \$2816 VDD VDD pfet_03v3 L=0.28U W=0.72U AS=0.1764P AD=0.36P
+ PS=1.26U PD=2.44U
M$1587 \$2917 RA7 VDD VDD pfet_03v3 L=0.28U W=0.72U AS=0.3312P AD=0.3888P
+ PS=2.36U PD=2.52U
M$1588 \$2787 \$2917 \$71 VDD pfet_03v3 L=0.28U W=0.36U AS=0.1584P AD=0.1152P
+ PS=1.6U PD=1U
M$1589 \$72 \$2918 \$2787 VDD pfet_03v3 L=0.28U W=0.36U AS=0.1152P AD=0.1584P
+ PS=1U PD=1.6U
M$1590 VDD RB7 \$2918 VDD pfet_03v3 L=0.28U W=0.72U AS=0.3708P AD=0.3168P
+ PS=2.47U PD=2.32U
M$1591 \$2817 \$139 VDD VDD pfet_03v3 L=0.28U W=0.72U AS=0.3168P AD=0.2097P
+ PS=2.32U PD=1.38U
M$1592 \$2818 \$2987 \$2817 VDD pfet_03v3 L=0.28U W=0.36U AS=0.2097P AD=0.1278P
+ PS=1.38U PD=1.07U
M$1593 \$3067 \$2919 \$2818 VDD pfet_03v3 L=0.28U W=0.36U AS=0.1278P AD=0.0567P
+ PS=1.07U PD=0.675U
M$1594 VDD \$2794 \$3067 VDD pfet_03v3 L=0.28U W=0.36U AS=0.0567P AD=0.1584P
+ PS=0.675U PD=1.6U
M$1595 \$2919 \$2818 VDD VDD pfet_03v3 L=0.28U W=0.36U AS=0.1764P AD=0.1584P
+ PS=1.26U PD=1.6U
M$1596 \$2788 \$2818 VDD VDD pfet_03v3 L=0.28U W=0.72U AS=0.1764P AD=0.36P
+ PS=1.26U PD=2.44U
M$1597 \$2920 RA7 VDD VDD pfet_03v3 L=0.28U W=0.72U AS=0.3312P AD=0.3888P
+ PS=2.36U PD=2.52U
M$1598 \$2788 \$2920 \$73 VDD pfet_03v3 L=0.28U W=0.36U AS=0.1584P AD=0.1152P
+ PS=1.6U PD=1U
M$1599 \$74 \$2921 \$2788 VDD pfet_03v3 L=0.28U W=0.36U AS=0.1152P AD=0.1584P
+ PS=1U PD=1.6U
M$1600 VDD RB7 \$2921 VDD pfet_03v3 L=0.28U W=0.72U AS=0.3708P AD=0.3168P
+ PS=2.47U PD=2.32U
M$1601 \$2819 \$142 VDD VDD pfet_03v3 L=0.28U W=0.72U AS=0.3168P AD=0.2097P
+ PS=2.32U PD=1.38U
M$1602 \$2820 \$2987 \$2819 VDD pfet_03v3 L=0.28U W=0.36U AS=0.2097P AD=0.1278P
+ PS=1.38U PD=1.07U
M$1603 \$3053 \$2922 \$2820 VDD pfet_03v3 L=0.28U W=0.36U AS=0.1278P AD=0.0567P
+ PS=1.07U PD=0.675U
M$1604 VDD \$2794 \$3053 VDD pfet_03v3 L=0.28U W=0.36U AS=0.0567P AD=0.1584P
+ PS=0.675U PD=1.6U
M$1605 \$2922 \$2820 VDD VDD pfet_03v3 L=0.28U W=0.36U AS=0.1764P AD=0.1584P
+ PS=1.26U PD=1.6U
M$1606 \$2789 \$2820 VDD VDD pfet_03v3 L=0.28U W=0.72U AS=0.1764P AD=0.36P
+ PS=1.26U PD=2.44U
M$1607 \$2923 RA7 VDD VDD pfet_03v3 L=0.28U W=0.72U AS=0.3312P AD=0.3888P
+ PS=2.36U PD=2.52U
M$1608 \$2789 \$2923 \$75 VDD pfet_03v3 L=0.28U W=0.36U AS=0.1584P AD=0.1152P
+ PS=1.6U PD=1U
M$1609 \$76 \$2924 \$2789 VDD pfet_03v3 L=0.28U W=0.36U AS=0.1152P AD=0.1584P
+ PS=1U PD=1.6U
M$1610 VDD RB7 \$2924 VDD pfet_03v3 L=0.28U W=0.72U AS=0.3708P AD=0.3168P
+ PS=2.47U PD=2.32U
M$1611 \$2821 \$145 VDD VDD pfet_03v3 L=0.28U W=0.72U AS=0.3168P AD=0.2097P
+ PS=2.32U PD=1.38U
M$1612 \$2822 \$2987 \$2821 VDD pfet_03v3 L=0.28U W=0.36U AS=0.2097P AD=0.1278P
+ PS=1.38U PD=1.07U
M$1613 \$3035 \$2925 \$2822 VDD pfet_03v3 L=0.28U W=0.36U AS=0.1278P AD=0.0567P
+ PS=1.07U PD=0.675U
M$1614 VDD \$2794 \$3035 VDD pfet_03v3 L=0.28U W=0.36U AS=0.0567P AD=0.1584P
+ PS=0.675U PD=1.6U
M$1615 \$2925 \$2822 VDD VDD pfet_03v3 L=0.28U W=0.36U AS=0.1764P AD=0.1584P
+ PS=1.26U PD=1.6U
M$1616 \$2790 \$2822 VDD VDD pfet_03v3 L=0.28U W=0.72U AS=0.1764P AD=0.36P
+ PS=1.26U PD=2.44U
M$1617 \$2926 RA7 VDD VDD pfet_03v3 L=0.28U W=0.72U AS=0.3312P AD=0.3888P
+ PS=2.36U PD=2.52U
M$1618 \$2790 \$2926 \$77 VDD pfet_03v3 L=0.28U W=0.36U AS=0.1584P AD=0.1152P
+ PS=1.6U PD=1U
M$1619 \$78 \$2927 \$2790 VDD pfet_03v3 L=0.28U W=0.36U AS=0.1152P AD=0.1584P
+ PS=1U PD=1.6U
M$1620 VDD RB7 \$2927 VDD pfet_03v3 L=0.28U W=0.72U AS=0.3708P AD=0.3168P
+ PS=2.47U PD=2.32U
M$1621 \$2823 \$148 VDD VDD pfet_03v3 L=0.28U W=0.72U AS=0.3168P AD=0.2097P
+ PS=2.32U PD=1.38U
M$1622 \$2824 \$2987 \$2823 VDD pfet_03v3 L=0.28U W=0.36U AS=0.2097P AD=0.1278P
+ PS=1.38U PD=1.07U
M$1623 \$3016 \$2928 \$2824 VDD pfet_03v3 L=0.28U W=0.36U AS=0.1278P AD=0.0567P
+ PS=1.07U PD=0.675U
M$1624 VDD \$2794 \$3016 VDD pfet_03v3 L=0.28U W=0.36U AS=0.0567P AD=0.1584P
+ PS=0.675U PD=1.6U
M$1625 \$2928 \$2824 VDD VDD pfet_03v3 L=0.28U W=0.36U AS=0.1764P AD=0.1584P
+ PS=1.26U PD=1.6U
M$1626 \$2791 \$2824 VDD VDD pfet_03v3 L=0.28U W=0.72U AS=0.1764P AD=0.36P
+ PS=1.26U PD=2.44U
M$1627 \$2929 RA7 VDD VDD pfet_03v3 L=0.28U W=0.72U AS=0.3312P AD=0.3888P
+ PS=2.36U PD=2.52U
M$1628 \$2791 \$2929 \$79 VDD pfet_03v3 L=0.28U W=0.36U AS=0.1584P AD=0.1152P
+ PS=1.6U PD=1U
M$1629 \$80 \$2930 \$2791 VDD pfet_03v3 L=0.28U W=0.36U AS=0.1152P AD=0.1584P
+ PS=1U PD=1.6U
M$1630 VDD RB7 \$2930 VDD pfet_03v3 L=0.28U W=0.72U AS=0.3708P AD=0.3168P
+ PS=2.47U PD=2.32U
M$1631 \$2825 \$151 VDD VDD pfet_03v3 L=0.28U W=0.72U AS=0.3168P AD=0.2097P
+ PS=2.32U PD=1.38U
M$1632 \$2826 \$2987 \$2825 VDD pfet_03v3 L=0.28U W=0.36U AS=0.2097P AD=0.1278P
+ PS=1.38U PD=1.07U
M$1633 \$2997 \$2931 \$2826 VDD pfet_03v3 L=0.28U W=0.36U AS=0.1278P AD=0.0567P
+ PS=1.07U PD=0.675U
M$1634 VDD \$2794 \$2997 VDD pfet_03v3 L=0.28U W=0.36U AS=0.0567P AD=0.1584P
+ PS=0.675U PD=1.6U
M$1635 \$2931 \$2826 VDD VDD pfet_03v3 L=0.28U W=0.36U AS=0.1764P AD=0.1584P
+ PS=1.26U PD=1.6U
M$1636 \$2792 \$2826 VDD VDD pfet_03v3 L=0.28U W=0.72U AS=0.1764P AD=0.36P
+ PS=1.26U PD=2.44U
M$1637 \$2932 RA7 VDD VDD pfet_03v3 L=0.28U W=0.72U AS=0.3312P AD=0.3888P
+ PS=2.36U PD=2.52U
M$1638 \$2792 \$2932 \$81 VDD pfet_03v3 L=0.28U W=0.36U AS=0.1584P AD=0.1152P
+ PS=1.6U PD=1U
M$1639 \$82 \$2933 \$2792 VDD pfet_03v3 L=0.28U W=0.36U AS=0.1152P AD=0.1584P
+ PS=1U PD=1.6U
M$1640 VDD RB7 \$2933 VDD pfet_03v3 L=0.28U W=0.72U AS=0.3708P AD=0.3168P
+ PS=2.47U PD=2.32U
M$1641 \$3093 WE6 VDD VDD pfet_03v3 L=0.28U W=0.72U AS=0.3168P AD=0.1872P
+ PS=2.32U PD=1.24U
M$1642 VDD CLK \$3093 VDD pfet_03v3 L=0.28U W=0.72U AS=0.1872P AD=0.3168P
+ PS=1.24U PD=2.32U
M$1643 \$3094 \$3093 VDD VDD pfet_03v3 L=0.28U W=2.54U AS=0.889P AD=0.6688P
+ PS=5.21U PD=3.65U
M$1645 \$3095 \$3094 VDD VDD pfet_03v3 L=0.28U W=2.68U AS=0.7272P AD=0.9782P
+ PS=3.78U PD=5.48U
M$1647 \$3097 \$3095 \$3096 VDD pfet_03v3 L=0.28U W=0.36U AS=0.2097P AD=0.1278P
+ PS=1.38U PD=1.07U
M$1648 \$3198 \$3098 \$3097 VDD pfet_03v3 L=0.28U W=0.36U AS=0.1278P AD=0.0567P
+ PS=1.07U PD=0.675U
M$1649 VDD \$3094 \$3198 VDD pfet_03v3 L=0.28U W=0.36U AS=0.0567P AD=0.1584P
+ PS=0.675U PD=1.6U
M$1650 \$3096 \$106 VDD VDD pfet_03v3 L=0.28U W=0.72U AS=0.3168P AD=0.2097P
+ PS=2.32U PD=1.38U
M$1651 VDD \$3097 \$3098 VDD pfet_03v3 L=0.28U W=0.36U AS=0.1584P AD=0.1764P
+ PS=1.6U PD=1.26U
M$1652 \$3099 \$3097 VDD VDD pfet_03v3 L=0.28U W=0.72U AS=0.1764P AD=0.36P
+ PS=1.26U PD=2.44U
M$1653 \$3101 RB6 VDD VDD pfet_03v3 L=0.28U W=0.72U AS=0.3312P AD=0.3888P
+ PS=2.36U PD=2.52U
M$1654 \$3099 \$3101 \$51 VDD pfet_03v3 L=0.28U W=0.36U AS=0.1584P AD=0.1152P
+ PS=1.6U PD=1U
M$1655 \$52 \$3102 \$3099 VDD pfet_03v3 L=0.28U W=0.36U AS=0.1152P AD=0.1584P
+ PS=1U PD=1.6U
M$1656 VDD RA6 \$3102 VDD pfet_03v3 L=0.28U W=0.72U AS=0.3708P AD=0.3168P
+ PS=2.47U PD=2.32U
M$1657 \$3104 \$3095 \$3103 VDD pfet_03v3 L=0.28U W=0.36U AS=0.2097P AD=0.1278P
+ PS=1.38U PD=1.07U
M$1658 \$3207 \$3105 \$3104 VDD pfet_03v3 L=0.28U W=0.36U AS=0.1278P AD=0.0567P
+ PS=1.07U PD=0.675U
M$1659 VDD \$3094 \$3207 VDD pfet_03v3 L=0.28U W=0.36U AS=0.0567P AD=0.1584P
+ PS=0.675U PD=1.6U
M$1660 \$3103 \$109 VDD VDD pfet_03v3 L=0.28U W=0.72U AS=0.3168P AD=0.2097P
+ PS=2.32U PD=1.38U
M$1661 VDD \$3104 \$3105 VDD pfet_03v3 L=0.28U W=0.36U AS=0.1584P AD=0.1764P
+ PS=1.6U PD=1.26U
M$1662 \$3106 \$3104 VDD VDD pfet_03v3 L=0.28U W=0.72U AS=0.1764P AD=0.36P
+ PS=1.26U PD=2.44U
M$1663 \$3107 RB6 VDD VDD pfet_03v3 L=0.28U W=0.72U AS=0.3312P AD=0.3888P
+ PS=2.36U PD=2.52U
M$1664 \$3106 \$3107 \$53 VDD pfet_03v3 L=0.28U W=0.36U AS=0.1584P AD=0.1152P
+ PS=1.6U PD=1U
M$1665 \$54 \$3108 \$3106 VDD pfet_03v3 L=0.28U W=0.36U AS=0.1152P AD=0.1584P
+ PS=1U PD=1.6U
M$1666 VDD RA6 \$3108 VDD pfet_03v3 L=0.28U W=0.72U AS=0.3708P AD=0.3168P
+ PS=2.47U PD=2.32U
M$1667 \$3110 \$3095 \$3109 VDD pfet_03v3 L=0.28U W=0.36U AS=0.2097P AD=0.1278P
+ PS=1.38U PD=1.07U
M$1668 \$3218 \$3111 \$3110 VDD pfet_03v3 L=0.28U W=0.36U AS=0.1278P AD=0.0567P
+ PS=1.07U PD=0.675U
M$1669 VDD \$3094 \$3218 VDD pfet_03v3 L=0.28U W=0.36U AS=0.0567P AD=0.1584P
+ PS=0.675U PD=1.6U
M$1670 \$3109 \$112 VDD VDD pfet_03v3 L=0.28U W=0.72U AS=0.3168P AD=0.2097P
+ PS=2.32U PD=1.38U
M$1671 VDD \$3110 \$3111 VDD pfet_03v3 L=0.28U W=0.36U AS=0.1584P AD=0.1764P
+ PS=1.6U PD=1.26U
M$1672 \$3112 \$3110 VDD VDD pfet_03v3 L=0.28U W=0.72U AS=0.1764P AD=0.36P
+ PS=1.26U PD=2.44U
M$1673 \$3113 RB6 VDD VDD pfet_03v3 L=0.28U W=0.72U AS=0.3312P AD=0.3888P
+ PS=2.36U PD=2.52U
M$1674 \$3112 \$3113 \$55 VDD pfet_03v3 L=0.28U W=0.36U AS=0.1584P AD=0.1152P
+ PS=1.6U PD=1U
M$1675 \$56 \$3114 \$3112 VDD pfet_03v3 L=0.28U W=0.36U AS=0.1152P AD=0.1584P
+ PS=1U PD=1.6U
M$1676 VDD RA6 \$3114 VDD pfet_03v3 L=0.28U W=0.72U AS=0.3708P AD=0.3168P
+ PS=2.47U PD=2.32U
M$1677 \$3116 \$3095 \$3115 VDD pfet_03v3 L=0.28U W=0.36U AS=0.2097P AD=0.1278P
+ PS=1.38U PD=1.07U
M$1678 \$3228 \$3117 \$3116 VDD pfet_03v3 L=0.28U W=0.36U AS=0.1278P AD=0.0567P
+ PS=1.07U PD=0.675U
M$1679 VDD \$3094 \$3228 VDD pfet_03v3 L=0.28U W=0.36U AS=0.0567P AD=0.1584P
+ PS=0.675U PD=1.6U
M$1680 \$3115 \$115 VDD VDD pfet_03v3 L=0.28U W=0.72U AS=0.3168P AD=0.2097P
+ PS=2.32U PD=1.38U
M$1681 VDD \$3116 \$3117 VDD pfet_03v3 L=0.28U W=0.36U AS=0.1584P AD=0.1764P
+ PS=1.6U PD=1.26U
M$1682 \$3118 \$3116 VDD VDD pfet_03v3 L=0.28U W=0.72U AS=0.1764P AD=0.36P
+ PS=1.26U PD=2.44U
M$1683 \$3119 RB6 VDD VDD pfet_03v3 L=0.28U W=0.72U AS=0.3312P AD=0.3888P
+ PS=2.36U PD=2.52U
M$1684 \$3118 \$3119 \$57 VDD pfet_03v3 L=0.28U W=0.36U AS=0.1584P AD=0.1152P
+ PS=1.6U PD=1U
M$1685 \$58 \$3120 \$3118 VDD pfet_03v3 L=0.28U W=0.36U AS=0.1152P AD=0.1584P
+ PS=1U PD=1.6U
M$1686 VDD RA6 \$3120 VDD pfet_03v3 L=0.28U W=0.72U AS=0.3708P AD=0.3168P
+ PS=2.47U PD=2.32U
M$1687 \$3122 \$3095 \$3121 VDD pfet_03v3 L=0.28U W=0.36U AS=0.2097P AD=0.1278P
+ PS=1.38U PD=1.07U
M$1688 \$3239 \$3123 \$3122 VDD pfet_03v3 L=0.28U W=0.36U AS=0.1278P AD=0.0567P
+ PS=1.07U PD=0.675U
M$1689 VDD \$3094 \$3239 VDD pfet_03v3 L=0.28U W=0.36U AS=0.0567P AD=0.1584P
+ PS=0.675U PD=1.6U
M$1690 \$3121 \$118 VDD VDD pfet_03v3 L=0.28U W=0.72U AS=0.3168P AD=0.2097P
+ PS=2.32U PD=1.38U
M$1691 VDD \$3122 \$3123 VDD pfet_03v3 L=0.28U W=0.36U AS=0.1584P AD=0.1764P
+ PS=1.6U PD=1.26U
M$1692 \$3124 \$3122 VDD VDD pfet_03v3 L=0.28U W=0.72U AS=0.1764P AD=0.36P
+ PS=1.26U PD=2.44U
M$1693 \$3125 RB6 VDD VDD pfet_03v3 L=0.28U W=0.72U AS=0.3312P AD=0.3888P
+ PS=2.36U PD=2.52U
M$1694 \$3124 \$3125 \$59 VDD pfet_03v3 L=0.28U W=0.36U AS=0.1584P AD=0.1152P
+ PS=1.6U PD=1U
M$1695 \$60 \$3126 \$3124 VDD pfet_03v3 L=0.28U W=0.36U AS=0.1152P AD=0.1584P
+ PS=1U PD=1.6U
M$1696 VDD RA6 \$3126 VDD pfet_03v3 L=0.28U W=0.72U AS=0.3708P AD=0.3168P
+ PS=2.47U PD=2.32U
M$1697 \$3128 \$3095 \$3127 VDD pfet_03v3 L=0.28U W=0.36U AS=0.2097P AD=0.1278P
+ PS=1.38U PD=1.07U
M$1698 \$3248 \$3129 \$3128 VDD pfet_03v3 L=0.28U W=0.36U AS=0.1278P AD=0.0567P
+ PS=1.07U PD=0.675U
M$1699 VDD \$3094 \$3248 VDD pfet_03v3 L=0.28U W=0.36U AS=0.0567P AD=0.1584P
+ PS=0.675U PD=1.6U
M$1700 \$3127 \$121 VDD VDD pfet_03v3 L=0.28U W=0.72U AS=0.3168P AD=0.2097P
+ PS=2.32U PD=1.38U
M$1701 VDD \$3128 \$3129 VDD pfet_03v3 L=0.28U W=0.36U AS=0.1584P AD=0.1764P
+ PS=1.6U PD=1.26U
M$1702 \$3130 \$3128 VDD VDD pfet_03v3 L=0.28U W=0.72U AS=0.1764P AD=0.36P
+ PS=1.26U PD=2.44U
M$1703 \$3131 RB6 VDD VDD pfet_03v3 L=0.28U W=0.72U AS=0.3312P AD=0.3888P
+ PS=2.36U PD=2.52U
M$1704 \$3130 \$3131 \$61 VDD pfet_03v3 L=0.28U W=0.36U AS=0.1584P AD=0.1152P
+ PS=1.6U PD=1U
M$1705 \$62 \$3132 \$3130 VDD pfet_03v3 L=0.28U W=0.36U AS=0.1152P AD=0.1584P
+ PS=1U PD=1.6U
M$1706 VDD RA6 \$3132 VDD pfet_03v3 L=0.28U W=0.72U AS=0.3708P AD=0.3168P
+ PS=2.47U PD=2.32U
M$1707 \$3134 \$3095 \$3133 VDD pfet_03v3 L=0.28U W=0.36U AS=0.2097P AD=0.1278P
+ PS=1.38U PD=1.07U
M$1708 \$3258 \$3135 \$3134 VDD pfet_03v3 L=0.28U W=0.36U AS=0.1278P AD=0.0567P
+ PS=1.07U PD=0.675U
M$1709 VDD \$3094 \$3258 VDD pfet_03v3 L=0.28U W=0.36U AS=0.0567P AD=0.1584P
+ PS=0.675U PD=1.6U
M$1710 \$3133 \$124 VDD VDD pfet_03v3 L=0.28U W=0.72U AS=0.3168P AD=0.2097P
+ PS=2.32U PD=1.38U
M$1711 VDD \$3134 \$3135 VDD pfet_03v3 L=0.28U W=0.36U AS=0.1584P AD=0.1764P
+ PS=1.6U PD=1.26U
M$1712 \$3136 \$3134 VDD VDD pfet_03v3 L=0.28U W=0.72U AS=0.1764P AD=0.36P
+ PS=1.26U PD=2.44U
M$1713 \$3137 RB6 VDD VDD pfet_03v3 L=0.28U W=0.72U AS=0.3312P AD=0.3888P
+ PS=2.36U PD=2.52U
M$1714 \$3136 \$3137 \$63 VDD pfet_03v3 L=0.28U W=0.36U AS=0.1584P AD=0.1152P
+ PS=1.6U PD=1U
M$1715 \$64 \$3138 \$3136 VDD pfet_03v3 L=0.28U W=0.36U AS=0.1152P AD=0.1584P
+ PS=1U PD=1.6U
M$1716 VDD RA6 \$3138 VDD pfet_03v3 L=0.28U W=0.72U AS=0.3708P AD=0.3168P
+ PS=2.47U PD=2.32U
M$1717 \$3140 \$3095 \$3139 VDD pfet_03v3 L=0.28U W=0.36U AS=0.2097P AD=0.1278P
+ PS=1.38U PD=1.07U
M$1718 \$3268 \$3141 \$3140 VDD pfet_03v3 L=0.28U W=0.36U AS=0.1278P AD=0.0567P
+ PS=1.07U PD=0.675U
M$1719 VDD \$3094 \$3268 VDD pfet_03v3 L=0.28U W=0.36U AS=0.0567P AD=0.1584P
+ PS=0.675U PD=1.6U
M$1720 \$3139 \$127 VDD VDD pfet_03v3 L=0.28U W=0.72U AS=0.3168P AD=0.2097P
+ PS=2.32U PD=1.38U
M$1721 VDD \$3140 \$3141 VDD pfet_03v3 L=0.28U W=0.36U AS=0.1584P AD=0.1764P
+ PS=1.6U PD=1.26U
M$1722 \$3142 \$3140 VDD VDD pfet_03v3 L=0.28U W=0.72U AS=0.1764P AD=0.36P
+ PS=1.26U PD=2.44U
M$1723 \$3143 RB6 VDD VDD pfet_03v3 L=0.28U W=0.72U AS=0.3312P AD=0.3888P
+ PS=2.36U PD=2.52U
M$1724 \$3142 \$3143 \$65 VDD pfet_03v3 L=0.28U W=0.36U AS=0.1584P AD=0.1152P
+ PS=1.6U PD=1U
M$1725 \$66 \$3144 \$3142 VDD pfet_03v3 L=0.28U W=0.36U AS=0.1152P AD=0.1584P
+ PS=1U PD=1.6U
M$1726 VDD RA6 \$3144 VDD pfet_03v3 L=0.28U W=0.72U AS=0.3708P AD=0.3168P
+ PS=2.47U PD=2.32U
M$1727 \$3146 \$3095 \$3145 VDD pfet_03v3 L=0.28U W=0.36U AS=0.2097P AD=0.1278P
+ PS=1.38U PD=1.07U
M$1728 \$3278 \$3147 \$3146 VDD pfet_03v3 L=0.28U W=0.36U AS=0.1278P AD=0.0567P
+ PS=1.07U PD=0.675U
M$1729 VDD \$3094 \$3278 VDD pfet_03v3 L=0.28U W=0.36U AS=0.0567P AD=0.1584P
+ PS=0.675U PD=1.6U
M$1730 \$3145 \$130 VDD VDD pfet_03v3 L=0.28U W=0.72U AS=0.3168P AD=0.2097P
+ PS=2.32U PD=1.38U
M$1731 VDD \$3146 \$3147 VDD pfet_03v3 L=0.28U W=0.36U AS=0.1584P AD=0.1764P
+ PS=1.6U PD=1.26U
M$1732 \$3148 \$3146 VDD VDD pfet_03v3 L=0.28U W=0.72U AS=0.1764P AD=0.36P
+ PS=1.26U PD=2.44U
M$1733 \$3149 RB6 VDD VDD pfet_03v3 L=0.28U W=0.72U AS=0.3312P AD=0.3888P
+ PS=2.36U PD=2.52U
M$1734 \$3148 \$3149 \$67 VDD pfet_03v3 L=0.28U W=0.36U AS=0.1584P AD=0.1152P
+ PS=1.6U PD=1U
M$1735 \$68 \$3150 \$3148 VDD pfet_03v3 L=0.28U W=0.36U AS=0.1152P AD=0.1584P
+ PS=1U PD=1.6U
M$1736 VDD RA6 \$3150 VDD pfet_03v3 L=0.28U W=0.72U AS=0.3708P AD=0.3168P
+ PS=2.47U PD=2.32U
M$1737 \$3152 \$3095 \$3151 VDD pfet_03v3 L=0.28U W=0.36U AS=0.2097P AD=0.1278P
+ PS=1.38U PD=1.07U
M$1738 \$3288 \$3153 \$3152 VDD pfet_03v3 L=0.28U W=0.36U AS=0.1278P AD=0.0567P
+ PS=1.07U PD=0.675U
M$1739 VDD \$3094 \$3288 VDD pfet_03v3 L=0.28U W=0.36U AS=0.0567P AD=0.1584P
+ PS=0.675U PD=1.6U
M$1740 \$3151 \$133 VDD VDD pfet_03v3 L=0.28U W=0.72U AS=0.3168P AD=0.2097P
+ PS=2.32U PD=1.38U
M$1741 VDD \$3152 \$3153 VDD pfet_03v3 L=0.28U W=0.36U AS=0.1584P AD=0.1764P
+ PS=1.6U PD=1.26U
M$1742 \$3154 \$3152 VDD VDD pfet_03v3 L=0.28U W=0.72U AS=0.1764P AD=0.36P
+ PS=1.26U PD=2.44U
M$1743 \$3155 RB6 VDD VDD pfet_03v3 L=0.28U W=0.72U AS=0.3312P AD=0.3888P
+ PS=2.36U PD=2.52U
M$1744 \$3154 \$3155 \$69 VDD pfet_03v3 L=0.28U W=0.36U AS=0.1584P AD=0.1152P
+ PS=1.6U PD=1U
M$1745 \$70 \$3156 \$3154 VDD pfet_03v3 L=0.28U W=0.36U AS=0.1152P AD=0.1584P
+ PS=1U PD=1.6U
M$1746 VDD RA6 \$3156 VDD pfet_03v3 L=0.28U W=0.72U AS=0.3708P AD=0.3168P
+ PS=2.47U PD=2.32U
M$1747 \$3158 \$3095 \$3157 VDD pfet_03v3 L=0.28U W=0.36U AS=0.2097P AD=0.1278P
+ PS=1.38U PD=1.07U
M$1748 \$3274 \$3159 \$3158 VDD pfet_03v3 L=0.28U W=0.36U AS=0.1278P AD=0.0567P
+ PS=1.07U PD=0.675U
M$1749 VDD \$3094 \$3274 VDD pfet_03v3 L=0.28U W=0.36U AS=0.0567P AD=0.1584P
+ PS=0.675U PD=1.6U
M$1750 \$3157 \$136 VDD VDD pfet_03v3 L=0.28U W=0.72U AS=0.3168P AD=0.2097P
+ PS=2.32U PD=1.38U
M$1751 VDD \$3158 \$3159 VDD pfet_03v3 L=0.28U W=0.36U AS=0.1584P AD=0.1764P
+ PS=1.6U PD=1.26U
M$1752 \$3160 \$3158 VDD VDD pfet_03v3 L=0.28U W=0.72U AS=0.1764P AD=0.36P
+ PS=1.26U PD=2.44U
M$1753 \$3161 RB6 VDD VDD pfet_03v3 L=0.28U W=0.72U AS=0.3312P AD=0.3888P
+ PS=2.36U PD=2.52U
M$1754 \$3160 \$3161 \$71 VDD pfet_03v3 L=0.28U W=0.36U AS=0.1584P AD=0.1152P
+ PS=1.6U PD=1U
M$1755 \$72 \$3162 \$3160 VDD pfet_03v3 L=0.28U W=0.36U AS=0.1152P AD=0.1584P
+ PS=1U PD=1.6U
M$1756 VDD RA6 \$3162 VDD pfet_03v3 L=0.28U W=0.72U AS=0.3708P AD=0.3168P
+ PS=2.47U PD=2.32U
M$1757 \$3164 \$3095 \$3163 VDD pfet_03v3 L=0.28U W=0.36U AS=0.2097P AD=0.1278P
+ PS=1.38U PD=1.07U
M$1758 \$3260 \$3165 \$3164 VDD pfet_03v3 L=0.28U W=0.36U AS=0.1278P AD=0.0567P
+ PS=1.07U PD=0.675U
M$1759 VDD \$3094 \$3260 VDD pfet_03v3 L=0.28U W=0.36U AS=0.0567P AD=0.1584P
+ PS=0.675U PD=1.6U
M$1760 \$3163 \$139 VDD VDD pfet_03v3 L=0.28U W=0.72U AS=0.3168P AD=0.2097P
+ PS=2.32U PD=1.38U
M$1761 VDD \$3164 \$3165 VDD pfet_03v3 L=0.28U W=0.36U AS=0.1584P AD=0.1764P
+ PS=1.6U PD=1.26U
M$1762 \$3166 \$3164 VDD VDD pfet_03v3 L=0.28U W=0.72U AS=0.1764P AD=0.36P
+ PS=1.26U PD=2.44U
M$1763 \$3167 RB6 VDD VDD pfet_03v3 L=0.28U W=0.72U AS=0.3312P AD=0.3888P
+ PS=2.36U PD=2.52U
M$1764 \$3166 \$3167 \$73 VDD pfet_03v3 L=0.28U W=0.36U AS=0.1584P AD=0.1152P
+ PS=1.6U PD=1U
M$1765 \$74 \$3168 \$3166 VDD pfet_03v3 L=0.28U W=0.36U AS=0.1152P AD=0.1584P
+ PS=1U PD=1.6U
M$1766 VDD RA6 \$3168 VDD pfet_03v3 L=0.28U W=0.72U AS=0.3708P AD=0.3168P
+ PS=2.47U PD=2.32U
M$1767 \$3170 \$3095 \$3169 VDD pfet_03v3 L=0.28U W=0.36U AS=0.2097P AD=0.1278P
+ PS=1.38U PD=1.07U
M$1768 \$3244 \$3171 \$3170 VDD pfet_03v3 L=0.28U W=0.36U AS=0.1278P AD=0.0567P
+ PS=1.07U PD=0.675U
M$1769 VDD \$3094 \$3244 VDD pfet_03v3 L=0.28U W=0.36U AS=0.0567P AD=0.1584P
+ PS=0.675U PD=1.6U
M$1770 \$3169 \$142 VDD VDD pfet_03v3 L=0.28U W=0.72U AS=0.3168P AD=0.2097P
+ PS=2.32U PD=1.38U
M$1771 VDD \$3170 \$3171 VDD pfet_03v3 L=0.28U W=0.36U AS=0.1584P AD=0.1764P
+ PS=1.6U PD=1.26U
M$1772 \$3172 \$3170 VDD VDD pfet_03v3 L=0.28U W=0.72U AS=0.1764P AD=0.36P
+ PS=1.26U PD=2.44U
M$1773 \$3173 RB6 VDD VDD pfet_03v3 L=0.28U W=0.72U AS=0.3312P AD=0.3888P
+ PS=2.36U PD=2.52U
M$1774 \$3172 \$3173 \$75 VDD pfet_03v3 L=0.28U W=0.36U AS=0.1584P AD=0.1152P
+ PS=1.6U PD=1U
M$1775 \$76 \$3174 \$3172 VDD pfet_03v3 L=0.28U W=0.36U AS=0.1152P AD=0.1584P
+ PS=1U PD=1.6U
M$1776 VDD RA6 \$3174 VDD pfet_03v3 L=0.28U W=0.72U AS=0.3708P AD=0.3168P
+ PS=2.47U PD=2.32U
M$1777 \$3176 \$3095 \$3175 VDD pfet_03v3 L=0.28U W=0.36U AS=0.2097P AD=0.1278P
+ PS=1.38U PD=1.07U
M$1778 \$3233 \$3177 \$3176 VDD pfet_03v3 L=0.28U W=0.36U AS=0.1278P AD=0.0567P
+ PS=1.07U PD=0.675U
M$1779 VDD \$3094 \$3233 VDD pfet_03v3 L=0.28U W=0.36U AS=0.0567P AD=0.1584P
+ PS=0.675U PD=1.6U
M$1780 \$3175 \$145 VDD VDD pfet_03v3 L=0.28U W=0.72U AS=0.3168P AD=0.2097P
+ PS=2.32U PD=1.38U
M$1781 VDD \$3176 \$3177 VDD pfet_03v3 L=0.28U W=0.36U AS=0.1584P AD=0.1764P
+ PS=1.6U PD=1.26U
M$1782 \$3178 \$3176 VDD VDD pfet_03v3 L=0.28U W=0.72U AS=0.1764P AD=0.36P
+ PS=1.26U PD=2.44U
M$1783 \$3179 RB6 VDD VDD pfet_03v3 L=0.28U W=0.72U AS=0.3312P AD=0.3888P
+ PS=2.36U PD=2.52U
M$1784 \$3178 \$3179 \$77 VDD pfet_03v3 L=0.28U W=0.36U AS=0.1584P AD=0.1152P
+ PS=1.6U PD=1U
M$1785 \$78 \$3180 \$3178 VDD pfet_03v3 L=0.28U W=0.36U AS=0.1152P AD=0.1584P
+ PS=1U PD=1.6U
M$1786 VDD RA6 \$3180 VDD pfet_03v3 L=0.28U W=0.72U AS=0.3708P AD=0.3168P
+ PS=2.47U PD=2.32U
M$1787 \$3182 \$3095 \$3181 VDD pfet_03v3 L=0.28U W=0.36U AS=0.2097P AD=0.1278P
+ PS=1.38U PD=1.07U
M$1788 \$3217 \$3183 \$3182 VDD pfet_03v3 L=0.28U W=0.36U AS=0.1278P AD=0.0567P
+ PS=1.07U PD=0.675U
M$1789 VDD \$3094 \$3217 VDD pfet_03v3 L=0.28U W=0.36U AS=0.0567P AD=0.1584P
+ PS=0.675U PD=1.6U
M$1790 \$3181 \$148 VDD VDD pfet_03v3 L=0.28U W=0.72U AS=0.3168P AD=0.2097P
+ PS=2.32U PD=1.38U
M$1791 VDD \$3182 \$3183 VDD pfet_03v3 L=0.28U W=0.36U AS=0.1584P AD=0.1764P
+ PS=1.6U PD=1.26U
M$1792 \$3184 \$3182 VDD VDD pfet_03v3 L=0.28U W=0.72U AS=0.1764P AD=0.36P
+ PS=1.26U PD=2.44U
M$1793 \$3185 RB6 VDD VDD pfet_03v3 L=0.28U W=0.72U AS=0.3312P AD=0.3888P
+ PS=2.36U PD=2.52U
M$1794 \$3184 \$3185 \$79 VDD pfet_03v3 L=0.28U W=0.36U AS=0.1584P AD=0.1152P
+ PS=1.6U PD=1U
M$1795 \$80 \$3186 \$3184 VDD pfet_03v3 L=0.28U W=0.36U AS=0.1152P AD=0.1584P
+ PS=1U PD=1.6U
M$1796 VDD RA6 \$3186 VDD pfet_03v3 L=0.28U W=0.72U AS=0.3708P AD=0.3168P
+ PS=2.47U PD=2.32U
M$1797 \$3188 \$3095 \$3187 VDD pfet_03v3 L=0.28U W=0.36U AS=0.2097P AD=0.1278P
+ PS=1.38U PD=1.07U
M$1798 \$3203 \$3189 \$3188 VDD pfet_03v3 L=0.28U W=0.36U AS=0.1278P AD=0.0567P
+ PS=1.07U PD=0.675U
M$1799 VDD \$3094 \$3203 VDD pfet_03v3 L=0.28U W=0.36U AS=0.0567P AD=0.1584P
+ PS=0.675U PD=1.6U
M$1800 \$3187 \$151 VDD VDD pfet_03v3 L=0.28U W=0.72U AS=0.3168P AD=0.2097P
+ PS=2.32U PD=1.38U
M$1801 VDD \$3188 \$3189 VDD pfet_03v3 L=0.28U W=0.36U AS=0.1584P AD=0.1764P
+ PS=1.6U PD=1.26U
M$1802 \$3190 \$3188 VDD VDD pfet_03v3 L=0.28U W=0.72U AS=0.1764P AD=0.36P
+ PS=1.26U PD=2.44U
M$1803 \$3191 RB6 VDD VDD pfet_03v3 L=0.28U W=0.72U AS=0.3312P AD=0.3888P
+ PS=2.36U PD=2.52U
M$1804 \$3190 \$3191 \$81 VDD pfet_03v3 L=0.28U W=0.36U AS=0.1584P AD=0.1152P
+ PS=1.6U PD=1U
M$1805 \$82 \$3192 \$3190 VDD pfet_03v3 L=0.28U W=0.36U AS=0.1152P AD=0.1584P
+ PS=1U PD=1.6U
M$1806 VDD RA6 \$3192 VDD pfet_03v3 L=0.28U W=0.72U AS=0.3708P AD=0.3168P
+ PS=2.47U PD=2.32U
M$1807 \$3412 WE5 VDD VDD pfet_03v3 L=0.28U W=0.72U AS=0.3168P AD=0.1872P
+ PS=2.32U PD=1.24U
M$1808 VDD CLK \$3412 VDD pfet_03v3 L=0.28U W=0.72U AS=0.1872P AD=0.3168P
+ PS=1.24U PD=2.32U
M$1809 \$3413 \$3412 VDD VDD pfet_03v3 L=0.28U W=2.54U AS=0.8974P AD=0.6604P
+ PS=5.28U PD=3.58U
M$1811 \$3600 \$3413 VDD VDD pfet_03v3 L=0.28U W=2.68U AS=0.7272P AD=0.9782P
+ PS=3.78U PD=5.48U
M$1813 \$3414 \$106 VDD VDD pfet_03v3 L=0.28U W=0.72U AS=0.3168P AD=0.2097P
+ PS=2.32U PD=1.38U
M$1814 \$3415 \$3600 \$3414 VDD pfet_03v3 L=0.28U W=0.36U AS=0.2097P AD=0.1278P
+ PS=1.38U PD=1.07U
M$1815 \$3606 \$3498 \$3415 VDD pfet_03v3 L=0.28U W=0.36U AS=0.1278P AD=0.0567P
+ PS=1.07U PD=0.675U
M$1816 VDD \$3413 \$3606 VDD pfet_03v3 L=0.28U W=0.36U AS=0.0567P AD=0.1584P
+ PS=0.675U PD=1.6U
M$1817 \$3498 \$3415 VDD VDD pfet_03v3 L=0.28U W=0.36U AS=0.1764P AD=0.1584P
+ PS=1.26U PD=1.6U
M$1818 \$3396 \$3415 VDD VDD pfet_03v3 L=0.28U W=0.72U AS=0.1764P AD=0.36P
+ PS=1.26U PD=2.44U
M$1819 \$3500 RA5 VDD VDD pfet_03v3 L=0.28U W=0.72U AS=0.3312P AD=0.3888P
+ PS=2.36U PD=2.52U
M$1820 \$3396 \$3500 \$51 VDD pfet_03v3 L=0.28U W=0.36U AS=0.1584P AD=0.1152P
+ PS=1.6U PD=1U
M$1821 \$52 \$3501 \$3396 VDD pfet_03v3 L=0.28U W=0.36U AS=0.1152P AD=0.1584P
+ PS=1U PD=1.6U
M$1822 VDD RB5 \$3501 VDD pfet_03v3 L=0.28U W=0.72U AS=0.3708P AD=0.3168P
+ PS=2.47U PD=2.32U
M$1823 \$3416 \$109 VDD VDD pfet_03v3 L=0.28U W=0.72U AS=0.3168P AD=0.2097P
+ PS=2.32U PD=1.38U
M$1824 \$3417 \$3600 \$3416 VDD pfet_03v3 L=0.28U W=0.36U AS=0.2097P AD=0.1278P
+ PS=1.38U PD=1.07U
M$1825 \$3618 \$3502 \$3417 VDD pfet_03v3 L=0.28U W=0.36U AS=0.1278P AD=0.0567P
+ PS=1.07U PD=0.675U
M$1826 VDD \$3413 \$3618 VDD pfet_03v3 L=0.28U W=0.36U AS=0.0567P AD=0.1584P
+ PS=0.675U PD=1.6U
M$1827 \$3502 \$3417 VDD VDD pfet_03v3 L=0.28U W=0.36U AS=0.1764P AD=0.1584P
+ PS=1.26U PD=1.6U
M$1828 \$3397 \$3417 VDD VDD pfet_03v3 L=0.28U W=0.72U AS=0.1764P AD=0.36P
+ PS=1.26U PD=2.44U
M$1829 \$3503 RA5 VDD VDD pfet_03v3 L=0.28U W=0.72U AS=0.3312P AD=0.3888P
+ PS=2.36U PD=2.52U
M$1830 \$3397 \$3503 \$53 VDD pfet_03v3 L=0.28U W=0.36U AS=0.1584P AD=0.1152P
+ PS=1.6U PD=1U
M$1831 \$54 \$3504 \$3397 VDD pfet_03v3 L=0.28U W=0.36U AS=0.1152P AD=0.1584P
+ PS=1U PD=1.6U
M$1832 VDD RB5 \$3504 VDD pfet_03v3 L=0.28U W=0.72U AS=0.3708P AD=0.3168P
+ PS=2.47U PD=2.32U
M$1833 \$3418 \$112 VDD VDD pfet_03v3 L=0.28U W=0.72U AS=0.3168P AD=0.2097P
+ PS=2.32U PD=1.38U
M$1834 \$3419 \$3600 \$3418 VDD pfet_03v3 L=0.28U W=0.36U AS=0.2097P AD=0.1278P
+ PS=1.38U PD=1.07U
M$1835 \$3627 \$3505 \$3419 VDD pfet_03v3 L=0.28U W=0.36U AS=0.1278P AD=0.0567P
+ PS=1.07U PD=0.675U
M$1836 VDD \$3413 \$3627 VDD pfet_03v3 L=0.28U W=0.36U AS=0.0567P AD=0.1584P
+ PS=0.675U PD=1.6U
M$1837 \$3505 \$3419 VDD VDD pfet_03v3 L=0.28U W=0.36U AS=0.1764P AD=0.1584P
+ PS=1.26U PD=1.6U
M$1838 \$3398 \$3419 VDD VDD pfet_03v3 L=0.28U W=0.72U AS=0.1764P AD=0.36P
+ PS=1.26U PD=2.44U
M$1839 \$3506 RA5 VDD VDD pfet_03v3 L=0.28U W=0.72U AS=0.3312P AD=0.3888P
+ PS=2.36U PD=2.52U
M$1840 \$3398 \$3506 \$55 VDD pfet_03v3 L=0.28U W=0.36U AS=0.1584P AD=0.1152P
+ PS=1.6U PD=1U
M$1841 \$56 \$3507 \$3398 VDD pfet_03v3 L=0.28U W=0.36U AS=0.1152P AD=0.1584P
+ PS=1U PD=1.6U
M$1842 VDD RB5 \$3507 VDD pfet_03v3 L=0.28U W=0.72U AS=0.3708P AD=0.3168P
+ PS=2.47U PD=2.32U
M$1843 \$3420 \$115 VDD VDD pfet_03v3 L=0.28U W=0.72U AS=0.3168P AD=0.2097P
+ PS=2.32U PD=1.38U
M$1844 \$3421 \$3600 \$3420 VDD pfet_03v3 L=0.28U W=0.36U AS=0.2097P AD=0.1278P
+ PS=1.38U PD=1.07U
M$1845 \$3638 \$3508 \$3421 VDD pfet_03v3 L=0.28U W=0.36U AS=0.1278P AD=0.0567P
+ PS=1.07U PD=0.675U
M$1846 VDD \$3413 \$3638 VDD pfet_03v3 L=0.28U W=0.36U AS=0.0567P AD=0.1584P
+ PS=0.675U PD=1.6U
M$1847 \$3508 \$3421 VDD VDD pfet_03v3 L=0.28U W=0.36U AS=0.1764P AD=0.1584P
+ PS=1.26U PD=1.6U
M$1848 \$3399 \$3421 VDD VDD pfet_03v3 L=0.28U W=0.72U AS=0.1764P AD=0.36P
+ PS=1.26U PD=2.44U
M$1849 \$3509 RA5 VDD VDD pfet_03v3 L=0.28U W=0.72U AS=0.3312P AD=0.3888P
+ PS=2.36U PD=2.52U
M$1850 \$3399 \$3509 \$57 VDD pfet_03v3 L=0.28U W=0.36U AS=0.1584P AD=0.1152P
+ PS=1.6U PD=1U
M$1851 \$58 \$3510 \$3399 VDD pfet_03v3 L=0.28U W=0.36U AS=0.1152P AD=0.1584P
+ PS=1U PD=1.6U
M$1852 VDD RB5 \$3510 VDD pfet_03v3 L=0.28U W=0.72U AS=0.3708P AD=0.3168P
+ PS=2.47U PD=2.32U
M$1853 \$3422 \$118 VDD VDD pfet_03v3 L=0.28U W=0.72U AS=0.3168P AD=0.2097P
+ PS=2.32U PD=1.38U
M$1854 \$3423 \$3600 \$3422 VDD pfet_03v3 L=0.28U W=0.36U AS=0.2097P AD=0.1278P
+ PS=1.38U PD=1.07U
M$1855 \$3647 \$3511 \$3423 VDD pfet_03v3 L=0.28U W=0.36U AS=0.1278P AD=0.0567P
+ PS=1.07U PD=0.675U
M$1856 VDD \$3413 \$3647 VDD pfet_03v3 L=0.28U W=0.36U AS=0.0567P AD=0.1584P
+ PS=0.675U PD=1.6U
M$1857 \$3511 \$3423 VDD VDD pfet_03v3 L=0.28U W=0.36U AS=0.1764P AD=0.1584P
+ PS=1.26U PD=1.6U
M$1858 \$3400 \$3423 VDD VDD pfet_03v3 L=0.28U W=0.72U AS=0.1764P AD=0.36P
+ PS=1.26U PD=2.44U
M$1859 \$3512 RA5 VDD VDD pfet_03v3 L=0.28U W=0.72U AS=0.3312P AD=0.3888P
+ PS=2.36U PD=2.52U
M$1860 \$3400 \$3512 \$59 VDD pfet_03v3 L=0.28U W=0.36U AS=0.1584P AD=0.1152P
+ PS=1.6U PD=1U
M$1861 \$60 \$3513 \$3400 VDD pfet_03v3 L=0.28U W=0.36U AS=0.1152P AD=0.1584P
+ PS=1U PD=1.6U
M$1862 VDD RB5 \$3513 VDD pfet_03v3 L=0.28U W=0.72U AS=0.3708P AD=0.3168P
+ PS=2.47U PD=2.32U
M$1863 \$3424 \$121 VDD VDD pfet_03v3 L=0.28U W=0.72U AS=0.3168P AD=0.2097P
+ PS=2.32U PD=1.38U
M$1864 \$3425 \$3600 \$3424 VDD pfet_03v3 L=0.28U W=0.36U AS=0.2097P AD=0.1278P
+ PS=1.38U PD=1.07U
M$1865 \$3657 \$3514 \$3425 VDD pfet_03v3 L=0.28U W=0.36U AS=0.1278P AD=0.0567P
+ PS=1.07U PD=0.675U
M$1866 VDD \$3413 \$3657 VDD pfet_03v3 L=0.28U W=0.36U AS=0.0567P AD=0.1584P
+ PS=0.675U PD=1.6U
M$1867 \$3514 \$3425 VDD VDD pfet_03v3 L=0.28U W=0.36U AS=0.1764P AD=0.1584P
+ PS=1.26U PD=1.6U
M$1868 \$3401 \$3425 VDD VDD pfet_03v3 L=0.28U W=0.72U AS=0.1764P AD=0.36P
+ PS=1.26U PD=2.44U
M$1869 \$3515 RA5 VDD VDD pfet_03v3 L=0.28U W=0.72U AS=0.3312P AD=0.3888P
+ PS=2.36U PD=2.52U
M$1870 \$3401 \$3515 \$61 VDD pfet_03v3 L=0.28U W=0.36U AS=0.1584P AD=0.1152P
+ PS=1.6U PD=1U
M$1871 \$62 \$3516 \$3401 VDD pfet_03v3 L=0.28U W=0.36U AS=0.1152P AD=0.1584P
+ PS=1U PD=1.6U
M$1872 VDD RB5 \$3516 VDD pfet_03v3 L=0.28U W=0.72U AS=0.3708P AD=0.3168P
+ PS=2.47U PD=2.32U
M$1873 \$3426 \$124 VDD VDD pfet_03v3 L=0.28U W=0.72U AS=0.3168P AD=0.2097P
+ PS=2.32U PD=1.38U
M$1874 \$3427 \$3600 \$3426 VDD pfet_03v3 L=0.28U W=0.36U AS=0.2097P AD=0.1278P
+ PS=1.38U PD=1.07U
M$1875 \$3668 \$3517 \$3427 VDD pfet_03v3 L=0.28U W=0.36U AS=0.1278P AD=0.0567P
+ PS=1.07U PD=0.675U
M$1876 VDD \$3413 \$3668 VDD pfet_03v3 L=0.28U W=0.36U AS=0.0567P AD=0.1584P
+ PS=0.675U PD=1.6U
M$1877 \$3517 \$3427 VDD VDD pfet_03v3 L=0.28U W=0.36U AS=0.1764P AD=0.1584P
+ PS=1.26U PD=1.6U
M$1878 \$3402 \$3427 VDD VDD pfet_03v3 L=0.28U W=0.72U AS=0.1764P AD=0.36P
+ PS=1.26U PD=2.44U
M$1879 \$3518 RA5 VDD VDD pfet_03v3 L=0.28U W=0.72U AS=0.3312P AD=0.3888P
+ PS=2.36U PD=2.52U
M$1880 \$3402 \$3518 \$63 VDD pfet_03v3 L=0.28U W=0.36U AS=0.1584P AD=0.1152P
+ PS=1.6U PD=1U
M$1881 \$64 \$3519 \$3402 VDD pfet_03v3 L=0.28U W=0.36U AS=0.1152P AD=0.1584P
+ PS=1U PD=1.6U
M$1882 VDD RB5 \$3519 VDD pfet_03v3 L=0.28U W=0.72U AS=0.3708P AD=0.3168P
+ PS=2.47U PD=2.32U
M$1883 \$3428 \$127 VDD VDD pfet_03v3 L=0.28U W=0.72U AS=0.3168P AD=0.2097P
+ PS=2.32U PD=1.38U
M$1884 \$3429 \$3600 \$3428 VDD pfet_03v3 L=0.28U W=0.36U AS=0.2097P AD=0.1278P
+ PS=1.38U PD=1.07U
M$1885 \$3679 \$3520 \$3429 VDD pfet_03v3 L=0.28U W=0.36U AS=0.1278P AD=0.0567P
+ PS=1.07U PD=0.675U
M$1886 VDD \$3413 \$3679 VDD pfet_03v3 L=0.28U W=0.36U AS=0.0567P AD=0.1584P
+ PS=0.675U PD=1.6U
M$1887 \$3520 \$3429 VDD VDD pfet_03v3 L=0.28U W=0.36U AS=0.1764P AD=0.1584P
+ PS=1.26U PD=1.6U
M$1888 \$3403 \$3429 VDD VDD pfet_03v3 L=0.28U W=0.72U AS=0.1764P AD=0.36P
+ PS=1.26U PD=2.44U
M$1889 \$3521 RA5 VDD VDD pfet_03v3 L=0.28U W=0.72U AS=0.3312P AD=0.3888P
+ PS=2.36U PD=2.52U
M$1890 \$3403 \$3521 \$65 VDD pfet_03v3 L=0.28U W=0.36U AS=0.1584P AD=0.1152P
+ PS=1.6U PD=1U
M$1891 \$66 \$3522 \$3403 VDD pfet_03v3 L=0.28U W=0.36U AS=0.1152P AD=0.1584P
+ PS=1U PD=1.6U
M$1892 VDD RB5 \$3522 VDD pfet_03v3 L=0.28U W=0.72U AS=0.3708P AD=0.3168P
+ PS=2.47U PD=2.32U
M$1893 \$3430 \$130 VDD VDD pfet_03v3 L=0.28U W=0.72U AS=0.3168P AD=0.2097P
+ PS=2.32U PD=1.38U
M$1894 \$3431 \$3600 \$3430 VDD pfet_03v3 L=0.28U W=0.36U AS=0.2097P AD=0.1278P
+ PS=1.38U PD=1.07U
M$1895 \$3688 \$3523 \$3431 VDD pfet_03v3 L=0.28U W=0.36U AS=0.1278P AD=0.0567P
+ PS=1.07U PD=0.675U
M$1896 VDD \$3413 \$3688 VDD pfet_03v3 L=0.28U W=0.36U AS=0.0567P AD=0.1584P
+ PS=0.675U PD=1.6U
M$1897 \$3523 \$3431 VDD VDD pfet_03v3 L=0.28U W=0.36U AS=0.1764P AD=0.1584P
+ PS=1.26U PD=1.6U
M$1898 \$3404 \$3431 VDD VDD pfet_03v3 L=0.28U W=0.72U AS=0.1764P AD=0.36P
+ PS=1.26U PD=2.44U
M$1899 \$3524 RA5 VDD VDD pfet_03v3 L=0.28U W=0.72U AS=0.3312P AD=0.3888P
+ PS=2.36U PD=2.52U
M$1900 \$3404 \$3524 \$67 VDD pfet_03v3 L=0.28U W=0.36U AS=0.1584P AD=0.1152P
+ PS=1.6U PD=1U
M$1901 \$68 \$3525 \$3404 VDD pfet_03v3 L=0.28U W=0.36U AS=0.1152P AD=0.1584P
+ PS=1U PD=1.6U
M$1902 VDD RB5 \$3525 VDD pfet_03v3 L=0.28U W=0.72U AS=0.3708P AD=0.3168P
+ PS=2.47U PD=2.32U
M$1903 \$3432 \$133 VDD VDD pfet_03v3 L=0.28U W=0.72U AS=0.3168P AD=0.2097P
+ PS=2.32U PD=1.38U
M$1904 \$3433 \$3600 \$3432 VDD pfet_03v3 L=0.28U W=0.36U AS=0.2097P AD=0.1278P
+ PS=1.38U PD=1.07U
M$1905 \$3698 \$3526 \$3433 VDD pfet_03v3 L=0.28U W=0.36U AS=0.1278P AD=0.0567P
+ PS=1.07U PD=0.675U
M$1906 VDD \$3413 \$3698 VDD pfet_03v3 L=0.28U W=0.36U AS=0.0567P AD=0.1584P
+ PS=0.675U PD=1.6U
M$1907 \$3526 \$3433 VDD VDD pfet_03v3 L=0.28U W=0.36U AS=0.1764P AD=0.1584P
+ PS=1.26U PD=1.6U
M$1908 \$3405 \$3433 VDD VDD pfet_03v3 L=0.28U W=0.72U AS=0.1764P AD=0.36P
+ PS=1.26U PD=2.44U
M$1909 \$3527 RA5 VDD VDD pfet_03v3 L=0.28U W=0.72U AS=0.3312P AD=0.3888P
+ PS=2.36U PD=2.52U
M$1910 \$3405 \$3527 \$69 VDD pfet_03v3 L=0.28U W=0.36U AS=0.1584P AD=0.1152P
+ PS=1.6U PD=1U
M$1911 \$70 \$3528 \$3405 VDD pfet_03v3 L=0.28U W=0.36U AS=0.1152P AD=0.1584P
+ PS=1U PD=1.6U
M$1912 VDD RB5 \$3528 VDD pfet_03v3 L=0.28U W=0.72U AS=0.3708P AD=0.3168P
+ PS=2.47U PD=2.32U
M$1913 \$3434 \$136 VDD VDD pfet_03v3 L=0.28U W=0.72U AS=0.3168P AD=0.2097P
+ PS=2.32U PD=1.38U
M$1914 \$3435 \$3600 \$3434 VDD pfet_03v3 L=0.28U W=0.36U AS=0.2097P AD=0.1278P
+ PS=1.38U PD=1.07U
M$1915 \$3699 \$3529 \$3435 VDD pfet_03v3 L=0.28U W=0.36U AS=0.1278P AD=0.0567P
+ PS=1.07U PD=0.675U
M$1916 VDD \$3413 \$3699 VDD pfet_03v3 L=0.28U W=0.36U AS=0.0567P AD=0.1584P
+ PS=0.675U PD=1.6U
M$1917 \$3529 \$3435 VDD VDD pfet_03v3 L=0.28U W=0.36U AS=0.1764P AD=0.1584P
+ PS=1.26U PD=1.6U
M$1918 \$3406 \$3435 VDD VDD pfet_03v3 L=0.28U W=0.72U AS=0.1764P AD=0.36P
+ PS=1.26U PD=2.44U
M$1919 \$3530 RA5 VDD VDD pfet_03v3 L=0.28U W=0.72U AS=0.3312P AD=0.3888P
+ PS=2.36U PD=2.52U
M$1920 \$3406 \$3530 \$71 VDD pfet_03v3 L=0.28U W=0.36U AS=0.1584P AD=0.1152P
+ PS=1.6U PD=1U
M$1921 \$72 \$3531 \$3406 VDD pfet_03v3 L=0.28U W=0.36U AS=0.1152P AD=0.1584P
+ PS=1U PD=1.6U
M$1922 VDD RB5 \$3531 VDD pfet_03v3 L=0.28U W=0.72U AS=0.3708P AD=0.3168P
+ PS=2.47U PD=2.32U
M$1923 \$3436 \$139 VDD VDD pfet_03v3 L=0.28U W=0.72U AS=0.3168P AD=0.2097P
+ PS=2.32U PD=1.38U
M$1924 \$3437 \$3600 \$3436 VDD pfet_03v3 L=0.28U W=0.36U AS=0.2097P AD=0.1278P
+ PS=1.38U PD=1.07U
M$1925 \$3680 \$3532 \$3437 VDD pfet_03v3 L=0.28U W=0.36U AS=0.1278P AD=0.0567P
+ PS=1.07U PD=0.675U
M$1926 VDD \$3413 \$3680 VDD pfet_03v3 L=0.28U W=0.36U AS=0.0567P AD=0.1584P
+ PS=0.675U PD=1.6U
M$1927 \$3532 \$3437 VDD VDD pfet_03v3 L=0.28U W=0.36U AS=0.1764P AD=0.1584P
+ PS=1.26U PD=1.6U
M$1928 \$3407 \$3437 VDD VDD pfet_03v3 L=0.28U W=0.72U AS=0.1764P AD=0.36P
+ PS=1.26U PD=2.44U
M$1929 \$3533 RA5 VDD VDD pfet_03v3 L=0.28U W=0.72U AS=0.3312P AD=0.3888P
+ PS=2.36U PD=2.52U
M$1930 \$3407 \$3533 \$73 VDD pfet_03v3 L=0.28U W=0.36U AS=0.1584P AD=0.1152P
+ PS=1.6U PD=1U
M$1931 \$74 \$3534 \$3407 VDD pfet_03v3 L=0.28U W=0.36U AS=0.1152P AD=0.1584P
+ PS=1U PD=1.6U
M$1932 VDD RB5 \$3534 VDD pfet_03v3 L=0.28U W=0.72U AS=0.3708P AD=0.3168P
+ PS=2.47U PD=2.32U
M$1933 \$3438 \$142 VDD VDD pfet_03v3 L=0.28U W=0.72U AS=0.3168P AD=0.2097P
+ PS=2.32U PD=1.38U
M$1934 \$3439 \$3600 \$3438 VDD pfet_03v3 L=0.28U W=0.36U AS=0.2097P AD=0.1278P
+ PS=1.38U PD=1.07U
M$1935 \$3666 \$3535 \$3439 VDD pfet_03v3 L=0.28U W=0.36U AS=0.1278P AD=0.0567P
+ PS=1.07U PD=0.675U
M$1936 VDD \$3413 \$3666 VDD pfet_03v3 L=0.28U W=0.36U AS=0.0567P AD=0.1584P
+ PS=0.675U PD=1.6U
M$1937 \$3535 \$3439 VDD VDD pfet_03v3 L=0.28U W=0.36U AS=0.1764P AD=0.1584P
+ PS=1.26U PD=1.6U
M$1938 \$3408 \$3439 VDD VDD pfet_03v3 L=0.28U W=0.72U AS=0.1764P AD=0.36P
+ PS=1.26U PD=2.44U
M$1939 \$3536 RA5 VDD VDD pfet_03v3 L=0.28U W=0.72U AS=0.3312P AD=0.3888P
+ PS=2.36U PD=2.52U
M$1940 \$3408 \$3536 \$75 VDD pfet_03v3 L=0.28U W=0.36U AS=0.1584P AD=0.1152P
+ PS=1.6U PD=1U
M$1941 \$76 \$3537 \$3408 VDD pfet_03v3 L=0.28U W=0.36U AS=0.1152P AD=0.1584P
+ PS=1U PD=1.6U
M$1942 VDD RB5 \$3537 VDD pfet_03v3 L=0.28U W=0.72U AS=0.3708P AD=0.3168P
+ PS=2.47U PD=2.32U
M$1943 \$3440 \$145 VDD VDD pfet_03v3 L=0.28U W=0.72U AS=0.3168P AD=0.2097P
+ PS=2.32U PD=1.38U
M$1944 \$3441 \$3600 \$3440 VDD pfet_03v3 L=0.28U W=0.36U AS=0.2097P AD=0.1278P
+ PS=1.38U PD=1.07U
M$1945 \$3648 \$3538 \$3441 VDD pfet_03v3 L=0.28U W=0.36U AS=0.1278P AD=0.0567P
+ PS=1.07U PD=0.675U
M$1946 VDD \$3413 \$3648 VDD pfet_03v3 L=0.28U W=0.36U AS=0.0567P AD=0.1584P
+ PS=0.675U PD=1.6U
M$1947 \$3538 \$3441 VDD VDD pfet_03v3 L=0.28U W=0.36U AS=0.1764P AD=0.1584P
+ PS=1.26U PD=1.6U
M$1948 \$3409 \$3441 VDD VDD pfet_03v3 L=0.28U W=0.72U AS=0.1764P AD=0.36P
+ PS=1.26U PD=2.44U
M$1949 \$3539 RA5 VDD VDD pfet_03v3 L=0.28U W=0.72U AS=0.3312P AD=0.3888P
+ PS=2.36U PD=2.52U
M$1950 \$3409 \$3539 \$77 VDD pfet_03v3 L=0.28U W=0.36U AS=0.1584P AD=0.1152P
+ PS=1.6U PD=1U
M$1951 \$78 \$3540 \$3409 VDD pfet_03v3 L=0.28U W=0.36U AS=0.1152P AD=0.1584P
+ PS=1U PD=1.6U
M$1952 VDD RB5 \$3540 VDD pfet_03v3 L=0.28U W=0.72U AS=0.3708P AD=0.3168P
+ PS=2.47U PD=2.32U
M$1953 \$3442 \$148 VDD VDD pfet_03v3 L=0.28U W=0.72U AS=0.3168P AD=0.2097P
+ PS=2.32U PD=1.38U
M$1954 \$3443 \$3600 \$3442 VDD pfet_03v3 L=0.28U W=0.36U AS=0.2097P AD=0.1278P
+ PS=1.38U PD=1.07U
M$1955 \$3629 \$3541 \$3443 VDD pfet_03v3 L=0.28U W=0.36U AS=0.1278P AD=0.0567P
+ PS=1.07U PD=0.675U
M$1956 VDD \$3413 \$3629 VDD pfet_03v3 L=0.28U W=0.36U AS=0.0567P AD=0.1584P
+ PS=0.675U PD=1.6U
M$1957 \$3541 \$3443 VDD VDD pfet_03v3 L=0.28U W=0.36U AS=0.1764P AD=0.1584P
+ PS=1.26U PD=1.6U
M$1958 \$3410 \$3443 VDD VDD pfet_03v3 L=0.28U W=0.72U AS=0.1764P AD=0.36P
+ PS=1.26U PD=2.44U
M$1959 \$3542 RA5 VDD VDD pfet_03v3 L=0.28U W=0.72U AS=0.3312P AD=0.3888P
+ PS=2.36U PD=2.52U
M$1960 \$3410 \$3542 \$79 VDD pfet_03v3 L=0.28U W=0.36U AS=0.1584P AD=0.1152P
+ PS=1.6U PD=1U
M$1961 \$80 \$3543 \$3410 VDD pfet_03v3 L=0.28U W=0.36U AS=0.1152P AD=0.1584P
+ PS=1U PD=1.6U
M$1962 VDD RB5 \$3543 VDD pfet_03v3 L=0.28U W=0.72U AS=0.3708P AD=0.3168P
+ PS=2.47U PD=2.32U
M$1963 \$3444 \$151 VDD VDD pfet_03v3 L=0.28U W=0.72U AS=0.3168P AD=0.2097P
+ PS=2.32U PD=1.38U
M$1964 \$3445 \$3600 \$3444 VDD pfet_03v3 L=0.28U W=0.36U AS=0.2097P AD=0.1278P
+ PS=1.38U PD=1.07U
M$1965 \$3610 \$3544 \$3445 VDD pfet_03v3 L=0.28U W=0.36U AS=0.1278P AD=0.0567P
+ PS=1.07U PD=0.675U
M$1966 VDD \$3413 \$3610 VDD pfet_03v3 L=0.28U W=0.36U AS=0.0567P AD=0.1584P
+ PS=0.675U PD=1.6U
M$1967 \$3544 \$3445 VDD VDD pfet_03v3 L=0.28U W=0.36U AS=0.1764P AD=0.1584P
+ PS=1.26U PD=1.6U
M$1968 \$3411 \$3445 VDD VDD pfet_03v3 L=0.28U W=0.72U AS=0.1764P AD=0.36P
+ PS=1.26U PD=2.44U
M$1969 \$3545 RA5 VDD VDD pfet_03v3 L=0.28U W=0.72U AS=0.3312P AD=0.3888P
+ PS=2.36U PD=2.52U
M$1970 \$3411 \$3545 \$81 VDD pfet_03v3 L=0.28U W=0.36U AS=0.1584P AD=0.1152P
+ PS=1.6U PD=1U
M$1971 \$82 \$3546 \$3411 VDD pfet_03v3 L=0.28U W=0.36U AS=0.1152P AD=0.1584P
+ PS=1U PD=1.6U
M$1972 VDD RB5 \$3546 VDD pfet_03v3 L=0.28U W=0.72U AS=0.3708P AD=0.3168P
+ PS=2.47U PD=2.32U
M$1973 \$3706 WE4 VDD VDD pfet_03v3 L=0.28U W=0.72U AS=0.3168P AD=0.1872P
+ PS=2.32U PD=1.24U
M$1974 VDD CLK \$3706 VDD pfet_03v3 L=0.28U W=0.72U AS=0.1872P AD=0.3168P
+ PS=1.24U PD=2.32U
M$1975 \$3707 \$3706 VDD VDD pfet_03v3 L=0.28U W=2.54U AS=0.889P AD=0.6688P
+ PS=5.21U PD=3.65U
M$1977 \$3708 \$3707 VDD VDD pfet_03v3 L=0.28U W=2.68U AS=0.7272P AD=0.9782P
+ PS=3.78U PD=5.48U
M$1979 \$3710 \$3708 \$3709 VDD pfet_03v3 L=0.28U W=0.36U AS=0.2097P AD=0.1278P
+ PS=1.38U PD=1.07U
M$1980 \$3811 \$3711 \$3710 VDD pfet_03v3 L=0.28U W=0.36U AS=0.1278P AD=0.0567P
+ PS=1.07U PD=0.675U
M$1981 VDD \$3707 \$3811 VDD pfet_03v3 L=0.28U W=0.36U AS=0.0567P AD=0.1584P
+ PS=0.675U PD=1.6U
M$1982 \$3709 \$106 VDD VDD pfet_03v3 L=0.28U W=0.72U AS=0.3168P AD=0.2097P
+ PS=2.32U PD=1.38U
M$1983 VDD \$3710 \$3711 VDD pfet_03v3 L=0.28U W=0.36U AS=0.1584P AD=0.1764P
+ PS=1.6U PD=1.26U
M$1984 \$3712 \$3710 VDD VDD pfet_03v3 L=0.28U W=0.72U AS=0.1764P AD=0.36P
+ PS=1.26U PD=2.44U
M$1985 \$3714 RB4 VDD VDD pfet_03v3 L=0.28U W=0.72U AS=0.3312P AD=0.3888P
+ PS=2.36U PD=2.52U
M$1986 \$3712 \$3714 \$51 VDD pfet_03v3 L=0.28U W=0.36U AS=0.1584P AD=0.1152P
+ PS=1.6U PD=1U
M$1987 \$52 \$3715 \$3712 VDD pfet_03v3 L=0.28U W=0.36U AS=0.1152P AD=0.1584P
+ PS=1U PD=1.6U
M$1988 VDD RA4 \$3715 VDD pfet_03v3 L=0.28U W=0.72U AS=0.3708P AD=0.3168P
+ PS=2.47U PD=2.32U
M$1989 \$3717 \$3708 \$3716 VDD pfet_03v3 L=0.28U W=0.36U AS=0.2097P AD=0.1278P
+ PS=1.38U PD=1.07U
M$1990 \$3820 \$3718 \$3717 VDD pfet_03v3 L=0.28U W=0.36U AS=0.1278P AD=0.0567P
+ PS=1.07U PD=0.675U
M$1991 VDD \$3707 \$3820 VDD pfet_03v3 L=0.28U W=0.36U AS=0.0567P AD=0.1584P
+ PS=0.675U PD=1.6U
M$1992 \$3716 \$109 VDD VDD pfet_03v3 L=0.28U W=0.72U AS=0.3168P AD=0.2097P
+ PS=2.32U PD=1.38U
M$1993 VDD \$3717 \$3718 VDD pfet_03v3 L=0.28U W=0.36U AS=0.1584P AD=0.1764P
+ PS=1.6U PD=1.26U
M$1994 \$3719 \$3717 VDD VDD pfet_03v3 L=0.28U W=0.72U AS=0.1764P AD=0.36P
+ PS=1.26U PD=2.44U
M$1995 \$3720 RB4 VDD VDD pfet_03v3 L=0.28U W=0.72U AS=0.3312P AD=0.3888P
+ PS=2.36U PD=2.52U
M$1996 \$3719 \$3720 \$53 VDD pfet_03v3 L=0.28U W=0.36U AS=0.1584P AD=0.1152P
+ PS=1.6U PD=1U
M$1997 \$54 \$3721 \$3719 VDD pfet_03v3 L=0.28U W=0.36U AS=0.1152P AD=0.1584P
+ PS=1U PD=1.6U
M$1998 VDD RA4 \$3721 VDD pfet_03v3 L=0.28U W=0.72U AS=0.3708P AD=0.3168P
+ PS=2.47U PD=2.32U
M$1999 \$3723 \$3708 \$3722 VDD pfet_03v3 L=0.28U W=0.36U AS=0.2097P AD=0.1278P
+ PS=1.38U PD=1.07U
M$2000 \$3831 \$3724 \$3723 VDD pfet_03v3 L=0.28U W=0.36U AS=0.1278P AD=0.0567P
+ PS=1.07U PD=0.675U
M$2001 VDD \$3707 \$3831 VDD pfet_03v3 L=0.28U W=0.36U AS=0.0567P AD=0.1584P
+ PS=0.675U PD=1.6U
M$2002 \$3722 \$112 VDD VDD pfet_03v3 L=0.28U W=0.72U AS=0.3168P AD=0.2097P
+ PS=2.32U PD=1.38U
M$2003 VDD \$3723 \$3724 VDD pfet_03v3 L=0.28U W=0.36U AS=0.1584P AD=0.1764P
+ PS=1.6U PD=1.26U
M$2004 \$3725 \$3723 VDD VDD pfet_03v3 L=0.28U W=0.72U AS=0.1764P AD=0.36P
+ PS=1.26U PD=2.44U
M$2005 \$3726 RB4 VDD VDD pfet_03v3 L=0.28U W=0.72U AS=0.3312P AD=0.3888P
+ PS=2.36U PD=2.52U
M$2006 \$3725 \$3726 \$55 VDD pfet_03v3 L=0.28U W=0.36U AS=0.1584P AD=0.1152P
+ PS=1.6U PD=1U
M$2007 \$56 \$3727 \$3725 VDD pfet_03v3 L=0.28U W=0.36U AS=0.1152P AD=0.1584P
+ PS=1U PD=1.6U
M$2008 VDD RA4 \$3727 VDD pfet_03v3 L=0.28U W=0.72U AS=0.3708P AD=0.3168P
+ PS=2.47U PD=2.32U
M$2009 \$3729 \$3708 \$3728 VDD pfet_03v3 L=0.28U W=0.36U AS=0.2097P AD=0.1278P
+ PS=1.38U PD=1.07U
M$2010 \$3841 \$3730 \$3729 VDD pfet_03v3 L=0.28U W=0.36U AS=0.1278P AD=0.0567P
+ PS=1.07U PD=0.675U
M$2011 VDD \$3707 \$3841 VDD pfet_03v3 L=0.28U W=0.36U AS=0.0567P AD=0.1584P
+ PS=0.675U PD=1.6U
M$2012 \$3728 \$115 VDD VDD pfet_03v3 L=0.28U W=0.72U AS=0.3168P AD=0.2097P
+ PS=2.32U PD=1.38U
M$2013 VDD \$3729 \$3730 VDD pfet_03v3 L=0.28U W=0.36U AS=0.1584P AD=0.1764P
+ PS=1.6U PD=1.26U
M$2014 \$3731 \$3729 VDD VDD pfet_03v3 L=0.28U W=0.72U AS=0.1764P AD=0.36P
+ PS=1.26U PD=2.44U
M$2015 \$3732 RB4 VDD VDD pfet_03v3 L=0.28U W=0.72U AS=0.3312P AD=0.3888P
+ PS=2.36U PD=2.52U
M$2016 \$3731 \$3732 \$57 VDD pfet_03v3 L=0.28U W=0.36U AS=0.1584P AD=0.1152P
+ PS=1.6U PD=1U
M$2017 \$58 \$3733 \$3731 VDD pfet_03v3 L=0.28U W=0.36U AS=0.1152P AD=0.1584P
+ PS=1U PD=1.6U
M$2018 VDD RA4 \$3733 VDD pfet_03v3 L=0.28U W=0.72U AS=0.3708P AD=0.3168P
+ PS=2.47U PD=2.32U
M$2019 \$3735 \$3708 \$3734 VDD pfet_03v3 L=0.28U W=0.36U AS=0.2097P AD=0.1278P
+ PS=1.38U PD=1.07U
M$2020 \$3852 \$3736 \$3735 VDD pfet_03v3 L=0.28U W=0.36U AS=0.1278P AD=0.0567P
+ PS=1.07U PD=0.675U
M$2021 VDD \$3707 \$3852 VDD pfet_03v3 L=0.28U W=0.36U AS=0.0567P AD=0.1584P
+ PS=0.675U PD=1.6U
M$2022 \$3734 \$118 VDD VDD pfet_03v3 L=0.28U W=0.72U AS=0.3168P AD=0.2097P
+ PS=2.32U PD=1.38U
M$2023 VDD \$3735 \$3736 VDD pfet_03v3 L=0.28U W=0.36U AS=0.1584P AD=0.1764P
+ PS=1.6U PD=1.26U
M$2024 \$3737 \$3735 VDD VDD pfet_03v3 L=0.28U W=0.72U AS=0.1764P AD=0.36P
+ PS=1.26U PD=2.44U
M$2025 \$3738 RB4 VDD VDD pfet_03v3 L=0.28U W=0.72U AS=0.3312P AD=0.3888P
+ PS=2.36U PD=2.52U
M$2026 \$3737 \$3738 \$59 VDD pfet_03v3 L=0.28U W=0.36U AS=0.1584P AD=0.1152P
+ PS=1.6U PD=1U
M$2027 \$60 \$3739 \$3737 VDD pfet_03v3 L=0.28U W=0.36U AS=0.1152P AD=0.1584P
+ PS=1U PD=1.6U
M$2028 VDD RA4 \$3739 VDD pfet_03v3 L=0.28U W=0.72U AS=0.3708P AD=0.3168P
+ PS=2.47U PD=2.32U
M$2029 \$3741 \$3708 \$3740 VDD pfet_03v3 L=0.28U W=0.36U AS=0.2097P AD=0.1278P
+ PS=1.38U PD=1.07U
M$2030 \$3861 \$3742 \$3741 VDD pfet_03v3 L=0.28U W=0.36U AS=0.1278P AD=0.0567P
+ PS=1.07U PD=0.675U
M$2031 VDD \$3707 \$3861 VDD pfet_03v3 L=0.28U W=0.36U AS=0.0567P AD=0.1584P
+ PS=0.675U PD=1.6U
M$2032 \$3740 \$121 VDD VDD pfet_03v3 L=0.28U W=0.72U AS=0.3168P AD=0.2097P
+ PS=2.32U PD=1.38U
M$2033 VDD \$3741 \$3742 VDD pfet_03v3 L=0.28U W=0.36U AS=0.1584P AD=0.1764P
+ PS=1.6U PD=1.26U
M$2034 \$3743 \$3741 VDD VDD pfet_03v3 L=0.28U W=0.72U AS=0.1764P AD=0.36P
+ PS=1.26U PD=2.44U
M$2035 \$3744 RB4 VDD VDD pfet_03v3 L=0.28U W=0.72U AS=0.3312P AD=0.3888P
+ PS=2.36U PD=2.52U
M$2036 \$3743 \$3744 \$61 VDD pfet_03v3 L=0.28U W=0.36U AS=0.1584P AD=0.1152P
+ PS=1.6U PD=1U
M$2037 \$62 \$3745 \$3743 VDD pfet_03v3 L=0.28U W=0.36U AS=0.1152P AD=0.1584P
+ PS=1U PD=1.6U
M$2038 VDD RA4 \$3745 VDD pfet_03v3 L=0.28U W=0.72U AS=0.3708P AD=0.3168P
+ PS=2.47U PD=2.32U
M$2039 \$3747 \$3708 \$3746 VDD pfet_03v3 L=0.28U W=0.36U AS=0.2097P AD=0.1278P
+ PS=1.38U PD=1.07U
M$2040 \$3871 \$3748 \$3747 VDD pfet_03v3 L=0.28U W=0.36U AS=0.1278P AD=0.0567P
+ PS=1.07U PD=0.675U
M$2041 VDD \$3707 \$3871 VDD pfet_03v3 L=0.28U W=0.36U AS=0.0567P AD=0.1584P
+ PS=0.675U PD=1.6U
M$2042 \$3746 \$124 VDD VDD pfet_03v3 L=0.28U W=0.72U AS=0.3168P AD=0.2097P
+ PS=2.32U PD=1.38U
M$2043 VDD \$3747 \$3748 VDD pfet_03v3 L=0.28U W=0.36U AS=0.1584P AD=0.1764P
+ PS=1.6U PD=1.26U
M$2044 \$3749 \$3747 VDD VDD pfet_03v3 L=0.28U W=0.72U AS=0.1764P AD=0.36P
+ PS=1.26U PD=2.44U
M$2045 \$3750 RB4 VDD VDD pfet_03v3 L=0.28U W=0.72U AS=0.3312P AD=0.3888P
+ PS=2.36U PD=2.52U
M$2046 \$3749 \$3750 \$63 VDD pfet_03v3 L=0.28U W=0.36U AS=0.1584P AD=0.1152P
+ PS=1.6U PD=1U
M$2047 \$64 \$3751 \$3749 VDD pfet_03v3 L=0.28U W=0.36U AS=0.1152P AD=0.1584P
+ PS=1U PD=1.6U
M$2048 VDD RA4 \$3751 VDD pfet_03v3 L=0.28U W=0.72U AS=0.3708P AD=0.3168P
+ PS=2.47U PD=2.32U
M$2049 \$3753 \$3708 \$3752 VDD pfet_03v3 L=0.28U W=0.36U AS=0.2097P AD=0.1278P
+ PS=1.38U PD=1.07U
M$2050 \$3881 \$3754 \$3753 VDD pfet_03v3 L=0.28U W=0.36U AS=0.1278P AD=0.0567P
+ PS=1.07U PD=0.675U
M$2051 VDD \$3707 \$3881 VDD pfet_03v3 L=0.28U W=0.36U AS=0.0567P AD=0.1584P
+ PS=0.675U PD=1.6U
M$2052 \$3752 \$127 VDD VDD pfet_03v3 L=0.28U W=0.72U AS=0.3168P AD=0.2097P
+ PS=2.32U PD=1.38U
M$2053 VDD \$3753 \$3754 VDD pfet_03v3 L=0.28U W=0.36U AS=0.1584P AD=0.1764P
+ PS=1.6U PD=1.26U
M$2054 \$3755 \$3753 VDD VDD pfet_03v3 L=0.28U W=0.72U AS=0.1764P AD=0.36P
+ PS=1.26U PD=2.44U
M$2055 \$3756 RB4 VDD VDD pfet_03v3 L=0.28U W=0.72U AS=0.3312P AD=0.3888P
+ PS=2.36U PD=2.52U
M$2056 \$3755 \$3756 \$65 VDD pfet_03v3 L=0.28U W=0.36U AS=0.1584P AD=0.1152P
+ PS=1.6U PD=1U
M$2057 \$66 \$3757 \$3755 VDD pfet_03v3 L=0.28U W=0.36U AS=0.1152P AD=0.1584P
+ PS=1U PD=1.6U
M$2058 VDD RA4 \$3757 VDD pfet_03v3 L=0.28U W=0.72U AS=0.3708P AD=0.3168P
+ PS=2.47U PD=2.32U
M$2059 \$3759 \$3708 \$3758 VDD pfet_03v3 L=0.28U W=0.36U AS=0.2097P AD=0.1278P
+ PS=1.38U PD=1.07U
M$2060 \$3891 \$3760 \$3759 VDD pfet_03v3 L=0.28U W=0.36U AS=0.1278P AD=0.0567P
+ PS=1.07U PD=0.675U
M$2061 VDD \$3707 \$3891 VDD pfet_03v3 L=0.28U W=0.36U AS=0.0567P AD=0.1584P
+ PS=0.675U PD=1.6U
M$2062 \$3758 \$130 VDD VDD pfet_03v3 L=0.28U W=0.72U AS=0.3168P AD=0.2097P
+ PS=2.32U PD=1.38U
M$2063 VDD \$3759 \$3760 VDD pfet_03v3 L=0.28U W=0.36U AS=0.1584P AD=0.1764P
+ PS=1.6U PD=1.26U
M$2064 \$3761 \$3759 VDD VDD pfet_03v3 L=0.28U W=0.72U AS=0.1764P AD=0.36P
+ PS=1.26U PD=2.44U
M$2065 \$3762 RB4 VDD VDD pfet_03v3 L=0.28U W=0.72U AS=0.3312P AD=0.3888P
+ PS=2.36U PD=2.52U
M$2066 \$3761 \$3762 \$67 VDD pfet_03v3 L=0.28U W=0.36U AS=0.1584P AD=0.1152P
+ PS=1.6U PD=1U
M$2067 \$68 \$3763 \$3761 VDD pfet_03v3 L=0.28U W=0.36U AS=0.1152P AD=0.1584P
+ PS=1U PD=1.6U
M$2068 VDD RA4 \$3763 VDD pfet_03v3 L=0.28U W=0.72U AS=0.3708P AD=0.3168P
+ PS=2.47U PD=2.32U
M$2069 \$3765 \$3708 \$3764 VDD pfet_03v3 L=0.28U W=0.36U AS=0.2097P AD=0.1278P
+ PS=1.38U PD=1.07U
M$2070 \$3901 \$3766 \$3765 VDD pfet_03v3 L=0.28U W=0.36U AS=0.1278P AD=0.0567P
+ PS=1.07U PD=0.675U
M$2071 VDD \$3707 \$3901 VDD pfet_03v3 L=0.28U W=0.36U AS=0.0567P AD=0.1584P
+ PS=0.675U PD=1.6U
M$2072 \$3764 \$133 VDD VDD pfet_03v3 L=0.28U W=0.72U AS=0.3168P AD=0.2097P
+ PS=2.32U PD=1.38U
M$2073 VDD \$3765 \$3766 VDD pfet_03v3 L=0.28U W=0.36U AS=0.1584P AD=0.1764P
+ PS=1.6U PD=1.26U
M$2074 \$3767 \$3765 VDD VDD pfet_03v3 L=0.28U W=0.72U AS=0.1764P AD=0.36P
+ PS=1.26U PD=2.44U
M$2075 \$3768 RB4 VDD VDD pfet_03v3 L=0.28U W=0.72U AS=0.3312P AD=0.3888P
+ PS=2.36U PD=2.52U
M$2076 \$3767 \$3768 \$69 VDD pfet_03v3 L=0.28U W=0.36U AS=0.1584P AD=0.1152P
+ PS=1.6U PD=1U
M$2077 \$70 \$3769 \$3767 VDD pfet_03v3 L=0.28U W=0.36U AS=0.1152P AD=0.1584P
+ PS=1U PD=1.6U
M$2078 VDD RA4 \$3769 VDD pfet_03v3 L=0.28U W=0.72U AS=0.3708P AD=0.3168P
+ PS=2.47U PD=2.32U
M$2079 \$3771 \$3708 \$3770 VDD pfet_03v3 L=0.28U W=0.36U AS=0.2097P AD=0.1278P
+ PS=1.38U PD=1.07U
M$2080 \$3888 \$3772 \$3771 VDD pfet_03v3 L=0.28U W=0.36U AS=0.1278P AD=0.0567P
+ PS=1.07U PD=0.675U
M$2081 VDD \$3707 \$3888 VDD pfet_03v3 L=0.28U W=0.36U AS=0.0567P AD=0.1584P
+ PS=0.675U PD=1.6U
M$2082 \$3770 \$136 VDD VDD pfet_03v3 L=0.28U W=0.72U AS=0.3168P AD=0.2097P
+ PS=2.32U PD=1.38U
M$2083 VDD \$3771 \$3772 VDD pfet_03v3 L=0.28U W=0.36U AS=0.1584P AD=0.1764P
+ PS=1.6U PD=1.26U
M$2084 \$3773 \$3771 VDD VDD pfet_03v3 L=0.28U W=0.72U AS=0.1764P AD=0.36P
+ PS=1.26U PD=2.44U
M$2085 \$3774 RB4 VDD VDD pfet_03v3 L=0.28U W=0.72U AS=0.3312P AD=0.3888P
+ PS=2.36U PD=2.52U
M$2086 \$3773 \$3774 \$71 VDD pfet_03v3 L=0.28U W=0.36U AS=0.1584P AD=0.1152P
+ PS=1.6U PD=1U
M$2087 \$72 \$3775 \$3773 VDD pfet_03v3 L=0.28U W=0.36U AS=0.1152P AD=0.1584P
+ PS=1U PD=1.6U
M$2088 VDD RA4 \$3775 VDD pfet_03v3 L=0.28U W=0.72U AS=0.3708P AD=0.3168P
+ PS=2.47U PD=2.32U
M$2089 \$3777 \$3708 \$3776 VDD pfet_03v3 L=0.28U W=0.36U AS=0.2097P AD=0.1278P
+ PS=1.38U PD=1.07U
M$2090 \$3873 \$3778 \$3777 VDD pfet_03v3 L=0.28U W=0.36U AS=0.1278P AD=0.0567P
+ PS=1.07U PD=0.675U
M$2091 VDD \$3707 \$3873 VDD pfet_03v3 L=0.28U W=0.36U AS=0.0567P AD=0.1584P
+ PS=0.675U PD=1.6U
M$2092 \$3776 \$139 VDD VDD pfet_03v3 L=0.28U W=0.72U AS=0.3168P AD=0.2097P
+ PS=2.32U PD=1.38U
M$2093 VDD \$3777 \$3778 VDD pfet_03v3 L=0.28U W=0.36U AS=0.1584P AD=0.1764P
+ PS=1.6U PD=1.26U
M$2094 \$3779 \$3777 VDD VDD pfet_03v3 L=0.28U W=0.72U AS=0.1764P AD=0.36P
+ PS=1.26U PD=2.44U
M$2095 \$3780 RB4 VDD VDD pfet_03v3 L=0.28U W=0.72U AS=0.3312P AD=0.3888P
+ PS=2.36U PD=2.52U
M$2096 \$3779 \$3780 \$73 VDD pfet_03v3 L=0.28U W=0.36U AS=0.1584P AD=0.1152P
+ PS=1.6U PD=1U
M$2097 \$74 \$3781 \$3779 VDD pfet_03v3 L=0.28U W=0.36U AS=0.1152P AD=0.1584P
+ PS=1U PD=1.6U
M$2098 VDD RA4 \$3781 VDD pfet_03v3 L=0.28U W=0.72U AS=0.3708P AD=0.3168P
+ PS=2.47U PD=2.32U
M$2099 \$3783 \$3708 \$3782 VDD pfet_03v3 L=0.28U W=0.36U AS=0.2097P AD=0.1278P
+ PS=1.38U PD=1.07U
M$2100 \$3857 \$3784 \$3783 VDD pfet_03v3 L=0.28U W=0.36U AS=0.1278P AD=0.0567P
+ PS=1.07U PD=0.675U
M$2101 VDD \$3707 \$3857 VDD pfet_03v3 L=0.28U W=0.36U AS=0.0567P AD=0.1584P
+ PS=0.675U PD=1.6U
M$2102 \$3782 \$142 VDD VDD pfet_03v3 L=0.28U W=0.72U AS=0.3168P AD=0.2097P
+ PS=2.32U PD=1.38U
M$2103 VDD \$3783 \$3784 VDD pfet_03v3 L=0.28U W=0.36U AS=0.1584P AD=0.1764P
+ PS=1.6U PD=1.26U
M$2104 \$3785 \$3783 VDD VDD pfet_03v3 L=0.28U W=0.72U AS=0.1764P AD=0.36P
+ PS=1.26U PD=2.44U
M$2105 \$3786 RB4 VDD VDD pfet_03v3 L=0.28U W=0.72U AS=0.3312P AD=0.3888P
+ PS=2.36U PD=2.52U
M$2106 \$3785 \$3786 \$75 VDD pfet_03v3 L=0.28U W=0.36U AS=0.1584P AD=0.1152P
+ PS=1.6U PD=1U
M$2107 \$76 \$3787 \$3785 VDD pfet_03v3 L=0.28U W=0.36U AS=0.1152P AD=0.1584P
+ PS=1U PD=1.6U
M$2108 VDD RA4 \$3787 VDD pfet_03v3 L=0.28U W=0.72U AS=0.3708P AD=0.3168P
+ PS=2.47U PD=2.32U
M$2109 \$3789 \$3708 \$3788 VDD pfet_03v3 L=0.28U W=0.36U AS=0.2097P AD=0.1278P
+ PS=1.38U PD=1.07U
M$2110 \$3846 \$3790 \$3789 VDD pfet_03v3 L=0.28U W=0.36U AS=0.1278P AD=0.0567P
+ PS=1.07U PD=0.675U
M$2111 VDD \$3707 \$3846 VDD pfet_03v3 L=0.28U W=0.36U AS=0.0567P AD=0.1584P
+ PS=0.675U PD=1.6U
M$2112 \$3788 \$145 VDD VDD pfet_03v3 L=0.28U W=0.72U AS=0.3168P AD=0.2097P
+ PS=2.32U PD=1.38U
M$2113 VDD \$3789 \$3790 VDD pfet_03v3 L=0.28U W=0.36U AS=0.1584P AD=0.1764P
+ PS=1.6U PD=1.26U
M$2114 \$3791 \$3789 VDD VDD pfet_03v3 L=0.28U W=0.72U AS=0.1764P AD=0.36P
+ PS=1.26U PD=2.44U
M$2115 \$3792 RB4 VDD VDD pfet_03v3 L=0.28U W=0.72U AS=0.3312P AD=0.3888P
+ PS=2.36U PD=2.52U
M$2116 \$3791 \$3792 \$77 VDD pfet_03v3 L=0.28U W=0.36U AS=0.1584P AD=0.1152P
+ PS=1.6U PD=1U
M$2117 \$78 \$3793 \$3791 VDD pfet_03v3 L=0.28U W=0.36U AS=0.1152P AD=0.1584P
+ PS=1U PD=1.6U
M$2118 VDD RA4 \$3793 VDD pfet_03v3 L=0.28U W=0.72U AS=0.3708P AD=0.3168P
+ PS=2.47U PD=2.32U
M$2119 \$3795 \$3708 \$3794 VDD pfet_03v3 L=0.28U W=0.36U AS=0.2097P AD=0.1278P
+ PS=1.38U PD=1.07U
M$2120 \$3830 \$3796 \$3795 VDD pfet_03v3 L=0.28U W=0.36U AS=0.1278P AD=0.0567P
+ PS=1.07U PD=0.675U
M$2121 VDD \$3707 \$3830 VDD pfet_03v3 L=0.28U W=0.36U AS=0.0567P AD=0.1584P
+ PS=0.675U PD=1.6U
M$2122 \$3794 \$148 VDD VDD pfet_03v3 L=0.28U W=0.72U AS=0.3168P AD=0.2097P
+ PS=2.32U PD=1.38U
M$2123 VDD \$3795 \$3796 VDD pfet_03v3 L=0.28U W=0.36U AS=0.1584P AD=0.1764P
+ PS=1.6U PD=1.26U
M$2124 \$3797 \$3795 VDD VDD pfet_03v3 L=0.28U W=0.72U AS=0.1764P AD=0.36P
+ PS=1.26U PD=2.44U
M$2125 \$3798 RB4 VDD VDD pfet_03v3 L=0.28U W=0.72U AS=0.3312P AD=0.3888P
+ PS=2.36U PD=2.52U
M$2126 \$3797 \$3798 \$79 VDD pfet_03v3 L=0.28U W=0.36U AS=0.1584P AD=0.1152P
+ PS=1.6U PD=1U
M$2127 \$80 \$3799 \$3797 VDD pfet_03v3 L=0.28U W=0.36U AS=0.1152P AD=0.1584P
+ PS=1U PD=1.6U
M$2128 VDD RA4 \$3799 VDD pfet_03v3 L=0.28U W=0.72U AS=0.3708P AD=0.3168P
+ PS=2.47U PD=2.32U
M$2129 \$3801 \$3708 \$3800 VDD pfet_03v3 L=0.28U W=0.36U AS=0.2097P AD=0.1278P
+ PS=1.38U PD=1.07U
M$2130 \$3816 \$3802 \$3801 VDD pfet_03v3 L=0.28U W=0.36U AS=0.1278P AD=0.0567P
+ PS=1.07U PD=0.675U
M$2131 VDD \$3707 \$3816 VDD pfet_03v3 L=0.28U W=0.36U AS=0.0567P AD=0.1584P
+ PS=0.675U PD=1.6U
M$2132 \$3800 \$151 VDD VDD pfet_03v3 L=0.28U W=0.72U AS=0.3168P AD=0.2097P
+ PS=2.32U PD=1.38U
M$2133 VDD \$3801 \$3802 VDD pfet_03v3 L=0.28U W=0.36U AS=0.1584P AD=0.1764P
+ PS=1.6U PD=1.26U
M$2134 \$3803 \$3801 VDD VDD pfet_03v3 L=0.28U W=0.72U AS=0.1764P AD=0.36P
+ PS=1.26U PD=2.44U
M$2135 \$3804 RB4 VDD VDD pfet_03v3 L=0.28U W=0.72U AS=0.3312P AD=0.3888P
+ PS=2.36U PD=2.52U
M$2136 \$3803 \$3804 \$81 VDD pfet_03v3 L=0.28U W=0.36U AS=0.1584P AD=0.1152P
+ PS=1.6U PD=1U
M$2137 \$82 \$3805 \$3803 VDD pfet_03v3 L=0.28U W=0.36U AS=0.1152P AD=0.1584P
+ PS=1U PD=1.6U
M$2138 VDD RA4 \$3805 VDD pfet_03v3 L=0.28U W=0.72U AS=0.3708P AD=0.3168P
+ PS=2.47U PD=2.32U
M$2139 \$4025 WE3 VDD VDD pfet_03v3 L=0.28U W=0.72U AS=0.3168P AD=0.1872P
+ PS=2.32U PD=1.24U
M$2140 VDD CLK \$4025 VDD pfet_03v3 L=0.28U W=0.72U AS=0.1872P AD=0.3168P
+ PS=1.24U PD=2.32U
M$2141 \$4026 \$4025 VDD VDD pfet_03v3 L=0.28U W=2.54U AS=0.8974P AD=0.6604P
+ PS=5.28U PD=3.58U
M$2143 \$4213 \$4026 VDD VDD pfet_03v3 L=0.28U W=2.68U AS=0.7272P AD=0.9782P
+ PS=3.78U PD=5.48U
M$2145 \$4027 \$106 VDD VDD pfet_03v3 L=0.28U W=0.72U AS=0.3168P AD=0.2097P
+ PS=2.32U PD=1.38U
M$2146 \$4028 \$4213 \$4027 VDD pfet_03v3 L=0.28U W=0.36U AS=0.2097P AD=0.1278P
+ PS=1.38U PD=1.07U
M$2147 \$4219 \$4111 \$4028 VDD pfet_03v3 L=0.28U W=0.36U AS=0.1278P AD=0.0567P
+ PS=1.07U PD=0.675U
M$2148 VDD \$4026 \$4219 VDD pfet_03v3 L=0.28U W=0.36U AS=0.0567P AD=0.1584P
+ PS=0.675U PD=1.6U
M$2149 \$4111 \$4028 VDD VDD pfet_03v3 L=0.28U W=0.36U AS=0.1764P AD=0.1584P
+ PS=1.26U PD=1.6U
M$2150 \$4009 \$4028 VDD VDD pfet_03v3 L=0.28U W=0.72U AS=0.1764P AD=0.36P
+ PS=1.26U PD=2.44U
M$2151 \$4113 RA3 VDD VDD pfet_03v3 L=0.28U W=0.72U AS=0.3312P AD=0.3888P
+ PS=2.36U PD=2.52U
M$2152 \$4009 \$4113 \$51 VDD pfet_03v3 L=0.28U W=0.36U AS=0.1584P AD=0.1152P
+ PS=1.6U PD=1U
M$2153 \$52 \$4114 \$4009 VDD pfet_03v3 L=0.28U W=0.36U AS=0.1152P AD=0.1584P
+ PS=1U PD=1.6U
M$2154 VDD RB3 \$4114 VDD pfet_03v3 L=0.28U W=0.72U AS=0.3708P AD=0.3168P
+ PS=2.47U PD=2.32U
M$2155 \$4029 \$109 VDD VDD pfet_03v3 L=0.28U W=0.72U AS=0.3168P AD=0.2097P
+ PS=2.32U PD=1.38U
M$2156 \$4030 \$4213 \$4029 VDD pfet_03v3 L=0.28U W=0.36U AS=0.2097P AD=0.1278P
+ PS=1.38U PD=1.07U
M$2157 \$4231 \$4115 \$4030 VDD pfet_03v3 L=0.28U W=0.36U AS=0.1278P AD=0.0567P
+ PS=1.07U PD=0.675U
M$2158 VDD \$4026 \$4231 VDD pfet_03v3 L=0.28U W=0.36U AS=0.0567P AD=0.1584P
+ PS=0.675U PD=1.6U
M$2159 \$4115 \$4030 VDD VDD pfet_03v3 L=0.28U W=0.36U AS=0.1764P AD=0.1584P
+ PS=1.26U PD=1.6U
M$2160 \$4010 \$4030 VDD VDD pfet_03v3 L=0.28U W=0.72U AS=0.1764P AD=0.36P
+ PS=1.26U PD=2.44U
M$2161 \$4116 RA3 VDD VDD pfet_03v3 L=0.28U W=0.72U AS=0.3312P AD=0.3888P
+ PS=2.36U PD=2.52U
M$2162 \$4010 \$4116 \$53 VDD pfet_03v3 L=0.28U W=0.36U AS=0.1584P AD=0.1152P
+ PS=1.6U PD=1U
M$2163 \$54 \$4117 \$4010 VDD pfet_03v3 L=0.28U W=0.36U AS=0.1152P AD=0.1584P
+ PS=1U PD=1.6U
M$2164 VDD RB3 \$4117 VDD pfet_03v3 L=0.28U W=0.72U AS=0.3708P AD=0.3168P
+ PS=2.47U PD=2.32U
M$2165 \$4031 \$112 VDD VDD pfet_03v3 L=0.28U W=0.72U AS=0.3168P AD=0.2097P
+ PS=2.32U PD=1.38U
M$2166 \$4032 \$4213 \$4031 VDD pfet_03v3 L=0.28U W=0.36U AS=0.2097P AD=0.1278P
+ PS=1.38U PD=1.07U
M$2167 \$4240 \$4118 \$4032 VDD pfet_03v3 L=0.28U W=0.36U AS=0.1278P AD=0.0567P
+ PS=1.07U PD=0.675U
M$2168 VDD \$4026 \$4240 VDD pfet_03v3 L=0.28U W=0.36U AS=0.0567P AD=0.1584P
+ PS=0.675U PD=1.6U
M$2169 \$4118 \$4032 VDD VDD pfet_03v3 L=0.28U W=0.36U AS=0.1764P AD=0.1584P
+ PS=1.26U PD=1.6U
M$2170 \$4011 \$4032 VDD VDD pfet_03v3 L=0.28U W=0.72U AS=0.1764P AD=0.36P
+ PS=1.26U PD=2.44U
M$2171 \$4119 RA3 VDD VDD pfet_03v3 L=0.28U W=0.72U AS=0.3312P AD=0.3888P
+ PS=2.36U PD=2.52U
M$2172 \$4011 \$4119 \$55 VDD pfet_03v3 L=0.28U W=0.36U AS=0.1584P AD=0.1152P
+ PS=1.6U PD=1U
M$2173 \$56 \$4120 \$4011 VDD pfet_03v3 L=0.28U W=0.36U AS=0.1152P AD=0.1584P
+ PS=1U PD=1.6U
M$2174 VDD RB3 \$4120 VDD pfet_03v3 L=0.28U W=0.72U AS=0.3708P AD=0.3168P
+ PS=2.47U PD=2.32U
M$2175 \$4033 \$115 VDD VDD pfet_03v3 L=0.28U W=0.72U AS=0.3168P AD=0.2097P
+ PS=2.32U PD=1.38U
M$2176 \$4034 \$4213 \$4033 VDD pfet_03v3 L=0.28U W=0.36U AS=0.2097P AD=0.1278P
+ PS=1.38U PD=1.07U
M$2177 \$4251 \$4121 \$4034 VDD pfet_03v3 L=0.28U W=0.36U AS=0.1278P AD=0.0567P
+ PS=1.07U PD=0.675U
M$2178 VDD \$4026 \$4251 VDD pfet_03v3 L=0.28U W=0.36U AS=0.0567P AD=0.1584P
+ PS=0.675U PD=1.6U
M$2179 \$4121 \$4034 VDD VDD pfet_03v3 L=0.28U W=0.36U AS=0.1764P AD=0.1584P
+ PS=1.26U PD=1.6U
M$2180 \$4012 \$4034 VDD VDD pfet_03v3 L=0.28U W=0.72U AS=0.1764P AD=0.36P
+ PS=1.26U PD=2.44U
M$2181 \$4122 RA3 VDD VDD pfet_03v3 L=0.28U W=0.72U AS=0.3312P AD=0.3888P
+ PS=2.36U PD=2.52U
M$2182 \$4012 \$4122 \$57 VDD pfet_03v3 L=0.28U W=0.36U AS=0.1584P AD=0.1152P
+ PS=1.6U PD=1U
M$2183 \$58 \$4123 \$4012 VDD pfet_03v3 L=0.28U W=0.36U AS=0.1152P AD=0.1584P
+ PS=1U PD=1.6U
M$2184 VDD RB3 \$4123 VDD pfet_03v3 L=0.28U W=0.72U AS=0.3708P AD=0.3168P
+ PS=2.47U PD=2.32U
M$2185 \$4035 \$118 VDD VDD pfet_03v3 L=0.28U W=0.72U AS=0.3168P AD=0.2097P
+ PS=2.32U PD=1.38U
M$2186 \$4036 \$4213 \$4035 VDD pfet_03v3 L=0.28U W=0.36U AS=0.2097P AD=0.1278P
+ PS=1.38U PD=1.07U
M$2187 \$4260 \$4124 \$4036 VDD pfet_03v3 L=0.28U W=0.36U AS=0.1278P AD=0.0567P
+ PS=1.07U PD=0.675U
M$2188 VDD \$4026 \$4260 VDD pfet_03v3 L=0.28U W=0.36U AS=0.0567P AD=0.1584P
+ PS=0.675U PD=1.6U
M$2189 \$4124 \$4036 VDD VDD pfet_03v3 L=0.28U W=0.36U AS=0.1764P AD=0.1584P
+ PS=1.26U PD=1.6U
M$2190 \$4013 \$4036 VDD VDD pfet_03v3 L=0.28U W=0.72U AS=0.1764P AD=0.36P
+ PS=1.26U PD=2.44U
M$2191 \$4125 RA3 VDD VDD pfet_03v3 L=0.28U W=0.72U AS=0.3312P AD=0.3888P
+ PS=2.36U PD=2.52U
M$2192 \$4013 \$4125 \$59 VDD pfet_03v3 L=0.28U W=0.36U AS=0.1584P AD=0.1152P
+ PS=1.6U PD=1U
M$2193 \$60 \$4126 \$4013 VDD pfet_03v3 L=0.28U W=0.36U AS=0.1152P AD=0.1584P
+ PS=1U PD=1.6U
M$2194 VDD RB3 \$4126 VDD pfet_03v3 L=0.28U W=0.72U AS=0.3708P AD=0.3168P
+ PS=2.47U PD=2.32U
M$2195 \$4037 \$121 VDD VDD pfet_03v3 L=0.28U W=0.72U AS=0.3168P AD=0.2097P
+ PS=2.32U PD=1.38U
M$2196 \$4038 \$4213 \$4037 VDD pfet_03v3 L=0.28U W=0.36U AS=0.2097P AD=0.1278P
+ PS=1.38U PD=1.07U
M$2197 \$4270 \$4127 \$4038 VDD pfet_03v3 L=0.28U W=0.36U AS=0.1278P AD=0.0567P
+ PS=1.07U PD=0.675U
M$2198 VDD \$4026 \$4270 VDD pfet_03v3 L=0.28U W=0.36U AS=0.0567P AD=0.1584P
+ PS=0.675U PD=1.6U
M$2199 \$4127 \$4038 VDD VDD pfet_03v3 L=0.28U W=0.36U AS=0.1764P AD=0.1584P
+ PS=1.26U PD=1.6U
M$2200 \$4014 \$4038 VDD VDD pfet_03v3 L=0.28U W=0.72U AS=0.1764P AD=0.36P
+ PS=1.26U PD=2.44U
M$2201 \$4128 RA3 VDD VDD pfet_03v3 L=0.28U W=0.72U AS=0.3312P AD=0.3888P
+ PS=2.36U PD=2.52U
M$2202 \$4014 \$4128 \$61 VDD pfet_03v3 L=0.28U W=0.36U AS=0.1584P AD=0.1152P
+ PS=1.6U PD=1U
M$2203 \$62 \$4129 \$4014 VDD pfet_03v3 L=0.28U W=0.36U AS=0.1152P AD=0.1584P
+ PS=1U PD=1.6U
M$2204 VDD RB3 \$4129 VDD pfet_03v3 L=0.28U W=0.72U AS=0.3708P AD=0.3168P
+ PS=2.47U PD=2.32U
M$2205 \$4039 \$124 VDD VDD pfet_03v3 L=0.28U W=0.72U AS=0.3168P AD=0.2097P
+ PS=2.32U PD=1.38U
M$2206 \$4040 \$4213 \$4039 VDD pfet_03v3 L=0.28U W=0.36U AS=0.2097P AD=0.1278P
+ PS=1.38U PD=1.07U
M$2207 \$4281 \$4130 \$4040 VDD pfet_03v3 L=0.28U W=0.36U AS=0.1278P AD=0.0567P
+ PS=1.07U PD=0.675U
M$2208 VDD \$4026 \$4281 VDD pfet_03v3 L=0.28U W=0.36U AS=0.0567P AD=0.1584P
+ PS=0.675U PD=1.6U
M$2209 \$4130 \$4040 VDD VDD pfet_03v3 L=0.28U W=0.36U AS=0.1764P AD=0.1584P
+ PS=1.26U PD=1.6U
M$2210 \$4015 \$4040 VDD VDD pfet_03v3 L=0.28U W=0.72U AS=0.1764P AD=0.36P
+ PS=1.26U PD=2.44U
M$2211 \$4131 RA3 VDD VDD pfet_03v3 L=0.28U W=0.72U AS=0.3312P AD=0.3888P
+ PS=2.36U PD=2.52U
M$2212 \$4015 \$4131 \$63 VDD pfet_03v3 L=0.28U W=0.36U AS=0.1584P AD=0.1152P
+ PS=1.6U PD=1U
M$2213 \$64 \$4132 \$4015 VDD pfet_03v3 L=0.28U W=0.36U AS=0.1152P AD=0.1584P
+ PS=1U PD=1.6U
M$2214 VDD RB3 \$4132 VDD pfet_03v3 L=0.28U W=0.72U AS=0.3708P AD=0.3168P
+ PS=2.47U PD=2.32U
M$2215 \$4041 \$127 VDD VDD pfet_03v3 L=0.28U W=0.72U AS=0.3168P AD=0.2097P
+ PS=2.32U PD=1.38U
M$2216 \$4042 \$4213 \$4041 VDD pfet_03v3 L=0.28U W=0.36U AS=0.2097P AD=0.1278P
+ PS=1.38U PD=1.07U
M$2217 \$4292 \$4133 \$4042 VDD pfet_03v3 L=0.28U W=0.36U AS=0.1278P AD=0.0567P
+ PS=1.07U PD=0.675U
M$2218 VDD \$4026 \$4292 VDD pfet_03v3 L=0.28U W=0.36U AS=0.0567P AD=0.1584P
+ PS=0.675U PD=1.6U
M$2219 \$4133 \$4042 VDD VDD pfet_03v3 L=0.28U W=0.36U AS=0.1764P AD=0.1584P
+ PS=1.26U PD=1.6U
M$2220 \$4016 \$4042 VDD VDD pfet_03v3 L=0.28U W=0.72U AS=0.1764P AD=0.36P
+ PS=1.26U PD=2.44U
M$2221 \$4134 RA3 VDD VDD pfet_03v3 L=0.28U W=0.72U AS=0.3312P AD=0.3888P
+ PS=2.36U PD=2.52U
M$2222 \$4016 \$4134 \$65 VDD pfet_03v3 L=0.28U W=0.36U AS=0.1584P AD=0.1152P
+ PS=1.6U PD=1U
M$2223 \$66 \$4135 \$4016 VDD pfet_03v3 L=0.28U W=0.36U AS=0.1152P AD=0.1584P
+ PS=1U PD=1.6U
M$2224 VDD RB3 \$4135 VDD pfet_03v3 L=0.28U W=0.72U AS=0.3708P AD=0.3168P
+ PS=2.47U PD=2.32U
M$2225 \$4043 \$130 VDD VDD pfet_03v3 L=0.28U W=0.72U AS=0.3168P AD=0.2097P
+ PS=2.32U PD=1.38U
M$2226 \$4044 \$4213 \$4043 VDD pfet_03v3 L=0.28U W=0.36U AS=0.2097P AD=0.1278P
+ PS=1.38U PD=1.07U
M$2227 \$4301 \$4136 \$4044 VDD pfet_03v3 L=0.28U W=0.36U AS=0.1278P AD=0.0567P
+ PS=1.07U PD=0.675U
M$2228 VDD \$4026 \$4301 VDD pfet_03v3 L=0.28U W=0.36U AS=0.0567P AD=0.1584P
+ PS=0.675U PD=1.6U
M$2229 \$4136 \$4044 VDD VDD pfet_03v3 L=0.28U W=0.36U AS=0.1764P AD=0.1584P
+ PS=1.26U PD=1.6U
M$2230 \$4017 \$4044 VDD VDD pfet_03v3 L=0.28U W=0.72U AS=0.1764P AD=0.36P
+ PS=1.26U PD=2.44U
M$2231 \$4137 RA3 VDD VDD pfet_03v3 L=0.28U W=0.72U AS=0.3312P AD=0.3888P
+ PS=2.36U PD=2.52U
M$2232 \$4017 \$4137 \$67 VDD pfet_03v3 L=0.28U W=0.36U AS=0.1584P AD=0.1152P
+ PS=1.6U PD=1U
M$2233 \$68 \$4138 \$4017 VDD pfet_03v3 L=0.28U W=0.36U AS=0.1152P AD=0.1584P
+ PS=1U PD=1.6U
M$2234 VDD RB3 \$4138 VDD pfet_03v3 L=0.28U W=0.72U AS=0.3708P AD=0.3168P
+ PS=2.47U PD=2.32U
M$2235 \$4045 \$133 VDD VDD pfet_03v3 L=0.28U W=0.72U AS=0.3168P AD=0.2097P
+ PS=2.32U PD=1.38U
M$2236 \$4046 \$4213 \$4045 VDD pfet_03v3 L=0.28U W=0.36U AS=0.2097P AD=0.1278P
+ PS=1.38U PD=1.07U
M$2237 \$4311 \$4139 \$4046 VDD pfet_03v3 L=0.28U W=0.36U AS=0.1278P AD=0.0567P
+ PS=1.07U PD=0.675U
M$2238 VDD \$4026 \$4311 VDD pfet_03v3 L=0.28U W=0.36U AS=0.0567P AD=0.1584P
+ PS=0.675U PD=1.6U
M$2239 \$4139 \$4046 VDD VDD pfet_03v3 L=0.28U W=0.36U AS=0.1764P AD=0.1584P
+ PS=1.26U PD=1.6U
M$2240 \$4018 \$4046 VDD VDD pfet_03v3 L=0.28U W=0.72U AS=0.1764P AD=0.36P
+ PS=1.26U PD=2.44U
M$2241 \$4140 RA3 VDD VDD pfet_03v3 L=0.28U W=0.72U AS=0.3312P AD=0.3888P
+ PS=2.36U PD=2.52U
M$2242 \$4018 \$4140 \$69 VDD pfet_03v3 L=0.28U W=0.36U AS=0.1584P AD=0.1152P
+ PS=1.6U PD=1U
M$2243 \$70 \$4141 \$4018 VDD pfet_03v3 L=0.28U W=0.36U AS=0.1152P AD=0.1584P
+ PS=1U PD=1.6U
M$2244 VDD RB3 \$4141 VDD pfet_03v3 L=0.28U W=0.72U AS=0.3708P AD=0.3168P
+ PS=2.47U PD=2.32U
M$2245 \$4047 \$136 VDD VDD pfet_03v3 L=0.28U W=0.72U AS=0.3168P AD=0.2097P
+ PS=2.32U PD=1.38U
M$2246 \$4048 \$4213 \$4047 VDD pfet_03v3 L=0.28U W=0.36U AS=0.2097P AD=0.1278P
+ PS=1.38U PD=1.07U
M$2247 \$4312 \$4142 \$4048 VDD pfet_03v3 L=0.28U W=0.36U AS=0.1278P AD=0.0567P
+ PS=1.07U PD=0.675U
M$2248 VDD \$4026 \$4312 VDD pfet_03v3 L=0.28U W=0.36U AS=0.0567P AD=0.1584P
+ PS=0.675U PD=1.6U
M$2249 \$4142 \$4048 VDD VDD pfet_03v3 L=0.28U W=0.36U AS=0.1764P AD=0.1584P
+ PS=1.26U PD=1.6U
M$2250 \$4019 \$4048 VDD VDD pfet_03v3 L=0.28U W=0.72U AS=0.1764P AD=0.36P
+ PS=1.26U PD=2.44U
M$2251 \$4143 RA3 VDD VDD pfet_03v3 L=0.28U W=0.72U AS=0.3312P AD=0.3888P
+ PS=2.36U PD=2.52U
M$2252 \$4019 \$4143 \$71 VDD pfet_03v3 L=0.28U W=0.36U AS=0.1584P AD=0.1152P
+ PS=1.6U PD=1U
M$2253 \$72 \$4144 \$4019 VDD pfet_03v3 L=0.28U W=0.36U AS=0.1152P AD=0.1584P
+ PS=1U PD=1.6U
M$2254 VDD RB3 \$4144 VDD pfet_03v3 L=0.28U W=0.72U AS=0.3708P AD=0.3168P
+ PS=2.47U PD=2.32U
M$2255 \$4049 \$139 VDD VDD pfet_03v3 L=0.28U W=0.72U AS=0.3168P AD=0.2097P
+ PS=2.32U PD=1.38U
M$2256 \$4050 \$4213 \$4049 VDD pfet_03v3 L=0.28U W=0.36U AS=0.2097P AD=0.1278P
+ PS=1.38U PD=1.07U
M$2257 \$4293 \$4145 \$4050 VDD pfet_03v3 L=0.28U W=0.36U AS=0.1278P AD=0.0567P
+ PS=1.07U PD=0.675U
M$2258 VDD \$4026 \$4293 VDD pfet_03v3 L=0.28U W=0.36U AS=0.0567P AD=0.1584P
+ PS=0.675U PD=1.6U
M$2259 \$4145 \$4050 VDD VDD pfet_03v3 L=0.28U W=0.36U AS=0.1764P AD=0.1584P
+ PS=1.26U PD=1.6U
M$2260 \$4020 \$4050 VDD VDD pfet_03v3 L=0.28U W=0.72U AS=0.1764P AD=0.36P
+ PS=1.26U PD=2.44U
M$2261 \$4146 RA3 VDD VDD pfet_03v3 L=0.28U W=0.72U AS=0.3312P AD=0.3888P
+ PS=2.36U PD=2.52U
M$2262 \$4020 \$4146 \$73 VDD pfet_03v3 L=0.28U W=0.36U AS=0.1584P AD=0.1152P
+ PS=1.6U PD=1U
M$2263 \$74 \$4147 \$4020 VDD pfet_03v3 L=0.28U W=0.36U AS=0.1152P AD=0.1584P
+ PS=1U PD=1.6U
M$2264 VDD RB3 \$4147 VDD pfet_03v3 L=0.28U W=0.72U AS=0.3708P AD=0.3168P
+ PS=2.47U PD=2.32U
M$2265 \$4051 \$142 VDD VDD pfet_03v3 L=0.28U W=0.72U AS=0.3168P AD=0.2097P
+ PS=2.32U PD=1.38U
M$2266 \$4052 \$4213 \$4051 VDD pfet_03v3 L=0.28U W=0.36U AS=0.2097P AD=0.1278P
+ PS=1.38U PD=1.07U
M$2267 \$4279 \$4148 \$4052 VDD pfet_03v3 L=0.28U W=0.36U AS=0.1278P AD=0.0567P
+ PS=1.07U PD=0.675U
M$2268 VDD \$4026 \$4279 VDD pfet_03v3 L=0.28U W=0.36U AS=0.0567P AD=0.1584P
+ PS=0.675U PD=1.6U
M$2269 \$4148 \$4052 VDD VDD pfet_03v3 L=0.28U W=0.36U AS=0.1764P AD=0.1584P
+ PS=1.26U PD=1.6U
M$2270 \$4021 \$4052 VDD VDD pfet_03v3 L=0.28U W=0.72U AS=0.1764P AD=0.36P
+ PS=1.26U PD=2.44U
M$2271 \$4149 RA3 VDD VDD pfet_03v3 L=0.28U W=0.72U AS=0.3312P AD=0.3888P
+ PS=2.36U PD=2.52U
M$2272 \$4021 \$4149 \$75 VDD pfet_03v3 L=0.28U W=0.36U AS=0.1584P AD=0.1152P
+ PS=1.6U PD=1U
M$2273 \$76 \$4150 \$4021 VDD pfet_03v3 L=0.28U W=0.36U AS=0.1152P AD=0.1584P
+ PS=1U PD=1.6U
M$2274 VDD RB3 \$4150 VDD pfet_03v3 L=0.28U W=0.72U AS=0.3708P AD=0.3168P
+ PS=2.47U PD=2.32U
M$2275 \$4053 \$145 VDD VDD pfet_03v3 L=0.28U W=0.72U AS=0.3168P AD=0.2097P
+ PS=2.32U PD=1.38U
M$2276 \$4054 \$4213 \$4053 VDD pfet_03v3 L=0.28U W=0.36U AS=0.2097P AD=0.1278P
+ PS=1.38U PD=1.07U
M$2277 \$4261 \$4151 \$4054 VDD pfet_03v3 L=0.28U W=0.36U AS=0.1278P AD=0.0567P
+ PS=1.07U PD=0.675U
M$2278 VDD \$4026 \$4261 VDD pfet_03v3 L=0.28U W=0.36U AS=0.0567P AD=0.1584P
+ PS=0.675U PD=1.6U
M$2279 \$4151 \$4054 VDD VDD pfet_03v3 L=0.28U W=0.36U AS=0.1764P AD=0.1584P
+ PS=1.26U PD=1.6U
M$2280 \$4022 \$4054 VDD VDD pfet_03v3 L=0.28U W=0.72U AS=0.1764P AD=0.36P
+ PS=1.26U PD=2.44U
M$2281 \$4152 RA3 VDD VDD pfet_03v3 L=0.28U W=0.72U AS=0.3312P AD=0.3888P
+ PS=2.36U PD=2.52U
M$2282 \$4022 \$4152 \$77 VDD pfet_03v3 L=0.28U W=0.36U AS=0.1584P AD=0.1152P
+ PS=1.6U PD=1U
M$2283 \$78 \$4153 \$4022 VDD pfet_03v3 L=0.28U W=0.36U AS=0.1152P AD=0.1584P
+ PS=1U PD=1.6U
M$2284 VDD RB3 \$4153 VDD pfet_03v3 L=0.28U W=0.72U AS=0.3708P AD=0.3168P
+ PS=2.47U PD=2.32U
M$2285 \$4055 \$148 VDD VDD pfet_03v3 L=0.28U W=0.72U AS=0.3168P AD=0.2097P
+ PS=2.32U PD=1.38U
M$2286 \$4056 \$4213 \$4055 VDD pfet_03v3 L=0.28U W=0.36U AS=0.2097P AD=0.1278P
+ PS=1.38U PD=1.07U
M$2287 \$4242 \$4154 \$4056 VDD pfet_03v3 L=0.28U W=0.36U AS=0.1278P AD=0.0567P
+ PS=1.07U PD=0.675U
M$2288 VDD \$4026 \$4242 VDD pfet_03v3 L=0.28U W=0.36U AS=0.0567P AD=0.1584P
+ PS=0.675U PD=1.6U
M$2289 \$4154 \$4056 VDD VDD pfet_03v3 L=0.28U W=0.36U AS=0.1764P AD=0.1584P
+ PS=1.26U PD=1.6U
M$2290 \$4023 \$4056 VDD VDD pfet_03v3 L=0.28U W=0.72U AS=0.1764P AD=0.36P
+ PS=1.26U PD=2.44U
M$2291 \$4155 RA3 VDD VDD pfet_03v3 L=0.28U W=0.72U AS=0.3312P AD=0.3888P
+ PS=2.36U PD=2.52U
M$2292 \$4023 \$4155 \$79 VDD pfet_03v3 L=0.28U W=0.36U AS=0.1584P AD=0.1152P
+ PS=1.6U PD=1U
M$2293 \$80 \$4156 \$4023 VDD pfet_03v3 L=0.28U W=0.36U AS=0.1152P AD=0.1584P
+ PS=1U PD=1.6U
M$2294 VDD RB3 \$4156 VDD pfet_03v3 L=0.28U W=0.72U AS=0.3708P AD=0.3168P
+ PS=2.47U PD=2.32U
M$2295 \$4057 \$151 VDD VDD pfet_03v3 L=0.28U W=0.72U AS=0.3168P AD=0.2097P
+ PS=2.32U PD=1.38U
M$2296 \$4058 \$4213 \$4057 VDD pfet_03v3 L=0.28U W=0.36U AS=0.2097P AD=0.1278P
+ PS=1.38U PD=1.07U
M$2297 \$4223 \$4157 \$4058 VDD pfet_03v3 L=0.28U W=0.36U AS=0.1278P AD=0.0567P
+ PS=1.07U PD=0.675U
M$2298 VDD \$4026 \$4223 VDD pfet_03v3 L=0.28U W=0.36U AS=0.0567P AD=0.1584P
+ PS=0.675U PD=1.6U
M$2299 \$4157 \$4058 VDD VDD pfet_03v3 L=0.28U W=0.36U AS=0.1764P AD=0.1584P
+ PS=1.26U PD=1.6U
M$2300 \$4024 \$4058 VDD VDD pfet_03v3 L=0.28U W=0.72U AS=0.1764P AD=0.36P
+ PS=1.26U PD=2.44U
M$2301 \$4158 RA3 VDD VDD pfet_03v3 L=0.28U W=0.72U AS=0.3312P AD=0.3888P
+ PS=2.36U PD=2.52U
M$2302 \$4024 \$4158 \$81 VDD pfet_03v3 L=0.28U W=0.36U AS=0.1584P AD=0.1152P
+ PS=1.6U PD=1U
M$2303 \$82 \$4159 \$4024 VDD pfet_03v3 L=0.28U W=0.36U AS=0.1152P AD=0.1584P
+ PS=1U PD=1.6U
M$2304 VDD RB3 \$4159 VDD pfet_03v3 L=0.28U W=0.72U AS=0.3708P AD=0.3168P
+ PS=2.47U PD=2.32U
M$2305 \$4319 WE2 VDD VDD pfet_03v3 L=0.28U W=0.72U AS=0.3168P AD=0.1872P
+ PS=2.32U PD=1.24U
M$2306 VDD CLK \$4319 VDD pfet_03v3 L=0.28U W=0.72U AS=0.1872P AD=0.3168P
+ PS=1.24U PD=2.32U
M$2307 \$4320 \$4319 VDD VDD pfet_03v3 L=0.28U W=2.54U AS=0.889P AD=0.6688P
+ PS=5.21U PD=3.65U
M$2309 \$4321 \$4320 VDD VDD pfet_03v3 L=0.28U W=2.68U AS=0.7272P AD=0.9782P
+ PS=3.78U PD=5.48U
M$2311 \$4323 \$4321 \$4322 VDD pfet_03v3 L=0.28U W=0.36U AS=0.2097P AD=0.1278P
+ PS=1.38U PD=1.07U
M$2312 \$4424 \$4324 \$4323 VDD pfet_03v3 L=0.28U W=0.36U AS=0.1278P AD=0.0567P
+ PS=1.07U PD=0.675U
M$2313 VDD \$4320 \$4424 VDD pfet_03v3 L=0.28U W=0.36U AS=0.0567P AD=0.1584P
+ PS=0.675U PD=1.6U
M$2314 \$4322 \$106 VDD VDD pfet_03v3 L=0.28U W=0.72U AS=0.3168P AD=0.2097P
+ PS=2.32U PD=1.38U
M$2315 VDD \$4323 \$4324 VDD pfet_03v3 L=0.28U W=0.36U AS=0.1584P AD=0.1764P
+ PS=1.6U PD=1.26U
M$2316 \$4325 \$4323 VDD VDD pfet_03v3 L=0.28U W=0.72U AS=0.1764P AD=0.36P
+ PS=1.26U PD=2.44U
M$2317 \$4327 RB2 VDD VDD pfet_03v3 L=0.28U W=0.72U AS=0.3312P AD=0.3888P
+ PS=2.36U PD=2.52U
M$2318 \$4325 \$4327 \$51 VDD pfet_03v3 L=0.28U W=0.36U AS=0.1584P AD=0.1152P
+ PS=1.6U PD=1U
M$2319 \$52 \$4328 \$4325 VDD pfet_03v3 L=0.28U W=0.36U AS=0.1152P AD=0.1584P
+ PS=1U PD=1.6U
M$2320 VDD RA2 \$4328 VDD pfet_03v3 L=0.28U W=0.72U AS=0.3708P AD=0.3168P
+ PS=2.47U PD=2.32U
M$2321 \$4330 \$4321 \$4329 VDD pfet_03v3 L=0.28U W=0.36U AS=0.2097P AD=0.1278P
+ PS=1.38U PD=1.07U
M$2322 \$4433 \$4331 \$4330 VDD pfet_03v3 L=0.28U W=0.36U AS=0.1278P AD=0.0567P
+ PS=1.07U PD=0.675U
M$2323 VDD \$4320 \$4433 VDD pfet_03v3 L=0.28U W=0.36U AS=0.0567P AD=0.1584P
+ PS=0.675U PD=1.6U
M$2324 \$4329 \$109 VDD VDD pfet_03v3 L=0.28U W=0.72U AS=0.3168P AD=0.2097P
+ PS=2.32U PD=1.38U
M$2325 VDD \$4330 \$4331 VDD pfet_03v3 L=0.28U W=0.36U AS=0.1584P AD=0.1764P
+ PS=1.6U PD=1.26U
M$2326 \$4332 \$4330 VDD VDD pfet_03v3 L=0.28U W=0.72U AS=0.1764P AD=0.36P
+ PS=1.26U PD=2.44U
M$2327 \$4333 RB2 VDD VDD pfet_03v3 L=0.28U W=0.72U AS=0.3312P AD=0.3888P
+ PS=2.36U PD=2.52U
M$2328 \$4332 \$4333 \$53 VDD pfet_03v3 L=0.28U W=0.36U AS=0.1584P AD=0.1152P
+ PS=1.6U PD=1U
M$2329 \$54 \$4334 \$4332 VDD pfet_03v3 L=0.28U W=0.36U AS=0.1152P AD=0.1584P
+ PS=1U PD=1.6U
M$2330 VDD RA2 \$4334 VDD pfet_03v3 L=0.28U W=0.72U AS=0.3708P AD=0.3168P
+ PS=2.47U PD=2.32U
M$2331 \$4336 \$4321 \$4335 VDD pfet_03v3 L=0.28U W=0.36U AS=0.2097P AD=0.1278P
+ PS=1.38U PD=1.07U
M$2332 \$4444 \$4337 \$4336 VDD pfet_03v3 L=0.28U W=0.36U AS=0.1278P AD=0.0567P
+ PS=1.07U PD=0.675U
M$2333 VDD \$4320 \$4444 VDD pfet_03v3 L=0.28U W=0.36U AS=0.0567P AD=0.1584P
+ PS=0.675U PD=1.6U
M$2334 \$4335 \$112 VDD VDD pfet_03v3 L=0.28U W=0.72U AS=0.3168P AD=0.2097P
+ PS=2.32U PD=1.38U
M$2335 VDD \$4336 \$4337 VDD pfet_03v3 L=0.28U W=0.36U AS=0.1584P AD=0.1764P
+ PS=1.6U PD=1.26U
M$2336 \$4338 \$4336 VDD VDD pfet_03v3 L=0.28U W=0.72U AS=0.1764P AD=0.36P
+ PS=1.26U PD=2.44U
M$2337 \$4339 RB2 VDD VDD pfet_03v3 L=0.28U W=0.72U AS=0.3312P AD=0.3888P
+ PS=2.36U PD=2.52U
M$2338 \$4338 \$4339 \$55 VDD pfet_03v3 L=0.28U W=0.36U AS=0.1584P AD=0.1152P
+ PS=1.6U PD=1U
M$2339 \$56 \$4340 \$4338 VDD pfet_03v3 L=0.28U W=0.36U AS=0.1152P AD=0.1584P
+ PS=1U PD=1.6U
M$2340 VDD RA2 \$4340 VDD pfet_03v3 L=0.28U W=0.72U AS=0.3708P AD=0.3168P
+ PS=2.47U PD=2.32U
M$2341 \$4342 \$4321 \$4341 VDD pfet_03v3 L=0.28U W=0.36U AS=0.2097P AD=0.1278P
+ PS=1.38U PD=1.07U
M$2342 \$4454 \$4343 \$4342 VDD pfet_03v3 L=0.28U W=0.36U AS=0.1278P AD=0.0567P
+ PS=1.07U PD=0.675U
M$2343 VDD \$4320 \$4454 VDD pfet_03v3 L=0.28U W=0.36U AS=0.0567P AD=0.1584P
+ PS=0.675U PD=1.6U
M$2344 \$4341 \$115 VDD VDD pfet_03v3 L=0.28U W=0.72U AS=0.3168P AD=0.2097P
+ PS=2.32U PD=1.38U
M$2345 VDD \$4342 \$4343 VDD pfet_03v3 L=0.28U W=0.36U AS=0.1584P AD=0.1764P
+ PS=1.6U PD=1.26U
M$2346 \$4344 \$4342 VDD VDD pfet_03v3 L=0.28U W=0.72U AS=0.1764P AD=0.36P
+ PS=1.26U PD=2.44U
M$2347 \$4345 RB2 VDD VDD pfet_03v3 L=0.28U W=0.72U AS=0.3312P AD=0.3888P
+ PS=2.36U PD=2.52U
M$2348 \$4344 \$4345 \$57 VDD pfet_03v3 L=0.28U W=0.36U AS=0.1584P AD=0.1152P
+ PS=1.6U PD=1U
M$2349 \$58 \$4346 \$4344 VDD pfet_03v3 L=0.28U W=0.36U AS=0.1152P AD=0.1584P
+ PS=1U PD=1.6U
M$2350 VDD RA2 \$4346 VDD pfet_03v3 L=0.28U W=0.72U AS=0.3708P AD=0.3168P
+ PS=2.47U PD=2.32U
M$2351 \$4348 \$4321 \$4347 VDD pfet_03v3 L=0.28U W=0.36U AS=0.2097P AD=0.1278P
+ PS=1.38U PD=1.07U
M$2352 \$4465 \$4349 \$4348 VDD pfet_03v3 L=0.28U W=0.36U AS=0.1278P AD=0.0567P
+ PS=1.07U PD=0.675U
M$2353 VDD \$4320 \$4465 VDD pfet_03v3 L=0.28U W=0.36U AS=0.0567P AD=0.1584P
+ PS=0.675U PD=1.6U
M$2354 \$4347 \$118 VDD VDD pfet_03v3 L=0.28U W=0.72U AS=0.3168P AD=0.2097P
+ PS=2.32U PD=1.38U
M$2355 VDD \$4348 \$4349 VDD pfet_03v3 L=0.28U W=0.36U AS=0.1584P AD=0.1764P
+ PS=1.6U PD=1.26U
M$2356 \$4350 \$4348 VDD VDD pfet_03v3 L=0.28U W=0.72U AS=0.1764P AD=0.36P
+ PS=1.26U PD=2.44U
M$2357 \$4351 RB2 VDD VDD pfet_03v3 L=0.28U W=0.72U AS=0.3312P AD=0.3888P
+ PS=2.36U PD=2.52U
M$2358 \$4350 \$4351 \$59 VDD pfet_03v3 L=0.28U W=0.36U AS=0.1584P AD=0.1152P
+ PS=1.6U PD=1U
M$2359 \$60 \$4352 \$4350 VDD pfet_03v3 L=0.28U W=0.36U AS=0.1152P AD=0.1584P
+ PS=1U PD=1.6U
M$2360 VDD RA2 \$4352 VDD pfet_03v3 L=0.28U W=0.72U AS=0.3708P AD=0.3168P
+ PS=2.47U PD=2.32U
M$2361 \$4354 \$4321 \$4353 VDD pfet_03v3 L=0.28U W=0.36U AS=0.2097P AD=0.1278P
+ PS=1.38U PD=1.07U
M$2362 \$4474 \$4355 \$4354 VDD pfet_03v3 L=0.28U W=0.36U AS=0.1278P AD=0.0567P
+ PS=1.07U PD=0.675U
M$2363 VDD \$4320 \$4474 VDD pfet_03v3 L=0.28U W=0.36U AS=0.0567P AD=0.1584P
+ PS=0.675U PD=1.6U
M$2364 \$4353 \$121 VDD VDD pfet_03v3 L=0.28U W=0.72U AS=0.3168P AD=0.2097P
+ PS=2.32U PD=1.38U
M$2365 VDD \$4354 \$4355 VDD pfet_03v3 L=0.28U W=0.36U AS=0.1584P AD=0.1764P
+ PS=1.6U PD=1.26U
M$2366 \$4356 \$4354 VDD VDD pfet_03v3 L=0.28U W=0.72U AS=0.1764P AD=0.36P
+ PS=1.26U PD=2.44U
M$2367 \$4357 RB2 VDD VDD pfet_03v3 L=0.28U W=0.72U AS=0.3312P AD=0.3888P
+ PS=2.36U PD=2.52U
M$2368 \$4356 \$4357 \$61 VDD pfet_03v3 L=0.28U W=0.36U AS=0.1584P AD=0.1152P
+ PS=1.6U PD=1U
M$2369 \$62 \$4358 \$4356 VDD pfet_03v3 L=0.28U W=0.36U AS=0.1152P AD=0.1584P
+ PS=1U PD=1.6U
M$2370 VDD RA2 \$4358 VDD pfet_03v3 L=0.28U W=0.72U AS=0.3708P AD=0.3168P
+ PS=2.47U PD=2.32U
M$2371 \$4360 \$4321 \$4359 VDD pfet_03v3 L=0.28U W=0.36U AS=0.2097P AD=0.1278P
+ PS=1.38U PD=1.07U
M$2372 \$4484 \$4361 \$4360 VDD pfet_03v3 L=0.28U W=0.36U AS=0.1278P AD=0.0567P
+ PS=1.07U PD=0.675U
M$2373 VDD \$4320 \$4484 VDD pfet_03v3 L=0.28U W=0.36U AS=0.0567P AD=0.1584P
+ PS=0.675U PD=1.6U
M$2374 \$4359 \$124 VDD VDD pfet_03v3 L=0.28U W=0.72U AS=0.3168P AD=0.2097P
+ PS=2.32U PD=1.38U
M$2375 VDD \$4360 \$4361 VDD pfet_03v3 L=0.28U W=0.36U AS=0.1584P AD=0.1764P
+ PS=1.6U PD=1.26U
M$2376 \$4362 \$4360 VDD VDD pfet_03v3 L=0.28U W=0.72U AS=0.1764P AD=0.36P
+ PS=1.26U PD=2.44U
M$2377 \$4363 RB2 VDD VDD pfet_03v3 L=0.28U W=0.72U AS=0.3312P AD=0.3888P
+ PS=2.36U PD=2.52U
M$2378 \$4362 \$4363 \$63 VDD pfet_03v3 L=0.28U W=0.36U AS=0.1584P AD=0.1152P
+ PS=1.6U PD=1U
M$2379 \$64 \$4364 \$4362 VDD pfet_03v3 L=0.28U W=0.36U AS=0.1152P AD=0.1584P
+ PS=1U PD=1.6U
M$2380 VDD RA2 \$4364 VDD pfet_03v3 L=0.28U W=0.72U AS=0.3708P AD=0.3168P
+ PS=2.47U PD=2.32U
M$2381 \$4366 \$4321 \$4365 VDD pfet_03v3 L=0.28U W=0.36U AS=0.2097P AD=0.1278P
+ PS=1.38U PD=1.07U
M$2382 \$4494 \$4367 \$4366 VDD pfet_03v3 L=0.28U W=0.36U AS=0.1278P AD=0.0567P
+ PS=1.07U PD=0.675U
M$2383 VDD \$4320 \$4494 VDD pfet_03v3 L=0.28U W=0.36U AS=0.0567P AD=0.1584P
+ PS=0.675U PD=1.6U
M$2384 \$4365 \$127 VDD VDD pfet_03v3 L=0.28U W=0.72U AS=0.3168P AD=0.2097P
+ PS=2.32U PD=1.38U
M$2385 VDD \$4366 \$4367 VDD pfet_03v3 L=0.28U W=0.36U AS=0.1584P AD=0.1764P
+ PS=1.6U PD=1.26U
M$2386 \$4368 \$4366 VDD VDD pfet_03v3 L=0.28U W=0.72U AS=0.1764P AD=0.36P
+ PS=1.26U PD=2.44U
M$2387 \$4369 RB2 VDD VDD pfet_03v3 L=0.28U W=0.72U AS=0.3312P AD=0.3888P
+ PS=2.36U PD=2.52U
M$2388 \$4368 \$4369 \$65 VDD pfet_03v3 L=0.28U W=0.36U AS=0.1584P AD=0.1152P
+ PS=1.6U PD=1U
M$2389 \$66 \$4370 \$4368 VDD pfet_03v3 L=0.28U W=0.36U AS=0.1152P AD=0.1584P
+ PS=1U PD=1.6U
M$2390 VDD RA2 \$4370 VDD pfet_03v3 L=0.28U W=0.72U AS=0.3708P AD=0.3168P
+ PS=2.47U PD=2.32U
M$2391 \$4372 \$4321 \$4371 VDD pfet_03v3 L=0.28U W=0.36U AS=0.2097P AD=0.1278P
+ PS=1.38U PD=1.07U
M$2392 \$4504 \$4373 \$4372 VDD pfet_03v3 L=0.28U W=0.36U AS=0.1278P AD=0.0567P
+ PS=1.07U PD=0.675U
M$2393 VDD \$4320 \$4504 VDD pfet_03v3 L=0.28U W=0.36U AS=0.0567P AD=0.1584P
+ PS=0.675U PD=1.6U
M$2394 \$4371 \$130 VDD VDD pfet_03v3 L=0.28U W=0.72U AS=0.3168P AD=0.2097P
+ PS=2.32U PD=1.38U
M$2395 VDD \$4372 \$4373 VDD pfet_03v3 L=0.28U W=0.36U AS=0.1584P AD=0.1764P
+ PS=1.6U PD=1.26U
M$2396 \$4374 \$4372 VDD VDD pfet_03v3 L=0.28U W=0.72U AS=0.1764P AD=0.36P
+ PS=1.26U PD=2.44U
M$2397 \$4375 RB2 VDD VDD pfet_03v3 L=0.28U W=0.72U AS=0.3312P AD=0.3888P
+ PS=2.36U PD=2.52U
M$2398 \$4374 \$4375 \$67 VDD pfet_03v3 L=0.28U W=0.36U AS=0.1584P AD=0.1152P
+ PS=1.6U PD=1U
M$2399 \$68 \$4376 \$4374 VDD pfet_03v3 L=0.28U W=0.36U AS=0.1152P AD=0.1584P
+ PS=1U PD=1.6U
M$2400 VDD RA2 \$4376 VDD pfet_03v3 L=0.28U W=0.72U AS=0.3708P AD=0.3168P
+ PS=2.47U PD=2.32U
M$2401 \$4378 \$4321 \$4377 VDD pfet_03v3 L=0.28U W=0.36U AS=0.2097P AD=0.1278P
+ PS=1.38U PD=1.07U
M$2402 \$4514 \$4379 \$4378 VDD pfet_03v3 L=0.28U W=0.36U AS=0.1278P AD=0.0567P
+ PS=1.07U PD=0.675U
M$2403 VDD \$4320 \$4514 VDD pfet_03v3 L=0.28U W=0.36U AS=0.0567P AD=0.1584P
+ PS=0.675U PD=1.6U
M$2404 \$4377 \$133 VDD VDD pfet_03v3 L=0.28U W=0.72U AS=0.3168P AD=0.2097P
+ PS=2.32U PD=1.38U
M$2405 VDD \$4378 \$4379 VDD pfet_03v3 L=0.28U W=0.36U AS=0.1584P AD=0.1764P
+ PS=1.6U PD=1.26U
M$2406 \$4380 \$4378 VDD VDD pfet_03v3 L=0.28U W=0.72U AS=0.1764P AD=0.36P
+ PS=1.26U PD=2.44U
M$2407 \$4381 RB2 VDD VDD pfet_03v3 L=0.28U W=0.72U AS=0.3312P AD=0.3888P
+ PS=2.36U PD=2.52U
M$2408 \$4380 \$4381 \$69 VDD pfet_03v3 L=0.28U W=0.36U AS=0.1584P AD=0.1152P
+ PS=1.6U PD=1U
M$2409 \$70 \$4382 \$4380 VDD pfet_03v3 L=0.28U W=0.36U AS=0.1152P AD=0.1584P
+ PS=1U PD=1.6U
M$2410 VDD RA2 \$4382 VDD pfet_03v3 L=0.28U W=0.72U AS=0.3708P AD=0.3168P
+ PS=2.47U PD=2.32U
M$2411 \$4384 \$4321 \$4383 VDD pfet_03v3 L=0.28U W=0.36U AS=0.2097P AD=0.1278P
+ PS=1.38U PD=1.07U
M$2412 \$4501 \$4385 \$4384 VDD pfet_03v3 L=0.28U W=0.36U AS=0.1278P AD=0.0567P
+ PS=1.07U PD=0.675U
M$2413 VDD \$4320 \$4501 VDD pfet_03v3 L=0.28U W=0.36U AS=0.0567P AD=0.1584P
+ PS=0.675U PD=1.6U
M$2414 \$4383 \$136 VDD VDD pfet_03v3 L=0.28U W=0.72U AS=0.3168P AD=0.2097P
+ PS=2.32U PD=1.38U
M$2415 VDD \$4384 \$4385 VDD pfet_03v3 L=0.28U W=0.36U AS=0.1584P AD=0.1764P
+ PS=1.6U PD=1.26U
M$2416 \$4386 \$4384 VDD VDD pfet_03v3 L=0.28U W=0.72U AS=0.1764P AD=0.36P
+ PS=1.26U PD=2.44U
M$2417 \$4387 RB2 VDD VDD pfet_03v3 L=0.28U W=0.72U AS=0.3312P AD=0.3888P
+ PS=2.36U PD=2.52U
M$2418 \$4386 \$4387 \$71 VDD pfet_03v3 L=0.28U W=0.36U AS=0.1584P AD=0.1152P
+ PS=1.6U PD=1U
M$2419 \$72 \$4388 \$4386 VDD pfet_03v3 L=0.28U W=0.36U AS=0.1152P AD=0.1584P
+ PS=1U PD=1.6U
M$2420 VDD RA2 \$4388 VDD pfet_03v3 L=0.28U W=0.72U AS=0.3708P AD=0.3168P
+ PS=2.47U PD=2.32U
M$2421 \$4390 \$4321 \$4389 VDD pfet_03v3 L=0.28U W=0.36U AS=0.2097P AD=0.1278P
+ PS=1.38U PD=1.07U
M$2422 \$4486 \$4391 \$4390 VDD pfet_03v3 L=0.28U W=0.36U AS=0.1278P AD=0.0567P
+ PS=1.07U PD=0.675U
M$2423 VDD \$4320 \$4486 VDD pfet_03v3 L=0.28U W=0.36U AS=0.0567P AD=0.1584P
+ PS=0.675U PD=1.6U
M$2424 \$4389 \$139 VDD VDD pfet_03v3 L=0.28U W=0.72U AS=0.3168P AD=0.2097P
+ PS=2.32U PD=1.38U
M$2425 VDD \$4390 \$4391 VDD pfet_03v3 L=0.28U W=0.36U AS=0.1584P AD=0.1764P
+ PS=1.6U PD=1.26U
M$2426 \$4392 \$4390 VDD VDD pfet_03v3 L=0.28U W=0.72U AS=0.1764P AD=0.36P
+ PS=1.26U PD=2.44U
M$2427 \$4393 RB2 VDD VDD pfet_03v3 L=0.28U W=0.72U AS=0.3312P AD=0.3888P
+ PS=2.36U PD=2.52U
M$2428 \$4392 \$4393 \$73 VDD pfet_03v3 L=0.28U W=0.36U AS=0.1584P AD=0.1152P
+ PS=1.6U PD=1U
M$2429 \$74 \$4394 \$4392 VDD pfet_03v3 L=0.28U W=0.36U AS=0.1152P AD=0.1584P
+ PS=1U PD=1.6U
M$2430 VDD RA2 \$4394 VDD pfet_03v3 L=0.28U W=0.72U AS=0.3708P AD=0.3168P
+ PS=2.47U PD=2.32U
M$2431 \$4396 \$4321 \$4395 VDD pfet_03v3 L=0.28U W=0.36U AS=0.2097P AD=0.1278P
+ PS=1.38U PD=1.07U
M$2432 \$4470 \$4397 \$4396 VDD pfet_03v3 L=0.28U W=0.36U AS=0.1278P AD=0.0567P
+ PS=1.07U PD=0.675U
M$2433 VDD \$4320 \$4470 VDD pfet_03v3 L=0.28U W=0.36U AS=0.0567P AD=0.1584P
+ PS=0.675U PD=1.6U
M$2434 \$4395 \$142 VDD VDD pfet_03v3 L=0.28U W=0.72U AS=0.3168P AD=0.2097P
+ PS=2.32U PD=1.38U
M$2435 VDD \$4396 \$4397 VDD pfet_03v3 L=0.28U W=0.36U AS=0.1584P AD=0.1764P
+ PS=1.6U PD=1.26U
M$2436 \$4398 \$4396 VDD VDD pfet_03v3 L=0.28U W=0.72U AS=0.1764P AD=0.36P
+ PS=1.26U PD=2.44U
M$2437 \$4399 RB2 VDD VDD pfet_03v3 L=0.28U W=0.72U AS=0.3312P AD=0.3888P
+ PS=2.36U PD=2.52U
M$2438 \$4398 \$4399 \$75 VDD pfet_03v3 L=0.28U W=0.36U AS=0.1584P AD=0.1152P
+ PS=1.6U PD=1U
M$2439 \$76 \$4400 \$4398 VDD pfet_03v3 L=0.28U W=0.36U AS=0.1152P AD=0.1584P
+ PS=1U PD=1.6U
M$2440 VDD RA2 \$4400 VDD pfet_03v3 L=0.28U W=0.72U AS=0.3708P AD=0.3168P
+ PS=2.47U PD=2.32U
M$2441 \$4402 \$4321 \$4401 VDD pfet_03v3 L=0.28U W=0.36U AS=0.2097P AD=0.1278P
+ PS=1.38U PD=1.07U
M$2442 \$4459 \$4403 \$4402 VDD pfet_03v3 L=0.28U W=0.36U AS=0.1278P AD=0.0567P
+ PS=1.07U PD=0.675U
M$2443 VDD \$4320 \$4459 VDD pfet_03v3 L=0.28U W=0.36U AS=0.0567P AD=0.1584P
+ PS=0.675U PD=1.6U
M$2444 \$4401 \$145 VDD VDD pfet_03v3 L=0.28U W=0.72U AS=0.3168P AD=0.2097P
+ PS=2.32U PD=1.38U
M$2445 VDD \$4402 \$4403 VDD pfet_03v3 L=0.28U W=0.36U AS=0.1584P AD=0.1764P
+ PS=1.6U PD=1.26U
M$2446 \$4404 \$4402 VDD VDD pfet_03v3 L=0.28U W=0.72U AS=0.1764P AD=0.36P
+ PS=1.26U PD=2.44U
M$2447 \$4405 RB2 VDD VDD pfet_03v3 L=0.28U W=0.72U AS=0.3312P AD=0.3888P
+ PS=2.36U PD=2.52U
M$2448 \$4404 \$4405 \$77 VDD pfet_03v3 L=0.28U W=0.36U AS=0.1584P AD=0.1152P
+ PS=1.6U PD=1U
M$2449 \$78 \$4406 \$4404 VDD pfet_03v3 L=0.28U W=0.36U AS=0.1152P AD=0.1584P
+ PS=1U PD=1.6U
M$2450 VDD RA2 \$4406 VDD pfet_03v3 L=0.28U W=0.72U AS=0.3708P AD=0.3168P
+ PS=2.47U PD=2.32U
M$2451 \$4408 \$4321 \$4407 VDD pfet_03v3 L=0.28U W=0.36U AS=0.2097P AD=0.1278P
+ PS=1.38U PD=1.07U
M$2452 \$4443 \$4409 \$4408 VDD pfet_03v3 L=0.28U W=0.36U AS=0.1278P AD=0.0567P
+ PS=1.07U PD=0.675U
M$2453 VDD \$4320 \$4443 VDD pfet_03v3 L=0.28U W=0.36U AS=0.0567P AD=0.1584P
+ PS=0.675U PD=1.6U
M$2454 \$4407 \$148 VDD VDD pfet_03v3 L=0.28U W=0.72U AS=0.3168P AD=0.2097P
+ PS=2.32U PD=1.38U
M$2455 VDD \$4408 \$4409 VDD pfet_03v3 L=0.28U W=0.36U AS=0.1584P AD=0.1764P
+ PS=1.6U PD=1.26U
M$2456 \$4410 \$4408 VDD VDD pfet_03v3 L=0.28U W=0.72U AS=0.1764P AD=0.36P
+ PS=1.26U PD=2.44U
M$2457 \$4411 RB2 VDD VDD pfet_03v3 L=0.28U W=0.72U AS=0.3312P AD=0.3888P
+ PS=2.36U PD=2.52U
M$2458 \$4410 \$4411 \$79 VDD pfet_03v3 L=0.28U W=0.36U AS=0.1584P AD=0.1152P
+ PS=1.6U PD=1U
M$2459 \$80 \$4412 \$4410 VDD pfet_03v3 L=0.28U W=0.36U AS=0.1152P AD=0.1584P
+ PS=1U PD=1.6U
M$2460 VDD RA2 \$4412 VDD pfet_03v3 L=0.28U W=0.72U AS=0.3708P AD=0.3168P
+ PS=2.47U PD=2.32U
M$2461 \$4414 \$4321 \$4413 VDD pfet_03v3 L=0.28U W=0.36U AS=0.2097P AD=0.1278P
+ PS=1.38U PD=1.07U
M$2462 \$4429 \$4415 \$4414 VDD pfet_03v3 L=0.28U W=0.36U AS=0.1278P AD=0.0567P
+ PS=1.07U PD=0.675U
M$2463 VDD \$4320 \$4429 VDD pfet_03v3 L=0.28U W=0.36U AS=0.0567P AD=0.1584P
+ PS=0.675U PD=1.6U
M$2464 \$4413 \$151 VDD VDD pfet_03v3 L=0.28U W=0.72U AS=0.3168P AD=0.2097P
+ PS=2.32U PD=1.38U
M$2465 VDD \$4414 \$4415 VDD pfet_03v3 L=0.28U W=0.36U AS=0.1584P AD=0.1764P
+ PS=1.6U PD=1.26U
M$2466 \$4416 \$4414 VDD VDD pfet_03v3 L=0.28U W=0.72U AS=0.1764P AD=0.36P
+ PS=1.26U PD=2.44U
M$2467 \$4417 RB2 VDD VDD pfet_03v3 L=0.28U W=0.72U AS=0.3312P AD=0.3888P
+ PS=2.36U PD=2.52U
M$2468 \$4416 \$4417 \$81 VDD pfet_03v3 L=0.28U W=0.36U AS=0.1584P AD=0.1152P
+ PS=1.6U PD=1U
M$2469 \$82 \$4418 \$4416 VDD pfet_03v3 L=0.28U W=0.36U AS=0.1152P AD=0.1584P
+ PS=1U PD=1.6U
M$2470 VDD RA2 \$4418 VDD pfet_03v3 L=0.28U W=0.72U AS=0.3708P AD=0.3168P
+ PS=2.47U PD=2.32U
M$2471 \$4638 WE1 VDD VDD pfet_03v3 L=0.28U W=0.72U AS=0.3168P AD=0.1872P
+ PS=2.32U PD=1.24U
M$2472 VDD CLK \$4638 VDD pfet_03v3 L=0.28U W=0.72U AS=0.1872P AD=0.3168P
+ PS=1.24U PD=2.32U
M$2473 \$4639 \$4638 VDD VDD pfet_03v3 L=0.28U W=2.54U AS=0.8974P AD=0.6604P
+ PS=5.28U PD=3.58U
M$2475 \$4832 \$4639 VDD VDD pfet_03v3 L=0.28U W=2.68U AS=0.7272P AD=0.9782P
+ PS=3.78U PD=5.48U
M$2477 \$4640 \$106 VDD VDD pfet_03v3 L=0.28U W=0.72U AS=0.3168P AD=0.2097P
+ PS=2.32U PD=1.38U
M$2478 \$4641 \$4832 \$4640 VDD pfet_03v3 L=0.28U W=0.36U AS=0.2097P AD=0.1278P
+ PS=1.38U PD=1.07U
M$2479 \$4838 \$4730 \$4641 VDD pfet_03v3 L=0.28U W=0.36U AS=0.1278P AD=0.0567P
+ PS=1.07U PD=0.675U
M$2480 VDD \$4639 \$4838 VDD pfet_03v3 L=0.28U W=0.36U AS=0.0567P AD=0.1584P
+ PS=0.675U PD=1.6U
M$2481 \$4730 \$4641 VDD VDD pfet_03v3 L=0.28U W=0.36U AS=0.1764P AD=0.1584P
+ PS=1.26U PD=1.6U
M$2482 \$4622 \$4641 VDD VDD pfet_03v3 L=0.28U W=0.72U AS=0.1764P AD=0.36P
+ PS=1.26U PD=2.44U
M$2483 \$4732 RA1 VDD VDD pfet_03v3 L=0.28U W=0.72U AS=0.3312P AD=0.3888P
+ PS=2.36U PD=2.52U
M$2484 \$4622 \$4732 \$51 VDD pfet_03v3 L=0.28U W=0.36U AS=0.1584P AD=0.1152P
+ PS=1.6U PD=1U
M$2485 \$52 \$4733 \$4622 VDD pfet_03v3 L=0.28U W=0.36U AS=0.1152P AD=0.1584P
+ PS=1U PD=1.6U
M$2486 VDD RB1 \$4733 VDD pfet_03v3 L=0.28U W=0.72U AS=0.3708P AD=0.3168P
+ PS=2.47U PD=2.32U
M$2487 \$4642 \$109 VDD VDD pfet_03v3 L=0.28U W=0.72U AS=0.3168P AD=0.2097P
+ PS=2.32U PD=1.38U
M$2488 \$4643 \$4832 \$4642 VDD pfet_03v3 L=0.28U W=0.36U AS=0.2097P AD=0.1278P
+ PS=1.38U PD=1.07U
M$2489 \$4850 \$4734 \$4643 VDD pfet_03v3 L=0.28U W=0.36U AS=0.1278P AD=0.0567P
+ PS=1.07U PD=0.675U
M$2490 VDD \$4639 \$4850 VDD pfet_03v3 L=0.28U W=0.36U AS=0.0567P AD=0.1584P
+ PS=0.675U PD=1.6U
M$2491 \$4734 \$4643 VDD VDD pfet_03v3 L=0.28U W=0.36U AS=0.1764P AD=0.1584P
+ PS=1.26U PD=1.6U
M$2492 \$4623 \$4643 VDD VDD pfet_03v3 L=0.28U W=0.72U AS=0.1764P AD=0.36P
+ PS=1.26U PD=2.44U
M$2493 \$4735 RA1 VDD VDD pfet_03v3 L=0.28U W=0.72U AS=0.3312P AD=0.3888P
+ PS=2.36U PD=2.52U
M$2494 \$4623 \$4735 \$53 VDD pfet_03v3 L=0.28U W=0.36U AS=0.1584P AD=0.1152P
+ PS=1.6U PD=1U
M$2495 \$54 \$4736 \$4623 VDD pfet_03v3 L=0.28U W=0.36U AS=0.1152P AD=0.1584P
+ PS=1U PD=1.6U
M$2496 VDD RB1 \$4736 VDD pfet_03v3 L=0.28U W=0.72U AS=0.3708P AD=0.3168P
+ PS=2.47U PD=2.32U
M$2497 \$4644 \$112 VDD VDD pfet_03v3 L=0.28U W=0.72U AS=0.3168P AD=0.2097P
+ PS=2.32U PD=1.38U
M$2498 \$4645 \$4832 \$4644 VDD pfet_03v3 L=0.28U W=0.36U AS=0.2097P AD=0.1278P
+ PS=1.38U PD=1.07U
M$2499 \$4859 \$4737 \$4645 VDD pfet_03v3 L=0.28U W=0.36U AS=0.1278P AD=0.0567P
+ PS=1.07U PD=0.675U
M$2500 VDD \$4639 \$4859 VDD pfet_03v3 L=0.28U W=0.36U AS=0.0567P AD=0.1584P
+ PS=0.675U PD=1.6U
M$2501 \$4737 \$4645 VDD VDD pfet_03v3 L=0.28U W=0.36U AS=0.1764P AD=0.1584P
+ PS=1.26U PD=1.6U
M$2502 \$4624 \$4645 VDD VDD pfet_03v3 L=0.28U W=0.72U AS=0.1764P AD=0.36P
+ PS=1.26U PD=2.44U
M$2503 \$4738 RA1 VDD VDD pfet_03v3 L=0.28U W=0.72U AS=0.3312P AD=0.3888P
+ PS=2.36U PD=2.52U
M$2504 \$4624 \$4738 \$55 VDD pfet_03v3 L=0.28U W=0.36U AS=0.1584P AD=0.1152P
+ PS=1.6U PD=1U
M$2505 \$56 \$4739 \$4624 VDD pfet_03v3 L=0.28U W=0.36U AS=0.1152P AD=0.1584P
+ PS=1U PD=1.6U
M$2506 VDD RB1 \$4739 VDD pfet_03v3 L=0.28U W=0.72U AS=0.3708P AD=0.3168P
+ PS=2.47U PD=2.32U
M$2507 \$4646 \$115 VDD VDD pfet_03v3 L=0.28U W=0.72U AS=0.3168P AD=0.2097P
+ PS=2.32U PD=1.38U
M$2508 \$4647 \$4832 \$4646 VDD pfet_03v3 L=0.28U W=0.36U AS=0.2097P AD=0.1278P
+ PS=1.38U PD=1.07U
M$2509 \$4870 \$4740 \$4647 VDD pfet_03v3 L=0.28U W=0.36U AS=0.1278P AD=0.0567P
+ PS=1.07U PD=0.675U
M$2510 VDD \$4639 \$4870 VDD pfet_03v3 L=0.28U W=0.36U AS=0.0567P AD=0.1584P
+ PS=0.675U PD=1.6U
M$2511 \$4740 \$4647 VDD VDD pfet_03v3 L=0.28U W=0.36U AS=0.1764P AD=0.1584P
+ PS=1.26U PD=1.6U
M$2512 \$4625 \$4647 VDD VDD pfet_03v3 L=0.28U W=0.72U AS=0.1764P AD=0.36P
+ PS=1.26U PD=2.44U
M$2513 \$4741 RA1 VDD VDD pfet_03v3 L=0.28U W=0.72U AS=0.3312P AD=0.3888P
+ PS=2.36U PD=2.52U
M$2514 \$4625 \$4741 \$57 VDD pfet_03v3 L=0.28U W=0.36U AS=0.1584P AD=0.1152P
+ PS=1.6U PD=1U
M$2515 \$58 \$4742 \$4625 VDD pfet_03v3 L=0.28U W=0.36U AS=0.1152P AD=0.1584P
+ PS=1U PD=1.6U
M$2516 VDD RB1 \$4742 VDD pfet_03v3 L=0.28U W=0.72U AS=0.3708P AD=0.3168P
+ PS=2.47U PD=2.32U
M$2517 \$4648 \$118 VDD VDD pfet_03v3 L=0.28U W=0.72U AS=0.3168P AD=0.2097P
+ PS=2.32U PD=1.38U
M$2518 \$4649 \$4832 \$4648 VDD pfet_03v3 L=0.28U W=0.36U AS=0.2097P AD=0.1278P
+ PS=1.38U PD=1.07U
M$2519 \$4879 \$4743 \$4649 VDD pfet_03v3 L=0.28U W=0.36U AS=0.1278P AD=0.0567P
+ PS=1.07U PD=0.675U
M$2520 VDD \$4639 \$4879 VDD pfet_03v3 L=0.28U W=0.36U AS=0.0567P AD=0.1584P
+ PS=0.675U PD=1.6U
M$2521 \$4743 \$4649 VDD VDD pfet_03v3 L=0.28U W=0.36U AS=0.1764P AD=0.1584P
+ PS=1.26U PD=1.6U
M$2522 \$4626 \$4649 VDD VDD pfet_03v3 L=0.28U W=0.72U AS=0.1764P AD=0.36P
+ PS=1.26U PD=2.44U
M$2523 \$4744 RA1 VDD VDD pfet_03v3 L=0.28U W=0.72U AS=0.3312P AD=0.3888P
+ PS=2.36U PD=2.52U
M$2524 \$4626 \$4744 \$59 VDD pfet_03v3 L=0.28U W=0.36U AS=0.1584P AD=0.1152P
+ PS=1.6U PD=1U
M$2525 \$60 \$4745 \$4626 VDD pfet_03v3 L=0.28U W=0.36U AS=0.1152P AD=0.1584P
+ PS=1U PD=1.6U
M$2526 VDD RB1 \$4745 VDD pfet_03v3 L=0.28U W=0.72U AS=0.3708P AD=0.3168P
+ PS=2.47U PD=2.32U
M$2527 \$4650 \$121 VDD VDD pfet_03v3 L=0.28U W=0.72U AS=0.3168P AD=0.2097P
+ PS=2.32U PD=1.38U
M$2528 \$4651 \$4832 \$4650 VDD pfet_03v3 L=0.28U W=0.36U AS=0.2097P AD=0.1278P
+ PS=1.38U PD=1.07U
M$2529 \$4889 \$4746 \$4651 VDD pfet_03v3 L=0.28U W=0.36U AS=0.1278P AD=0.0567P
+ PS=1.07U PD=0.675U
M$2530 VDD \$4639 \$4889 VDD pfet_03v3 L=0.28U W=0.36U AS=0.0567P AD=0.1584P
+ PS=0.675U PD=1.6U
M$2531 \$4746 \$4651 VDD VDD pfet_03v3 L=0.28U W=0.36U AS=0.1764P AD=0.1584P
+ PS=1.26U PD=1.6U
M$2532 \$4627 \$4651 VDD VDD pfet_03v3 L=0.28U W=0.72U AS=0.1764P AD=0.36P
+ PS=1.26U PD=2.44U
M$2533 \$4747 RA1 VDD VDD pfet_03v3 L=0.28U W=0.72U AS=0.3312P AD=0.3888P
+ PS=2.36U PD=2.52U
M$2534 \$4627 \$4747 \$61 VDD pfet_03v3 L=0.28U W=0.36U AS=0.1584P AD=0.1152P
+ PS=1.6U PD=1U
M$2535 \$62 \$4748 \$4627 VDD pfet_03v3 L=0.28U W=0.36U AS=0.1152P AD=0.1584P
+ PS=1U PD=1.6U
M$2536 VDD RB1 \$4748 VDD pfet_03v3 L=0.28U W=0.72U AS=0.3708P AD=0.3168P
+ PS=2.47U PD=2.32U
M$2537 \$4652 \$124 VDD VDD pfet_03v3 L=0.28U W=0.72U AS=0.3168P AD=0.2097P
+ PS=2.32U PD=1.38U
M$2538 \$4653 \$4832 \$4652 VDD pfet_03v3 L=0.28U W=0.36U AS=0.2097P AD=0.1278P
+ PS=1.38U PD=1.07U
M$2539 \$4900 \$4749 \$4653 VDD pfet_03v3 L=0.28U W=0.36U AS=0.1278P AD=0.0567P
+ PS=1.07U PD=0.675U
M$2540 VDD \$4639 \$4900 VDD pfet_03v3 L=0.28U W=0.36U AS=0.0567P AD=0.1584P
+ PS=0.675U PD=1.6U
M$2541 \$4749 \$4653 VDD VDD pfet_03v3 L=0.28U W=0.36U AS=0.1764P AD=0.1584P
+ PS=1.26U PD=1.6U
M$2542 \$4628 \$4653 VDD VDD pfet_03v3 L=0.28U W=0.72U AS=0.1764P AD=0.36P
+ PS=1.26U PD=2.44U
M$2543 \$4750 RA1 VDD VDD pfet_03v3 L=0.28U W=0.72U AS=0.3312P AD=0.3888P
+ PS=2.36U PD=2.52U
M$2544 \$4628 \$4750 \$63 VDD pfet_03v3 L=0.28U W=0.36U AS=0.1584P AD=0.1152P
+ PS=1.6U PD=1U
M$2545 \$64 \$4751 \$4628 VDD pfet_03v3 L=0.28U W=0.36U AS=0.1152P AD=0.1584P
+ PS=1U PD=1.6U
M$2546 VDD RB1 \$4751 VDD pfet_03v3 L=0.28U W=0.72U AS=0.3708P AD=0.3168P
+ PS=2.47U PD=2.32U
M$2547 \$4654 \$127 VDD VDD pfet_03v3 L=0.28U W=0.72U AS=0.3168P AD=0.2097P
+ PS=2.32U PD=1.38U
M$2548 \$4655 \$4832 \$4654 VDD pfet_03v3 L=0.28U W=0.36U AS=0.2097P AD=0.1278P
+ PS=1.38U PD=1.07U
M$2549 \$4911 \$4752 \$4655 VDD pfet_03v3 L=0.28U W=0.36U AS=0.1278P AD=0.0567P
+ PS=1.07U PD=0.675U
M$2550 VDD \$4639 \$4911 VDD pfet_03v3 L=0.28U W=0.36U AS=0.0567P AD=0.1584P
+ PS=0.675U PD=1.6U
M$2551 \$4752 \$4655 VDD VDD pfet_03v3 L=0.28U W=0.36U AS=0.1764P AD=0.1584P
+ PS=1.26U PD=1.6U
M$2552 \$4629 \$4655 VDD VDD pfet_03v3 L=0.28U W=0.72U AS=0.1764P AD=0.36P
+ PS=1.26U PD=2.44U
M$2553 \$4753 RA1 VDD VDD pfet_03v3 L=0.28U W=0.72U AS=0.3312P AD=0.3888P
+ PS=2.36U PD=2.52U
M$2554 \$4629 \$4753 \$65 VDD pfet_03v3 L=0.28U W=0.36U AS=0.1584P AD=0.1152P
+ PS=1.6U PD=1U
M$2555 \$66 \$4754 \$4629 VDD pfet_03v3 L=0.28U W=0.36U AS=0.1152P AD=0.1584P
+ PS=1U PD=1.6U
M$2556 VDD RB1 \$4754 VDD pfet_03v3 L=0.28U W=0.72U AS=0.3708P AD=0.3168P
+ PS=2.47U PD=2.32U
M$2557 \$4656 \$130 VDD VDD pfet_03v3 L=0.28U W=0.72U AS=0.3168P AD=0.2097P
+ PS=2.32U PD=1.38U
M$2558 \$4657 \$4832 \$4656 VDD pfet_03v3 L=0.28U W=0.36U AS=0.2097P AD=0.1278P
+ PS=1.38U PD=1.07U
M$2559 \$4920 \$4755 \$4657 VDD pfet_03v3 L=0.28U W=0.36U AS=0.1278P AD=0.0567P
+ PS=1.07U PD=0.675U
M$2560 VDD \$4639 \$4920 VDD pfet_03v3 L=0.28U W=0.36U AS=0.0567P AD=0.1584P
+ PS=0.675U PD=1.6U
M$2561 \$4755 \$4657 VDD VDD pfet_03v3 L=0.28U W=0.36U AS=0.1764P AD=0.1584P
+ PS=1.26U PD=1.6U
M$2562 \$4630 \$4657 VDD VDD pfet_03v3 L=0.28U W=0.72U AS=0.1764P AD=0.36P
+ PS=1.26U PD=2.44U
M$2563 \$4756 RA1 VDD VDD pfet_03v3 L=0.28U W=0.72U AS=0.3312P AD=0.3888P
+ PS=2.36U PD=2.52U
M$2564 \$4630 \$4756 \$67 VDD pfet_03v3 L=0.28U W=0.36U AS=0.1584P AD=0.1152P
+ PS=1.6U PD=1U
M$2565 \$68 \$4757 \$4630 VDD pfet_03v3 L=0.28U W=0.36U AS=0.1152P AD=0.1584P
+ PS=1U PD=1.6U
M$2566 VDD RB1 \$4757 VDD pfet_03v3 L=0.28U W=0.72U AS=0.3708P AD=0.3168P
+ PS=2.47U PD=2.32U
M$2567 \$4658 \$133 VDD VDD pfet_03v3 L=0.28U W=0.72U AS=0.3168P AD=0.2097P
+ PS=2.32U PD=1.38U
M$2568 \$4659 \$4832 \$4658 VDD pfet_03v3 L=0.28U W=0.36U AS=0.2097P AD=0.1278P
+ PS=1.38U PD=1.07U
M$2569 \$4930 \$4758 \$4659 VDD pfet_03v3 L=0.28U W=0.36U AS=0.1278P AD=0.0567P
+ PS=1.07U PD=0.675U
M$2570 VDD \$4639 \$4930 VDD pfet_03v3 L=0.28U W=0.36U AS=0.0567P AD=0.1584P
+ PS=0.675U PD=1.6U
M$2571 \$4758 \$4659 VDD VDD pfet_03v3 L=0.28U W=0.36U AS=0.1764P AD=0.1584P
+ PS=1.26U PD=1.6U
M$2572 \$4631 \$4659 VDD VDD pfet_03v3 L=0.28U W=0.72U AS=0.1764P AD=0.36P
+ PS=1.26U PD=2.44U
M$2573 \$4759 RA1 VDD VDD pfet_03v3 L=0.28U W=0.72U AS=0.3312P AD=0.3888P
+ PS=2.36U PD=2.52U
M$2574 \$4631 \$4759 \$69 VDD pfet_03v3 L=0.28U W=0.36U AS=0.1584P AD=0.1152P
+ PS=1.6U PD=1U
M$2575 \$70 \$4760 \$4631 VDD pfet_03v3 L=0.28U W=0.36U AS=0.1152P AD=0.1584P
+ PS=1U PD=1.6U
M$2576 VDD RB1 \$4760 VDD pfet_03v3 L=0.28U W=0.72U AS=0.3708P AD=0.3168P
+ PS=2.47U PD=2.32U
M$2577 \$4660 \$136 VDD VDD pfet_03v3 L=0.28U W=0.72U AS=0.3168P AD=0.2097P
+ PS=2.32U PD=1.38U
M$2578 \$4661 \$4832 \$4660 VDD pfet_03v3 L=0.28U W=0.36U AS=0.2097P AD=0.1278P
+ PS=1.38U PD=1.07U
M$2579 \$4931 \$4761 \$4661 VDD pfet_03v3 L=0.28U W=0.36U AS=0.1278P AD=0.0567P
+ PS=1.07U PD=0.675U
M$2580 VDD \$4639 \$4931 VDD pfet_03v3 L=0.28U W=0.36U AS=0.0567P AD=0.1584P
+ PS=0.675U PD=1.6U
M$2581 \$4761 \$4661 VDD VDD pfet_03v3 L=0.28U W=0.36U AS=0.1764P AD=0.1584P
+ PS=1.26U PD=1.6U
M$2582 \$4632 \$4661 VDD VDD pfet_03v3 L=0.28U W=0.72U AS=0.1764P AD=0.36P
+ PS=1.26U PD=2.44U
M$2583 \$4762 RA1 VDD VDD pfet_03v3 L=0.28U W=0.72U AS=0.3312P AD=0.3888P
+ PS=2.36U PD=2.52U
M$2584 \$4632 \$4762 \$71 VDD pfet_03v3 L=0.28U W=0.36U AS=0.1584P AD=0.1152P
+ PS=1.6U PD=1U
M$2585 \$72 \$4763 \$4632 VDD pfet_03v3 L=0.28U W=0.36U AS=0.1152P AD=0.1584P
+ PS=1U PD=1.6U
M$2586 VDD RB1 \$4763 VDD pfet_03v3 L=0.28U W=0.72U AS=0.3708P AD=0.3168P
+ PS=2.47U PD=2.32U
M$2587 \$4662 \$139 VDD VDD pfet_03v3 L=0.28U W=0.72U AS=0.3168P AD=0.2097P
+ PS=2.32U PD=1.38U
M$2588 \$4663 \$4832 \$4662 VDD pfet_03v3 L=0.28U W=0.36U AS=0.2097P AD=0.1278P
+ PS=1.38U PD=1.07U
M$2589 \$4912 \$4764 \$4663 VDD pfet_03v3 L=0.28U W=0.36U AS=0.1278P AD=0.0567P
+ PS=1.07U PD=0.675U
M$2590 VDD \$4639 \$4912 VDD pfet_03v3 L=0.28U W=0.36U AS=0.0567P AD=0.1584P
+ PS=0.675U PD=1.6U
M$2591 \$4764 \$4663 VDD VDD pfet_03v3 L=0.28U W=0.36U AS=0.1764P AD=0.1584P
+ PS=1.26U PD=1.6U
M$2592 \$4633 \$4663 VDD VDD pfet_03v3 L=0.28U W=0.72U AS=0.1764P AD=0.36P
+ PS=1.26U PD=2.44U
M$2593 \$4765 RA1 VDD VDD pfet_03v3 L=0.28U W=0.72U AS=0.3312P AD=0.3888P
+ PS=2.36U PD=2.52U
M$2594 \$4633 \$4765 \$73 VDD pfet_03v3 L=0.28U W=0.36U AS=0.1584P AD=0.1152P
+ PS=1.6U PD=1U
M$2595 \$74 \$4766 \$4633 VDD pfet_03v3 L=0.28U W=0.36U AS=0.1152P AD=0.1584P
+ PS=1U PD=1.6U
M$2596 VDD RB1 \$4766 VDD pfet_03v3 L=0.28U W=0.72U AS=0.3708P AD=0.3168P
+ PS=2.47U PD=2.32U
M$2597 \$4664 \$142 VDD VDD pfet_03v3 L=0.28U W=0.72U AS=0.3168P AD=0.2097P
+ PS=2.32U PD=1.38U
M$2598 \$4665 \$4832 \$4664 VDD pfet_03v3 L=0.28U W=0.36U AS=0.2097P AD=0.1278P
+ PS=1.38U PD=1.07U
M$2599 \$4897 \$4767 \$4665 VDD pfet_03v3 L=0.28U W=0.36U AS=0.1278P AD=0.0567P
+ PS=1.07U PD=0.675U
M$2600 VDD \$4639 \$4897 VDD pfet_03v3 L=0.28U W=0.36U AS=0.0567P AD=0.1584P
+ PS=0.675U PD=1.6U
M$2601 \$4767 \$4665 VDD VDD pfet_03v3 L=0.28U W=0.36U AS=0.1764P AD=0.1584P
+ PS=1.26U PD=1.6U
M$2602 \$4634 \$4665 VDD VDD pfet_03v3 L=0.28U W=0.72U AS=0.1764P AD=0.36P
+ PS=1.26U PD=2.44U
M$2603 \$4768 RA1 VDD VDD pfet_03v3 L=0.28U W=0.72U AS=0.3312P AD=0.3888P
+ PS=2.36U PD=2.52U
M$2604 \$4634 \$4768 \$75 VDD pfet_03v3 L=0.28U W=0.36U AS=0.1584P AD=0.1152P
+ PS=1.6U PD=1U
M$2605 \$76 \$4769 \$4634 VDD pfet_03v3 L=0.28U W=0.36U AS=0.1152P AD=0.1584P
+ PS=1U PD=1.6U
M$2606 VDD RB1 \$4769 VDD pfet_03v3 L=0.28U W=0.72U AS=0.3708P AD=0.3168P
+ PS=2.47U PD=2.32U
M$2607 \$4666 \$145 VDD VDD pfet_03v3 L=0.28U W=0.72U AS=0.3168P AD=0.2097P
+ PS=2.32U PD=1.38U
M$2608 \$4667 \$4832 \$4666 VDD pfet_03v3 L=0.28U W=0.36U AS=0.2097P AD=0.1278P
+ PS=1.38U PD=1.07U
M$2609 \$4880 \$4770 \$4667 VDD pfet_03v3 L=0.28U W=0.36U AS=0.1278P AD=0.0567P
+ PS=1.07U PD=0.675U
M$2610 VDD \$4639 \$4880 VDD pfet_03v3 L=0.28U W=0.36U AS=0.0567P AD=0.1584P
+ PS=0.675U PD=1.6U
M$2611 \$4770 \$4667 VDD VDD pfet_03v3 L=0.28U W=0.36U AS=0.1764P AD=0.1584P
+ PS=1.26U PD=1.6U
M$2612 \$4635 \$4667 VDD VDD pfet_03v3 L=0.28U W=0.72U AS=0.1764P AD=0.36P
+ PS=1.26U PD=2.44U
M$2613 \$4771 RA1 VDD VDD pfet_03v3 L=0.28U W=0.72U AS=0.3312P AD=0.3888P
+ PS=2.36U PD=2.52U
M$2614 \$4635 \$4771 \$77 VDD pfet_03v3 L=0.28U W=0.36U AS=0.1584P AD=0.1152P
+ PS=1.6U PD=1U
M$2615 \$78 \$4772 \$4635 VDD pfet_03v3 L=0.28U W=0.36U AS=0.1152P AD=0.1584P
+ PS=1U PD=1.6U
M$2616 VDD RB1 \$4772 VDD pfet_03v3 L=0.28U W=0.72U AS=0.3708P AD=0.3168P
+ PS=2.47U PD=2.32U
M$2617 \$4668 \$148 VDD VDD pfet_03v3 L=0.28U W=0.72U AS=0.3168P AD=0.2097P
+ PS=2.32U PD=1.38U
M$2618 \$4669 \$4832 \$4668 VDD pfet_03v3 L=0.28U W=0.36U AS=0.2097P AD=0.1278P
+ PS=1.38U PD=1.07U
M$2619 \$4861 \$4773 \$4669 VDD pfet_03v3 L=0.28U W=0.36U AS=0.1278P AD=0.0567P
+ PS=1.07U PD=0.675U
M$2620 VDD \$4639 \$4861 VDD pfet_03v3 L=0.28U W=0.36U AS=0.0567P AD=0.1584P
+ PS=0.675U PD=1.6U
M$2621 \$4773 \$4669 VDD VDD pfet_03v3 L=0.28U W=0.36U AS=0.1764P AD=0.1584P
+ PS=1.26U PD=1.6U
M$2622 \$4636 \$4669 VDD VDD pfet_03v3 L=0.28U W=0.72U AS=0.1764P AD=0.36P
+ PS=1.26U PD=2.44U
M$2623 \$4774 RA1 VDD VDD pfet_03v3 L=0.28U W=0.72U AS=0.3312P AD=0.3888P
+ PS=2.36U PD=2.52U
M$2624 \$4636 \$4774 \$79 VDD pfet_03v3 L=0.28U W=0.36U AS=0.1584P AD=0.1152P
+ PS=1.6U PD=1U
M$2625 \$80 \$4775 \$4636 VDD pfet_03v3 L=0.28U W=0.36U AS=0.1152P AD=0.1584P
+ PS=1U PD=1.6U
M$2626 VDD RB1 \$4775 VDD pfet_03v3 L=0.28U W=0.72U AS=0.3708P AD=0.3168P
+ PS=2.47U PD=2.32U
M$2627 \$4670 \$151 VDD VDD pfet_03v3 L=0.28U W=0.72U AS=0.3168P AD=0.2097P
+ PS=2.32U PD=1.38U
M$2628 \$4671 \$4832 \$4670 VDD pfet_03v3 L=0.28U W=0.36U AS=0.2097P AD=0.1278P
+ PS=1.38U PD=1.07U
M$2629 \$4843 \$4776 \$4671 VDD pfet_03v3 L=0.28U W=0.36U AS=0.1278P AD=0.0567P
+ PS=1.07U PD=0.675U
M$2630 VDD \$4639 \$4843 VDD pfet_03v3 L=0.28U W=0.36U AS=0.0567P AD=0.1584P
+ PS=0.675U PD=1.6U
M$2631 \$4776 \$4671 VDD VDD pfet_03v3 L=0.28U W=0.36U AS=0.1764P AD=0.1584P
+ PS=1.26U PD=1.6U
M$2632 \$4637 \$4671 VDD VDD pfet_03v3 L=0.28U W=0.72U AS=0.1764P AD=0.36P
+ PS=1.26U PD=2.44U
M$2633 \$4777 RA1 VDD VDD pfet_03v3 L=0.28U W=0.72U AS=0.3312P AD=0.3888P
+ PS=2.36U PD=2.52U
M$2634 \$4637 \$4777 \$81 VDD pfet_03v3 L=0.28U W=0.36U AS=0.1584P AD=0.1152P
+ PS=1.6U PD=1U
M$2635 \$82 \$4778 \$4637 VDD pfet_03v3 L=0.28U W=0.36U AS=0.1152P AD=0.1584P
+ PS=1U PD=1.6U
M$2636 VDD RB1 \$4778 VDD pfet_03v3 L=0.28U W=0.72U AS=0.3708P AD=0.3168P
+ PS=2.47U PD=2.32U
M$2637 \$4938 WE0 VDD VDD pfet_03v3 L=0.28U W=0.72U AS=0.3168P AD=0.1872P
+ PS=2.32U PD=1.24U
M$2638 VDD CLK \$4938 VDD pfet_03v3 L=0.28U W=0.72U AS=0.1872P AD=0.3168P
+ PS=1.24U PD=2.32U
M$2639 \$4939 \$4938 VDD VDD pfet_03v3 L=0.28U W=2.54U AS=0.889P AD=0.6688P
+ PS=5.21U PD=3.65U
M$2641 \$4940 \$4939 VDD VDD pfet_03v3 L=0.28U W=2.68U AS=0.7272P AD=0.9782P
+ PS=3.78U PD=5.48U
M$2643 \$4942 \$4940 \$4941 VDD pfet_03v3 L=0.28U W=0.36U AS=0.2097P AD=0.1278P
+ PS=1.38U PD=1.07U
M$2644 \$5043 \$4943 \$4942 VDD pfet_03v3 L=0.28U W=0.36U AS=0.1278P AD=0.0567P
+ PS=1.07U PD=0.675U
M$2645 VDD \$4939 \$5043 VDD pfet_03v3 L=0.28U W=0.36U AS=0.0567P AD=0.1584P
+ PS=0.675U PD=1.6U
M$2646 \$4941 \$106 VDD VDD pfet_03v3 L=0.28U W=0.72U AS=0.3168P AD=0.2097P
+ PS=2.32U PD=1.38U
M$2647 VDD \$4942 \$4943 VDD pfet_03v3 L=0.28U W=0.36U AS=0.1584P AD=0.1764P
+ PS=1.6U PD=1.26U
M$2648 \$4944 \$4942 VDD VDD pfet_03v3 L=0.28U W=0.72U AS=0.1764P AD=0.36P
+ PS=1.26U PD=2.44U
M$2649 \$4946 RB0 VDD VDD pfet_03v3 L=0.28U W=0.72U AS=0.3312P AD=0.3888P
+ PS=2.36U PD=2.52U
M$2650 \$4944 \$4946 \$51 VDD pfet_03v3 L=0.28U W=0.36U AS=0.1584P AD=0.1152P
+ PS=1.6U PD=1U
M$2651 \$52 \$4947 \$4944 VDD pfet_03v3 L=0.28U W=0.36U AS=0.1152P AD=0.1584P
+ PS=1U PD=1.6U
M$2652 VDD RA0 \$4947 VDD pfet_03v3 L=0.28U W=0.72U AS=0.3708P AD=0.3168P
+ PS=2.47U PD=2.32U
M$2653 \$4949 \$4940 \$4948 VDD pfet_03v3 L=0.28U W=0.36U AS=0.2097P AD=0.1278P
+ PS=1.38U PD=1.07U
M$2654 \$5052 \$4950 \$4949 VDD pfet_03v3 L=0.28U W=0.36U AS=0.1278P AD=0.0567P
+ PS=1.07U PD=0.675U
M$2655 VDD \$4939 \$5052 VDD pfet_03v3 L=0.28U W=0.36U AS=0.0567P AD=0.1584P
+ PS=0.675U PD=1.6U
M$2656 \$4948 \$109 VDD VDD pfet_03v3 L=0.28U W=0.72U AS=0.3168P AD=0.2097P
+ PS=2.32U PD=1.38U
M$2657 VDD \$4949 \$4950 VDD pfet_03v3 L=0.28U W=0.36U AS=0.1584P AD=0.1764P
+ PS=1.6U PD=1.26U
M$2658 \$4951 \$4949 VDD VDD pfet_03v3 L=0.28U W=0.72U AS=0.1764P AD=0.36P
+ PS=1.26U PD=2.44U
M$2659 \$4952 RB0 VDD VDD pfet_03v3 L=0.28U W=0.72U AS=0.3312P AD=0.3888P
+ PS=2.36U PD=2.52U
M$2660 \$4951 \$4952 \$53 VDD pfet_03v3 L=0.28U W=0.36U AS=0.1584P AD=0.1152P
+ PS=1.6U PD=1U
M$2661 \$54 \$4953 \$4951 VDD pfet_03v3 L=0.28U W=0.36U AS=0.1152P AD=0.1584P
+ PS=1U PD=1.6U
M$2662 VDD RA0 \$4953 VDD pfet_03v3 L=0.28U W=0.72U AS=0.3708P AD=0.3168P
+ PS=2.47U PD=2.32U
M$2663 \$4955 \$4940 \$4954 VDD pfet_03v3 L=0.28U W=0.36U AS=0.2097P AD=0.1278P
+ PS=1.38U PD=1.07U
M$2664 \$5063 \$4956 \$4955 VDD pfet_03v3 L=0.28U W=0.36U AS=0.1278P AD=0.0567P
+ PS=1.07U PD=0.675U
M$2665 VDD \$4939 \$5063 VDD pfet_03v3 L=0.28U W=0.36U AS=0.0567P AD=0.1584P
+ PS=0.675U PD=1.6U
M$2666 \$4954 \$112 VDD VDD pfet_03v3 L=0.28U W=0.72U AS=0.3168P AD=0.2097P
+ PS=2.32U PD=1.38U
M$2667 VDD \$4955 \$4956 VDD pfet_03v3 L=0.28U W=0.36U AS=0.1584P AD=0.1764P
+ PS=1.6U PD=1.26U
M$2668 \$4957 \$4955 VDD VDD pfet_03v3 L=0.28U W=0.72U AS=0.1764P AD=0.36P
+ PS=1.26U PD=2.44U
M$2669 \$4958 RB0 VDD VDD pfet_03v3 L=0.28U W=0.72U AS=0.3312P AD=0.3888P
+ PS=2.36U PD=2.52U
M$2670 \$4957 \$4958 \$55 VDD pfet_03v3 L=0.28U W=0.36U AS=0.1584P AD=0.1152P
+ PS=1.6U PD=1U
M$2671 \$56 \$4959 \$4957 VDD pfet_03v3 L=0.28U W=0.36U AS=0.1152P AD=0.1584P
+ PS=1U PD=1.6U
M$2672 VDD RA0 \$4959 VDD pfet_03v3 L=0.28U W=0.72U AS=0.3708P AD=0.3168P
+ PS=2.47U PD=2.32U
M$2673 \$4961 \$4940 \$4960 VDD pfet_03v3 L=0.28U W=0.36U AS=0.2097P AD=0.1278P
+ PS=1.38U PD=1.07U
M$2674 \$5073 \$4962 \$4961 VDD pfet_03v3 L=0.28U W=0.36U AS=0.1278P AD=0.0567P
+ PS=1.07U PD=0.675U
M$2675 VDD \$4939 \$5073 VDD pfet_03v3 L=0.28U W=0.36U AS=0.0567P AD=0.1584P
+ PS=0.675U PD=1.6U
M$2676 \$4960 \$115 VDD VDD pfet_03v3 L=0.28U W=0.72U AS=0.3168P AD=0.2097P
+ PS=2.32U PD=1.38U
M$2677 VDD \$4961 \$4962 VDD pfet_03v3 L=0.28U W=0.36U AS=0.1584P AD=0.1764P
+ PS=1.6U PD=1.26U
M$2678 \$4963 \$4961 VDD VDD pfet_03v3 L=0.28U W=0.72U AS=0.1764P AD=0.36P
+ PS=1.26U PD=2.44U
M$2679 \$4964 RB0 VDD VDD pfet_03v3 L=0.28U W=0.72U AS=0.3312P AD=0.3888P
+ PS=2.36U PD=2.52U
M$2680 \$4963 \$4964 \$57 VDD pfet_03v3 L=0.28U W=0.36U AS=0.1584P AD=0.1152P
+ PS=1.6U PD=1U
M$2681 \$58 \$4965 \$4963 VDD pfet_03v3 L=0.28U W=0.36U AS=0.1152P AD=0.1584P
+ PS=1U PD=1.6U
M$2682 VDD RA0 \$4965 VDD pfet_03v3 L=0.28U W=0.72U AS=0.3708P AD=0.3168P
+ PS=2.47U PD=2.32U
M$2683 \$4967 \$4940 \$4966 VDD pfet_03v3 L=0.28U W=0.36U AS=0.2097P AD=0.1278P
+ PS=1.38U PD=1.07U
M$2684 \$5084 \$4968 \$4967 VDD pfet_03v3 L=0.28U W=0.36U AS=0.1278P AD=0.0567P
+ PS=1.07U PD=0.675U
M$2685 VDD \$4939 \$5084 VDD pfet_03v3 L=0.28U W=0.36U AS=0.0567P AD=0.1584P
+ PS=0.675U PD=1.6U
M$2686 \$4966 \$118 VDD VDD pfet_03v3 L=0.28U W=0.72U AS=0.3168P AD=0.2097P
+ PS=2.32U PD=1.38U
M$2687 VDD \$4967 \$4968 VDD pfet_03v3 L=0.28U W=0.36U AS=0.1584P AD=0.1764P
+ PS=1.6U PD=1.26U
M$2688 \$4969 \$4967 VDD VDD pfet_03v3 L=0.28U W=0.72U AS=0.1764P AD=0.36P
+ PS=1.26U PD=2.44U
M$2689 \$4970 RB0 VDD VDD pfet_03v3 L=0.28U W=0.72U AS=0.3312P AD=0.3888P
+ PS=2.36U PD=2.52U
M$2690 \$4969 \$4970 \$59 VDD pfet_03v3 L=0.28U W=0.36U AS=0.1584P AD=0.1152P
+ PS=1.6U PD=1U
M$2691 \$60 \$4971 \$4969 VDD pfet_03v3 L=0.28U W=0.36U AS=0.1152P AD=0.1584P
+ PS=1U PD=1.6U
M$2692 VDD RA0 \$4971 VDD pfet_03v3 L=0.28U W=0.72U AS=0.3708P AD=0.3168P
+ PS=2.47U PD=2.32U
M$2693 \$4973 \$4940 \$4972 VDD pfet_03v3 L=0.28U W=0.36U AS=0.2097P AD=0.1278P
+ PS=1.38U PD=1.07U
M$2694 \$5093 \$4974 \$4973 VDD pfet_03v3 L=0.28U W=0.36U AS=0.1278P AD=0.0567P
+ PS=1.07U PD=0.675U
M$2695 VDD \$4939 \$5093 VDD pfet_03v3 L=0.28U W=0.36U AS=0.0567P AD=0.1584P
+ PS=0.675U PD=1.6U
M$2696 \$4972 \$121 VDD VDD pfet_03v3 L=0.28U W=0.72U AS=0.3168P AD=0.2097P
+ PS=2.32U PD=1.38U
M$2697 VDD \$4973 \$4974 VDD pfet_03v3 L=0.28U W=0.36U AS=0.1584P AD=0.1764P
+ PS=1.6U PD=1.26U
M$2698 \$4975 \$4973 VDD VDD pfet_03v3 L=0.28U W=0.72U AS=0.1764P AD=0.36P
+ PS=1.26U PD=2.44U
M$2699 \$4976 RB0 VDD VDD pfet_03v3 L=0.28U W=0.72U AS=0.3312P AD=0.3888P
+ PS=2.36U PD=2.52U
M$2700 \$4975 \$4976 \$61 VDD pfet_03v3 L=0.28U W=0.36U AS=0.1584P AD=0.1152P
+ PS=1.6U PD=1U
M$2701 \$62 \$4977 \$4975 VDD pfet_03v3 L=0.28U W=0.36U AS=0.1152P AD=0.1584P
+ PS=1U PD=1.6U
M$2702 VDD RA0 \$4977 VDD pfet_03v3 L=0.28U W=0.72U AS=0.3708P AD=0.3168P
+ PS=2.47U PD=2.32U
M$2703 \$4979 \$4940 \$4978 VDD pfet_03v3 L=0.28U W=0.36U AS=0.2097P AD=0.1278P
+ PS=1.38U PD=1.07U
M$2704 \$5103 \$4980 \$4979 VDD pfet_03v3 L=0.28U W=0.36U AS=0.1278P AD=0.0567P
+ PS=1.07U PD=0.675U
M$2705 VDD \$4939 \$5103 VDD pfet_03v3 L=0.28U W=0.36U AS=0.0567P AD=0.1584P
+ PS=0.675U PD=1.6U
M$2706 \$4978 \$124 VDD VDD pfet_03v3 L=0.28U W=0.72U AS=0.3168P AD=0.2097P
+ PS=2.32U PD=1.38U
M$2707 VDD \$4979 \$4980 VDD pfet_03v3 L=0.28U W=0.36U AS=0.1584P AD=0.1764P
+ PS=1.6U PD=1.26U
M$2708 \$4981 \$4979 VDD VDD pfet_03v3 L=0.28U W=0.72U AS=0.1764P AD=0.36P
+ PS=1.26U PD=2.44U
M$2709 \$4982 RB0 VDD VDD pfet_03v3 L=0.28U W=0.72U AS=0.3312P AD=0.3888P
+ PS=2.36U PD=2.52U
M$2710 \$4981 \$4982 \$63 VDD pfet_03v3 L=0.28U W=0.36U AS=0.1584P AD=0.1152P
+ PS=1.6U PD=1U
M$2711 \$64 \$4983 \$4981 VDD pfet_03v3 L=0.28U W=0.36U AS=0.1152P AD=0.1584P
+ PS=1U PD=1.6U
M$2712 VDD RA0 \$4983 VDD pfet_03v3 L=0.28U W=0.72U AS=0.3708P AD=0.3168P
+ PS=2.47U PD=2.32U
M$2713 \$4985 \$4940 \$4984 VDD pfet_03v3 L=0.28U W=0.36U AS=0.2097P AD=0.1278P
+ PS=1.38U PD=1.07U
M$2714 \$5113 \$4986 \$4985 VDD pfet_03v3 L=0.28U W=0.36U AS=0.1278P AD=0.0567P
+ PS=1.07U PD=0.675U
M$2715 VDD \$4939 \$5113 VDD pfet_03v3 L=0.28U W=0.36U AS=0.0567P AD=0.1584P
+ PS=0.675U PD=1.6U
M$2716 \$4984 \$127 VDD VDD pfet_03v3 L=0.28U W=0.72U AS=0.3168P AD=0.2097P
+ PS=2.32U PD=1.38U
M$2717 VDD \$4985 \$4986 VDD pfet_03v3 L=0.28U W=0.36U AS=0.1584P AD=0.1764P
+ PS=1.6U PD=1.26U
M$2718 \$4987 \$4985 VDD VDD pfet_03v3 L=0.28U W=0.72U AS=0.1764P AD=0.36P
+ PS=1.26U PD=2.44U
M$2719 \$4988 RB0 VDD VDD pfet_03v3 L=0.28U W=0.72U AS=0.3312P AD=0.3888P
+ PS=2.36U PD=2.52U
M$2720 \$4987 \$4988 \$65 VDD pfet_03v3 L=0.28U W=0.36U AS=0.1584P AD=0.1152P
+ PS=1.6U PD=1U
M$2721 \$66 \$4989 \$4987 VDD pfet_03v3 L=0.28U W=0.36U AS=0.1152P AD=0.1584P
+ PS=1U PD=1.6U
M$2722 VDD RA0 \$4989 VDD pfet_03v3 L=0.28U W=0.72U AS=0.3708P AD=0.3168P
+ PS=2.47U PD=2.32U
M$2723 \$4991 \$4940 \$4990 VDD pfet_03v3 L=0.28U W=0.36U AS=0.2097P AD=0.1278P
+ PS=1.38U PD=1.07U
M$2724 \$5123 \$4992 \$4991 VDD pfet_03v3 L=0.28U W=0.36U AS=0.1278P AD=0.0567P
+ PS=1.07U PD=0.675U
M$2725 VDD \$4939 \$5123 VDD pfet_03v3 L=0.28U W=0.36U AS=0.0567P AD=0.1584P
+ PS=0.675U PD=1.6U
M$2726 \$4990 \$130 VDD VDD pfet_03v3 L=0.28U W=0.72U AS=0.3168P AD=0.2097P
+ PS=2.32U PD=1.38U
M$2727 VDD \$4991 \$4992 VDD pfet_03v3 L=0.28U W=0.36U AS=0.1584P AD=0.1764P
+ PS=1.6U PD=1.26U
M$2728 \$4993 \$4991 VDD VDD pfet_03v3 L=0.28U W=0.72U AS=0.1764P AD=0.36P
+ PS=1.26U PD=2.44U
M$2729 \$4994 RB0 VDD VDD pfet_03v3 L=0.28U W=0.72U AS=0.3312P AD=0.3888P
+ PS=2.36U PD=2.52U
M$2730 \$4993 \$4994 \$67 VDD pfet_03v3 L=0.28U W=0.36U AS=0.1584P AD=0.1152P
+ PS=1.6U PD=1U
M$2731 \$68 \$4995 \$4993 VDD pfet_03v3 L=0.28U W=0.36U AS=0.1152P AD=0.1584P
+ PS=1U PD=1.6U
M$2732 VDD RA0 \$4995 VDD pfet_03v3 L=0.28U W=0.72U AS=0.3708P AD=0.3168P
+ PS=2.47U PD=2.32U
M$2733 \$4997 \$4940 \$4996 VDD pfet_03v3 L=0.28U W=0.36U AS=0.2097P AD=0.1278P
+ PS=1.38U PD=1.07U
M$2734 \$5133 \$4998 \$4997 VDD pfet_03v3 L=0.28U W=0.36U AS=0.1278P AD=0.0567P
+ PS=1.07U PD=0.675U
M$2735 VDD \$4939 \$5133 VDD pfet_03v3 L=0.28U W=0.36U AS=0.0567P AD=0.1584P
+ PS=0.675U PD=1.6U
M$2736 \$4996 \$133 VDD VDD pfet_03v3 L=0.28U W=0.72U AS=0.3168P AD=0.2097P
+ PS=2.32U PD=1.38U
M$2737 VDD \$4997 \$4998 VDD pfet_03v3 L=0.28U W=0.36U AS=0.1584P AD=0.1764P
+ PS=1.6U PD=1.26U
M$2738 \$4999 \$4997 VDD VDD pfet_03v3 L=0.28U W=0.72U AS=0.1764P AD=0.36P
+ PS=1.26U PD=2.44U
M$2739 \$5000 RB0 VDD VDD pfet_03v3 L=0.28U W=0.72U AS=0.3312P AD=0.3888P
+ PS=2.36U PD=2.52U
M$2740 \$4999 \$5000 \$69 VDD pfet_03v3 L=0.28U W=0.36U AS=0.1584P AD=0.1152P
+ PS=1.6U PD=1U
M$2741 \$70 \$5001 \$4999 VDD pfet_03v3 L=0.28U W=0.36U AS=0.1152P AD=0.1584P
+ PS=1U PD=1.6U
M$2742 VDD RA0 \$5001 VDD pfet_03v3 L=0.28U W=0.72U AS=0.3708P AD=0.3168P
+ PS=2.47U PD=2.32U
M$2743 \$5003 \$4940 \$5002 VDD pfet_03v3 L=0.28U W=0.36U AS=0.2097P AD=0.1278P
+ PS=1.38U PD=1.07U
M$2744 \$5119 \$5004 \$5003 VDD pfet_03v3 L=0.28U W=0.36U AS=0.1278P AD=0.0567P
+ PS=1.07U PD=0.675U
M$2745 VDD \$4939 \$5119 VDD pfet_03v3 L=0.28U W=0.36U AS=0.0567P AD=0.1584P
+ PS=0.675U PD=1.6U
M$2746 \$5002 \$136 VDD VDD pfet_03v3 L=0.28U W=0.72U AS=0.3168P AD=0.2097P
+ PS=2.32U PD=1.38U
M$2747 VDD \$5003 \$5004 VDD pfet_03v3 L=0.28U W=0.36U AS=0.1584P AD=0.1764P
+ PS=1.6U PD=1.26U
M$2748 \$5005 \$5003 VDD VDD pfet_03v3 L=0.28U W=0.72U AS=0.1764P AD=0.36P
+ PS=1.26U PD=2.44U
M$2749 \$5006 RB0 VDD VDD pfet_03v3 L=0.28U W=0.72U AS=0.3312P AD=0.3888P
+ PS=2.36U PD=2.52U
M$2750 \$5005 \$5006 \$71 VDD pfet_03v3 L=0.28U W=0.36U AS=0.1584P AD=0.1152P
+ PS=1.6U PD=1U
M$2751 \$72 \$5007 \$5005 VDD pfet_03v3 L=0.28U W=0.36U AS=0.1152P AD=0.1584P
+ PS=1U PD=1.6U
M$2752 VDD RA0 \$5007 VDD pfet_03v3 L=0.28U W=0.72U AS=0.3708P AD=0.3168P
+ PS=2.47U PD=2.32U
M$2753 \$5009 \$4940 \$5008 VDD pfet_03v3 L=0.28U W=0.36U AS=0.2097P AD=0.1278P
+ PS=1.38U PD=1.07U
M$2754 \$5105 \$5010 \$5009 VDD pfet_03v3 L=0.28U W=0.36U AS=0.1278P AD=0.0567P
+ PS=1.07U PD=0.675U
M$2755 VDD \$4939 \$5105 VDD pfet_03v3 L=0.28U W=0.36U AS=0.0567P AD=0.1584P
+ PS=0.675U PD=1.6U
M$2756 \$5008 \$139 VDD VDD pfet_03v3 L=0.28U W=0.72U AS=0.3168P AD=0.2097P
+ PS=2.32U PD=1.38U
M$2757 VDD \$5009 \$5010 VDD pfet_03v3 L=0.28U W=0.36U AS=0.1584P AD=0.1764P
+ PS=1.6U PD=1.26U
M$2758 \$5011 \$5009 VDD VDD pfet_03v3 L=0.28U W=0.72U AS=0.1764P AD=0.36P
+ PS=1.26U PD=2.44U
M$2759 \$5012 RB0 VDD VDD pfet_03v3 L=0.28U W=0.72U AS=0.3312P AD=0.3888P
+ PS=2.36U PD=2.52U
M$2760 \$5011 \$5012 \$73 VDD pfet_03v3 L=0.28U W=0.36U AS=0.1584P AD=0.1152P
+ PS=1.6U PD=1U
M$2761 \$74 \$5013 \$5011 VDD pfet_03v3 L=0.28U W=0.36U AS=0.1152P AD=0.1584P
+ PS=1U PD=1.6U
M$2762 VDD RA0 \$5013 VDD pfet_03v3 L=0.28U W=0.72U AS=0.3708P AD=0.3168P
+ PS=2.47U PD=2.32U
M$2763 \$5015 \$4940 \$5014 VDD pfet_03v3 L=0.28U W=0.36U AS=0.2097P AD=0.1278P
+ PS=1.38U PD=1.07U
M$2764 \$5089 \$5016 \$5015 VDD pfet_03v3 L=0.28U W=0.36U AS=0.1278P AD=0.0567P
+ PS=1.07U PD=0.675U
M$2765 VDD \$4939 \$5089 VDD pfet_03v3 L=0.28U W=0.36U AS=0.0567P AD=0.1584P
+ PS=0.675U PD=1.6U
M$2766 \$5014 \$142 VDD VDD pfet_03v3 L=0.28U W=0.72U AS=0.3168P AD=0.2097P
+ PS=2.32U PD=1.38U
M$2767 VDD \$5015 \$5016 VDD pfet_03v3 L=0.28U W=0.36U AS=0.1584P AD=0.1764P
+ PS=1.6U PD=1.26U
M$2768 \$5017 \$5015 VDD VDD pfet_03v3 L=0.28U W=0.72U AS=0.1764P AD=0.36P
+ PS=1.26U PD=2.44U
M$2769 \$5018 RB0 VDD VDD pfet_03v3 L=0.28U W=0.72U AS=0.3312P AD=0.3888P
+ PS=2.36U PD=2.52U
M$2770 \$5017 \$5018 \$75 VDD pfet_03v3 L=0.28U W=0.36U AS=0.1584P AD=0.1152P
+ PS=1.6U PD=1U
M$2771 \$76 \$5019 \$5017 VDD pfet_03v3 L=0.28U W=0.36U AS=0.1152P AD=0.1584P
+ PS=1U PD=1.6U
M$2772 VDD RA0 \$5019 VDD pfet_03v3 L=0.28U W=0.72U AS=0.3708P AD=0.3168P
+ PS=2.47U PD=2.32U
M$2773 \$5021 \$4940 \$5020 VDD pfet_03v3 L=0.28U W=0.36U AS=0.2097P AD=0.1278P
+ PS=1.38U PD=1.07U
M$2774 \$5078 \$5022 \$5021 VDD pfet_03v3 L=0.28U W=0.36U AS=0.1278P AD=0.0567P
+ PS=1.07U PD=0.675U
M$2775 VDD \$4939 \$5078 VDD pfet_03v3 L=0.28U W=0.36U AS=0.0567P AD=0.1584P
+ PS=0.675U PD=1.6U
M$2776 \$5020 \$145 VDD VDD pfet_03v3 L=0.28U W=0.72U AS=0.3168P AD=0.2097P
+ PS=2.32U PD=1.38U
M$2777 VDD \$5021 \$5022 VDD pfet_03v3 L=0.28U W=0.36U AS=0.1584P AD=0.1764P
+ PS=1.6U PD=1.26U
M$2778 \$5023 \$5021 VDD VDD pfet_03v3 L=0.28U W=0.72U AS=0.1764P AD=0.36P
+ PS=1.26U PD=2.44U
M$2779 \$5024 RB0 VDD VDD pfet_03v3 L=0.28U W=0.72U AS=0.3312P AD=0.3888P
+ PS=2.36U PD=2.52U
M$2780 \$5023 \$5024 \$77 VDD pfet_03v3 L=0.28U W=0.36U AS=0.1584P AD=0.1152P
+ PS=1.6U PD=1U
M$2781 \$78 \$5025 \$5023 VDD pfet_03v3 L=0.28U W=0.36U AS=0.1152P AD=0.1584P
+ PS=1U PD=1.6U
M$2782 VDD RA0 \$5025 VDD pfet_03v3 L=0.28U W=0.72U AS=0.3708P AD=0.3168P
+ PS=2.47U PD=2.32U
M$2783 \$5027 \$4940 \$5026 VDD pfet_03v3 L=0.28U W=0.36U AS=0.2097P AD=0.1278P
+ PS=1.38U PD=1.07U
M$2784 \$5062 \$5028 \$5027 VDD pfet_03v3 L=0.28U W=0.36U AS=0.1278P AD=0.0567P
+ PS=1.07U PD=0.675U
M$2785 VDD \$4939 \$5062 VDD pfet_03v3 L=0.28U W=0.36U AS=0.0567P AD=0.1584P
+ PS=0.675U PD=1.6U
M$2786 \$5026 \$148 VDD VDD pfet_03v3 L=0.28U W=0.72U AS=0.3168P AD=0.2097P
+ PS=2.32U PD=1.38U
M$2787 VDD \$5027 \$5028 VDD pfet_03v3 L=0.28U W=0.36U AS=0.1584P AD=0.1764P
+ PS=1.6U PD=1.26U
M$2788 \$5029 \$5027 VDD VDD pfet_03v3 L=0.28U W=0.72U AS=0.1764P AD=0.36P
+ PS=1.26U PD=2.44U
M$2789 \$5030 RB0 VDD VDD pfet_03v3 L=0.28U W=0.72U AS=0.3312P AD=0.3888P
+ PS=2.36U PD=2.52U
M$2790 \$5029 \$5030 \$79 VDD pfet_03v3 L=0.28U W=0.36U AS=0.1584P AD=0.1152P
+ PS=1.6U PD=1U
M$2791 \$80 \$5031 \$5029 VDD pfet_03v3 L=0.28U W=0.36U AS=0.1152P AD=0.1584P
+ PS=1U PD=1.6U
M$2792 VDD RA0 \$5031 VDD pfet_03v3 L=0.28U W=0.72U AS=0.3708P AD=0.3168P
+ PS=2.47U PD=2.32U
M$2793 \$5033 \$4940 \$5032 VDD pfet_03v3 L=0.28U W=0.36U AS=0.2097P AD=0.1278P
+ PS=1.38U PD=1.07U
M$2794 \$5048 \$5034 \$5033 VDD pfet_03v3 L=0.28U W=0.36U AS=0.1278P AD=0.0567P
+ PS=1.07U PD=0.675U
M$2795 VDD \$4939 \$5048 VDD pfet_03v3 L=0.28U W=0.36U AS=0.0567P AD=0.1584P
+ PS=0.675U PD=1.6U
M$2796 \$5032 \$151 VDD VDD pfet_03v3 L=0.28U W=0.72U AS=0.3168P AD=0.2097P
+ PS=2.32U PD=1.38U
M$2797 VDD \$5033 \$5034 VDD pfet_03v3 L=0.28U W=0.36U AS=0.1584P AD=0.1764P
+ PS=1.6U PD=1.26U
M$2798 \$5035 \$5033 VDD VDD pfet_03v3 L=0.28U W=0.72U AS=0.1764P AD=0.36P
+ PS=1.26U PD=2.44U
M$2799 \$5036 RB0 VDD VDD pfet_03v3 L=0.28U W=0.72U AS=0.3312P AD=0.3888P
+ PS=2.36U PD=2.52U
M$2800 \$5035 \$5036 \$81 VDD pfet_03v3 L=0.28U W=0.36U AS=0.1584P AD=0.1152P
+ PS=1.6U PD=1U
M$2801 \$82 \$5037 \$5035 VDD pfet_03v3 L=0.28U W=0.36U AS=0.1152P AD=0.1584P
+ PS=1U PD=1.6U
M$2802 VDD RA0 \$5037 VDD pfet_03v3 L=0.28U W=0.72U AS=0.3708P AD=0.3168P
+ PS=2.47U PD=2.32U
M$2803 VSS \$51 QA0 VSS nfet_03v3 L=0.28U W=0.36U AS=0.2052P AD=0.1242P
+ PS=1.86U PD=1.05U
M$2804 QB0 \$52 VSS VSS nfet_03v3 L=0.28U W=0.36U AS=0.1242P AD=0.2052P
+ PS=1.05U PD=1.86U
M$2805 VSS \$53 QA1 VSS nfet_03v3 L=0.28U W=0.36U AS=0.2052P AD=0.1242P
+ PS=1.86U PD=1.05U
M$2806 QB1 \$54 VSS VSS nfet_03v3 L=0.28U W=0.36U AS=0.1242P AD=0.2052P
+ PS=1.05U PD=1.86U
M$2807 VSS \$55 QA2 VSS nfet_03v3 L=0.28U W=0.36U AS=0.2052P AD=0.1242P
+ PS=1.86U PD=1.05U
M$2808 QB2 \$56 VSS VSS nfet_03v3 L=0.28U W=0.36U AS=0.1242P AD=0.2052P
+ PS=1.05U PD=1.86U
M$2809 VSS \$57 QA3 VSS nfet_03v3 L=0.28U W=0.36U AS=0.2052P AD=0.1242P
+ PS=1.86U PD=1.05U
M$2810 QB3 \$58 VSS VSS nfet_03v3 L=0.28U W=0.36U AS=0.1242P AD=0.2052P
+ PS=1.05U PD=1.86U
M$2811 VSS \$59 QA4 VSS nfet_03v3 L=0.28U W=0.36U AS=0.2052P AD=0.1242P
+ PS=1.86U PD=1.05U
M$2812 QB4 \$60 VSS VSS nfet_03v3 L=0.28U W=0.36U AS=0.1242P AD=0.2052P
+ PS=1.05U PD=1.86U
M$2813 VSS \$61 QA5 VSS nfet_03v3 L=0.28U W=0.36U AS=0.2052P AD=0.1242P
+ PS=1.86U PD=1.05U
M$2814 QB5 \$62 VSS VSS nfet_03v3 L=0.28U W=0.36U AS=0.1242P AD=0.2052P
+ PS=1.05U PD=1.86U
M$2815 VSS \$63 QA6 VSS nfet_03v3 L=0.28U W=0.36U AS=0.2052P AD=0.1242P
+ PS=1.86U PD=1.05U
M$2816 QB6 \$64 VSS VSS nfet_03v3 L=0.28U W=0.36U AS=0.1242P AD=0.2052P
+ PS=1.05U PD=1.86U
M$2817 VSS \$65 QA7 VSS nfet_03v3 L=0.28U W=0.36U AS=0.2052P AD=0.1242P
+ PS=1.86U PD=1.05U
M$2818 QB7 \$66 VSS VSS nfet_03v3 L=0.28U W=0.36U AS=0.1242P AD=0.2052P
+ PS=1.05U PD=1.86U
M$2819 VSS \$67 QA8 VSS nfet_03v3 L=0.28U W=0.36U AS=0.2052P AD=0.1242P
+ PS=1.86U PD=1.05U
M$2820 QB8 \$68 VSS VSS nfet_03v3 L=0.28U W=0.36U AS=0.1242P AD=0.2052P
+ PS=1.05U PD=1.86U
M$2821 VSS \$69 QA9 VSS nfet_03v3 L=0.28U W=0.36U AS=0.2052P AD=0.1242P
+ PS=1.86U PD=1.05U
M$2822 QB9 \$70 VSS VSS nfet_03v3 L=0.28U W=0.36U AS=0.1242P AD=0.2052P
+ PS=1.05U PD=1.86U
M$2823 VSS \$71 QA10 VSS nfet_03v3 L=0.28U W=0.36U AS=0.2052P AD=0.1242P
+ PS=1.86U PD=1.05U
M$2824 QB10 \$72 VSS VSS nfet_03v3 L=0.28U W=0.36U AS=0.1242P AD=0.2052P
+ PS=1.05U PD=1.86U
M$2825 VSS \$73 QA11 VSS nfet_03v3 L=0.28U W=0.36U AS=0.2052P AD=0.1242P
+ PS=1.86U PD=1.05U
M$2826 QB11 \$74 VSS VSS nfet_03v3 L=0.28U W=0.36U AS=0.1242P AD=0.2052P
+ PS=1.05U PD=1.86U
M$2827 VSS \$75 QA12 VSS nfet_03v3 L=0.28U W=0.36U AS=0.2052P AD=0.1242P
+ PS=1.86U PD=1.05U
M$2828 QB12 \$76 VSS VSS nfet_03v3 L=0.28U W=0.36U AS=0.1242P AD=0.2052P
+ PS=1.05U PD=1.86U
M$2829 VSS \$77 QA13 VSS nfet_03v3 L=0.28U W=0.36U AS=0.2052P AD=0.1242P
+ PS=1.86U PD=1.05U
M$2830 QB13 \$78 VSS VSS nfet_03v3 L=0.28U W=0.36U AS=0.1242P AD=0.2052P
+ PS=1.05U PD=1.86U
M$2831 VSS \$79 QA14 VSS nfet_03v3 L=0.28U W=0.36U AS=0.2052P AD=0.1242P
+ PS=1.86U PD=1.05U
M$2832 QB14 \$80 VSS VSS nfet_03v3 L=0.28U W=0.36U AS=0.1242P AD=0.2052P
+ PS=1.05U PD=1.86U
M$2833 VSS \$81 QA15 VSS nfet_03v3 L=0.28U W=0.36U AS=0.2052P AD=0.1242P
+ PS=1.86U PD=1.05U
M$2834 QB15 \$82 VSS VSS nfet_03v3 L=0.28U W=0.36U AS=0.1242P AD=0.2052P
+ PS=1.05U PD=1.86U
M$2835 \$105 WEM VSS VSS nfet_03v3 L=0.28U W=1.26U AS=0.4599P AD=0.4599P
+ PS=3.35U PD=3.35U
M$2837 \$106 \$219 VSS VSS nfet_03v3 L=0.28U W=1.24U AS=0.434P AD=0.434P
+ PS=3.26U PD=3.26U
M$2839 \$109 \$221 VSS VSS nfet_03v3 L=0.28U W=1.24U AS=0.434P AD=0.434P
+ PS=3.26U PD=3.26U
M$2841 \$112 \$223 VSS VSS nfet_03v3 L=0.28U W=1.24U AS=0.434P AD=0.434P
+ PS=3.26U PD=3.26U
M$2843 \$115 \$225 VSS VSS nfet_03v3 L=0.28U W=1.24U AS=0.434P AD=0.434P
+ PS=3.26U PD=3.26U
M$2845 \$118 \$227 VSS VSS nfet_03v3 L=0.28U W=1.24U AS=0.434P AD=0.434P
+ PS=3.26U PD=3.26U
M$2847 \$121 \$229 VSS VSS nfet_03v3 L=0.28U W=1.24U AS=0.434P AD=0.434P
+ PS=3.26U PD=3.26U
M$2849 \$124 \$231 VSS VSS nfet_03v3 L=0.28U W=1.24U AS=0.434P AD=0.434P
+ PS=3.26U PD=3.26U
M$2851 \$127 \$233 VSS VSS nfet_03v3 L=0.28U W=1.24U AS=0.434P AD=0.434P
+ PS=3.26U PD=3.26U
M$2853 \$130 \$235 VSS VSS nfet_03v3 L=0.28U W=1.24U AS=0.434P AD=0.434P
+ PS=3.26U PD=3.26U
M$2855 \$133 \$237 VSS VSS nfet_03v3 L=0.28U W=1.24U AS=0.434P AD=0.434P
+ PS=3.26U PD=3.26U
M$2857 \$136 \$239 VSS VSS nfet_03v3 L=0.28U W=1.24U AS=0.434P AD=0.434P
+ PS=3.26U PD=3.26U
M$2859 \$139 \$241 VSS VSS nfet_03v3 L=0.28U W=1.24U AS=0.434P AD=0.434P
+ PS=3.26U PD=3.26U
M$2861 \$142 \$243 VSS VSS nfet_03v3 L=0.28U W=1.24U AS=0.434P AD=0.434P
+ PS=3.26U PD=3.26U
M$2863 \$145 \$245 VSS VSS nfet_03v3 L=0.28U W=1.24U AS=0.434P AD=0.434P
+ PS=3.26U PD=3.26U
M$2865 \$148 \$247 VSS VSS nfet_03v3 L=0.28U W=1.24U AS=0.434P AD=0.434P
+ PS=3.26U PD=3.26U
M$2867 \$151 \$249 VSS VSS nfet_03v3 L=0.28U W=1.24U AS=0.434P AD=0.434P
+ PS=3.26U PD=3.26U
M$2869 \$107 \$219 VSS VSS nfet_03v3 L=0.28U W=0.36U AS=0.1584P AD=0.1584P
+ PS=1.6U PD=1.6U
M$2870 \$311 \$105 VSS VSS nfet_03v3 L=0.28U W=0.36U AS=0.1584P AD=0.0567P
+ PS=1.6U PD=0.675U
M$2871 \$219 \$107 \$311 VSS nfet_03v3 L=0.28U W=0.36U AS=0.0567P AD=0.1278P
+ PS=0.675U PD=1.07U
M$2872 \$108 WEM \$219 VSS nfet_03v3 L=0.28U W=0.36U AS=0.1278P AD=0.1188P
+ PS=1.07U PD=1.02U
M$2873 VSS D0 \$108 VSS nfet_03v3 L=0.28U W=0.36U AS=0.1188P AD=0.1584P
+ PS=1.02U PD=1.6U
M$2874 \$110 \$221 VSS VSS nfet_03v3 L=0.28U W=0.36U AS=0.1584P AD=0.1584P
+ PS=1.6U PD=1.6U
M$2875 \$322 \$105 VSS VSS nfet_03v3 L=0.28U W=0.36U AS=0.1584P AD=0.0567P
+ PS=1.6U PD=0.675U
M$2876 \$221 \$110 \$322 VSS nfet_03v3 L=0.28U W=0.36U AS=0.0567P AD=0.1278P
+ PS=0.675U PD=1.07U
M$2877 \$111 WEM \$221 VSS nfet_03v3 L=0.28U W=0.36U AS=0.1278P AD=0.1188P
+ PS=1.07U PD=1.02U
M$2878 VSS D1 \$111 VSS nfet_03v3 L=0.28U W=0.36U AS=0.1188P AD=0.1584P
+ PS=1.02U PD=1.6U
M$2879 \$113 \$223 VSS VSS nfet_03v3 L=0.28U W=0.36U AS=0.1584P AD=0.1584P
+ PS=1.6U PD=1.6U
M$2880 \$331 \$105 VSS VSS nfet_03v3 L=0.28U W=0.36U AS=0.1584P AD=0.0567P
+ PS=1.6U PD=0.675U
M$2881 \$223 \$113 \$331 VSS nfet_03v3 L=0.28U W=0.36U AS=0.0567P AD=0.1278P
+ PS=0.675U PD=1.07U
M$2882 \$114 WEM \$223 VSS nfet_03v3 L=0.28U W=0.36U AS=0.1278P AD=0.1188P
+ PS=1.07U PD=1.02U
M$2883 VSS D2 \$114 VSS nfet_03v3 L=0.28U W=0.36U AS=0.1188P AD=0.1584P
+ PS=1.02U PD=1.6U
M$2884 \$116 \$225 VSS VSS nfet_03v3 L=0.28U W=0.36U AS=0.1584P AD=0.1584P
+ PS=1.6U PD=1.6U
M$2885 \$342 \$105 VSS VSS nfet_03v3 L=0.28U W=0.36U AS=0.1584P AD=0.0567P
+ PS=1.6U PD=0.675U
M$2886 \$225 \$116 \$342 VSS nfet_03v3 L=0.28U W=0.36U AS=0.0567P AD=0.1278P
+ PS=0.675U PD=1.07U
M$2887 \$117 WEM \$225 VSS nfet_03v3 L=0.28U W=0.36U AS=0.1278P AD=0.1188P
+ PS=1.07U PD=1.02U
M$2888 VSS D3 \$117 VSS nfet_03v3 L=0.28U W=0.36U AS=0.1188P AD=0.1584P
+ PS=1.02U PD=1.6U
M$2889 \$119 \$227 VSS VSS nfet_03v3 L=0.28U W=0.36U AS=0.1584P AD=0.1584P
+ PS=1.6U PD=1.6U
M$2890 \$350 \$105 VSS VSS nfet_03v3 L=0.28U W=0.36U AS=0.1584P AD=0.0567P
+ PS=1.6U PD=0.675U
M$2891 \$227 \$119 \$350 VSS nfet_03v3 L=0.28U W=0.36U AS=0.0567P AD=0.1278P
+ PS=0.675U PD=1.07U
M$2892 \$120 WEM \$227 VSS nfet_03v3 L=0.28U W=0.36U AS=0.1278P AD=0.1188P
+ PS=1.07U PD=1.02U
M$2893 VSS D4 \$120 VSS nfet_03v3 L=0.28U W=0.36U AS=0.1188P AD=0.1584P
+ PS=1.02U PD=1.6U
M$2894 \$122 \$229 VSS VSS nfet_03v3 L=0.28U W=0.36U AS=0.1584P AD=0.1584P
+ PS=1.6U PD=1.6U
M$2895 \$359 \$105 VSS VSS nfet_03v3 L=0.28U W=0.36U AS=0.1584P AD=0.0567P
+ PS=1.6U PD=0.675U
M$2896 \$229 \$122 \$359 VSS nfet_03v3 L=0.28U W=0.36U AS=0.0567P AD=0.1278P
+ PS=0.675U PD=1.07U
M$2897 \$123 WEM \$229 VSS nfet_03v3 L=0.28U W=0.36U AS=0.1278P AD=0.1188P
+ PS=1.07U PD=1.02U
M$2898 VSS D5 \$123 VSS nfet_03v3 L=0.28U W=0.36U AS=0.1188P AD=0.1584P
+ PS=1.02U PD=1.6U
M$2899 \$125 \$231 VSS VSS nfet_03v3 L=0.28U W=0.36U AS=0.1584P AD=0.1584P
+ PS=1.6U PD=1.6U
M$2900 \$370 \$105 VSS VSS nfet_03v3 L=0.28U W=0.36U AS=0.1584P AD=0.0567P
+ PS=1.6U PD=0.675U
M$2901 \$231 \$125 \$370 VSS nfet_03v3 L=0.28U W=0.36U AS=0.0567P AD=0.1278P
+ PS=0.675U PD=1.07U
M$2902 \$126 WEM \$231 VSS nfet_03v3 L=0.28U W=0.36U AS=0.1278P AD=0.1188P
+ PS=1.07U PD=1.02U
M$2903 VSS D6 \$126 VSS nfet_03v3 L=0.28U W=0.36U AS=0.1188P AD=0.1584P
+ PS=1.02U PD=1.6U
M$2904 \$128 \$233 VSS VSS nfet_03v3 L=0.28U W=0.36U AS=0.1584P AD=0.1584P
+ PS=1.6U PD=1.6U
M$2905 \$379 \$105 VSS VSS nfet_03v3 L=0.28U W=0.36U AS=0.1584P AD=0.0567P
+ PS=1.6U PD=0.675U
M$2906 \$233 \$128 \$379 VSS nfet_03v3 L=0.28U W=0.36U AS=0.0567P AD=0.1278P
+ PS=0.675U PD=1.07U
M$2907 \$129 WEM \$233 VSS nfet_03v3 L=0.28U W=0.36U AS=0.1278P AD=0.1188P
+ PS=1.07U PD=1.02U
M$2908 VSS D7 \$129 VSS nfet_03v3 L=0.28U W=0.36U AS=0.1188P AD=0.1584P
+ PS=1.02U PD=1.6U
M$2909 \$131 \$235 VSS VSS nfet_03v3 L=0.28U W=0.36U AS=0.1584P AD=0.1584P
+ PS=1.6U PD=1.6U
M$2910 \$388 \$105 VSS VSS nfet_03v3 L=0.28U W=0.36U AS=0.1584P AD=0.0567P
+ PS=1.6U PD=0.675U
M$2911 \$235 \$131 \$388 VSS nfet_03v3 L=0.28U W=0.36U AS=0.0567P AD=0.1278P
+ PS=0.675U PD=1.07U
M$2912 \$132 WEM \$235 VSS nfet_03v3 L=0.28U W=0.36U AS=0.1278P AD=0.1188P
+ PS=1.07U PD=1.02U
M$2913 VSS D8 \$132 VSS nfet_03v3 L=0.28U W=0.36U AS=0.1188P AD=0.1584P
+ PS=1.02U PD=1.6U
M$2914 \$134 \$237 VSS VSS nfet_03v3 L=0.28U W=0.36U AS=0.1584P AD=0.1584P
+ PS=1.6U PD=1.6U
M$2915 \$399 \$105 VSS VSS nfet_03v3 L=0.28U W=0.36U AS=0.1584P AD=0.0567P
+ PS=1.6U PD=0.675U
M$2916 \$237 \$134 \$399 VSS nfet_03v3 L=0.28U W=0.36U AS=0.0567P AD=0.1278P
+ PS=0.675U PD=1.07U
M$2917 \$135 WEM \$237 VSS nfet_03v3 L=0.28U W=0.36U AS=0.1278P AD=0.1188P
+ PS=1.07U PD=1.02U
M$2918 VSS D9 \$135 VSS nfet_03v3 L=0.28U W=0.36U AS=0.1188P AD=0.1584P
+ PS=1.02U PD=1.6U
M$2919 \$137 \$239 VSS VSS nfet_03v3 L=0.28U W=0.36U AS=0.1584P AD=0.1584P
+ PS=1.6U PD=1.6U
M$2920 \$408 \$105 VSS VSS nfet_03v3 L=0.28U W=0.36U AS=0.1584P AD=0.0567P
+ PS=1.6U PD=0.675U
M$2921 \$239 \$137 \$408 VSS nfet_03v3 L=0.28U W=0.36U AS=0.0567P AD=0.1278P
+ PS=0.675U PD=1.07U
M$2922 \$138 WEM \$239 VSS nfet_03v3 L=0.28U W=0.36U AS=0.1278P AD=0.1188P
+ PS=1.07U PD=1.02U
M$2923 VSS D10 \$138 VSS nfet_03v3 L=0.28U W=0.36U AS=0.1188P AD=0.1584P
+ PS=1.02U PD=1.6U
M$2924 \$140 \$241 VSS VSS nfet_03v3 L=0.28U W=0.36U AS=0.1584P AD=0.1584P
+ PS=1.6U PD=1.6U
M$2925 \$410 \$105 VSS VSS nfet_03v3 L=0.28U W=0.36U AS=0.1584P AD=0.0567P
+ PS=1.6U PD=0.675U
M$2926 \$241 \$140 \$410 VSS nfet_03v3 L=0.28U W=0.36U AS=0.0567P AD=0.1278P
+ PS=0.675U PD=1.07U
M$2927 \$141 WEM \$241 VSS nfet_03v3 L=0.28U W=0.36U AS=0.1278P AD=0.1188P
+ PS=1.07U PD=1.02U
M$2928 VSS D11 \$141 VSS nfet_03v3 L=0.28U W=0.36U AS=0.1188P AD=0.1584P
+ PS=1.02U PD=1.6U
M$2929 \$143 \$243 VSS VSS nfet_03v3 L=0.28U W=0.36U AS=0.1584P AD=0.1584P
+ PS=1.6U PD=1.6U
M$2930 \$384 \$105 VSS VSS nfet_03v3 L=0.28U W=0.36U AS=0.1584P AD=0.0567P
+ PS=1.6U PD=0.675U
M$2931 \$243 \$143 \$384 VSS nfet_03v3 L=0.28U W=0.36U AS=0.0567P AD=0.1278P
+ PS=0.675U PD=1.07U
M$2932 \$144 WEM \$243 VSS nfet_03v3 L=0.28U W=0.36U AS=0.1278P AD=0.1188P
+ PS=1.07U PD=1.02U
M$2933 VSS D12 \$144 VSS nfet_03v3 L=0.28U W=0.36U AS=0.1188P AD=0.1584P
+ PS=1.02U PD=1.6U
M$2934 \$146 \$245 VSS VSS nfet_03v3 L=0.28U W=0.36U AS=0.1584P AD=0.1584P
+ PS=1.6U PD=1.6U
M$2935 \$361 \$105 VSS VSS nfet_03v3 L=0.28U W=0.36U AS=0.1584P AD=0.0567P
+ PS=1.6U PD=0.675U
M$2936 \$245 \$146 \$361 VSS nfet_03v3 L=0.28U W=0.36U AS=0.0567P AD=0.1278P
+ PS=0.675U PD=1.07U
M$2937 \$147 WEM \$245 VSS nfet_03v3 L=0.28U W=0.36U AS=0.1278P AD=0.1188P
+ PS=1.07U PD=1.02U
M$2938 VSS D13 \$147 VSS nfet_03v3 L=0.28U W=0.36U AS=0.1188P AD=0.1584P
+ PS=1.02U PD=1.6U
M$2939 \$149 \$247 VSS VSS nfet_03v3 L=0.28U W=0.36U AS=0.1584P AD=0.1584P
+ PS=1.6U PD=1.6U
M$2940 \$334 \$105 VSS VSS nfet_03v3 L=0.28U W=0.36U AS=0.1584P AD=0.0567P
+ PS=1.6U PD=0.675U
M$2941 \$247 \$149 \$334 VSS nfet_03v3 L=0.28U W=0.36U AS=0.0567P AD=0.1278P
+ PS=0.675U PD=1.07U
M$2942 \$150 WEM \$247 VSS nfet_03v3 L=0.28U W=0.36U AS=0.1278P AD=0.1188P
+ PS=1.07U PD=1.02U
M$2943 VSS D14 \$150 VSS nfet_03v3 L=0.28U W=0.36U AS=0.1188P AD=0.1584P
+ PS=1.02U PD=1.6U
M$2944 \$152 \$249 VSS VSS nfet_03v3 L=0.28U W=0.36U AS=0.1584P AD=0.1584P
+ PS=1.6U PD=1.6U
M$2945 \$307 \$105 VSS VSS nfet_03v3 L=0.28U W=0.36U AS=0.1584P AD=0.0567P
+ PS=1.6U PD=0.675U
M$2946 \$249 \$152 \$307 VSS nfet_03v3 L=0.28U W=0.36U AS=0.0567P AD=0.1278P
+ PS=0.675U PD=1.07U
M$2947 \$153 WEM \$249 VSS nfet_03v3 L=0.28U W=0.36U AS=0.1278P AD=0.1188P
+ PS=1.07U PD=1.02U
M$2948 VSS D15 \$153 VSS nfet_03v3 L=0.28U W=0.36U AS=0.1188P AD=0.1584P
+ PS=1.02U PD=1.6U
M$2949 \$470 WE15 VSS VSS nfet_03v3 L=0.28U W=0.72U AS=0.3168P AD=0.1872P
+ PS=2.32U PD=1.24U
M$2950 \$254 CLK \$470 VSS nfet_03v3 L=0.28U W=0.72U AS=0.1872P AD=0.3168P
+ PS=1.24U PD=2.32U
M$2951 \$416 \$254 VSS VSS nfet_03v3 L=0.28U W=1.27U AS=0.4445P AD=0.3344P
+ PS=3.305U PD=2.345U
M$2953 \$523 \$416 VSS VSS nfet_03v3 L=0.28U W=1.34U AS=0.3636P AD=0.4891P
+ PS=2.44U PD=3.47U
M$2955 \$255 \$106 VSS VSS nfet_03v3 L=0.28U W=0.36U AS=0.1584P AD=0.1188P
+ PS=1.6U PD=1.02U
M$2956 \$256 \$416 \$255 VSS nfet_03v3 L=0.28U W=0.36U AS=0.1188P AD=0.1278P
+ PS=1.02U PD=1.07U
M$2957 \$310 \$420 \$256 VSS nfet_03v3 L=0.28U W=0.36U AS=0.1278P AD=0.0567P
+ PS=1.07U PD=0.675U
M$2958 VSS \$523 \$310 VSS nfet_03v3 L=0.28U W=0.36U AS=0.0567P AD=0.1584P
+ PS=0.675U PD=1.6U
M$2959 VSS \$256 \$420 VSS nfet_03v3 L=0.28U W=0.36U AS=0.1584P AD=0.0972P
+ PS=1.6U PD=0.9U
M$2960 \$257 \$256 VSS VSS nfet_03v3 L=0.28U W=0.36U AS=0.0972P AD=0.18P
+ PS=0.9U PD=1.72U
M$2961 \$422 RA15 VSS VSS nfet_03v3 L=0.28U W=0.36U AS=0.1656P AD=0.1944P
+ PS=1.64U PD=1.8U
M$2962 \$257 RA15 \$51 VSS nfet_03v3 L=0.28U W=0.36U AS=0.1584P AD=0.1152P
+ PS=1.6U PD=1U
M$2963 \$52 RB15 \$257 VSS nfet_03v3 L=0.28U W=0.36U AS=0.1152P AD=0.1584P
+ PS=1U PD=1.6U
M$2964 VSS RB15 \$423 VSS nfet_03v3 L=0.28U W=0.36U AS=0.1854P AD=0.1584P
+ PS=1.75U PD=1.6U
M$2965 \$258 \$109 VSS VSS nfet_03v3 L=0.28U W=0.36U AS=0.1584P AD=0.1188P
+ PS=1.6U PD=1.02U
M$2966 \$259 \$416 \$258 VSS nfet_03v3 L=0.28U W=0.36U AS=0.1188P AD=0.1278P
+ PS=1.02U PD=1.07U
M$2967 \$321 \$424 \$259 VSS nfet_03v3 L=0.28U W=0.36U AS=0.1278P AD=0.0567P
+ PS=1.07U PD=0.675U
M$2968 VSS \$523 \$321 VSS nfet_03v3 L=0.28U W=0.36U AS=0.0567P AD=0.1584P
+ PS=0.675U PD=1.6U
M$2969 VSS \$259 \$424 VSS nfet_03v3 L=0.28U W=0.36U AS=0.1584P AD=0.0972P
+ PS=1.6U PD=0.9U
M$2970 \$260 \$259 VSS VSS nfet_03v3 L=0.28U W=0.36U AS=0.0972P AD=0.18P
+ PS=0.9U PD=1.72U
M$2971 \$425 RA15 VSS VSS nfet_03v3 L=0.28U W=0.36U AS=0.1656P AD=0.1944P
+ PS=1.64U PD=1.8U
M$2972 \$260 RA15 \$53 VSS nfet_03v3 L=0.28U W=0.36U AS=0.1584P AD=0.1152P
+ PS=1.6U PD=1U
M$2973 \$54 RB15 \$260 VSS nfet_03v3 L=0.28U W=0.36U AS=0.1152P AD=0.1584P
+ PS=1U PD=1.6U
M$2974 VSS RB15 \$426 VSS nfet_03v3 L=0.28U W=0.36U AS=0.1854P AD=0.1584P
+ PS=1.75U PD=1.6U
M$2975 \$261 \$112 VSS VSS nfet_03v3 L=0.28U W=0.36U AS=0.1584P AD=0.1188P
+ PS=1.6U PD=1.02U
M$2976 \$262 \$416 \$261 VSS nfet_03v3 L=0.28U W=0.36U AS=0.1188P AD=0.1278P
+ PS=1.02U PD=1.07U
M$2977 \$330 \$427 \$262 VSS nfet_03v3 L=0.28U W=0.36U AS=0.1278P AD=0.0567P
+ PS=1.07U PD=0.675U
M$2978 VSS \$523 \$330 VSS nfet_03v3 L=0.28U W=0.36U AS=0.0567P AD=0.1584P
+ PS=0.675U PD=1.6U
M$2979 VSS \$262 \$427 VSS nfet_03v3 L=0.28U W=0.36U AS=0.1584P AD=0.0972P
+ PS=1.6U PD=0.9U
M$2980 \$263 \$262 VSS VSS nfet_03v3 L=0.28U W=0.36U AS=0.0972P AD=0.18P
+ PS=0.9U PD=1.72U
M$2981 \$428 RA15 VSS VSS nfet_03v3 L=0.28U W=0.36U AS=0.1656P AD=0.1944P
+ PS=1.64U PD=1.8U
M$2982 \$263 RA15 \$55 VSS nfet_03v3 L=0.28U W=0.36U AS=0.1584P AD=0.1152P
+ PS=1.6U PD=1U
M$2983 \$56 RB15 \$263 VSS nfet_03v3 L=0.28U W=0.36U AS=0.1152P AD=0.1584P
+ PS=1U PD=1.6U
M$2984 VSS RB15 \$429 VSS nfet_03v3 L=0.28U W=0.36U AS=0.1854P AD=0.1584P
+ PS=1.75U PD=1.6U
M$2985 \$264 \$115 VSS VSS nfet_03v3 L=0.28U W=0.36U AS=0.1584P AD=0.1188P
+ PS=1.6U PD=1.02U
M$2986 \$265 \$416 \$264 VSS nfet_03v3 L=0.28U W=0.36U AS=0.1188P AD=0.1278P
+ PS=1.02U PD=1.07U
M$2987 \$340 \$430 \$265 VSS nfet_03v3 L=0.28U W=0.36U AS=0.1278P AD=0.0567P
+ PS=1.07U PD=0.675U
M$2988 VSS \$523 \$340 VSS nfet_03v3 L=0.28U W=0.36U AS=0.0567P AD=0.1584P
+ PS=0.675U PD=1.6U
M$2989 VSS \$265 \$430 VSS nfet_03v3 L=0.28U W=0.36U AS=0.1584P AD=0.0972P
+ PS=1.6U PD=0.9U
M$2990 \$266 \$265 VSS VSS nfet_03v3 L=0.28U W=0.36U AS=0.0972P AD=0.18P
+ PS=0.9U PD=1.72U
M$2991 \$432 RA15 VSS VSS nfet_03v3 L=0.28U W=0.36U AS=0.1656P AD=0.1944P
+ PS=1.64U PD=1.8U
M$2992 \$266 RA15 \$57 VSS nfet_03v3 L=0.28U W=0.36U AS=0.1584P AD=0.1152P
+ PS=1.6U PD=1U
M$2993 \$58 RB15 \$266 VSS nfet_03v3 L=0.28U W=0.36U AS=0.1152P AD=0.1584P
+ PS=1U PD=1.6U
M$2994 VSS RB15 \$433 VSS nfet_03v3 L=0.28U W=0.36U AS=0.1854P AD=0.1584P
+ PS=1.75U PD=1.6U
M$2995 \$267 \$118 VSS VSS nfet_03v3 L=0.28U W=0.36U AS=0.1584P AD=0.1188P
+ PS=1.6U PD=1.02U
M$2996 \$268 \$416 \$267 VSS nfet_03v3 L=0.28U W=0.36U AS=0.1188P AD=0.1278P
+ PS=1.02U PD=1.07U
M$2997 \$349 \$434 \$268 VSS nfet_03v3 L=0.28U W=0.36U AS=0.1278P AD=0.0567P
+ PS=1.07U PD=0.675U
M$2998 VSS \$523 \$349 VSS nfet_03v3 L=0.28U W=0.36U AS=0.0567P AD=0.1584P
+ PS=0.675U PD=1.6U
M$2999 VSS \$268 \$434 VSS nfet_03v3 L=0.28U W=0.36U AS=0.1584P AD=0.0972P
+ PS=1.6U PD=0.9U
M$3000 \$269 \$268 VSS VSS nfet_03v3 L=0.28U W=0.36U AS=0.0972P AD=0.18P
+ PS=0.9U PD=1.72U
M$3001 \$435 RA15 VSS VSS nfet_03v3 L=0.28U W=0.36U AS=0.1656P AD=0.1944P
+ PS=1.64U PD=1.8U
M$3002 \$269 RA15 \$59 VSS nfet_03v3 L=0.28U W=0.36U AS=0.1584P AD=0.1152P
+ PS=1.6U PD=1U
M$3003 \$60 RB15 \$269 VSS nfet_03v3 L=0.28U W=0.36U AS=0.1152P AD=0.1584P
+ PS=1U PD=1.6U
M$3004 VSS RB15 \$436 VSS nfet_03v3 L=0.28U W=0.36U AS=0.1854P AD=0.1584P
+ PS=1.75U PD=1.6U
M$3005 \$270 \$121 VSS VSS nfet_03v3 L=0.28U W=0.36U AS=0.1584P AD=0.1188P
+ PS=1.6U PD=1.02U
M$3006 \$271 \$416 \$270 VSS nfet_03v3 L=0.28U W=0.36U AS=0.1188P AD=0.1278P
+ PS=1.02U PD=1.07U
M$3007 \$358 \$437 \$271 VSS nfet_03v3 L=0.28U W=0.36U AS=0.1278P AD=0.0567P
+ PS=1.07U PD=0.675U
M$3008 VSS \$523 \$358 VSS nfet_03v3 L=0.28U W=0.36U AS=0.0567P AD=0.1584P
+ PS=0.675U PD=1.6U
M$3009 VSS \$271 \$437 VSS nfet_03v3 L=0.28U W=0.36U AS=0.1584P AD=0.0972P
+ PS=1.6U PD=0.9U
M$3010 \$272 \$271 VSS VSS nfet_03v3 L=0.28U W=0.36U AS=0.0972P AD=0.18P
+ PS=0.9U PD=1.72U
M$3011 \$438 RA15 VSS VSS nfet_03v3 L=0.28U W=0.36U AS=0.1656P AD=0.1944P
+ PS=1.64U PD=1.8U
M$3012 \$272 RA15 \$61 VSS nfet_03v3 L=0.28U W=0.36U AS=0.1584P AD=0.1152P
+ PS=1.6U PD=1U
M$3013 \$62 RB15 \$272 VSS nfet_03v3 L=0.28U W=0.36U AS=0.1152P AD=0.1584P
+ PS=1U PD=1.6U
M$3014 VSS RB15 \$439 VSS nfet_03v3 L=0.28U W=0.36U AS=0.1854P AD=0.1584P
+ PS=1.75U PD=1.6U
M$3015 \$273 \$124 VSS VSS nfet_03v3 L=0.28U W=0.36U AS=0.1584P AD=0.1188P
+ PS=1.6U PD=1.02U
M$3016 \$274 \$416 \$273 VSS nfet_03v3 L=0.28U W=0.36U AS=0.1188P AD=0.1278P
+ PS=1.02U PD=1.07U
M$3017 \$369 \$440 \$274 VSS nfet_03v3 L=0.28U W=0.36U AS=0.1278P AD=0.0567P
+ PS=1.07U PD=0.675U
M$3018 VSS \$523 \$369 VSS nfet_03v3 L=0.28U W=0.36U AS=0.0567P AD=0.1584P
+ PS=0.675U PD=1.6U
M$3019 VSS \$274 \$440 VSS nfet_03v3 L=0.28U W=0.36U AS=0.1584P AD=0.0972P
+ PS=1.6U PD=0.9U
M$3020 \$275 \$274 VSS VSS nfet_03v3 L=0.28U W=0.36U AS=0.0972P AD=0.18P
+ PS=0.9U PD=1.72U
M$3021 \$441 RA15 VSS VSS nfet_03v3 L=0.28U W=0.36U AS=0.1656P AD=0.1944P
+ PS=1.64U PD=1.8U
M$3022 \$275 RA15 \$63 VSS nfet_03v3 L=0.28U W=0.36U AS=0.1584P AD=0.1152P
+ PS=1.6U PD=1U
M$3023 \$64 RB15 \$275 VSS nfet_03v3 L=0.28U W=0.36U AS=0.1152P AD=0.1584P
+ PS=1U PD=1.6U
M$3024 VSS RB15 \$442 VSS nfet_03v3 L=0.28U W=0.36U AS=0.1854P AD=0.1584P
+ PS=1.75U PD=1.6U
M$3025 \$276 \$127 VSS VSS nfet_03v3 L=0.28U W=0.36U AS=0.1584P AD=0.1188P
+ PS=1.6U PD=1.02U
M$3026 \$277 \$416 \$276 VSS nfet_03v3 L=0.28U W=0.36U AS=0.1188P AD=0.1278P
+ PS=1.02U PD=1.07U
M$3027 \$377 \$443 \$277 VSS nfet_03v3 L=0.28U W=0.36U AS=0.1278P AD=0.0567P
+ PS=1.07U PD=0.675U
M$3028 VSS \$523 \$377 VSS nfet_03v3 L=0.28U W=0.36U AS=0.0567P AD=0.1584P
+ PS=0.675U PD=1.6U
M$3029 VSS \$277 \$443 VSS nfet_03v3 L=0.28U W=0.36U AS=0.1584P AD=0.0972P
+ PS=1.6U PD=0.9U
M$3030 \$278 \$277 VSS VSS nfet_03v3 L=0.28U W=0.36U AS=0.0972P AD=0.18P
+ PS=0.9U PD=1.72U
M$3031 \$444 RA15 VSS VSS nfet_03v3 L=0.28U W=0.36U AS=0.1656P AD=0.1944P
+ PS=1.64U PD=1.8U
M$3032 \$278 RA15 \$65 VSS nfet_03v3 L=0.28U W=0.36U AS=0.1584P AD=0.1152P
+ PS=1.6U PD=1U
M$3033 \$66 RB15 \$278 VSS nfet_03v3 L=0.28U W=0.36U AS=0.1152P AD=0.1584P
+ PS=1U PD=1.6U
M$3034 VSS RB15 \$445 VSS nfet_03v3 L=0.28U W=0.36U AS=0.1854P AD=0.1584P
+ PS=1.75U PD=1.6U
M$3035 \$279 \$130 VSS VSS nfet_03v3 L=0.28U W=0.36U AS=0.1584P AD=0.1188P
+ PS=1.6U PD=1.02U
M$3036 \$280 \$416 \$279 VSS nfet_03v3 L=0.28U W=0.36U AS=0.1188P AD=0.1278P
+ PS=1.02U PD=1.07U
M$3037 \$387 \$446 \$280 VSS nfet_03v3 L=0.28U W=0.36U AS=0.1278P AD=0.0567P
+ PS=1.07U PD=0.675U
M$3038 VSS \$523 \$387 VSS nfet_03v3 L=0.28U W=0.36U AS=0.0567P AD=0.1584P
+ PS=0.675U PD=1.6U
M$3039 VSS \$280 \$446 VSS nfet_03v3 L=0.28U W=0.36U AS=0.1584P AD=0.0972P
+ PS=1.6U PD=0.9U
M$3040 \$281 \$280 VSS VSS nfet_03v3 L=0.28U W=0.36U AS=0.0972P AD=0.18P
+ PS=0.9U PD=1.72U
M$3041 \$447 RA15 VSS VSS nfet_03v3 L=0.28U W=0.36U AS=0.1656P AD=0.1944P
+ PS=1.64U PD=1.8U
M$3042 \$281 RA15 \$67 VSS nfet_03v3 L=0.28U W=0.36U AS=0.1584P AD=0.1152P
+ PS=1.6U PD=1U
M$3043 \$68 RB15 \$281 VSS nfet_03v3 L=0.28U W=0.36U AS=0.1152P AD=0.1584P
+ PS=1U PD=1.6U
M$3044 VSS RB15 \$448 VSS nfet_03v3 L=0.28U W=0.36U AS=0.1854P AD=0.1584P
+ PS=1.75U PD=1.6U
M$3045 \$282 \$133 VSS VSS nfet_03v3 L=0.28U W=0.36U AS=0.1584P AD=0.1188P
+ PS=1.6U PD=1.02U
M$3046 \$283 \$416 \$282 VSS nfet_03v3 L=0.28U W=0.36U AS=0.1188P AD=0.1278P
+ PS=1.02U PD=1.07U
M$3047 \$398 \$449 \$283 VSS nfet_03v3 L=0.28U W=0.36U AS=0.1278P AD=0.0567P
+ PS=1.07U PD=0.675U
M$3048 VSS \$523 \$398 VSS nfet_03v3 L=0.28U W=0.36U AS=0.0567P AD=0.1584P
+ PS=0.675U PD=1.6U
M$3049 VSS \$283 \$449 VSS nfet_03v3 L=0.28U W=0.36U AS=0.1584P AD=0.0972P
+ PS=1.6U PD=0.9U
M$3050 \$284 \$283 VSS VSS nfet_03v3 L=0.28U W=0.36U AS=0.0972P AD=0.18P
+ PS=0.9U PD=1.72U
M$3051 \$450 RA15 VSS VSS nfet_03v3 L=0.28U W=0.36U AS=0.1656P AD=0.1944P
+ PS=1.64U PD=1.8U
M$3052 \$284 RA15 \$69 VSS nfet_03v3 L=0.28U W=0.36U AS=0.1584P AD=0.1152P
+ PS=1.6U PD=1U
M$3053 \$70 RB15 \$284 VSS nfet_03v3 L=0.28U W=0.36U AS=0.1152P AD=0.1584P
+ PS=1U PD=1.6U
M$3054 VSS RB15 \$451 VSS nfet_03v3 L=0.28U W=0.36U AS=0.1854P AD=0.1584P
+ PS=1.75U PD=1.6U
M$3055 \$285 \$136 VSS VSS nfet_03v3 L=0.28U W=0.36U AS=0.1584P AD=0.1188P
+ PS=1.6U PD=1.02U
M$3056 \$286 \$416 \$285 VSS nfet_03v3 L=0.28U W=0.36U AS=0.1188P AD=0.1278P
+ PS=1.02U PD=1.07U
M$3057 \$406 \$452 \$286 VSS nfet_03v3 L=0.28U W=0.36U AS=0.1278P AD=0.0567P
+ PS=1.07U PD=0.675U
M$3058 VSS \$523 \$406 VSS nfet_03v3 L=0.28U W=0.36U AS=0.0567P AD=0.1584P
+ PS=0.675U PD=1.6U
M$3059 VSS \$286 \$452 VSS nfet_03v3 L=0.28U W=0.36U AS=0.1584P AD=0.0972P
+ PS=1.6U PD=0.9U
M$3060 \$287 \$286 VSS VSS nfet_03v3 L=0.28U W=0.36U AS=0.0972P AD=0.18P
+ PS=0.9U PD=1.72U
M$3061 \$453 RA15 VSS VSS nfet_03v3 L=0.28U W=0.36U AS=0.1656P AD=0.1944P
+ PS=1.64U PD=1.8U
M$3062 \$287 RA15 \$71 VSS nfet_03v3 L=0.28U W=0.36U AS=0.1584P AD=0.1152P
+ PS=1.6U PD=1U
M$3063 \$72 RB15 \$287 VSS nfet_03v3 L=0.28U W=0.36U AS=0.1152P AD=0.1584P
+ PS=1U PD=1.6U
M$3064 VSS RB15 \$454 VSS nfet_03v3 L=0.28U W=0.36U AS=0.1854P AD=0.1584P
+ PS=1.75U PD=1.6U
M$3065 \$288 \$139 VSS VSS nfet_03v3 L=0.28U W=0.36U AS=0.1584P AD=0.1188P
+ PS=1.6U PD=1.02U
M$3066 \$289 \$416 \$288 VSS nfet_03v3 L=0.28U W=0.36U AS=0.1188P AD=0.1278P
+ PS=1.02U PD=1.07U
M$3067 \$413 \$455 \$289 VSS nfet_03v3 L=0.28U W=0.36U AS=0.1278P AD=0.0567P
+ PS=1.07U PD=0.675U
M$3068 VSS \$523 \$413 VSS nfet_03v3 L=0.28U W=0.36U AS=0.0567P AD=0.1584P
+ PS=0.675U PD=1.6U
M$3069 VSS \$289 \$455 VSS nfet_03v3 L=0.28U W=0.36U AS=0.1584P AD=0.0972P
+ PS=1.6U PD=0.9U
M$3070 \$290 \$289 VSS VSS nfet_03v3 L=0.28U W=0.36U AS=0.0972P AD=0.18P
+ PS=0.9U PD=1.72U
M$3071 \$456 RA15 VSS VSS nfet_03v3 L=0.28U W=0.36U AS=0.1656P AD=0.1944P
+ PS=1.64U PD=1.8U
M$3072 \$290 RA15 \$73 VSS nfet_03v3 L=0.28U W=0.36U AS=0.1584P AD=0.1152P
+ PS=1.6U PD=1U
M$3073 \$74 RB15 \$290 VSS nfet_03v3 L=0.28U W=0.36U AS=0.1152P AD=0.1584P
+ PS=1U PD=1.6U
M$3074 VSS RB15 \$457 VSS nfet_03v3 L=0.28U W=0.36U AS=0.1854P AD=0.1584P
+ PS=1.75U PD=1.6U
M$3075 \$291 \$142 VSS VSS nfet_03v3 L=0.28U W=0.36U AS=0.1584P AD=0.1188P
+ PS=1.6U PD=1.02U
M$3076 \$292 \$416 \$291 VSS nfet_03v3 L=0.28U W=0.36U AS=0.1188P AD=0.1278P
+ PS=1.02U PD=1.07U
M$3077 \$390 \$458 \$292 VSS nfet_03v3 L=0.28U W=0.36U AS=0.1278P AD=0.0567P
+ PS=1.07U PD=0.675U
M$3078 VSS \$523 \$390 VSS nfet_03v3 L=0.28U W=0.36U AS=0.0567P AD=0.1584P
+ PS=0.675U PD=1.6U
M$3079 VSS \$292 \$458 VSS nfet_03v3 L=0.28U W=0.36U AS=0.1584P AD=0.0972P
+ PS=1.6U PD=0.9U
M$3080 \$293 \$292 VSS VSS nfet_03v3 L=0.28U W=0.36U AS=0.0972P AD=0.18P
+ PS=0.9U PD=1.72U
M$3081 \$459 RA15 VSS VSS nfet_03v3 L=0.28U W=0.36U AS=0.1656P AD=0.1944P
+ PS=1.64U PD=1.8U
M$3082 \$293 RA15 \$75 VSS nfet_03v3 L=0.28U W=0.36U AS=0.1584P AD=0.1152P
+ PS=1.6U PD=1U
M$3083 \$76 RB15 \$293 VSS nfet_03v3 L=0.28U W=0.36U AS=0.1152P AD=0.1584P
+ PS=1U PD=1.6U
M$3084 VSS RB15 \$460 VSS nfet_03v3 L=0.28U W=0.36U AS=0.1854P AD=0.1584P
+ PS=1.75U PD=1.6U
M$3085 \$294 \$145 VSS VSS nfet_03v3 L=0.28U W=0.36U AS=0.1584P AD=0.1188P
+ PS=1.6U PD=1.02U
M$3086 \$295 \$416 \$294 VSS nfet_03v3 L=0.28U W=0.36U AS=0.1188P AD=0.1278P
+ PS=1.02U PD=1.07U
M$3087 \$363 \$461 \$295 VSS nfet_03v3 L=0.28U W=0.36U AS=0.1278P AD=0.0567P
+ PS=1.07U PD=0.675U
M$3088 VSS \$523 \$363 VSS nfet_03v3 L=0.28U W=0.36U AS=0.0567P AD=0.1584P
+ PS=0.675U PD=1.6U
M$3089 VSS \$295 \$461 VSS nfet_03v3 L=0.28U W=0.36U AS=0.1584P AD=0.0972P
+ PS=1.6U PD=0.9U
M$3090 \$296 \$295 VSS VSS nfet_03v3 L=0.28U W=0.36U AS=0.0972P AD=0.18P
+ PS=0.9U PD=1.72U
M$3091 \$462 RA15 VSS VSS nfet_03v3 L=0.28U W=0.36U AS=0.1656P AD=0.1944P
+ PS=1.64U PD=1.8U
M$3092 \$296 RA15 \$77 VSS nfet_03v3 L=0.28U W=0.36U AS=0.1584P AD=0.1152P
+ PS=1.6U PD=1U
M$3093 \$78 RB15 \$296 VSS nfet_03v3 L=0.28U W=0.36U AS=0.1152P AD=0.1584P
+ PS=1U PD=1.6U
M$3094 VSS RB15 \$463 VSS nfet_03v3 L=0.28U W=0.36U AS=0.1854P AD=0.1584P
+ PS=1.75U PD=1.6U
M$3095 \$297 \$148 VSS VSS nfet_03v3 L=0.28U W=0.36U AS=0.1584P AD=0.1188P
+ PS=1.6U PD=1.02U
M$3096 \$298 \$416 \$297 VSS nfet_03v3 L=0.28U W=0.36U AS=0.1188P AD=0.1278P
+ PS=1.02U PD=1.07U
M$3097 \$336 \$464 \$298 VSS nfet_03v3 L=0.28U W=0.36U AS=0.1278P AD=0.0567P
+ PS=1.07U PD=0.675U
M$3098 VSS \$523 \$336 VSS nfet_03v3 L=0.28U W=0.36U AS=0.0567P AD=0.1584P
+ PS=0.675U PD=1.6U
M$3099 VSS \$298 \$464 VSS nfet_03v3 L=0.28U W=0.36U AS=0.1584P AD=0.0972P
+ PS=1.6U PD=0.9U
M$3100 \$299 \$298 VSS VSS nfet_03v3 L=0.28U W=0.36U AS=0.0972P AD=0.18P
+ PS=0.9U PD=1.72U
M$3101 \$465 RA15 VSS VSS nfet_03v3 L=0.28U W=0.36U AS=0.1656P AD=0.1944P
+ PS=1.64U PD=1.8U
M$3102 \$299 RA15 \$79 VSS nfet_03v3 L=0.28U W=0.36U AS=0.1584P AD=0.1152P
+ PS=1.6U PD=1U
M$3103 \$80 RB15 \$299 VSS nfet_03v3 L=0.28U W=0.36U AS=0.1152P AD=0.1584P
+ PS=1U PD=1.6U
M$3104 VSS RB15 \$466 VSS nfet_03v3 L=0.28U W=0.36U AS=0.1854P AD=0.1584P
+ PS=1.75U PD=1.6U
M$3105 \$300 \$151 VSS VSS nfet_03v3 L=0.28U W=0.36U AS=0.1584P AD=0.1188P
+ PS=1.6U PD=1.02U
M$3106 \$301 \$416 \$300 VSS nfet_03v3 L=0.28U W=0.36U AS=0.1188P AD=0.1278P
+ PS=1.02U PD=1.07U
M$3107 \$312 \$467 \$301 VSS nfet_03v3 L=0.28U W=0.36U AS=0.1278P AD=0.0567P
+ PS=1.07U PD=0.675U
M$3108 VSS \$523 \$312 VSS nfet_03v3 L=0.28U W=0.36U AS=0.0567P AD=0.1584P
+ PS=0.675U PD=1.6U
M$3109 VSS \$301 \$467 VSS nfet_03v3 L=0.28U W=0.36U AS=0.1584P AD=0.0972P
+ PS=1.6U PD=0.9U
M$3110 \$302 \$301 VSS VSS nfet_03v3 L=0.28U W=0.36U AS=0.0972P AD=0.18P
+ PS=0.9U PD=1.72U
M$3111 \$468 RA15 VSS VSS nfet_03v3 L=0.28U W=0.36U AS=0.1656P AD=0.1944P
+ PS=1.64U PD=1.8U
M$3112 \$302 RA15 \$81 VSS nfet_03v3 L=0.28U W=0.36U AS=0.1584P AD=0.1152P
+ PS=1.6U PD=1U
M$3113 \$82 RB15 \$302 VSS nfet_03v3 L=0.28U W=0.36U AS=0.1152P AD=0.1584P
+ PS=1U PD=1.6U
M$3114 VSS RB15 \$469 VSS nfet_03v3 L=0.28U W=0.36U AS=0.1854P AD=0.1584P
+ PS=1.75U PD=1.6U
M$3115 \$833 WE14 VSS VSS nfet_03v3 L=0.28U W=0.72U AS=0.3168P AD=0.1872P
+ PS=2.32U PD=1.24U
M$3116 \$629 CLK \$833 VSS nfet_03v3 L=0.28U W=0.72U AS=0.1872P AD=0.3168P
+ PS=1.24U PD=2.32U
M$3117 \$630 \$629 VSS VSS nfet_03v3 L=0.28U W=1.27U AS=0.4487P AD=0.3302P
+ PS=3.34U PD=2.31U
M$3119 \$631 \$630 VSS VSS nfet_03v3 L=0.28U W=1.34U AS=0.3636P AD=0.4891P
+ PS=2.44U PD=3.47U
M$3121 \$637 RB14 VSS VSS nfet_03v3 L=0.28U W=0.36U AS=0.1656P AD=0.1944P
+ PS=1.64U PD=1.8U
M$3122 \$635 RB14 \$51 VSS nfet_03v3 L=0.28U W=0.36U AS=0.1584P AD=0.1152P
+ PS=1.6U PD=1U
M$3123 \$52 RA14 \$635 VSS nfet_03v3 L=0.28U W=0.36U AS=0.1152P AD=0.1584P
+ PS=1U PD=1.6U
M$3124 VSS RA14 \$638 VSS nfet_03v3 L=0.28U W=0.36U AS=0.1854P AD=0.1584P
+ PS=1.75U PD=1.6U
M$3125 \$643 RB14 VSS VSS nfet_03v3 L=0.28U W=0.36U AS=0.1656P AD=0.1944P
+ PS=1.64U PD=1.8U
M$3126 \$642 RB14 \$53 VSS nfet_03v3 L=0.28U W=0.36U AS=0.1584P AD=0.1152P
+ PS=1.6U PD=1U
M$3127 \$54 RA14 \$642 VSS nfet_03v3 L=0.28U W=0.36U AS=0.1152P AD=0.1584P
+ PS=1U PD=1.6U
M$3128 VSS RA14 \$644 VSS nfet_03v3 L=0.28U W=0.36U AS=0.1854P AD=0.1584P
+ PS=1.75U PD=1.6U
M$3129 \$649 RB14 VSS VSS nfet_03v3 L=0.28U W=0.36U AS=0.1656P AD=0.1944P
+ PS=1.64U PD=1.8U
M$3130 \$648 RB14 \$55 VSS nfet_03v3 L=0.28U W=0.36U AS=0.1584P AD=0.1152P
+ PS=1.6U PD=1U
M$3131 \$56 RA14 \$648 VSS nfet_03v3 L=0.28U W=0.36U AS=0.1152P AD=0.1584P
+ PS=1U PD=1.6U
M$3132 VSS RA14 \$650 VSS nfet_03v3 L=0.28U W=0.36U AS=0.1854P AD=0.1584P
+ PS=1.75U PD=1.6U
M$3133 \$655 RB14 VSS VSS nfet_03v3 L=0.28U W=0.36U AS=0.1656P AD=0.1944P
+ PS=1.64U PD=1.8U
M$3134 \$654 RB14 \$57 VSS nfet_03v3 L=0.28U W=0.36U AS=0.1584P AD=0.1152P
+ PS=1.6U PD=1U
M$3135 \$58 RA14 \$654 VSS nfet_03v3 L=0.28U W=0.36U AS=0.1152P AD=0.1584P
+ PS=1U PD=1.6U
M$3136 VSS RA14 \$656 VSS nfet_03v3 L=0.28U W=0.36U AS=0.1854P AD=0.1584P
+ PS=1.75U PD=1.6U
M$3137 \$661 RB14 VSS VSS nfet_03v3 L=0.28U W=0.36U AS=0.1656P AD=0.1944P
+ PS=1.64U PD=1.8U
M$3138 \$660 RB14 \$59 VSS nfet_03v3 L=0.28U W=0.36U AS=0.1584P AD=0.1152P
+ PS=1.6U PD=1U
M$3139 \$60 RA14 \$660 VSS nfet_03v3 L=0.28U W=0.36U AS=0.1152P AD=0.1584P
+ PS=1U PD=1.6U
M$3140 VSS RA14 \$662 VSS nfet_03v3 L=0.28U W=0.36U AS=0.1854P AD=0.1584P
+ PS=1.75U PD=1.6U
M$3141 \$667 RB14 VSS VSS nfet_03v3 L=0.28U W=0.36U AS=0.1656P AD=0.1944P
+ PS=1.64U PD=1.8U
M$3142 \$666 RB14 \$61 VSS nfet_03v3 L=0.28U W=0.36U AS=0.1584P AD=0.1152P
+ PS=1.6U PD=1U
M$3143 \$62 RA14 \$666 VSS nfet_03v3 L=0.28U W=0.36U AS=0.1152P AD=0.1584P
+ PS=1U PD=1.6U
M$3144 VSS RA14 \$668 VSS nfet_03v3 L=0.28U W=0.36U AS=0.1854P AD=0.1584P
+ PS=1.75U PD=1.6U
M$3145 \$673 RB14 VSS VSS nfet_03v3 L=0.28U W=0.36U AS=0.1656P AD=0.1944P
+ PS=1.64U PD=1.8U
M$3146 \$672 RB14 \$63 VSS nfet_03v3 L=0.28U W=0.36U AS=0.1584P AD=0.1152P
+ PS=1.6U PD=1U
M$3147 \$64 RA14 \$672 VSS nfet_03v3 L=0.28U W=0.36U AS=0.1152P AD=0.1584P
+ PS=1U PD=1.6U
M$3148 VSS RA14 \$674 VSS nfet_03v3 L=0.28U W=0.36U AS=0.1854P AD=0.1584P
+ PS=1.75U PD=1.6U
M$3149 \$679 RB14 VSS VSS nfet_03v3 L=0.28U W=0.36U AS=0.1656P AD=0.1944P
+ PS=1.64U PD=1.8U
M$3150 \$678 RB14 \$65 VSS nfet_03v3 L=0.28U W=0.36U AS=0.1584P AD=0.1152P
+ PS=1.6U PD=1U
M$3151 \$66 RA14 \$678 VSS nfet_03v3 L=0.28U W=0.36U AS=0.1152P AD=0.1584P
+ PS=1U PD=1.6U
M$3152 VSS RA14 \$680 VSS nfet_03v3 L=0.28U W=0.36U AS=0.1854P AD=0.1584P
+ PS=1.75U PD=1.6U
M$3153 \$685 RB14 VSS VSS nfet_03v3 L=0.28U W=0.36U AS=0.1656P AD=0.1944P
+ PS=1.64U PD=1.8U
M$3154 \$684 RB14 \$67 VSS nfet_03v3 L=0.28U W=0.36U AS=0.1584P AD=0.1152P
+ PS=1.6U PD=1U
M$3155 \$68 RA14 \$684 VSS nfet_03v3 L=0.28U W=0.36U AS=0.1152P AD=0.1584P
+ PS=1U PD=1.6U
M$3156 VSS RA14 \$686 VSS nfet_03v3 L=0.28U W=0.36U AS=0.1854P AD=0.1584P
+ PS=1.75U PD=1.6U
M$3157 \$691 RB14 VSS VSS nfet_03v3 L=0.28U W=0.36U AS=0.1656P AD=0.1944P
+ PS=1.64U PD=1.8U
M$3158 \$690 RB14 \$69 VSS nfet_03v3 L=0.28U W=0.36U AS=0.1584P AD=0.1152P
+ PS=1.6U PD=1U
M$3159 \$70 RA14 \$690 VSS nfet_03v3 L=0.28U W=0.36U AS=0.1152P AD=0.1584P
+ PS=1U PD=1.6U
M$3160 VSS RA14 \$692 VSS nfet_03v3 L=0.28U W=0.36U AS=0.1854P AD=0.1584P
+ PS=1.75U PD=1.6U
M$3161 \$697 RB14 VSS VSS nfet_03v3 L=0.28U W=0.36U AS=0.1656P AD=0.1944P
+ PS=1.64U PD=1.8U
M$3162 \$696 RB14 \$71 VSS nfet_03v3 L=0.28U W=0.36U AS=0.1584P AD=0.1152P
+ PS=1.6U PD=1U
M$3163 \$72 RA14 \$696 VSS nfet_03v3 L=0.28U W=0.36U AS=0.1152P AD=0.1584P
+ PS=1U PD=1.6U
M$3164 VSS RA14 \$698 VSS nfet_03v3 L=0.28U W=0.36U AS=0.1854P AD=0.1584P
+ PS=1.75U PD=1.6U
M$3165 \$703 RB14 VSS VSS nfet_03v3 L=0.28U W=0.36U AS=0.1656P AD=0.1944P
+ PS=1.64U PD=1.8U
M$3166 \$702 RB14 \$73 VSS nfet_03v3 L=0.28U W=0.36U AS=0.1584P AD=0.1152P
+ PS=1.6U PD=1U
M$3167 \$74 RA14 \$702 VSS nfet_03v3 L=0.28U W=0.36U AS=0.1152P AD=0.1584P
+ PS=1U PD=1.6U
M$3168 VSS RA14 \$704 VSS nfet_03v3 L=0.28U W=0.36U AS=0.1854P AD=0.1584P
+ PS=1.75U PD=1.6U
M$3169 \$709 RB14 VSS VSS nfet_03v3 L=0.28U W=0.36U AS=0.1656P AD=0.1944P
+ PS=1.64U PD=1.8U
M$3170 \$708 RB14 \$75 VSS nfet_03v3 L=0.28U W=0.36U AS=0.1584P AD=0.1152P
+ PS=1.6U PD=1U
M$3171 \$76 RA14 \$708 VSS nfet_03v3 L=0.28U W=0.36U AS=0.1152P AD=0.1584P
+ PS=1U PD=1.6U
M$3172 VSS RA14 \$710 VSS nfet_03v3 L=0.28U W=0.36U AS=0.1854P AD=0.1584P
+ PS=1.75U PD=1.6U
M$3173 \$715 RB14 VSS VSS nfet_03v3 L=0.28U W=0.36U AS=0.1656P AD=0.1944P
+ PS=1.64U PD=1.8U
M$3174 \$714 RB14 \$77 VSS nfet_03v3 L=0.28U W=0.36U AS=0.1584P AD=0.1152P
+ PS=1.6U PD=1U
M$3175 \$78 RA14 \$714 VSS nfet_03v3 L=0.28U W=0.36U AS=0.1152P AD=0.1584P
+ PS=1U PD=1.6U
M$3176 VSS RA14 \$716 VSS nfet_03v3 L=0.28U W=0.36U AS=0.1854P AD=0.1584P
+ PS=1.75U PD=1.6U
M$3177 \$721 RB14 VSS VSS nfet_03v3 L=0.28U W=0.36U AS=0.1656P AD=0.1944P
+ PS=1.64U PD=1.8U
M$3178 \$720 RB14 \$79 VSS nfet_03v3 L=0.28U W=0.36U AS=0.1584P AD=0.1152P
+ PS=1.6U PD=1U
M$3179 \$80 RA14 \$720 VSS nfet_03v3 L=0.28U W=0.36U AS=0.1152P AD=0.1584P
+ PS=1U PD=1.6U
M$3180 VSS RA14 \$722 VSS nfet_03v3 L=0.28U W=0.36U AS=0.1854P AD=0.1584P
+ PS=1.75U PD=1.6U
M$3181 \$727 RB14 VSS VSS nfet_03v3 L=0.28U W=0.36U AS=0.1656P AD=0.1944P
+ PS=1.64U PD=1.8U
M$3182 \$726 RB14 \$81 VSS nfet_03v3 L=0.28U W=0.36U AS=0.1584P AD=0.1152P
+ PS=1.6U PD=1U
M$3183 \$82 RA14 \$726 VSS nfet_03v3 L=0.28U W=0.36U AS=0.1152P AD=0.1584P
+ PS=1U PD=1.6U
M$3184 VSS RA14 \$728 VSS nfet_03v3 L=0.28U W=0.36U AS=0.1854P AD=0.1584P
+ PS=1.75U PD=1.6U
M$3185 \$632 \$106 VSS VSS nfet_03v3 L=0.28U W=0.36U AS=0.1584P AD=0.1188P
+ PS=1.6U PD=1.02U
M$3186 \$633 \$630 \$632 VSS nfet_03v3 L=0.28U W=0.36U AS=0.1188P AD=0.1278P
+ PS=1.02U PD=1.07U
M$3187 \$838 \$634 \$633 VSS nfet_03v3 L=0.28U W=0.36U AS=0.1278P AD=0.0567P
+ PS=1.07U PD=0.675U
M$3188 VSS \$631 \$838 VSS nfet_03v3 L=0.28U W=0.36U AS=0.0567P AD=0.1584P
+ PS=0.675U PD=1.6U
M$3189 VSS \$633 \$634 VSS nfet_03v3 L=0.28U W=0.36U AS=0.1584P AD=0.0972P
+ PS=1.6U PD=0.9U
M$3190 \$635 \$633 VSS VSS nfet_03v3 L=0.28U W=0.36U AS=0.0972P AD=0.18P
+ PS=0.9U PD=1.72U
M$3191 \$639 \$109 VSS VSS nfet_03v3 L=0.28U W=0.36U AS=0.1584P AD=0.1188P
+ PS=1.6U PD=1.02U
M$3192 \$640 \$630 \$639 VSS nfet_03v3 L=0.28U W=0.36U AS=0.1188P AD=0.1278P
+ PS=1.02U PD=1.07U
M$3193 \$845 \$641 \$640 VSS nfet_03v3 L=0.28U W=0.36U AS=0.1278P AD=0.0567P
+ PS=1.07U PD=0.675U
M$3194 VSS \$631 \$845 VSS nfet_03v3 L=0.28U W=0.36U AS=0.0567P AD=0.1584P
+ PS=0.675U PD=1.6U
M$3195 VSS \$640 \$641 VSS nfet_03v3 L=0.28U W=0.36U AS=0.1584P AD=0.0972P
+ PS=1.6U PD=0.9U
M$3196 \$642 \$640 VSS VSS nfet_03v3 L=0.28U W=0.36U AS=0.0972P AD=0.18P
+ PS=0.9U PD=1.72U
M$3197 \$645 \$112 VSS VSS nfet_03v3 L=0.28U W=0.36U AS=0.1584P AD=0.1188P
+ PS=1.6U PD=1.02U
M$3198 \$646 \$630 \$645 VSS nfet_03v3 L=0.28U W=0.36U AS=0.1188P AD=0.1278P
+ PS=1.02U PD=1.07U
M$3199 \$852 \$647 \$646 VSS nfet_03v3 L=0.28U W=0.36U AS=0.1278P AD=0.0567P
+ PS=1.07U PD=0.675U
M$3200 VSS \$631 \$852 VSS nfet_03v3 L=0.28U W=0.36U AS=0.0567P AD=0.1584P
+ PS=0.675U PD=1.6U
M$3201 VSS \$646 \$647 VSS nfet_03v3 L=0.28U W=0.36U AS=0.1584P AD=0.0972P
+ PS=1.6U PD=0.9U
M$3202 \$648 \$646 VSS VSS nfet_03v3 L=0.28U W=0.36U AS=0.0972P AD=0.18P
+ PS=0.9U PD=1.72U
M$3203 \$651 \$115 VSS VSS nfet_03v3 L=0.28U W=0.36U AS=0.1584P AD=0.1188P
+ PS=1.6U PD=1.02U
M$3204 \$652 \$630 \$651 VSS nfet_03v3 L=0.28U W=0.36U AS=0.1188P AD=0.1278P
+ PS=1.02U PD=1.07U
M$3205 \$860 \$653 \$652 VSS nfet_03v3 L=0.28U W=0.36U AS=0.1278P AD=0.0567P
+ PS=1.07U PD=0.675U
M$3206 VSS \$631 \$860 VSS nfet_03v3 L=0.28U W=0.36U AS=0.0567P AD=0.1584P
+ PS=0.675U PD=1.6U
M$3207 VSS \$652 \$653 VSS nfet_03v3 L=0.28U W=0.36U AS=0.1584P AD=0.0972P
+ PS=1.6U PD=0.9U
M$3208 \$654 \$652 VSS VSS nfet_03v3 L=0.28U W=0.36U AS=0.0972P AD=0.18P
+ PS=0.9U PD=1.72U
M$3209 \$657 \$118 VSS VSS nfet_03v3 L=0.28U W=0.36U AS=0.1584P AD=0.1188P
+ PS=1.6U PD=1.02U
M$3210 \$658 \$630 \$657 VSS nfet_03v3 L=0.28U W=0.36U AS=0.1188P AD=0.1278P
+ PS=1.02U PD=1.07U
M$3211 \$866 \$659 \$658 VSS nfet_03v3 L=0.28U W=0.36U AS=0.1278P AD=0.0567P
+ PS=1.07U PD=0.675U
M$3212 VSS \$631 \$866 VSS nfet_03v3 L=0.28U W=0.36U AS=0.0567P AD=0.1584P
+ PS=0.675U PD=1.6U
M$3213 VSS \$658 \$659 VSS nfet_03v3 L=0.28U W=0.36U AS=0.1584P AD=0.0972P
+ PS=1.6U PD=0.9U
M$3214 \$660 \$658 VSS VSS nfet_03v3 L=0.28U W=0.36U AS=0.0972P AD=0.18P
+ PS=0.9U PD=1.72U
M$3215 \$663 \$121 VSS VSS nfet_03v3 L=0.28U W=0.36U AS=0.1584P AD=0.1188P
+ PS=1.6U PD=1.02U
M$3216 \$664 \$630 \$663 VSS nfet_03v3 L=0.28U W=0.36U AS=0.1188P AD=0.1278P
+ PS=1.02U PD=1.07U
M$3217 \$874 \$665 \$664 VSS nfet_03v3 L=0.28U W=0.36U AS=0.1278P AD=0.0567P
+ PS=1.07U PD=0.675U
M$3218 VSS \$631 \$874 VSS nfet_03v3 L=0.28U W=0.36U AS=0.0567P AD=0.1584P
+ PS=0.675U PD=1.6U
M$3219 VSS \$664 \$665 VSS nfet_03v3 L=0.28U W=0.36U AS=0.1584P AD=0.0972P
+ PS=1.6U PD=0.9U
M$3220 \$666 \$664 VSS VSS nfet_03v3 L=0.28U W=0.36U AS=0.0972P AD=0.18P
+ PS=0.9U PD=1.72U
M$3221 \$669 \$124 VSS VSS nfet_03v3 L=0.28U W=0.36U AS=0.1584P AD=0.1188P
+ PS=1.6U PD=1.02U
M$3222 \$670 \$630 \$669 VSS nfet_03v3 L=0.28U W=0.36U AS=0.1188P AD=0.1278P
+ PS=1.02U PD=1.07U
M$3223 \$881 \$671 \$670 VSS nfet_03v3 L=0.28U W=0.36U AS=0.1278P AD=0.0567P
+ PS=1.07U PD=0.675U
M$3224 VSS \$631 \$881 VSS nfet_03v3 L=0.28U W=0.36U AS=0.0567P AD=0.1584P
+ PS=0.675U PD=1.6U
M$3225 VSS \$670 \$671 VSS nfet_03v3 L=0.28U W=0.36U AS=0.1584P AD=0.0972P
+ PS=1.6U PD=0.9U
M$3226 \$672 \$670 VSS VSS nfet_03v3 L=0.28U W=0.36U AS=0.0972P AD=0.18P
+ PS=0.9U PD=1.72U
M$3227 \$675 \$127 VSS VSS nfet_03v3 L=0.28U W=0.36U AS=0.1584P AD=0.1188P
+ PS=1.6U PD=1.02U
M$3228 \$676 \$630 \$675 VSS nfet_03v3 L=0.28U W=0.36U AS=0.1188P AD=0.1278P
+ PS=1.02U PD=1.07U
M$3229 \$888 \$677 \$676 VSS nfet_03v3 L=0.28U W=0.36U AS=0.1278P AD=0.0567P
+ PS=1.07U PD=0.675U
M$3230 VSS \$631 \$888 VSS nfet_03v3 L=0.28U W=0.36U AS=0.0567P AD=0.1584P
+ PS=0.675U PD=1.6U
M$3231 VSS \$676 \$677 VSS nfet_03v3 L=0.28U W=0.36U AS=0.1584P AD=0.0972P
+ PS=1.6U PD=0.9U
M$3232 \$678 \$676 VSS VSS nfet_03v3 L=0.28U W=0.36U AS=0.0972P AD=0.18P
+ PS=0.9U PD=1.72U
M$3233 \$681 \$130 VSS VSS nfet_03v3 L=0.28U W=0.36U AS=0.1584P AD=0.1188P
+ PS=1.6U PD=1.02U
M$3234 \$682 \$630 \$681 VSS nfet_03v3 L=0.28U W=0.36U AS=0.1188P AD=0.1278P
+ PS=1.02U PD=1.07U
M$3235 \$896 \$683 \$682 VSS nfet_03v3 L=0.28U W=0.36U AS=0.1278P AD=0.0567P
+ PS=1.07U PD=0.675U
M$3236 VSS \$631 \$896 VSS nfet_03v3 L=0.28U W=0.36U AS=0.0567P AD=0.1584P
+ PS=0.675U PD=1.6U
M$3237 VSS \$682 \$683 VSS nfet_03v3 L=0.28U W=0.36U AS=0.1584P AD=0.0972P
+ PS=1.6U PD=0.9U
M$3238 \$684 \$682 VSS VSS nfet_03v3 L=0.28U W=0.36U AS=0.0972P AD=0.18P
+ PS=0.9U PD=1.72U
M$3239 \$687 \$133 VSS VSS nfet_03v3 L=0.28U W=0.36U AS=0.1584P AD=0.1188P
+ PS=1.6U PD=1.02U
M$3240 \$688 \$630 \$687 VSS nfet_03v3 L=0.28U W=0.36U AS=0.1188P AD=0.1278P
+ PS=1.02U PD=1.07U
M$3241 \$902 \$689 \$688 VSS nfet_03v3 L=0.28U W=0.36U AS=0.1278P AD=0.0567P
+ PS=1.07U PD=0.675U
M$3242 VSS \$631 \$902 VSS nfet_03v3 L=0.28U W=0.36U AS=0.0567P AD=0.1584P
+ PS=0.675U PD=1.6U
M$3243 VSS \$688 \$689 VSS nfet_03v3 L=0.28U W=0.36U AS=0.1584P AD=0.0972P
+ PS=1.6U PD=0.9U
M$3244 \$690 \$688 VSS VSS nfet_03v3 L=0.28U W=0.36U AS=0.0972P AD=0.18P
+ PS=0.9U PD=1.72U
M$3245 \$693 \$136 VSS VSS nfet_03v3 L=0.28U W=0.36U AS=0.1584P AD=0.1188P
+ PS=1.6U PD=1.02U
M$3246 \$694 \$630 \$693 VSS nfet_03v3 L=0.28U W=0.36U AS=0.1188P AD=0.1278P
+ PS=1.02U PD=1.07U
M$3247 \$910 \$695 \$694 VSS nfet_03v3 L=0.28U W=0.36U AS=0.1278P AD=0.0567P
+ PS=1.07U PD=0.675U
M$3248 VSS \$631 \$910 VSS nfet_03v3 L=0.28U W=0.36U AS=0.0567P AD=0.1584P
+ PS=0.675U PD=1.6U
M$3249 VSS \$694 \$695 VSS nfet_03v3 L=0.28U W=0.36U AS=0.1584P AD=0.0972P
+ PS=1.6U PD=0.9U
M$3250 \$696 \$694 VSS VSS nfet_03v3 L=0.28U W=0.36U AS=0.0972P AD=0.18P
+ PS=0.9U PD=1.72U
M$3251 \$699 \$139 VSS VSS nfet_03v3 L=0.28U W=0.36U AS=0.1584P AD=0.1188P
+ PS=1.6U PD=1.02U
M$3252 \$700 \$630 \$699 VSS nfet_03v3 L=0.28U W=0.36U AS=0.1188P AD=0.1278P
+ PS=1.02U PD=1.07U
M$3253 \$917 \$701 \$700 VSS nfet_03v3 L=0.28U W=0.36U AS=0.1278P AD=0.0567P
+ PS=1.07U PD=0.675U
M$3254 VSS \$631 \$917 VSS nfet_03v3 L=0.28U W=0.36U AS=0.0567P AD=0.1584P
+ PS=0.675U PD=1.6U
M$3255 VSS \$700 \$701 VSS nfet_03v3 L=0.28U W=0.36U AS=0.1584P AD=0.0972P
+ PS=1.6U PD=0.9U
M$3256 \$702 \$700 VSS VSS nfet_03v3 L=0.28U W=0.36U AS=0.0972P AD=0.18P
+ PS=0.9U PD=1.72U
M$3257 \$705 \$142 VSS VSS nfet_03v3 L=0.28U W=0.36U AS=0.1584P AD=0.1188P
+ PS=1.6U PD=1.02U
M$3258 \$706 \$630 \$705 VSS nfet_03v3 L=0.28U W=0.36U AS=0.1188P AD=0.1278P
+ PS=1.02U PD=1.07U
M$3259 \$924 \$707 \$706 VSS nfet_03v3 L=0.28U W=0.36U AS=0.1278P AD=0.0567P
+ PS=1.07U PD=0.675U
M$3260 VSS \$631 \$924 VSS nfet_03v3 L=0.28U W=0.36U AS=0.0567P AD=0.1584P
+ PS=0.675U PD=1.6U
M$3261 VSS \$706 \$707 VSS nfet_03v3 L=0.28U W=0.36U AS=0.1584P AD=0.0972P
+ PS=1.6U PD=0.9U
M$3262 \$708 \$706 VSS VSS nfet_03v3 L=0.28U W=0.36U AS=0.0972P AD=0.18P
+ PS=0.9U PD=1.72U
M$3263 \$711 \$145 VSS VSS nfet_03v3 L=0.28U W=0.36U AS=0.1584P AD=0.1188P
+ PS=1.6U PD=1.02U
M$3264 \$712 \$630 \$711 VSS nfet_03v3 L=0.28U W=0.36U AS=0.1188P AD=0.1278P
+ PS=1.02U PD=1.07U
M$3265 \$929 \$713 \$712 VSS nfet_03v3 L=0.28U W=0.36U AS=0.1278P AD=0.0567P
+ PS=1.07U PD=0.675U
M$3266 VSS \$631 \$929 VSS nfet_03v3 L=0.28U W=0.36U AS=0.0567P AD=0.1584P
+ PS=0.675U PD=1.6U
M$3267 VSS \$712 \$713 VSS nfet_03v3 L=0.28U W=0.36U AS=0.1584P AD=0.0972P
+ PS=1.6U PD=0.9U
M$3268 \$714 \$712 VSS VSS nfet_03v3 L=0.28U W=0.36U AS=0.0972P AD=0.18P
+ PS=0.9U PD=1.72U
M$3269 \$717 \$148 VSS VSS nfet_03v3 L=0.28U W=0.36U AS=0.1584P AD=0.1188P
+ PS=1.6U PD=1.02U
M$3270 \$718 \$630 \$717 VSS nfet_03v3 L=0.28U W=0.36U AS=0.1188P AD=0.1278P
+ PS=1.02U PD=1.07U
M$3271 \$894 \$719 \$718 VSS nfet_03v3 L=0.28U W=0.36U AS=0.1278P AD=0.0567P
+ PS=1.07U PD=0.675U
M$3272 VSS \$631 \$894 VSS nfet_03v3 L=0.28U W=0.36U AS=0.0567P AD=0.1584P
+ PS=0.675U PD=1.6U
M$3273 VSS \$718 \$719 VSS nfet_03v3 L=0.28U W=0.36U AS=0.1584P AD=0.0972P
+ PS=1.6U PD=0.9U
M$3274 \$720 \$718 VSS VSS nfet_03v3 L=0.28U W=0.36U AS=0.0972P AD=0.18P
+ PS=0.9U PD=1.72U
M$3275 \$723 \$151 VSS VSS nfet_03v3 L=0.28U W=0.36U AS=0.1584P AD=0.1188P
+ PS=1.6U PD=1.02U
M$3276 \$724 \$630 \$723 VSS nfet_03v3 L=0.28U W=0.36U AS=0.1188P AD=0.1278P
+ PS=1.02U PD=1.07U
M$3277 \$859 \$725 \$724 VSS nfet_03v3 L=0.28U W=0.36U AS=0.1278P AD=0.0567P
+ PS=1.07U PD=0.675U
M$3278 VSS \$631 \$859 VSS nfet_03v3 L=0.28U W=0.36U AS=0.0567P AD=0.1584P
+ PS=0.675U PD=1.6U
M$3279 VSS \$724 \$725 VSS nfet_03v3 L=0.28U W=0.36U AS=0.1584P AD=0.0972P
+ PS=1.6U PD=0.9U
M$3280 \$726 \$724 VSS VSS nfet_03v3 L=0.28U W=0.36U AS=0.0972P AD=0.18P
+ PS=0.9U PD=1.72U
M$3281 \$1090 WE13 VSS VSS nfet_03v3 L=0.28U W=0.72U AS=0.3168P AD=0.1872P
+ PS=2.32U PD=1.24U
M$3282 \$948 CLK \$1090 VSS nfet_03v3 L=0.28U W=0.72U AS=0.1872P AD=0.3168P
+ PS=1.24U PD=2.32U
M$3283 \$949 \$948 VSS VSS nfet_03v3 L=0.28U W=1.27U AS=0.4445P AD=0.3344P
+ PS=3.305U PD=2.345U
M$3285 \$1142 \$949 VSS VSS nfet_03v3 L=0.28U W=1.34U AS=0.3636P AD=0.4891P
+ PS=2.44U PD=3.47U
M$3287 \$950 \$106 VSS VSS nfet_03v3 L=0.28U W=0.36U AS=0.1584P AD=0.1188P
+ PS=1.6U PD=1.02U
M$3288 \$951 \$949 \$950 VSS nfet_03v3 L=0.28U W=0.36U AS=0.1188P AD=0.1278P
+ PS=1.02U PD=1.07U
M$3289 \$988 \$1040 \$951 VSS nfet_03v3 L=0.28U W=0.36U AS=0.1278P AD=0.0567P
+ PS=1.07U PD=0.675U
M$3290 VSS \$1142 \$988 VSS nfet_03v3 L=0.28U W=0.36U AS=0.0567P AD=0.1584P
+ PS=0.675U PD=1.6U
M$3291 VSS \$951 \$1040 VSS nfet_03v3 L=0.28U W=0.36U AS=0.1584P AD=0.0972P
+ PS=1.6U PD=0.9U
M$3292 \$932 \$951 VSS VSS nfet_03v3 L=0.28U W=0.36U AS=0.0972P AD=0.18P
+ PS=0.9U PD=1.72U
M$3293 \$952 \$109 VSS VSS nfet_03v3 L=0.28U W=0.36U AS=0.1584P AD=0.1188P
+ PS=1.6U PD=1.02U
M$3294 \$953 \$949 \$952 VSS nfet_03v3 L=0.28U W=0.36U AS=0.1188P AD=0.1278P
+ PS=1.02U PD=1.07U
M$3295 \$999 \$1044 \$953 VSS nfet_03v3 L=0.28U W=0.36U AS=0.1278P AD=0.0567P
+ PS=1.07U PD=0.675U
M$3296 VSS \$1142 \$999 VSS nfet_03v3 L=0.28U W=0.36U AS=0.0567P AD=0.1584P
+ PS=0.675U PD=1.6U
M$3297 VSS \$953 \$1044 VSS nfet_03v3 L=0.28U W=0.36U AS=0.1584P AD=0.0972P
+ PS=1.6U PD=0.9U
M$3298 \$933 \$953 VSS VSS nfet_03v3 L=0.28U W=0.36U AS=0.0972P AD=0.18P
+ PS=0.9U PD=1.72U
M$3299 \$954 \$112 VSS VSS nfet_03v3 L=0.28U W=0.36U AS=0.1584P AD=0.1188P
+ PS=1.6U PD=1.02U
M$3300 \$955 \$949 \$954 VSS nfet_03v3 L=0.28U W=0.36U AS=0.1188P AD=0.1278P
+ PS=1.02U PD=1.07U
M$3301 \$1008 \$1047 \$955 VSS nfet_03v3 L=0.28U W=0.36U AS=0.1278P AD=0.0567P
+ PS=1.07U PD=0.675U
M$3302 VSS \$1142 \$1008 VSS nfet_03v3 L=0.28U W=0.36U AS=0.0567P AD=0.1584P
+ PS=0.675U PD=1.6U
M$3303 VSS \$955 \$1047 VSS nfet_03v3 L=0.28U W=0.36U AS=0.1584P AD=0.0972P
+ PS=1.6U PD=0.9U
M$3304 \$934 \$955 VSS VSS nfet_03v3 L=0.28U W=0.36U AS=0.0972P AD=0.18P
+ PS=0.9U PD=1.72U
M$3305 \$956 \$115 VSS VSS nfet_03v3 L=0.28U W=0.36U AS=0.1584P AD=0.1188P
+ PS=1.6U PD=1.02U
M$3306 \$957 \$949 \$956 VSS nfet_03v3 L=0.28U W=0.36U AS=0.1188P AD=0.1278P
+ PS=1.02U PD=1.07U
M$3307 \$1018 \$1050 \$957 VSS nfet_03v3 L=0.28U W=0.36U AS=0.1278P AD=0.0567P
+ PS=1.07U PD=0.675U
M$3308 VSS \$1142 \$1018 VSS nfet_03v3 L=0.28U W=0.36U AS=0.0567P AD=0.1584P
+ PS=0.675U PD=1.6U
M$3309 VSS \$957 \$1050 VSS nfet_03v3 L=0.28U W=0.36U AS=0.1584P AD=0.0972P
+ PS=1.6U PD=0.9U
M$3310 \$935 \$957 VSS VSS nfet_03v3 L=0.28U W=0.36U AS=0.0972P AD=0.18P
+ PS=0.9U PD=1.72U
M$3311 \$958 \$118 VSS VSS nfet_03v3 L=0.28U W=0.36U AS=0.1584P AD=0.1188P
+ PS=1.6U PD=1.02U
M$3312 \$959 \$949 \$958 VSS nfet_03v3 L=0.28U W=0.36U AS=0.1188P AD=0.1278P
+ PS=1.02U PD=1.07U
M$3313 \$1029 \$1053 \$959 VSS nfet_03v3 L=0.28U W=0.36U AS=0.1278P AD=0.0567P
+ PS=1.07U PD=0.675U
M$3314 VSS \$1142 \$1029 VSS nfet_03v3 L=0.28U W=0.36U AS=0.0567P AD=0.1584P
+ PS=0.675U PD=1.6U
M$3315 VSS \$959 \$1053 VSS nfet_03v3 L=0.28U W=0.36U AS=0.1584P AD=0.0972P
+ PS=1.6U PD=0.9U
M$3316 \$936 \$959 VSS VSS nfet_03v3 L=0.28U W=0.36U AS=0.0972P AD=0.18P
+ PS=0.9U PD=1.72U
M$3317 \$960 \$121 VSS VSS nfet_03v3 L=0.28U W=0.36U AS=0.1584P AD=0.1188P
+ PS=1.6U PD=1.02U
M$3318 \$961 \$949 \$960 VSS nfet_03v3 L=0.28U W=0.36U AS=0.1188P AD=0.1278P
+ PS=1.02U PD=1.07U
M$3319 \$1034 \$1056 \$961 VSS nfet_03v3 L=0.28U W=0.36U AS=0.1278P AD=0.0567P
+ PS=1.07U PD=0.675U
M$3320 VSS \$1142 \$1034 VSS nfet_03v3 L=0.28U W=0.36U AS=0.0567P AD=0.1584P
+ PS=0.675U PD=1.6U
M$3321 VSS \$961 \$1056 VSS nfet_03v3 L=0.28U W=0.36U AS=0.1584P AD=0.0972P
+ PS=1.6U PD=0.9U
M$3322 \$937 \$961 VSS VSS nfet_03v3 L=0.28U W=0.36U AS=0.0972P AD=0.18P
+ PS=0.9U PD=1.72U
M$3323 \$962 \$124 VSS VSS nfet_03v3 L=0.28U W=0.36U AS=0.1584P AD=0.1188P
+ PS=1.6U PD=1.02U
M$3324 \$963 \$949 \$962 VSS nfet_03v3 L=0.28U W=0.36U AS=0.1188P AD=0.1278P
+ PS=1.02U PD=1.07U
M$3325 \$1030 \$1059 \$963 VSS nfet_03v3 L=0.28U W=0.36U AS=0.1278P AD=0.0567P
+ PS=1.07U PD=0.675U
M$3326 VSS \$1142 \$1030 VSS nfet_03v3 L=0.28U W=0.36U AS=0.0567P AD=0.1584P
+ PS=0.675U PD=1.6U
M$3327 VSS \$963 \$1059 VSS nfet_03v3 L=0.28U W=0.36U AS=0.1584P AD=0.0972P
+ PS=1.6U PD=0.9U
M$3328 \$938 \$963 VSS VSS nfet_03v3 L=0.28U W=0.36U AS=0.0972P AD=0.18P
+ PS=0.9U PD=1.72U
M$3329 \$964 \$127 VSS VSS nfet_03v3 L=0.28U W=0.36U AS=0.1584P AD=0.1188P
+ PS=1.6U PD=1.02U
M$3330 \$965 \$949 \$964 VSS nfet_03v3 L=0.28U W=0.36U AS=0.1188P AD=0.1278P
+ PS=1.02U PD=1.07U
M$3331 \$1023 \$1062 \$965 VSS nfet_03v3 L=0.28U W=0.36U AS=0.1278P AD=0.0567P
+ PS=1.07U PD=0.675U
M$3332 VSS \$1142 \$1023 VSS nfet_03v3 L=0.28U W=0.36U AS=0.0567P AD=0.1584P
+ PS=0.675U PD=1.6U
M$3333 VSS \$965 \$1062 VSS nfet_03v3 L=0.28U W=0.36U AS=0.1584P AD=0.0972P
+ PS=1.6U PD=0.9U
M$3334 \$939 \$965 VSS VSS nfet_03v3 L=0.28U W=0.36U AS=0.0972P AD=0.18P
+ PS=0.9U PD=1.72U
M$3335 \$966 \$130 VSS VSS nfet_03v3 L=0.28U W=0.36U AS=0.1584P AD=0.1188P
+ PS=1.6U PD=1.02U
M$3336 \$967 \$949 \$966 VSS nfet_03v3 L=0.28U W=0.36U AS=0.1188P AD=0.1278P
+ PS=1.02U PD=1.07U
M$3337 \$1020 \$1065 \$967 VSS nfet_03v3 L=0.28U W=0.36U AS=0.1278P AD=0.0567P
+ PS=1.07U PD=0.675U
M$3338 VSS \$1142 \$1020 VSS nfet_03v3 L=0.28U W=0.36U AS=0.0567P AD=0.1584P
+ PS=0.675U PD=1.6U
M$3339 VSS \$967 \$1065 VSS nfet_03v3 L=0.28U W=0.36U AS=0.1584P AD=0.0972P
+ PS=1.6U PD=0.9U
M$3340 \$940 \$967 VSS VSS nfet_03v3 L=0.28U W=0.36U AS=0.0972P AD=0.18P
+ PS=0.9U PD=1.72U
M$3341 \$968 \$133 VSS VSS nfet_03v3 L=0.28U W=0.36U AS=0.1584P AD=0.1188P
+ PS=1.6U PD=1.02U
M$3342 \$969 \$949 \$968 VSS nfet_03v3 L=0.28U W=0.36U AS=0.1188P AD=0.1278P
+ PS=1.02U PD=1.07U
M$3343 \$1015 \$1068 \$969 VSS nfet_03v3 L=0.28U W=0.36U AS=0.1278P AD=0.0567P
+ PS=1.07U PD=0.675U
M$3344 VSS \$1142 \$1015 VSS nfet_03v3 L=0.28U W=0.36U AS=0.0567P AD=0.1584P
+ PS=0.675U PD=1.6U
M$3345 VSS \$969 \$1068 VSS nfet_03v3 L=0.28U W=0.36U AS=0.1584P AD=0.0972P
+ PS=1.6U PD=0.9U
M$3346 \$941 \$969 VSS VSS nfet_03v3 L=0.28U W=0.36U AS=0.0972P AD=0.18P
+ PS=0.9U PD=1.72U
M$3347 \$970 \$136 VSS VSS nfet_03v3 L=0.28U W=0.36U AS=0.1584P AD=0.1188P
+ PS=1.6U PD=1.02U
M$3348 \$971 \$949 \$970 VSS nfet_03v3 L=0.28U W=0.36U AS=0.1188P AD=0.1278P
+ PS=1.02U PD=1.07U
M$3349 \$1009 \$1071 \$971 VSS nfet_03v3 L=0.28U W=0.36U AS=0.1278P AD=0.0567P
+ PS=1.07U PD=0.675U
M$3350 VSS \$1142 \$1009 VSS nfet_03v3 L=0.28U W=0.36U AS=0.0567P AD=0.1584P
+ PS=0.675U PD=1.6U
M$3351 VSS \$971 \$1071 VSS nfet_03v3 L=0.28U W=0.36U AS=0.1584P AD=0.0972P
+ PS=1.6U PD=0.9U
M$3352 \$942 \$971 VSS VSS nfet_03v3 L=0.28U W=0.36U AS=0.0972P AD=0.18P
+ PS=0.9U PD=1.72U
M$3353 \$972 \$139 VSS VSS nfet_03v3 L=0.28U W=0.36U AS=0.1584P AD=0.1188P
+ PS=1.6U PD=1.02U
M$3354 \$973 \$949 \$972 VSS nfet_03v3 L=0.28U W=0.36U AS=0.1188P AD=0.1278P
+ PS=1.02U PD=1.07U
M$3355 \$1005 \$1074 \$973 VSS nfet_03v3 L=0.28U W=0.36U AS=0.1278P AD=0.0567P
+ PS=1.07U PD=0.675U
M$3356 VSS \$1142 \$1005 VSS nfet_03v3 L=0.28U W=0.36U AS=0.0567P AD=0.1584P
+ PS=0.675U PD=1.6U
M$3357 VSS \$973 \$1074 VSS nfet_03v3 L=0.28U W=0.36U AS=0.1584P AD=0.0972P
+ PS=1.6U PD=0.9U
M$3358 \$943 \$973 VSS VSS nfet_03v3 L=0.28U W=0.36U AS=0.0972P AD=0.18P
+ PS=0.9U PD=1.72U
M$3359 \$974 \$142 VSS VSS nfet_03v3 L=0.28U W=0.36U AS=0.1584P AD=0.1188P
+ PS=1.6U PD=1.02U
M$3360 \$975 \$949 \$974 VSS nfet_03v3 L=0.28U W=0.36U AS=0.1188P AD=0.1278P
+ PS=1.02U PD=1.07U
M$3361 \$1001 \$1077 \$975 VSS nfet_03v3 L=0.28U W=0.36U AS=0.1278P AD=0.0567P
+ PS=1.07U PD=0.675U
M$3362 VSS \$1142 \$1001 VSS nfet_03v3 L=0.28U W=0.36U AS=0.0567P AD=0.1584P
+ PS=0.675U PD=1.6U
M$3363 VSS \$975 \$1077 VSS nfet_03v3 L=0.28U W=0.36U AS=0.1584P AD=0.0972P
+ PS=1.6U PD=0.9U
M$3364 \$944 \$975 VSS VSS nfet_03v3 L=0.28U W=0.36U AS=0.0972P AD=0.18P
+ PS=0.9U PD=1.72U
M$3365 \$976 \$145 VSS VSS nfet_03v3 L=0.28U W=0.36U AS=0.1584P AD=0.1188P
+ PS=1.6U PD=1.02U
M$3366 \$977 \$949 \$976 VSS nfet_03v3 L=0.28U W=0.36U AS=0.1188P AD=0.1278P
+ PS=1.02U PD=1.07U
M$3367 \$994 \$1080 \$977 VSS nfet_03v3 L=0.28U W=0.36U AS=0.1278P AD=0.0567P
+ PS=1.07U PD=0.675U
M$3368 VSS \$1142 \$994 VSS nfet_03v3 L=0.28U W=0.36U AS=0.0567P AD=0.1584P
+ PS=0.675U PD=1.6U
M$3369 VSS \$977 \$1080 VSS nfet_03v3 L=0.28U W=0.36U AS=0.1584P AD=0.0972P
+ PS=1.6U PD=0.9U
M$3370 \$945 \$977 VSS VSS nfet_03v3 L=0.28U W=0.36U AS=0.0972P AD=0.18P
+ PS=0.9U PD=1.72U
M$3371 \$978 \$148 VSS VSS nfet_03v3 L=0.28U W=0.36U AS=0.1584P AD=0.1188P
+ PS=1.6U PD=1.02U
M$3372 \$979 \$949 \$978 VSS nfet_03v3 L=0.28U W=0.36U AS=0.1188P AD=0.1278P
+ PS=1.02U PD=1.07U
M$3373 \$989 \$1083 \$979 VSS nfet_03v3 L=0.28U W=0.36U AS=0.1278P AD=0.0567P
+ PS=1.07U PD=0.675U
M$3374 VSS \$1142 \$989 VSS nfet_03v3 L=0.28U W=0.36U AS=0.0567P AD=0.1584P
+ PS=0.675U PD=1.6U
M$3375 VSS \$979 \$1083 VSS nfet_03v3 L=0.28U W=0.36U AS=0.1584P AD=0.0972P
+ PS=1.6U PD=0.9U
M$3376 \$946 \$979 VSS VSS nfet_03v3 L=0.28U W=0.36U AS=0.0972P AD=0.18P
+ PS=0.9U PD=1.72U
M$3377 \$980 \$151 VSS VSS nfet_03v3 L=0.28U W=0.36U AS=0.1584P AD=0.1188P
+ PS=1.6U PD=1.02U
M$3378 \$981 \$949 \$980 VSS nfet_03v3 L=0.28U W=0.36U AS=0.1188P AD=0.1278P
+ PS=1.02U PD=1.07U
M$3379 \$984 \$1086 \$981 VSS nfet_03v3 L=0.28U W=0.36U AS=0.1278P AD=0.0567P
+ PS=1.07U PD=0.675U
M$3380 VSS \$1142 \$984 VSS nfet_03v3 L=0.28U W=0.36U AS=0.0567P AD=0.1584P
+ PS=0.675U PD=1.6U
M$3381 VSS \$981 \$1086 VSS nfet_03v3 L=0.28U W=0.36U AS=0.1584P AD=0.0972P
+ PS=1.6U PD=0.9U
M$3382 \$947 \$981 VSS VSS nfet_03v3 L=0.28U W=0.36U AS=0.0972P AD=0.18P
+ PS=0.9U PD=1.72U
M$3383 \$1256 RB12 VSS VSS nfet_03v3 L=0.28U W=0.36U AS=0.1656P AD=0.1944P
+ PS=1.64U PD=1.8U
M$3384 \$1042 RA13 VSS VSS nfet_03v3 L=0.28U W=0.36U AS=0.1656P AD=0.1944P
+ PS=1.64U PD=1.8U
M$3385 \$1254 RB12 \$51 VSS nfet_03v3 L=0.28U W=0.36U AS=0.1584P AD=0.1152P
+ PS=1.6U PD=1U
M$3386 \$52 RA12 \$1254 VSS nfet_03v3 L=0.28U W=0.36U AS=0.1152P AD=0.1584P
+ PS=1U PD=1.6U
M$3387 \$932 RA13 \$51 VSS nfet_03v3 L=0.28U W=0.36U AS=0.1584P AD=0.1152P
+ PS=1.6U PD=1U
M$3388 \$52 RB13 \$932 VSS nfet_03v3 L=0.28U W=0.36U AS=0.1152P AD=0.1584P
+ PS=1U PD=1.6U
M$3389 VSS RB13 \$1043 VSS nfet_03v3 L=0.28U W=0.36U AS=0.1854P AD=0.1584P
+ PS=1.75U PD=1.6U
M$3390 VSS RA12 \$1257 VSS nfet_03v3 L=0.28U W=0.36U AS=0.1854P AD=0.1584P
+ PS=1.75U PD=1.6U
M$3391 \$1262 RB12 VSS VSS nfet_03v3 L=0.28U W=0.36U AS=0.1656P AD=0.1944P
+ PS=1.64U PD=1.8U
M$3392 \$1045 RA13 VSS VSS nfet_03v3 L=0.28U W=0.36U AS=0.1656P AD=0.1944P
+ PS=1.64U PD=1.8U
M$3393 \$1261 RB12 \$53 VSS nfet_03v3 L=0.28U W=0.36U AS=0.1584P AD=0.1152P
+ PS=1.6U PD=1U
M$3394 \$54 RA12 \$1261 VSS nfet_03v3 L=0.28U W=0.36U AS=0.1152P AD=0.1584P
+ PS=1U PD=1.6U
M$3395 \$933 RA13 \$53 VSS nfet_03v3 L=0.28U W=0.36U AS=0.1584P AD=0.1152P
+ PS=1.6U PD=1U
M$3396 \$54 RB13 \$933 VSS nfet_03v3 L=0.28U W=0.36U AS=0.1152P AD=0.1584P
+ PS=1U PD=1.6U
M$3397 VSS RB13 \$1046 VSS nfet_03v3 L=0.28U W=0.36U AS=0.1854P AD=0.1584P
+ PS=1.75U PD=1.6U
M$3398 VSS RA12 \$1263 VSS nfet_03v3 L=0.28U W=0.36U AS=0.1854P AD=0.1584P
+ PS=1.75U PD=1.6U
M$3399 \$1048 RA13 VSS VSS nfet_03v3 L=0.28U W=0.36U AS=0.1656P AD=0.1944P
+ PS=1.64U PD=1.8U
M$3400 \$1268 RB12 VSS VSS nfet_03v3 L=0.28U W=0.36U AS=0.1656P AD=0.1944P
+ PS=1.64U PD=1.8U
M$3401 \$1267 RB12 \$55 VSS nfet_03v3 L=0.28U W=0.36U AS=0.1584P AD=0.1152P
+ PS=1.6U PD=1U
M$3402 \$56 RA12 \$1267 VSS nfet_03v3 L=0.28U W=0.36U AS=0.1152P AD=0.1584P
+ PS=1U PD=1.6U
M$3403 \$934 RA13 \$55 VSS nfet_03v3 L=0.28U W=0.36U AS=0.1584P AD=0.1152P
+ PS=1.6U PD=1U
M$3404 \$56 RB13 \$934 VSS nfet_03v3 L=0.28U W=0.36U AS=0.1152P AD=0.1584P
+ PS=1U PD=1.6U
M$3405 VSS RB13 \$1049 VSS nfet_03v3 L=0.28U W=0.36U AS=0.1854P AD=0.1584P
+ PS=1.75U PD=1.6U
M$3406 VSS RA12 \$1269 VSS nfet_03v3 L=0.28U W=0.36U AS=0.1854P AD=0.1584P
+ PS=1.75U PD=1.6U
M$3407 \$1274 RB12 VSS VSS nfet_03v3 L=0.28U W=0.36U AS=0.1656P AD=0.1944P
+ PS=1.64U PD=1.8U
M$3408 \$1051 RA13 VSS VSS nfet_03v3 L=0.28U W=0.36U AS=0.1656P AD=0.1944P
+ PS=1.64U PD=1.8U
M$3409 \$935 RA13 \$57 VSS nfet_03v3 L=0.28U W=0.36U AS=0.1584P AD=0.1152P
+ PS=1.6U PD=1U
M$3410 \$58 RB13 \$935 VSS nfet_03v3 L=0.28U W=0.36U AS=0.1152P AD=0.1584P
+ PS=1U PD=1.6U
M$3411 \$1273 RB12 \$57 VSS nfet_03v3 L=0.28U W=0.36U AS=0.1584P AD=0.1152P
+ PS=1.6U PD=1U
M$3412 \$58 RA12 \$1273 VSS nfet_03v3 L=0.28U W=0.36U AS=0.1152P AD=0.1584P
+ PS=1U PD=1.6U
M$3413 VSS RB13 \$1052 VSS nfet_03v3 L=0.28U W=0.36U AS=0.1854P AD=0.1584P
+ PS=1.75U PD=1.6U
M$3414 VSS RA12 \$1275 VSS nfet_03v3 L=0.28U W=0.36U AS=0.1854P AD=0.1584P
+ PS=1.75U PD=1.6U
M$3415 \$1054 RA13 VSS VSS nfet_03v3 L=0.28U W=0.36U AS=0.1656P AD=0.1944P
+ PS=1.64U PD=1.8U
M$3416 \$1280 RB12 VSS VSS nfet_03v3 L=0.28U W=0.36U AS=0.1656P AD=0.1944P
+ PS=1.64U PD=1.8U
M$3417 \$936 RA13 \$59 VSS nfet_03v3 L=0.28U W=0.36U AS=0.1584P AD=0.1152P
+ PS=1.6U PD=1U
M$3418 \$60 RB13 \$936 VSS nfet_03v3 L=0.28U W=0.36U AS=0.1152P AD=0.1584P
+ PS=1U PD=1.6U
M$3419 \$1279 RB12 \$59 VSS nfet_03v3 L=0.28U W=0.36U AS=0.1584P AD=0.1152P
+ PS=1.6U PD=1U
M$3420 \$60 RA12 \$1279 VSS nfet_03v3 L=0.28U W=0.36U AS=0.1152P AD=0.1584P
+ PS=1U PD=1.6U
M$3421 VSS RA12 \$1281 VSS nfet_03v3 L=0.28U W=0.36U AS=0.1854P AD=0.1584P
+ PS=1.75U PD=1.6U
M$3422 VSS RB13 \$1055 VSS nfet_03v3 L=0.28U W=0.36U AS=0.1854P AD=0.1584P
+ PS=1.75U PD=1.6U
M$3423 \$1057 RA13 VSS VSS nfet_03v3 L=0.28U W=0.36U AS=0.1656P AD=0.1944P
+ PS=1.64U PD=1.8U
M$3424 \$1286 RB12 VSS VSS nfet_03v3 L=0.28U W=0.36U AS=0.1656P AD=0.1944P
+ PS=1.64U PD=1.8U
M$3425 \$937 RA13 \$61 VSS nfet_03v3 L=0.28U W=0.36U AS=0.1584P AD=0.1152P
+ PS=1.6U PD=1U
M$3426 \$62 RB13 \$937 VSS nfet_03v3 L=0.28U W=0.36U AS=0.1152P AD=0.1584P
+ PS=1U PD=1.6U
M$3427 \$1285 RB12 \$61 VSS nfet_03v3 L=0.28U W=0.36U AS=0.1584P AD=0.1152P
+ PS=1.6U PD=1U
M$3428 \$62 RA12 \$1285 VSS nfet_03v3 L=0.28U W=0.36U AS=0.1152P AD=0.1584P
+ PS=1U PD=1.6U
M$3429 VSS RA12 \$1287 VSS nfet_03v3 L=0.28U W=0.36U AS=0.1854P AD=0.1584P
+ PS=1.75U PD=1.6U
M$3430 VSS RB13 \$1058 VSS nfet_03v3 L=0.28U W=0.36U AS=0.1854P AD=0.1584P
+ PS=1.75U PD=1.6U
M$3431 \$1292 RB12 VSS VSS nfet_03v3 L=0.28U W=0.36U AS=0.1656P AD=0.1944P
+ PS=1.64U PD=1.8U
M$3432 \$1060 RA13 VSS VSS nfet_03v3 L=0.28U W=0.36U AS=0.1656P AD=0.1944P
+ PS=1.64U PD=1.8U
M$3433 \$1291 RB12 \$63 VSS nfet_03v3 L=0.28U W=0.36U AS=0.1584P AD=0.1152P
+ PS=1.6U PD=1U
M$3434 \$64 RA12 \$1291 VSS nfet_03v3 L=0.28U W=0.36U AS=0.1152P AD=0.1584P
+ PS=1U PD=1.6U
M$3435 \$938 RA13 \$63 VSS nfet_03v3 L=0.28U W=0.36U AS=0.1584P AD=0.1152P
+ PS=1.6U PD=1U
M$3436 \$64 RB13 \$938 VSS nfet_03v3 L=0.28U W=0.36U AS=0.1152P AD=0.1584P
+ PS=1U PD=1.6U
M$3437 VSS RB13 \$1061 VSS nfet_03v3 L=0.28U W=0.36U AS=0.1854P AD=0.1584P
+ PS=1.75U PD=1.6U
M$3438 VSS RA12 \$1293 VSS nfet_03v3 L=0.28U W=0.36U AS=0.1854P AD=0.1584P
+ PS=1.75U PD=1.6U
M$3439 \$1298 RB12 VSS VSS nfet_03v3 L=0.28U W=0.36U AS=0.1656P AD=0.1944P
+ PS=1.64U PD=1.8U
M$3440 \$1063 RA13 VSS VSS nfet_03v3 L=0.28U W=0.36U AS=0.1656P AD=0.1944P
+ PS=1.64U PD=1.8U
M$3441 \$939 RA13 \$65 VSS nfet_03v3 L=0.28U W=0.36U AS=0.1584P AD=0.1152P
+ PS=1.6U PD=1U
M$3442 \$66 RB13 \$939 VSS nfet_03v3 L=0.28U W=0.36U AS=0.1152P AD=0.1584P
+ PS=1U PD=1.6U
M$3443 \$1297 RB12 \$65 VSS nfet_03v3 L=0.28U W=0.36U AS=0.1584P AD=0.1152P
+ PS=1.6U PD=1U
M$3444 \$66 RA12 \$1297 VSS nfet_03v3 L=0.28U W=0.36U AS=0.1152P AD=0.1584P
+ PS=1U PD=1.6U
M$3445 VSS RB13 \$1064 VSS nfet_03v3 L=0.28U W=0.36U AS=0.1854P AD=0.1584P
+ PS=1.75U PD=1.6U
M$3446 VSS RA12 \$1299 VSS nfet_03v3 L=0.28U W=0.36U AS=0.1854P AD=0.1584P
+ PS=1.75U PD=1.6U
M$3447 \$1304 RB12 VSS VSS nfet_03v3 L=0.28U W=0.36U AS=0.1656P AD=0.1944P
+ PS=1.64U PD=1.8U
M$3448 \$1066 RA13 VSS VSS nfet_03v3 L=0.28U W=0.36U AS=0.1656P AD=0.1944P
+ PS=1.64U PD=1.8U
M$3449 \$940 RA13 \$67 VSS nfet_03v3 L=0.28U W=0.36U AS=0.1584P AD=0.1152P
+ PS=1.6U PD=1U
M$3450 \$68 RB13 \$940 VSS nfet_03v3 L=0.28U W=0.36U AS=0.1152P AD=0.1584P
+ PS=1U PD=1.6U
M$3451 \$1303 RB12 \$67 VSS nfet_03v3 L=0.28U W=0.36U AS=0.1584P AD=0.1152P
+ PS=1.6U PD=1U
M$3452 \$68 RA12 \$1303 VSS nfet_03v3 L=0.28U W=0.36U AS=0.1152P AD=0.1584P
+ PS=1U PD=1.6U
M$3453 VSS RA12 \$1305 VSS nfet_03v3 L=0.28U W=0.36U AS=0.1854P AD=0.1584P
+ PS=1.75U PD=1.6U
M$3454 VSS RB13 \$1067 VSS nfet_03v3 L=0.28U W=0.36U AS=0.1854P AD=0.1584P
+ PS=1.75U PD=1.6U
M$3455 \$1069 RA13 VSS VSS nfet_03v3 L=0.28U W=0.36U AS=0.1656P AD=0.1944P
+ PS=1.64U PD=1.8U
M$3456 \$1310 RB12 VSS VSS nfet_03v3 L=0.28U W=0.36U AS=0.1656P AD=0.1944P
+ PS=1.64U PD=1.8U
M$3457 \$1309 RB12 \$69 VSS nfet_03v3 L=0.28U W=0.36U AS=0.1584P AD=0.1152P
+ PS=1.6U PD=1U
M$3458 \$70 RA12 \$1309 VSS nfet_03v3 L=0.28U W=0.36U AS=0.1152P AD=0.1584P
+ PS=1U PD=1.6U
M$3459 \$941 RA13 \$69 VSS nfet_03v3 L=0.28U W=0.36U AS=0.1584P AD=0.1152P
+ PS=1.6U PD=1U
M$3460 \$70 RB13 \$941 VSS nfet_03v3 L=0.28U W=0.36U AS=0.1152P AD=0.1584P
+ PS=1U PD=1.6U
M$3461 VSS RA12 \$1311 VSS nfet_03v3 L=0.28U W=0.36U AS=0.1854P AD=0.1584P
+ PS=1.75U PD=1.6U
M$3462 VSS RB13 \$1070 VSS nfet_03v3 L=0.28U W=0.36U AS=0.1854P AD=0.1584P
+ PS=1.75U PD=1.6U
M$3463 \$1072 RA13 VSS VSS nfet_03v3 L=0.28U W=0.36U AS=0.1656P AD=0.1944P
+ PS=1.64U PD=1.8U
M$3464 \$1316 RB12 VSS VSS nfet_03v3 L=0.28U W=0.36U AS=0.1656P AD=0.1944P
+ PS=1.64U PD=1.8U
M$3465 \$942 RA13 \$71 VSS nfet_03v3 L=0.28U W=0.36U AS=0.1584P AD=0.1152P
+ PS=1.6U PD=1U
M$3466 \$72 RB13 \$942 VSS nfet_03v3 L=0.28U W=0.36U AS=0.1152P AD=0.1584P
+ PS=1U PD=1.6U
M$3467 \$1315 RB12 \$71 VSS nfet_03v3 L=0.28U W=0.36U AS=0.1584P AD=0.1152P
+ PS=1.6U PD=1U
M$3468 \$72 RA12 \$1315 VSS nfet_03v3 L=0.28U W=0.36U AS=0.1152P AD=0.1584P
+ PS=1U PD=1.6U
M$3469 VSS RA12 \$1317 VSS nfet_03v3 L=0.28U W=0.36U AS=0.1854P AD=0.1584P
+ PS=1.75U PD=1.6U
M$3470 VSS RB13 \$1073 VSS nfet_03v3 L=0.28U W=0.36U AS=0.1854P AD=0.1584P
+ PS=1.75U PD=1.6U
M$3471 \$1075 RA13 VSS VSS nfet_03v3 L=0.28U W=0.36U AS=0.1656P AD=0.1944P
+ PS=1.64U PD=1.8U
M$3472 \$1322 RB12 VSS VSS nfet_03v3 L=0.28U W=0.36U AS=0.1656P AD=0.1944P
+ PS=1.64U PD=1.8U
M$3473 \$943 RA13 \$73 VSS nfet_03v3 L=0.28U W=0.36U AS=0.1584P AD=0.1152P
+ PS=1.6U PD=1U
M$3474 \$74 RB13 \$943 VSS nfet_03v3 L=0.28U W=0.36U AS=0.1152P AD=0.1584P
+ PS=1U PD=1.6U
M$3475 \$1321 RB12 \$73 VSS nfet_03v3 L=0.28U W=0.36U AS=0.1584P AD=0.1152P
+ PS=1.6U PD=1U
M$3476 \$74 RA12 \$1321 VSS nfet_03v3 L=0.28U W=0.36U AS=0.1152P AD=0.1584P
+ PS=1U PD=1.6U
M$3477 VSS RA12 \$1323 VSS nfet_03v3 L=0.28U W=0.36U AS=0.1854P AD=0.1584P
+ PS=1.75U PD=1.6U
M$3478 VSS RB13 \$1076 VSS nfet_03v3 L=0.28U W=0.36U AS=0.1854P AD=0.1584P
+ PS=1.75U PD=1.6U
M$3479 \$1078 RA13 VSS VSS nfet_03v3 L=0.28U W=0.36U AS=0.1656P AD=0.1944P
+ PS=1.64U PD=1.8U
M$3480 \$1328 RB12 VSS VSS nfet_03v3 L=0.28U W=0.36U AS=0.1656P AD=0.1944P
+ PS=1.64U PD=1.8U
M$3481 \$944 RA13 \$75 VSS nfet_03v3 L=0.28U W=0.36U AS=0.1584P AD=0.1152P
+ PS=1.6U PD=1U
M$3482 \$76 RB13 \$944 VSS nfet_03v3 L=0.28U W=0.36U AS=0.1152P AD=0.1584P
+ PS=1U PD=1.6U
M$3483 \$1327 RB12 \$75 VSS nfet_03v3 L=0.28U W=0.36U AS=0.1584P AD=0.1152P
+ PS=1.6U PD=1U
M$3484 \$76 RA12 \$1327 VSS nfet_03v3 L=0.28U W=0.36U AS=0.1152P AD=0.1584P
+ PS=1U PD=1.6U
M$3485 VSS RB13 \$1079 VSS nfet_03v3 L=0.28U W=0.36U AS=0.1854P AD=0.1584P
+ PS=1.75U PD=1.6U
M$3486 VSS RA12 \$1329 VSS nfet_03v3 L=0.28U W=0.36U AS=0.1854P AD=0.1584P
+ PS=1.75U PD=1.6U
M$3487 \$1334 RB12 VSS VSS nfet_03v3 L=0.28U W=0.36U AS=0.1656P AD=0.1944P
+ PS=1.64U PD=1.8U
M$3488 \$1081 RA13 VSS VSS nfet_03v3 L=0.28U W=0.36U AS=0.1656P AD=0.1944P
+ PS=1.64U PD=1.8U
M$3489 \$1333 RB12 \$77 VSS nfet_03v3 L=0.28U W=0.36U AS=0.1584P AD=0.1152P
+ PS=1.6U PD=1U
M$3490 \$78 RA12 \$1333 VSS nfet_03v3 L=0.28U W=0.36U AS=0.1152P AD=0.1584P
+ PS=1U PD=1.6U
M$3491 \$945 RA13 \$77 VSS nfet_03v3 L=0.28U W=0.36U AS=0.1584P AD=0.1152P
+ PS=1.6U PD=1U
M$3492 \$78 RB13 \$945 VSS nfet_03v3 L=0.28U W=0.36U AS=0.1152P AD=0.1584P
+ PS=1U PD=1.6U
M$3493 VSS RA12 \$1335 VSS nfet_03v3 L=0.28U W=0.36U AS=0.1854P AD=0.1584P
+ PS=1.75U PD=1.6U
M$3494 VSS RB13 \$1082 VSS nfet_03v3 L=0.28U W=0.36U AS=0.1854P AD=0.1584P
+ PS=1.75U PD=1.6U
M$3495 \$1340 RB12 VSS VSS nfet_03v3 L=0.28U W=0.36U AS=0.1656P AD=0.1944P
+ PS=1.64U PD=1.8U
M$3496 \$1084 RA13 VSS VSS nfet_03v3 L=0.28U W=0.36U AS=0.1656P AD=0.1944P
+ PS=1.64U PD=1.8U
M$3497 \$1339 RB12 \$79 VSS nfet_03v3 L=0.28U W=0.36U AS=0.1584P AD=0.1152P
+ PS=1.6U PD=1U
M$3498 \$80 RA12 \$1339 VSS nfet_03v3 L=0.28U W=0.36U AS=0.1152P AD=0.1584P
+ PS=1U PD=1.6U
M$3499 \$946 RA13 \$79 VSS nfet_03v3 L=0.28U W=0.36U AS=0.1584P AD=0.1152P
+ PS=1.6U PD=1U
M$3500 \$80 RB13 \$946 VSS nfet_03v3 L=0.28U W=0.36U AS=0.1152P AD=0.1584P
+ PS=1U PD=1.6U
M$3501 VSS RB13 \$1085 VSS nfet_03v3 L=0.28U W=0.36U AS=0.1854P AD=0.1584P
+ PS=1.75U PD=1.6U
M$3502 VSS RA12 \$1341 VSS nfet_03v3 L=0.28U W=0.36U AS=0.1854P AD=0.1584P
+ PS=1.75U PD=1.6U
M$3503 \$1087 RA13 VSS VSS nfet_03v3 L=0.28U W=0.36U AS=0.1656P AD=0.1944P
+ PS=1.64U PD=1.8U
M$3504 \$1346 RB12 VSS VSS nfet_03v3 L=0.28U W=0.36U AS=0.1656P AD=0.1944P
+ PS=1.64U PD=1.8U
M$3505 \$947 RA13 \$81 VSS nfet_03v3 L=0.28U W=0.36U AS=0.1584P AD=0.1152P
+ PS=1.6U PD=1U
M$3506 \$82 RB13 \$947 VSS nfet_03v3 L=0.28U W=0.36U AS=0.1152P AD=0.1584P
+ PS=1U PD=1.6U
M$3507 \$1345 RB12 \$81 VSS nfet_03v3 L=0.28U W=0.36U AS=0.1584P AD=0.1152P
+ PS=1.6U PD=1U
M$3508 \$82 RA12 \$1345 VSS nfet_03v3 L=0.28U W=0.36U AS=0.1152P AD=0.1584P
+ PS=1U PD=1.6U
M$3509 VSS RA12 \$1347 VSS nfet_03v3 L=0.28U W=0.36U AS=0.1854P AD=0.1584P
+ PS=1.75U PD=1.6U
M$3510 VSS RB13 \$1088 VSS nfet_03v3 L=0.28U W=0.36U AS=0.1854P AD=0.1584P
+ PS=1.75U PD=1.6U
M$3511 \$1452 WE12 VSS VSS nfet_03v3 L=0.28U W=0.72U AS=0.3168P AD=0.1872P
+ PS=2.32U PD=1.24U
M$3512 \$1248 CLK \$1452 VSS nfet_03v3 L=0.28U W=0.72U AS=0.1872P AD=0.3168P
+ PS=1.24U PD=2.32U
M$3513 \$1249 \$1248 VSS VSS nfet_03v3 L=0.28U W=1.27U AS=0.4487P AD=0.3302P
+ PS=3.34U PD=2.31U
M$3515 \$1250 \$1249 VSS VSS nfet_03v3 L=0.28U W=1.34U AS=0.3636P AD=0.4891P
+ PS=2.44U PD=3.47U
M$3517 \$1251 \$106 VSS VSS nfet_03v3 L=0.28U W=0.36U AS=0.1584P AD=0.1188P
+ PS=1.6U PD=1.02U
M$3518 \$1252 \$1249 \$1251 VSS nfet_03v3 L=0.28U W=0.36U AS=0.1188P AD=0.1278P
+ PS=1.02U PD=1.07U
M$3519 \$1457 \$1253 \$1252 VSS nfet_03v3 L=0.28U W=0.36U AS=0.1278P AD=0.0567P
+ PS=1.07U PD=0.675U
M$3520 VSS \$1250 \$1457 VSS nfet_03v3 L=0.28U W=0.36U AS=0.0567P AD=0.1584P
+ PS=0.675U PD=1.6U
M$3521 VSS \$1252 \$1253 VSS nfet_03v3 L=0.28U W=0.36U AS=0.1584P AD=0.0972P
+ PS=1.6U PD=0.9U
M$3522 \$1254 \$1252 VSS VSS nfet_03v3 L=0.28U W=0.36U AS=0.0972P AD=0.18P
+ PS=0.9U PD=1.72U
M$3523 \$1258 \$109 VSS VSS nfet_03v3 L=0.28U W=0.36U AS=0.1584P AD=0.1188P
+ PS=1.6U PD=1.02U
M$3524 \$1259 \$1249 \$1258 VSS nfet_03v3 L=0.28U W=0.36U AS=0.1188P AD=0.1278P
+ PS=1.02U PD=1.07U
M$3525 \$1464 \$1260 \$1259 VSS nfet_03v3 L=0.28U W=0.36U AS=0.1278P AD=0.0567P
+ PS=1.07U PD=0.675U
M$3526 VSS \$1250 \$1464 VSS nfet_03v3 L=0.28U W=0.36U AS=0.0567P AD=0.1584P
+ PS=0.675U PD=1.6U
M$3527 VSS \$1259 \$1260 VSS nfet_03v3 L=0.28U W=0.36U AS=0.1584P AD=0.0972P
+ PS=1.6U PD=0.9U
M$3528 \$1261 \$1259 VSS VSS nfet_03v3 L=0.28U W=0.36U AS=0.0972P AD=0.18P
+ PS=0.9U PD=1.72U
M$3529 \$1264 \$112 VSS VSS nfet_03v3 L=0.28U W=0.36U AS=0.1584P AD=0.1188P
+ PS=1.6U PD=1.02U
M$3530 \$1265 \$1249 \$1264 VSS nfet_03v3 L=0.28U W=0.36U AS=0.1188P AD=0.1278P
+ PS=1.02U PD=1.07U
M$3531 \$1471 \$1266 \$1265 VSS nfet_03v3 L=0.28U W=0.36U AS=0.1278P AD=0.0567P
+ PS=1.07U PD=0.675U
M$3532 VSS \$1250 \$1471 VSS nfet_03v3 L=0.28U W=0.36U AS=0.0567P AD=0.1584P
+ PS=0.675U PD=1.6U
M$3533 VSS \$1265 \$1266 VSS nfet_03v3 L=0.28U W=0.36U AS=0.1584P AD=0.0972P
+ PS=1.6U PD=0.9U
M$3534 \$1267 \$1265 VSS VSS nfet_03v3 L=0.28U W=0.36U AS=0.0972P AD=0.18P
+ PS=0.9U PD=1.72U
M$3535 \$1270 \$115 VSS VSS nfet_03v3 L=0.28U W=0.36U AS=0.1584P AD=0.1188P
+ PS=1.6U PD=1.02U
M$3536 \$1271 \$1249 \$1270 VSS nfet_03v3 L=0.28U W=0.36U AS=0.1188P AD=0.1278P
+ PS=1.02U PD=1.07U
M$3537 \$1479 \$1272 \$1271 VSS nfet_03v3 L=0.28U W=0.36U AS=0.1278P AD=0.0567P
+ PS=1.07U PD=0.675U
M$3538 VSS \$1250 \$1479 VSS nfet_03v3 L=0.28U W=0.36U AS=0.0567P AD=0.1584P
+ PS=0.675U PD=1.6U
M$3539 VSS \$1271 \$1272 VSS nfet_03v3 L=0.28U W=0.36U AS=0.1584P AD=0.0972P
+ PS=1.6U PD=0.9U
M$3540 \$1273 \$1271 VSS VSS nfet_03v3 L=0.28U W=0.36U AS=0.0972P AD=0.18P
+ PS=0.9U PD=1.72U
M$3541 \$1276 \$118 VSS VSS nfet_03v3 L=0.28U W=0.36U AS=0.1584P AD=0.1188P
+ PS=1.6U PD=1.02U
M$3542 \$1277 \$1249 \$1276 VSS nfet_03v3 L=0.28U W=0.36U AS=0.1188P AD=0.1278P
+ PS=1.02U PD=1.07U
M$3543 \$1485 \$1278 \$1277 VSS nfet_03v3 L=0.28U W=0.36U AS=0.1278P AD=0.0567P
+ PS=1.07U PD=0.675U
M$3544 VSS \$1250 \$1485 VSS nfet_03v3 L=0.28U W=0.36U AS=0.0567P AD=0.1584P
+ PS=0.675U PD=1.6U
M$3545 VSS \$1277 \$1278 VSS nfet_03v3 L=0.28U W=0.36U AS=0.1584P AD=0.0972P
+ PS=1.6U PD=0.9U
M$3546 \$1279 \$1277 VSS VSS nfet_03v3 L=0.28U W=0.36U AS=0.0972P AD=0.18P
+ PS=0.9U PD=1.72U
M$3547 \$1282 \$121 VSS VSS nfet_03v3 L=0.28U W=0.36U AS=0.1584P AD=0.1188P
+ PS=1.6U PD=1.02U
M$3548 \$1283 \$1249 \$1282 VSS nfet_03v3 L=0.28U W=0.36U AS=0.1188P AD=0.1278P
+ PS=1.02U PD=1.07U
M$3549 \$1493 \$1284 \$1283 VSS nfet_03v3 L=0.28U W=0.36U AS=0.1278P AD=0.0567P
+ PS=1.07U PD=0.675U
M$3550 VSS \$1250 \$1493 VSS nfet_03v3 L=0.28U W=0.36U AS=0.0567P AD=0.1584P
+ PS=0.675U PD=1.6U
M$3551 VSS \$1283 \$1284 VSS nfet_03v3 L=0.28U W=0.36U AS=0.1584P AD=0.0972P
+ PS=1.6U PD=0.9U
M$3552 \$1285 \$1283 VSS VSS nfet_03v3 L=0.28U W=0.36U AS=0.0972P AD=0.18P
+ PS=0.9U PD=1.72U
M$3553 \$1288 \$124 VSS VSS nfet_03v3 L=0.28U W=0.36U AS=0.1584P AD=0.1188P
+ PS=1.6U PD=1.02U
M$3554 \$1289 \$1249 \$1288 VSS nfet_03v3 L=0.28U W=0.36U AS=0.1188P AD=0.1278P
+ PS=1.02U PD=1.07U
M$3555 \$1500 \$1290 \$1289 VSS nfet_03v3 L=0.28U W=0.36U AS=0.1278P AD=0.0567P
+ PS=1.07U PD=0.675U
M$3556 VSS \$1250 \$1500 VSS nfet_03v3 L=0.28U W=0.36U AS=0.0567P AD=0.1584P
+ PS=0.675U PD=1.6U
M$3557 VSS \$1289 \$1290 VSS nfet_03v3 L=0.28U W=0.36U AS=0.1584P AD=0.0972P
+ PS=1.6U PD=0.9U
M$3558 \$1291 \$1289 VSS VSS nfet_03v3 L=0.28U W=0.36U AS=0.0972P AD=0.18P
+ PS=0.9U PD=1.72U
M$3559 \$1294 \$127 VSS VSS nfet_03v3 L=0.28U W=0.36U AS=0.1584P AD=0.1188P
+ PS=1.6U PD=1.02U
M$3560 \$1295 \$1249 \$1294 VSS nfet_03v3 L=0.28U W=0.36U AS=0.1188P AD=0.1278P
+ PS=1.02U PD=1.07U
M$3561 \$1507 \$1296 \$1295 VSS nfet_03v3 L=0.28U W=0.36U AS=0.1278P AD=0.0567P
+ PS=1.07U PD=0.675U
M$3562 VSS \$1250 \$1507 VSS nfet_03v3 L=0.28U W=0.36U AS=0.0567P AD=0.1584P
+ PS=0.675U PD=1.6U
M$3563 VSS \$1295 \$1296 VSS nfet_03v3 L=0.28U W=0.36U AS=0.1584P AD=0.0972P
+ PS=1.6U PD=0.9U
M$3564 \$1297 \$1295 VSS VSS nfet_03v3 L=0.28U W=0.36U AS=0.0972P AD=0.18P
+ PS=0.9U PD=1.72U
M$3565 \$1300 \$130 VSS VSS nfet_03v3 L=0.28U W=0.36U AS=0.1584P AD=0.1188P
+ PS=1.6U PD=1.02U
M$3566 \$1301 \$1249 \$1300 VSS nfet_03v3 L=0.28U W=0.36U AS=0.1188P AD=0.1278P
+ PS=1.02U PD=1.07U
M$3567 \$1515 \$1302 \$1301 VSS nfet_03v3 L=0.28U W=0.36U AS=0.1278P AD=0.0567P
+ PS=1.07U PD=0.675U
M$3568 VSS \$1250 \$1515 VSS nfet_03v3 L=0.28U W=0.36U AS=0.0567P AD=0.1584P
+ PS=0.675U PD=1.6U
M$3569 VSS \$1301 \$1302 VSS nfet_03v3 L=0.28U W=0.36U AS=0.1584P AD=0.0972P
+ PS=1.6U PD=0.9U
M$3570 \$1303 \$1301 VSS VSS nfet_03v3 L=0.28U W=0.36U AS=0.0972P AD=0.18P
+ PS=0.9U PD=1.72U
M$3571 \$1306 \$133 VSS VSS nfet_03v3 L=0.28U W=0.36U AS=0.1584P AD=0.1188P
+ PS=1.6U PD=1.02U
M$3572 \$1307 \$1249 \$1306 VSS nfet_03v3 L=0.28U W=0.36U AS=0.1188P AD=0.1278P
+ PS=1.02U PD=1.07U
M$3573 \$1521 \$1308 \$1307 VSS nfet_03v3 L=0.28U W=0.36U AS=0.1278P AD=0.0567P
+ PS=1.07U PD=0.675U
M$3574 VSS \$1250 \$1521 VSS nfet_03v3 L=0.28U W=0.36U AS=0.0567P AD=0.1584P
+ PS=0.675U PD=1.6U
M$3575 VSS \$1307 \$1308 VSS nfet_03v3 L=0.28U W=0.36U AS=0.1584P AD=0.0972P
+ PS=1.6U PD=0.9U
M$3576 \$1309 \$1307 VSS VSS nfet_03v3 L=0.28U W=0.36U AS=0.0972P AD=0.18P
+ PS=0.9U PD=1.72U
M$3577 \$1312 \$136 VSS VSS nfet_03v3 L=0.28U W=0.36U AS=0.1584P AD=0.1188P
+ PS=1.6U PD=1.02U
M$3578 \$1313 \$1249 \$1312 VSS nfet_03v3 L=0.28U W=0.36U AS=0.1188P AD=0.1278P
+ PS=1.02U PD=1.07U
M$3579 \$1529 \$1314 \$1313 VSS nfet_03v3 L=0.28U W=0.36U AS=0.1278P AD=0.0567P
+ PS=1.07U PD=0.675U
M$3580 VSS \$1250 \$1529 VSS nfet_03v3 L=0.28U W=0.36U AS=0.0567P AD=0.1584P
+ PS=0.675U PD=1.6U
M$3581 VSS \$1313 \$1314 VSS nfet_03v3 L=0.28U W=0.36U AS=0.1584P AD=0.0972P
+ PS=1.6U PD=0.9U
M$3582 \$1315 \$1313 VSS VSS nfet_03v3 L=0.28U W=0.36U AS=0.0972P AD=0.18P
+ PS=0.9U PD=1.72U
M$3583 \$1318 \$139 VSS VSS nfet_03v3 L=0.28U W=0.36U AS=0.1584P AD=0.1188P
+ PS=1.6U PD=1.02U
M$3584 \$1319 \$1249 \$1318 VSS nfet_03v3 L=0.28U W=0.36U AS=0.1188P AD=0.1278P
+ PS=1.02U PD=1.07U
M$3585 \$1536 \$1320 \$1319 VSS nfet_03v3 L=0.28U W=0.36U AS=0.1278P AD=0.0567P
+ PS=1.07U PD=0.675U
M$3586 VSS \$1250 \$1536 VSS nfet_03v3 L=0.28U W=0.36U AS=0.0567P AD=0.1584P
+ PS=0.675U PD=1.6U
M$3587 VSS \$1319 \$1320 VSS nfet_03v3 L=0.28U W=0.36U AS=0.1584P AD=0.0972P
+ PS=1.6U PD=0.9U
M$3588 \$1321 \$1319 VSS VSS nfet_03v3 L=0.28U W=0.36U AS=0.0972P AD=0.18P
+ PS=0.9U PD=1.72U
M$3589 \$1324 \$142 VSS VSS nfet_03v3 L=0.28U W=0.36U AS=0.1584P AD=0.1188P
+ PS=1.6U PD=1.02U
M$3590 \$1325 \$1249 \$1324 VSS nfet_03v3 L=0.28U W=0.36U AS=0.1188P AD=0.1278P
+ PS=1.02U PD=1.07U
M$3591 \$1543 \$1326 \$1325 VSS nfet_03v3 L=0.28U W=0.36U AS=0.1278P AD=0.0567P
+ PS=1.07U PD=0.675U
M$3592 VSS \$1250 \$1543 VSS nfet_03v3 L=0.28U W=0.36U AS=0.0567P AD=0.1584P
+ PS=0.675U PD=1.6U
M$3593 VSS \$1325 \$1326 VSS nfet_03v3 L=0.28U W=0.36U AS=0.1584P AD=0.0972P
+ PS=1.6U PD=0.9U
M$3594 \$1327 \$1325 VSS VSS nfet_03v3 L=0.28U W=0.36U AS=0.0972P AD=0.18P
+ PS=0.9U PD=1.72U
M$3595 \$1330 \$145 VSS VSS nfet_03v3 L=0.28U W=0.36U AS=0.1584P AD=0.1188P
+ PS=1.6U PD=1.02U
M$3596 \$1331 \$1249 \$1330 VSS nfet_03v3 L=0.28U W=0.36U AS=0.1188P AD=0.1278P
+ PS=1.02U PD=1.07U
M$3597 \$1546 \$1332 \$1331 VSS nfet_03v3 L=0.28U W=0.36U AS=0.1278P AD=0.0567P
+ PS=1.07U PD=0.675U
M$3598 VSS \$1250 \$1546 VSS nfet_03v3 L=0.28U W=0.36U AS=0.0567P AD=0.1584P
+ PS=0.675U PD=1.6U
M$3599 VSS \$1331 \$1332 VSS nfet_03v3 L=0.28U W=0.36U AS=0.1584P AD=0.0972P
+ PS=1.6U PD=0.9U
M$3600 \$1333 \$1331 VSS VSS nfet_03v3 L=0.28U W=0.36U AS=0.0972P AD=0.18P
+ PS=0.9U PD=1.72U
M$3601 \$1336 \$148 VSS VSS nfet_03v3 L=0.28U W=0.36U AS=0.1584P AD=0.1188P
+ PS=1.6U PD=1.02U
M$3602 \$1337 \$1249 \$1336 VSS nfet_03v3 L=0.28U W=0.36U AS=0.1188P AD=0.1278P
+ PS=1.02U PD=1.07U
M$3603 \$1512 \$1338 \$1337 VSS nfet_03v3 L=0.28U W=0.36U AS=0.1278P AD=0.0567P
+ PS=1.07U PD=0.675U
M$3604 VSS \$1250 \$1512 VSS nfet_03v3 L=0.28U W=0.36U AS=0.0567P AD=0.1584P
+ PS=0.675U PD=1.6U
M$3605 VSS \$1337 \$1338 VSS nfet_03v3 L=0.28U W=0.36U AS=0.1584P AD=0.0972P
+ PS=1.6U PD=0.9U
M$3606 \$1339 \$1337 VSS VSS nfet_03v3 L=0.28U W=0.36U AS=0.0972P AD=0.18P
+ PS=0.9U PD=1.72U
M$3607 \$1342 \$151 VSS VSS nfet_03v3 L=0.28U W=0.36U AS=0.1584P AD=0.1188P
+ PS=1.6U PD=1.02U
M$3608 \$1343 \$1249 \$1342 VSS nfet_03v3 L=0.28U W=0.36U AS=0.1188P AD=0.1278P
+ PS=1.02U PD=1.07U
M$3609 \$1478 \$1344 \$1343 VSS nfet_03v3 L=0.28U W=0.36U AS=0.1278P AD=0.0567P
+ PS=1.07U PD=0.675U
M$3610 VSS \$1250 \$1478 VSS nfet_03v3 L=0.28U W=0.36U AS=0.0567P AD=0.1584P
+ PS=0.675U PD=1.6U
M$3611 VSS \$1343 \$1344 VSS nfet_03v3 L=0.28U W=0.36U AS=0.1584P AD=0.0972P
+ PS=1.6U PD=0.9U
M$3612 \$1345 \$1343 VSS VSS nfet_03v3 L=0.28U W=0.36U AS=0.0972P AD=0.18P
+ PS=0.9U PD=1.72U
M$3613 \$1703 WE11 VSS VSS nfet_03v3 L=0.28U W=0.72U AS=0.3168P AD=0.1872P
+ PS=2.32U PD=1.24U
M$3614 \$1567 CLK \$1703 VSS nfet_03v3 L=0.28U W=0.72U AS=0.1872P AD=0.3168P
+ PS=1.24U PD=2.32U
M$3615 \$1568 \$1567 VSS VSS nfet_03v3 L=0.28U W=1.27U AS=0.4445P AD=0.3344P
+ PS=3.305U PD=2.345U
M$3617 \$1755 \$1568 VSS VSS nfet_03v3 L=0.28U W=1.34U AS=0.3636P AD=0.4891P
+ PS=2.44U PD=3.47U
M$3619 \$1569 \$106 VSS VSS nfet_03v3 L=0.28U W=0.36U AS=0.1584P AD=0.1188P
+ PS=1.6U PD=1.02U
M$3620 \$1570 \$1568 \$1569 VSS nfet_03v3 L=0.28U W=0.36U AS=0.1188P AD=0.1278P
+ PS=1.02U PD=1.07U
M$3621 \$1608 \$1653 \$1570 VSS nfet_03v3 L=0.28U W=0.36U AS=0.1278P AD=0.0567P
+ PS=1.07U PD=0.675U
M$3622 VSS \$1755 \$1608 VSS nfet_03v3 L=0.28U W=0.36U AS=0.0567P AD=0.1584P
+ PS=0.675U PD=1.6U
M$3623 VSS \$1570 \$1653 VSS nfet_03v3 L=0.28U W=0.36U AS=0.1584P AD=0.0972P
+ PS=1.6U PD=0.9U
M$3624 \$1551 \$1570 VSS VSS nfet_03v3 L=0.28U W=0.36U AS=0.0972P AD=0.18P
+ PS=0.9U PD=1.72U
M$3625 \$1571 \$109 VSS VSS nfet_03v3 L=0.28U W=0.36U AS=0.1584P AD=0.1188P
+ PS=1.6U PD=1.02U
M$3626 \$1572 \$1568 \$1571 VSS nfet_03v3 L=0.28U W=0.36U AS=0.1188P AD=0.1278P
+ PS=1.02U PD=1.07U
M$3627 \$1617 \$1657 \$1572 VSS nfet_03v3 L=0.28U W=0.36U AS=0.1278P AD=0.0567P
+ PS=1.07U PD=0.675U
M$3628 VSS \$1755 \$1617 VSS nfet_03v3 L=0.28U W=0.36U AS=0.0567P AD=0.1584P
+ PS=0.675U PD=1.6U
M$3629 VSS \$1572 \$1657 VSS nfet_03v3 L=0.28U W=0.36U AS=0.1584P AD=0.0972P
+ PS=1.6U PD=0.9U
M$3630 \$1552 \$1572 VSS VSS nfet_03v3 L=0.28U W=0.36U AS=0.0972P AD=0.18P
+ PS=0.9U PD=1.72U
M$3631 \$1573 \$112 VSS VSS nfet_03v3 L=0.28U W=0.36U AS=0.1584P AD=0.1188P
+ PS=1.6U PD=1.02U
M$3632 \$1574 \$1568 \$1573 VSS nfet_03v3 L=0.28U W=0.36U AS=0.1188P AD=0.1278P
+ PS=1.02U PD=1.07U
M$3633 \$1626 \$1660 \$1574 VSS nfet_03v3 L=0.28U W=0.36U AS=0.1278P AD=0.0567P
+ PS=1.07U PD=0.675U
M$3634 VSS \$1755 \$1626 VSS nfet_03v3 L=0.28U W=0.36U AS=0.0567P AD=0.1584P
+ PS=0.675U PD=1.6U
M$3635 VSS \$1574 \$1660 VSS nfet_03v3 L=0.28U W=0.36U AS=0.1584P AD=0.0972P
+ PS=1.6U PD=0.9U
M$3636 \$1553 \$1574 VSS VSS nfet_03v3 L=0.28U W=0.36U AS=0.0972P AD=0.18P
+ PS=0.9U PD=1.72U
M$3637 \$1575 \$115 VSS VSS nfet_03v3 L=0.28U W=0.36U AS=0.1584P AD=0.1188P
+ PS=1.6U PD=1.02U
M$3638 \$1576 \$1568 \$1575 VSS nfet_03v3 L=0.28U W=0.36U AS=0.1188P AD=0.1278P
+ PS=1.02U PD=1.07U
M$3639 \$1635 \$1663 \$1576 VSS nfet_03v3 L=0.28U W=0.36U AS=0.1278P AD=0.0567P
+ PS=1.07U PD=0.675U
M$3640 VSS \$1755 \$1635 VSS nfet_03v3 L=0.28U W=0.36U AS=0.0567P AD=0.1584P
+ PS=0.675U PD=1.6U
M$3641 VSS \$1576 \$1663 VSS nfet_03v3 L=0.28U W=0.36U AS=0.1584P AD=0.0972P
+ PS=1.6U PD=0.9U
M$3642 \$1554 \$1576 VSS VSS nfet_03v3 L=0.28U W=0.36U AS=0.0972P AD=0.18P
+ PS=0.9U PD=1.72U
M$3643 \$1577 \$118 VSS VSS nfet_03v3 L=0.28U W=0.36U AS=0.1584P AD=0.1188P
+ PS=1.6U PD=1.02U
M$3644 \$1578 \$1568 \$1577 VSS nfet_03v3 L=0.28U W=0.36U AS=0.1188P AD=0.1278P
+ PS=1.02U PD=1.07U
M$3645 \$1644 \$1666 \$1578 VSS nfet_03v3 L=0.28U W=0.36U AS=0.1278P AD=0.0567P
+ PS=1.07U PD=0.675U
M$3646 VSS \$1755 \$1644 VSS nfet_03v3 L=0.28U W=0.36U AS=0.0567P AD=0.1584P
+ PS=0.675U PD=1.6U
M$3647 VSS \$1578 \$1666 VSS nfet_03v3 L=0.28U W=0.36U AS=0.1584P AD=0.0972P
+ PS=1.6U PD=0.9U
M$3648 \$1555 \$1578 VSS VSS nfet_03v3 L=0.28U W=0.36U AS=0.0972P AD=0.18P
+ PS=0.9U PD=1.72U
M$3649 \$1579 \$121 VSS VSS nfet_03v3 L=0.28U W=0.36U AS=0.1584P AD=0.1188P
+ PS=1.6U PD=1.02U
M$3650 \$1580 \$1568 \$1579 VSS nfet_03v3 L=0.28U W=0.36U AS=0.1188P AD=0.1278P
+ PS=1.02U PD=1.07U
M$3651 \$1647 \$1669 \$1580 VSS nfet_03v3 L=0.28U W=0.36U AS=0.1278P AD=0.0567P
+ PS=1.07U PD=0.675U
M$3652 VSS \$1755 \$1647 VSS nfet_03v3 L=0.28U W=0.36U AS=0.0567P AD=0.1584P
+ PS=0.675U PD=1.6U
M$3653 VSS \$1580 \$1669 VSS nfet_03v3 L=0.28U W=0.36U AS=0.1584P AD=0.0972P
+ PS=1.6U PD=0.9U
M$3654 \$1556 \$1580 VSS VSS nfet_03v3 L=0.28U W=0.36U AS=0.0972P AD=0.18P
+ PS=0.9U PD=1.72U
M$3655 \$1581 \$124 VSS VSS nfet_03v3 L=0.28U W=0.36U AS=0.1584P AD=0.1188P
+ PS=1.6U PD=1.02U
M$3656 \$1582 \$1568 \$1581 VSS nfet_03v3 L=0.28U W=0.36U AS=0.1188P AD=0.1278P
+ PS=1.02U PD=1.07U
M$3657 \$1641 \$1672 \$1582 VSS nfet_03v3 L=0.28U W=0.36U AS=0.1278P AD=0.0567P
+ PS=1.07U PD=0.675U
M$3658 VSS \$1755 \$1641 VSS nfet_03v3 L=0.28U W=0.36U AS=0.0567P AD=0.1584P
+ PS=0.675U PD=1.6U
M$3659 VSS \$1582 \$1672 VSS nfet_03v3 L=0.28U W=0.36U AS=0.1584P AD=0.0972P
+ PS=1.6U PD=0.9U
M$3660 \$1557 \$1582 VSS VSS nfet_03v3 L=0.28U W=0.36U AS=0.0972P AD=0.18P
+ PS=0.9U PD=1.72U
M$3661 \$1583 \$127 VSS VSS nfet_03v3 L=0.28U W=0.36U AS=0.1584P AD=0.1188P
+ PS=1.6U PD=1.02U
M$3662 \$1584 \$1568 \$1583 VSS nfet_03v3 L=0.28U W=0.36U AS=0.1188P AD=0.1278P
+ PS=1.02U PD=1.07U
M$3663 \$1639 \$1675 \$1584 VSS nfet_03v3 L=0.28U W=0.36U AS=0.1278P AD=0.0567P
+ PS=1.07U PD=0.675U
M$3664 VSS \$1755 \$1639 VSS nfet_03v3 L=0.28U W=0.36U AS=0.0567P AD=0.1584P
+ PS=0.675U PD=1.6U
M$3665 VSS \$1584 \$1675 VSS nfet_03v3 L=0.28U W=0.36U AS=0.1584P AD=0.0972P
+ PS=1.6U PD=0.9U
M$3666 \$1558 \$1584 VSS VSS nfet_03v3 L=0.28U W=0.36U AS=0.0972P AD=0.18P
+ PS=0.9U PD=1.72U
M$3667 \$1585 \$130 VSS VSS nfet_03v3 L=0.28U W=0.36U AS=0.1584P AD=0.1188P
+ PS=1.6U PD=1.02U
M$3668 \$1586 \$1568 \$1585 VSS nfet_03v3 L=0.28U W=0.36U AS=0.1188P AD=0.1278P
+ PS=1.02U PD=1.07U
M$3669 \$1633 \$1678 \$1586 VSS nfet_03v3 L=0.28U W=0.36U AS=0.1278P AD=0.0567P
+ PS=1.07U PD=0.675U
M$3670 VSS \$1755 \$1633 VSS nfet_03v3 L=0.28U W=0.36U AS=0.0567P AD=0.1584P
+ PS=0.675U PD=1.6U
M$3671 VSS \$1586 \$1678 VSS nfet_03v3 L=0.28U W=0.36U AS=0.1584P AD=0.0972P
+ PS=1.6U PD=0.9U
M$3672 \$1559 \$1586 VSS VSS nfet_03v3 L=0.28U W=0.36U AS=0.0972P AD=0.18P
+ PS=0.9U PD=1.72U
M$3673 \$1587 \$133 VSS VSS nfet_03v3 L=0.28U W=0.36U AS=0.1584P AD=0.1188P
+ PS=1.6U PD=1.02U
M$3674 \$1588 \$1568 \$1587 VSS nfet_03v3 L=0.28U W=0.36U AS=0.1188P AD=0.1278P
+ PS=1.02U PD=1.07U
M$3675 \$1630 \$1681 \$1588 VSS nfet_03v3 L=0.28U W=0.36U AS=0.1278P AD=0.0567P
+ PS=1.07U PD=0.675U
M$3676 VSS \$1755 \$1630 VSS nfet_03v3 L=0.28U W=0.36U AS=0.0567P AD=0.1584P
+ PS=0.675U PD=1.6U
M$3677 VSS \$1588 \$1681 VSS nfet_03v3 L=0.28U W=0.36U AS=0.1584P AD=0.0972P
+ PS=1.6U PD=0.9U
M$3678 \$1560 \$1588 VSS VSS nfet_03v3 L=0.28U W=0.36U AS=0.0972P AD=0.18P
+ PS=0.9U PD=1.72U
M$3679 \$1589 \$136 VSS VSS nfet_03v3 L=0.28U W=0.36U AS=0.1584P AD=0.1188P
+ PS=1.6U PD=1.02U
M$3680 \$1590 \$1568 \$1589 VSS nfet_03v3 L=0.28U W=0.36U AS=0.1188P AD=0.1278P
+ PS=1.02U PD=1.07U
M$3681 \$1624 \$1684 \$1590 VSS nfet_03v3 L=0.28U W=0.36U AS=0.1278P AD=0.0567P
+ PS=1.07U PD=0.675U
M$3682 VSS \$1755 \$1624 VSS nfet_03v3 L=0.28U W=0.36U AS=0.0567P AD=0.1584P
+ PS=0.675U PD=1.6U
M$3683 VSS \$1590 \$1684 VSS nfet_03v3 L=0.28U W=0.36U AS=0.1584P AD=0.0972P
+ PS=1.6U PD=0.9U
M$3684 \$1561 \$1590 VSS VSS nfet_03v3 L=0.28U W=0.36U AS=0.0972P AD=0.18P
+ PS=0.9U PD=1.72U
M$3685 \$1591 \$139 VSS VSS nfet_03v3 L=0.28U W=0.36U AS=0.1584P AD=0.1188P
+ PS=1.6U PD=1.02U
M$3686 \$1592 \$1568 \$1591 VSS nfet_03v3 L=0.28U W=0.36U AS=0.1188P AD=0.1278P
+ PS=1.02U PD=1.07U
M$3687 \$1621 \$1687 \$1592 VSS nfet_03v3 L=0.28U W=0.36U AS=0.1278P AD=0.0567P
+ PS=1.07U PD=0.675U
M$3688 VSS \$1755 \$1621 VSS nfet_03v3 L=0.28U W=0.36U AS=0.0567P AD=0.1584P
+ PS=0.675U PD=1.6U
M$3689 VSS \$1592 \$1687 VSS nfet_03v3 L=0.28U W=0.36U AS=0.1584P AD=0.0972P
+ PS=1.6U PD=0.9U
M$3690 \$1562 \$1592 VSS VSS nfet_03v3 L=0.28U W=0.36U AS=0.0972P AD=0.18P
+ PS=0.9U PD=1.72U
M$3691 \$1593 \$142 VSS VSS nfet_03v3 L=0.28U W=0.36U AS=0.1584P AD=0.1188P
+ PS=1.6U PD=1.02U
M$3692 \$1594 \$1568 \$1593 VSS nfet_03v3 L=0.28U W=0.36U AS=0.1188P AD=0.1278P
+ PS=1.02U PD=1.07U
M$3693 \$1615 \$1690 \$1594 VSS nfet_03v3 L=0.28U W=0.36U AS=0.1278P AD=0.0567P
+ PS=1.07U PD=0.675U
M$3694 VSS \$1755 \$1615 VSS nfet_03v3 L=0.28U W=0.36U AS=0.0567P AD=0.1584P
+ PS=0.675U PD=1.6U
M$3695 VSS \$1594 \$1690 VSS nfet_03v3 L=0.28U W=0.36U AS=0.1584P AD=0.0972P
+ PS=1.6U PD=0.9U
M$3696 \$1563 \$1594 VSS VSS nfet_03v3 L=0.28U W=0.36U AS=0.0972P AD=0.18P
+ PS=0.9U PD=1.72U
M$3697 \$1595 \$145 VSS VSS nfet_03v3 L=0.28U W=0.36U AS=0.1584P AD=0.1188P
+ PS=1.6U PD=1.02U
M$3698 \$1596 \$1568 \$1595 VSS nfet_03v3 L=0.28U W=0.36U AS=0.1188P AD=0.1278P
+ PS=1.02U PD=1.07U
M$3699 \$1612 \$1693 \$1596 VSS nfet_03v3 L=0.28U W=0.36U AS=0.1278P AD=0.0567P
+ PS=1.07U PD=0.675U
M$3700 VSS \$1755 \$1612 VSS nfet_03v3 L=0.28U W=0.36U AS=0.0567P AD=0.1584P
+ PS=0.675U PD=1.6U
M$3701 VSS \$1596 \$1693 VSS nfet_03v3 L=0.28U W=0.36U AS=0.1584P AD=0.0972P
+ PS=1.6U PD=0.9U
M$3702 \$1564 \$1596 VSS VSS nfet_03v3 L=0.28U W=0.36U AS=0.0972P AD=0.18P
+ PS=0.9U PD=1.72U
M$3703 \$1597 \$148 VSS VSS nfet_03v3 L=0.28U W=0.36U AS=0.1584P AD=0.1188P
+ PS=1.6U PD=1.02U
M$3704 \$1598 \$1568 \$1597 VSS nfet_03v3 L=0.28U W=0.36U AS=0.1188P AD=0.1278P
+ PS=1.02U PD=1.07U
M$3705 \$1605 \$1696 \$1598 VSS nfet_03v3 L=0.28U W=0.36U AS=0.1278P AD=0.0567P
+ PS=1.07U PD=0.675U
M$3706 VSS \$1755 \$1605 VSS nfet_03v3 L=0.28U W=0.36U AS=0.0567P AD=0.1584P
+ PS=0.675U PD=1.6U
M$3707 VSS \$1598 \$1696 VSS nfet_03v3 L=0.28U W=0.36U AS=0.1584P AD=0.0972P
+ PS=1.6U PD=0.9U
M$3708 \$1565 \$1598 VSS VSS nfet_03v3 L=0.28U W=0.36U AS=0.0972P AD=0.18P
+ PS=0.9U PD=1.72U
M$3709 \$1599 \$151 VSS VSS nfet_03v3 L=0.28U W=0.36U AS=0.1584P AD=0.1188P
+ PS=1.6U PD=1.02U
M$3710 \$1600 \$1568 \$1599 VSS nfet_03v3 L=0.28U W=0.36U AS=0.1188P AD=0.1278P
+ PS=1.02U PD=1.07U
M$3711 \$1602 \$1699 \$1600 VSS nfet_03v3 L=0.28U W=0.36U AS=0.1278P AD=0.0567P
+ PS=1.07U PD=0.675U
M$3712 VSS \$1755 \$1602 VSS nfet_03v3 L=0.28U W=0.36U AS=0.0567P AD=0.1584P
+ PS=0.675U PD=1.6U
M$3713 VSS \$1600 \$1699 VSS nfet_03v3 L=0.28U W=0.36U AS=0.1584P AD=0.0972P
+ PS=1.6U PD=0.9U
M$3714 \$1566 \$1600 VSS VSS nfet_03v3 L=0.28U W=0.36U AS=0.0972P AD=0.18P
+ PS=0.9U PD=1.72U
M$3715 \$1869 RB10 VSS VSS nfet_03v3 L=0.28U W=0.36U AS=0.1656P AD=0.1944P
+ PS=1.64U PD=1.8U
M$3716 \$1655 RA11 VSS VSS nfet_03v3 L=0.28U W=0.36U AS=0.1656P AD=0.1944P
+ PS=1.64U PD=1.8U
M$3717 \$1867 RB10 \$51 VSS nfet_03v3 L=0.28U W=0.36U AS=0.1584P AD=0.1152P
+ PS=1.6U PD=1U
M$3718 \$52 RA10 \$1867 VSS nfet_03v3 L=0.28U W=0.36U AS=0.1152P AD=0.1584P
+ PS=1U PD=1.6U
M$3719 \$1551 RA11 \$51 VSS nfet_03v3 L=0.28U W=0.36U AS=0.1584P AD=0.1152P
+ PS=1.6U PD=1U
M$3720 \$52 RB11 \$1551 VSS nfet_03v3 L=0.28U W=0.36U AS=0.1152P AD=0.1584P
+ PS=1U PD=1.6U
M$3721 VSS RB11 \$1656 VSS nfet_03v3 L=0.28U W=0.36U AS=0.1854P AD=0.1584P
+ PS=1.75U PD=1.6U
M$3722 VSS RA10 \$1870 VSS nfet_03v3 L=0.28U W=0.36U AS=0.1854P AD=0.1584P
+ PS=1.75U PD=1.6U
M$3723 \$1875 RB10 VSS VSS nfet_03v3 L=0.28U W=0.36U AS=0.1656P AD=0.1944P
+ PS=1.64U PD=1.8U
M$3724 \$1658 RA11 VSS VSS nfet_03v3 L=0.28U W=0.36U AS=0.1656P AD=0.1944P
+ PS=1.64U PD=1.8U
M$3725 \$1552 RA11 \$53 VSS nfet_03v3 L=0.28U W=0.36U AS=0.1584P AD=0.1152P
+ PS=1.6U PD=1U
M$3726 \$54 RB11 \$1552 VSS nfet_03v3 L=0.28U W=0.36U AS=0.1152P AD=0.1584P
+ PS=1U PD=1.6U
M$3727 \$1874 RB10 \$53 VSS nfet_03v3 L=0.28U W=0.36U AS=0.1584P AD=0.1152P
+ PS=1.6U PD=1U
M$3728 \$54 RA10 \$1874 VSS nfet_03v3 L=0.28U W=0.36U AS=0.1152P AD=0.1584P
+ PS=1U PD=1.6U
M$3729 VSS RA10 \$1876 VSS nfet_03v3 L=0.28U W=0.36U AS=0.1854P AD=0.1584P
+ PS=1.75U PD=1.6U
M$3730 VSS RB11 \$1659 VSS nfet_03v3 L=0.28U W=0.36U AS=0.1854P AD=0.1584P
+ PS=1.75U PD=1.6U
M$3731 \$1661 RA11 VSS VSS nfet_03v3 L=0.28U W=0.36U AS=0.1656P AD=0.1944P
+ PS=1.64U PD=1.8U
M$3732 \$1881 RB10 VSS VSS nfet_03v3 L=0.28U W=0.36U AS=0.1656P AD=0.1944P
+ PS=1.64U PD=1.8U
M$3733 \$1553 RA11 \$55 VSS nfet_03v3 L=0.28U W=0.36U AS=0.1584P AD=0.1152P
+ PS=1.6U PD=1U
M$3734 \$56 RB11 \$1553 VSS nfet_03v3 L=0.28U W=0.36U AS=0.1152P AD=0.1584P
+ PS=1U PD=1.6U
M$3735 \$1880 RB10 \$55 VSS nfet_03v3 L=0.28U W=0.36U AS=0.1584P AD=0.1152P
+ PS=1.6U PD=1U
M$3736 \$56 RA10 \$1880 VSS nfet_03v3 L=0.28U W=0.36U AS=0.1152P AD=0.1584P
+ PS=1U PD=1.6U
M$3737 VSS RB11 \$1662 VSS nfet_03v3 L=0.28U W=0.36U AS=0.1854P AD=0.1584P
+ PS=1.75U PD=1.6U
M$3738 VSS RA10 \$1882 VSS nfet_03v3 L=0.28U W=0.36U AS=0.1854P AD=0.1584P
+ PS=1.75U PD=1.6U
M$3739 \$1887 RB10 VSS VSS nfet_03v3 L=0.28U W=0.36U AS=0.1656P AD=0.1944P
+ PS=1.64U PD=1.8U
M$3740 \$1664 RA11 VSS VSS nfet_03v3 L=0.28U W=0.36U AS=0.1656P AD=0.1944P
+ PS=1.64U PD=1.8U
M$3741 \$1554 RA11 \$57 VSS nfet_03v3 L=0.28U W=0.36U AS=0.1584P AD=0.1152P
+ PS=1.6U PD=1U
M$3742 \$58 RB11 \$1554 VSS nfet_03v3 L=0.28U W=0.36U AS=0.1152P AD=0.1584P
+ PS=1U PD=1.6U
M$3743 \$1886 RB10 \$57 VSS nfet_03v3 L=0.28U W=0.36U AS=0.1584P AD=0.1152P
+ PS=1.6U PD=1U
M$3744 \$58 RA10 \$1886 VSS nfet_03v3 L=0.28U W=0.36U AS=0.1152P AD=0.1584P
+ PS=1U PD=1.6U
M$3745 VSS RB11 \$1665 VSS nfet_03v3 L=0.28U W=0.36U AS=0.1854P AD=0.1584P
+ PS=1.75U PD=1.6U
M$3746 VSS RA10 \$1888 VSS nfet_03v3 L=0.28U W=0.36U AS=0.1854P AD=0.1584P
+ PS=1.75U PD=1.6U
M$3747 \$1893 RB10 VSS VSS nfet_03v3 L=0.28U W=0.36U AS=0.1656P AD=0.1944P
+ PS=1.64U PD=1.8U
M$3748 \$1667 RA11 VSS VSS nfet_03v3 L=0.28U W=0.36U AS=0.1656P AD=0.1944P
+ PS=1.64U PD=1.8U
M$3749 \$1555 RA11 \$59 VSS nfet_03v3 L=0.28U W=0.36U AS=0.1584P AD=0.1152P
+ PS=1.6U PD=1U
M$3750 \$60 RB11 \$1555 VSS nfet_03v3 L=0.28U W=0.36U AS=0.1152P AD=0.1584P
+ PS=1U PD=1.6U
M$3751 \$1892 RB10 \$59 VSS nfet_03v3 L=0.28U W=0.36U AS=0.1584P AD=0.1152P
+ PS=1.6U PD=1U
M$3752 \$60 RA10 \$1892 VSS nfet_03v3 L=0.28U W=0.36U AS=0.1152P AD=0.1584P
+ PS=1U PD=1.6U
M$3753 VSS RB11 \$1668 VSS nfet_03v3 L=0.28U W=0.36U AS=0.1854P AD=0.1584P
+ PS=1.75U PD=1.6U
M$3754 VSS RA10 \$1894 VSS nfet_03v3 L=0.28U W=0.36U AS=0.1854P AD=0.1584P
+ PS=1.75U PD=1.6U
M$3755 \$1899 RB10 VSS VSS nfet_03v3 L=0.28U W=0.36U AS=0.1656P AD=0.1944P
+ PS=1.64U PD=1.8U
M$3756 \$1670 RA11 VSS VSS nfet_03v3 L=0.28U W=0.36U AS=0.1656P AD=0.1944P
+ PS=1.64U PD=1.8U
M$3757 \$1898 RB10 \$61 VSS nfet_03v3 L=0.28U W=0.36U AS=0.1584P AD=0.1152P
+ PS=1.6U PD=1U
M$3758 \$62 RA10 \$1898 VSS nfet_03v3 L=0.28U W=0.36U AS=0.1152P AD=0.1584P
+ PS=1U PD=1.6U
M$3759 \$1556 RA11 \$61 VSS nfet_03v3 L=0.28U W=0.36U AS=0.1584P AD=0.1152P
+ PS=1.6U PD=1U
M$3760 \$62 RB11 \$1556 VSS nfet_03v3 L=0.28U W=0.36U AS=0.1152P AD=0.1584P
+ PS=1U PD=1.6U
M$3761 VSS RB11 \$1671 VSS nfet_03v3 L=0.28U W=0.36U AS=0.1854P AD=0.1584P
+ PS=1.75U PD=1.6U
M$3762 VSS RA10 \$1900 VSS nfet_03v3 L=0.28U W=0.36U AS=0.1854P AD=0.1584P
+ PS=1.75U PD=1.6U
M$3763 \$1905 RB10 VSS VSS nfet_03v3 L=0.28U W=0.36U AS=0.1656P AD=0.1944P
+ PS=1.64U PD=1.8U
M$3764 \$1673 RA11 VSS VSS nfet_03v3 L=0.28U W=0.36U AS=0.1656P AD=0.1944P
+ PS=1.64U PD=1.8U
M$3765 \$1904 RB10 \$63 VSS nfet_03v3 L=0.28U W=0.36U AS=0.1584P AD=0.1152P
+ PS=1.6U PD=1U
M$3766 \$64 RA10 \$1904 VSS nfet_03v3 L=0.28U W=0.36U AS=0.1152P AD=0.1584P
+ PS=1U PD=1.6U
M$3767 \$1557 RA11 \$63 VSS nfet_03v3 L=0.28U W=0.36U AS=0.1584P AD=0.1152P
+ PS=1.6U PD=1U
M$3768 \$64 RB11 \$1557 VSS nfet_03v3 L=0.28U W=0.36U AS=0.1152P AD=0.1584P
+ PS=1U PD=1.6U
M$3769 VSS RA10 \$1906 VSS nfet_03v3 L=0.28U W=0.36U AS=0.1854P AD=0.1584P
+ PS=1.75U PD=1.6U
M$3770 VSS RB11 \$1674 VSS nfet_03v3 L=0.28U W=0.36U AS=0.1854P AD=0.1584P
+ PS=1.75U PD=1.6U
M$3771 \$1911 RB10 VSS VSS nfet_03v3 L=0.28U W=0.36U AS=0.1656P AD=0.1944P
+ PS=1.64U PD=1.8U
M$3772 \$1676 RA11 VSS VSS nfet_03v3 L=0.28U W=0.36U AS=0.1656P AD=0.1944P
+ PS=1.64U PD=1.8U
M$3773 \$1910 RB10 \$65 VSS nfet_03v3 L=0.28U W=0.36U AS=0.1584P AD=0.1152P
+ PS=1.6U PD=1U
M$3774 \$66 RA10 \$1910 VSS nfet_03v3 L=0.28U W=0.36U AS=0.1152P AD=0.1584P
+ PS=1U PD=1.6U
M$3775 \$1558 RA11 \$65 VSS nfet_03v3 L=0.28U W=0.36U AS=0.1584P AD=0.1152P
+ PS=1.6U PD=1U
M$3776 \$66 RB11 \$1558 VSS nfet_03v3 L=0.28U W=0.36U AS=0.1152P AD=0.1584P
+ PS=1U PD=1.6U
M$3777 VSS RB11 \$1677 VSS nfet_03v3 L=0.28U W=0.36U AS=0.1854P AD=0.1584P
+ PS=1.75U PD=1.6U
M$3778 VSS RA10 \$1912 VSS nfet_03v3 L=0.28U W=0.36U AS=0.1854P AD=0.1584P
+ PS=1.75U PD=1.6U
M$3779 \$1679 RA11 VSS VSS nfet_03v3 L=0.28U W=0.36U AS=0.1656P AD=0.1944P
+ PS=1.64U PD=1.8U
M$3780 \$1917 RB10 VSS VSS nfet_03v3 L=0.28U W=0.36U AS=0.1656P AD=0.1944P
+ PS=1.64U PD=1.8U
M$3781 \$1916 RB10 \$67 VSS nfet_03v3 L=0.28U W=0.36U AS=0.1584P AD=0.1152P
+ PS=1.6U PD=1U
M$3782 \$68 RA10 \$1916 VSS nfet_03v3 L=0.28U W=0.36U AS=0.1152P AD=0.1584P
+ PS=1U PD=1.6U
M$3783 \$1559 RA11 \$67 VSS nfet_03v3 L=0.28U W=0.36U AS=0.1584P AD=0.1152P
+ PS=1.6U PD=1U
M$3784 \$68 RB11 \$1559 VSS nfet_03v3 L=0.28U W=0.36U AS=0.1152P AD=0.1584P
+ PS=1U PD=1.6U
M$3785 VSS RA10 \$1918 VSS nfet_03v3 L=0.28U W=0.36U AS=0.1854P AD=0.1584P
+ PS=1.75U PD=1.6U
M$3786 VSS RB11 \$1680 VSS nfet_03v3 L=0.28U W=0.36U AS=0.1854P AD=0.1584P
+ PS=1.75U PD=1.6U
M$3787 \$1923 RB10 VSS VSS nfet_03v3 L=0.28U W=0.36U AS=0.1656P AD=0.1944P
+ PS=1.64U PD=1.8U
M$3788 \$1682 RA11 VSS VSS nfet_03v3 L=0.28U W=0.36U AS=0.1656P AD=0.1944P
+ PS=1.64U PD=1.8U
M$3789 \$1922 RB10 \$69 VSS nfet_03v3 L=0.28U W=0.36U AS=0.1584P AD=0.1152P
+ PS=1.6U PD=1U
M$3790 \$70 RA10 \$1922 VSS nfet_03v3 L=0.28U W=0.36U AS=0.1152P AD=0.1584P
+ PS=1U PD=1.6U
M$3791 \$1560 RA11 \$69 VSS nfet_03v3 L=0.28U W=0.36U AS=0.1584P AD=0.1152P
+ PS=1.6U PD=1U
M$3792 \$70 RB11 \$1560 VSS nfet_03v3 L=0.28U W=0.36U AS=0.1152P AD=0.1584P
+ PS=1U PD=1.6U
M$3793 VSS RB11 \$1683 VSS nfet_03v3 L=0.28U W=0.36U AS=0.1854P AD=0.1584P
+ PS=1.75U PD=1.6U
M$3794 VSS RA10 \$1924 VSS nfet_03v3 L=0.28U W=0.36U AS=0.1854P AD=0.1584P
+ PS=1.75U PD=1.6U
M$3795 \$1929 RB10 VSS VSS nfet_03v3 L=0.28U W=0.36U AS=0.1656P AD=0.1944P
+ PS=1.64U PD=1.8U
M$3796 \$1685 RA11 VSS VSS nfet_03v3 L=0.28U W=0.36U AS=0.1656P AD=0.1944P
+ PS=1.64U PD=1.8U
M$3797 \$1928 RB10 \$71 VSS nfet_03v3 L=0.28U W=0.36U AS=0.1584P AD=0.1152P
+ PS=1.6U PD=1U
M$3798 \$72 RA10 \$1928 VSS nfet_03v3 L=0.28U W=0.36U AS=0.1152P AD=0.1584P
+ PS=1U PD=1.6U
M$3799 \$1561 RA11 \$71 VSS nfet_03v3 L=0.28U W=0.36U AS=0.1584P AD=0.1152P
+ PS=1.6U PD=1U
M$3800 \$72 RB11 \$1561 VSS nfet_03v3 L=0.28U W=0.36U AS=0.1152P AD=0.1584P
+ PS=1U PD=1.6U
M$3801 VSS RA10 \$1930 VSS nfet_03v3 L=0.28U W=0.36U AS=0.1854P AD=0.1584P
+ PS=1.75U PD=1.6U
M$3802 VSS RB11 \$1686 VSS nfet_03v3 L=0.28U W=0.36U AS=0.1854P AD=0.1584P
+ PS=1.75U PD=1.6U
M$3803 \$1688 RA11 VSS VSS nfet_03v3 L=0.28U W=0.36U AS=0.1656P AD=0.1944P
+ PS=1.64U PD=1.8U
M$3804 \$1935 RB10 VSS VSS nfet_03v3 L=0.28U W=0.36U AS=0.1656P AD=0.1944P
+ PS=1.64U PD=1.8U
M$3805 \$1562 RA11 \$73 VSS nfet_03v3 L=0.28U W=0.36U AS=0.1584P AD=0.1152P
+ PS=1.6U PD=1U
M$3806 \$74 RB11 \$1562 VSS nfet_03v3 L=0.28U W=0.36U AS=0.1152P AD=0.1584P
+ PS=1U PD=1.6U
M$3807 \$1934 RB10 \$73 VSS nfet_03v3 L=0.28U W=0.36U AS=0.1584P AD=0.1152P
+ PS=1.6U PD=1U
M$3808 \$74 RA10 \$1934 VSS nfet_03v3 L=0.28U W=0.36U AS=0.1152P AD=0.1584P
+ PS=1U PD=1.6U
M$3809 VSS RA10 \$1936 VSS nfet_03v3 L=0.28U W=0.36U AS=0.1854P AD=0.1584P
+ PS=1.75U PD=1.6U
M$3810 VSS RB11 \$1689 VSS nfet_03v3 L=0.28U W=0.36U AS=0.1854P AD=0.1584P
+ PS=1.75U PD=1.6U
M$3811 \$1691 RA11 VSS VSS nfet_03v3 L=0.28U W=0.36U AS=0.1656P AD=0.1944P
+ PS=1.64U PD=1.8U
M$3812 \$1941 RB10 VSS VSS nfet_03v3 L=0.28U W=0.36U AS=0.1656P AD=0.1944P
+ PS=1.64U PD=1.8U
M$3813 \$1563 RA11 \$75 VSS nfet_03v3 L=0.28U W=0.36U AS=0.1584P AD=0.1152P
+ PS=1.6U PD=1U
M$3814 \$76 RB11 \$1563 VSS nfet_03v3 L=0.28U W=0.36U AS=0.1152P AD=0.1584P
+ PS=1U PD=1.6U
M$3815 \$1940 RB10 \$75 VSS nfet_03v3 L=0.28U W=0.36U AS=0.1584P AD=0.1152P
+ PS=1.6U PD=1U
M$3816 \$76 RA10 \$1940 VSS nfet_03v3 L=0.28U W=0.36U AS=0.1152P AD=0.1584P
+ PS=1U PD=1.6U
M$3817 VSS RA10 \$1942 VSS nfet_03v3 L=0.28U W=0.36U AS=0.1854P AD=0.1584P
+ PS=1.75U PD=1.6U
M$3818 VSS RB11 \$1692 VSS nfet_03v3 L=0.28U W=0.36U AS=0.1854P AD=0.1584P
+ PS=1.75U PD=1.6U
M$3819 \$1694 RA11 VSS VSS nfet_03v3 L=0.28U W=0.36U AS=0.1656P AD=0.1944P
+ PS=1.64U PD=1.8U
M$3820 \$1947 RB10 VSS VSS nfet_03v3 L=0.28U W=0.36U AS=0.1656P AD=0.1944P
+ PS=1.64U PD=1.8U
M$3821 \$1946 RB10 \$77 VSS nfet_03v3 L=0.28U W=0.36U AS=0.1584P AD=0.1152P
+ PS=1.6U PD=1U
M$3822 \$78 RA10 \$1946 VSS nfet_03v3 L=0.28U W=0.36U AS=0.1152P AD=0.1584P
+ PS=1U PD=1.6U
M$3823 \$1564 RA11 \$77 VSS nfet_03v3 L=0.28U W=0.36U AS=0.1584P AD=0.1152P
+ PS=1.6U PD=1U
M$3824 \$78 RB11 \$1564 VSS nfet_03v3 L=0.28U W=0.36U AS=0.1152P AD=0.1584P
+ PS=1U PD=1.6U
M$3825 VSS RB11 \$1695 VSS nfet_03v3 L=0.28U W=0.36U AS=0.1854P AD=0.1584P
+ PS=1.75U PD=1.6U
M$3826 VSS RA10 \$1948 VSS nfet_03v3 L=0.28U W=0.36U AS=0.1854P AD=0.1584P
+ PS=1.75U PD=1.6U
M$3827 \$1953 RB10 VSS VSS nfet_03v3 L=0.28U W=0.36U AS=0.1656P AD=0.1944P
+ PS=1.64U PD=1.8U
M$3828 \$1697 RA11 VSS VSS nfet_03v3 L=0.28U W=0.36U AS=0.1656P AD=0.1944P
+ PS=1.64U PD=1.8U
M$3829 \$1952 RB10 \$79 VSS nfet_03v3 L=0.28U W=0.36U AS=0.1584P AD=0.1152P
+ PS=1.6U PD=1U
M$3830 \$80 RA10 \$1952 VSS nfet_03v3 L=0.28U W=0.36U AS=0.1152P AD=0.1584P
+ PS=1U PD=1.6U
M$3831 \$1565 RA11 \$79 VSS nfet_03v3 L=0.28U W=0.36U AS=0.1584P AD=0.1152P
+ PS=1.6U PD=1U
M$3832 \$80 RB11 \$1565 VSS nfet_03v3 L=0.28U W=0.36U AS=0.1152P AD=0.1584P
+ PS=1U PD=1.6U
M$3833 VSS RA10 \$1954 VSS nfet_03v3 L=0.28U W=0.36U AS=0.1854P AD=0.1584P
+ PS=1.75U PD=1.6U
M$3834 VSS RB11 \$1698 VSS nfet_03v3 L=0.28U W=0.36U AS=0.1854P AD=0.1584P
+ PS=1.75U PD=1.6U
M$3835 \$1700 RA11 VSS VSS nfet_03v3 L=0.28U W=0.36U AS=0.1656P AD=0.1944P
+ PS=1.64U PD=1.8U
M$3836 \$1959 RB10 VSS VSS nfet_03v3 L=0.28U W=0.36U AS=0.1656P AD=0.1944P
+ PS=1.64U PD=1.8U
M$3837 \$1958 RB10 \$81 VSS nfet_03v3 L=0.28U W=0.36U AS=0.1584P AD=0.1152P
+ PS=1.6U PD=1U
M$3838 \$82 RA10 \$1958 VSS nfet_03v3 L=0.28U W=0.36U AS=0.1152P AD=0.1584P
+ PS=1U PD=1.6U
M$3839 \$1566 RA11 \$81 VSS nfet_03v3 L=0.28U W=0.36U AS=0.1584P AD=0.1152P
+ PS=1.6U PD=1U
M$3840 \$82 RB11 \$1566 VSS nfet_03v3 L=0.28U W=0.36U AS=0.1152P AD=0.1584P
+ PS=1U PD=1.6U
M$3841 VSS RB11 \$1701 VSS nfet_03v3 L=0.28U W=0.36U AS=0.1854P AD=0.1584P
+ PS=1.75U PD=1.6U
M$3842 VSS RA10 \$1960 VSS nfet_03v3 L=0.28U W=0.36U AS=0.1854P AD=0.1584P
+ PS=1.75U PD=1.6U
M$3843 \$2065 WE10 VSS VSS nfet_03v3 L=0.28U W=0.72U AS=0.3168P AD=0.1872P
+ PS=2.32U PD=1.24U
M$3844 \$1861 CLK \$2065 VSS nfet_03v3 L=0.28U W=0.72U AS=0.1872P AD=0.3168P
+ PS=1.24U PD=2.32U
M$3845 \$1862 \$1861 VSS VSS nfet_03v3 L=0.28U W=1.27U AS=0.4487P AD=0.3302P
+ PS=3.34U PD=2.31U
M$3847 \$1863 \$1862 VSS VSS nfet_03v3 L=0.28U W=1.34U AS=0.3636P AD=0.4891P
+ PS=2.44U PD=3.47U
M$3849 \$1864 \$106 VSS VSS nfet_03v3 L=0.28U W=0.36U AS=0.1584P AD=0.1188P
+ PS=1.6U PD=1.02U
M$3850 \$1865 \$1862 \$1864 VSS nfet_03v3 L=0.28U W=0.36U AS=0.1188P AD=0.1278P
+ PS=1.02U PD=1.07U
M$3851 \$2070 \$1866 \$1865 VSS nfet_03v3 L=0.28U W=0.36U AS=0.1278P AD=0.0567P
+ PS=1.07U PD=0.675U
M$3852 VSS \$1863 \$2070 VSS nfet_03v3 L=0.28U W=0.36U AS=0.0567P AD=0.1584P
+ PS=0.675U PD=1.6U
M$3853 VSS \$1865 \$1866 VSS nfet_03v3 L=0.28U W=0.36U AS=0.1584P AD=0.0972P
+ PS=1.6U PD=0.9U
M$3854 \$1867 \$1865 VSS VSS nfet_03v3 L=0.28U W=0.36U AS=0.0972P AD=0.18P
+ PS=0.9U PD=1.72U
M$3855 \$1871 \$109 VSS VSS nfet_03v3 L=0.28U W=0.36U AS=0.1584P AD=0.1188P
+ PS=1.6U PD=1.02U
M$3856 \$1872 \$1862 \$1871 VSS nfet_03v3 L=0.28U W=0.36U AS=0.1188P AD=0.1278P
+ PS=1.02U PD=1.07U
M$3857 \$2077 \$1873 \$1872 VSS nfet_03v3 L=0.28U W=0.36U AS=0.1278P AD=0.0567P
+ PS=1.07U PD=0.675U
M$3858 VSS \$1863 \$2077 VSS nfet_03v3 L=0.28U W=0.36U AS=0.0567P AD=0.1584P
+ PS=0.675U PD=1.6U
M$3859 VSS \$1872 \$1873 VSS nfet_03v3 L=0.28U W=0.36U AS=0.1584P AD=0.0972P
+ PS=1.6U PD=0.9U
M$3860 \$1874 \$1872 VSS VSS nfet_03v3 L=0.28U W=0.36U AS=0.0972P AD=0.18P
+ PS=0.9U PD=1.72U
M$3861 \$1877 \$112 VSS VSS nfet_03v3 L=0.28U W=0.36U AS=0.1584P AD=0.1188P
+ PS=1.6U PD=1.02U
M$3862 \$1878 \$1862 \$1877 VSS nfet_03v3 L=0.28U W=0.36U AS=0.1188P AD=0.1278P
+ PS=1.02U PD=1.07U
M$3863 \$2084 \$1879 \$1878 VSS nfet_03v3 L=0.28U W=0.36U AS=0.1278P AD=0.0567P
+ PS=1.07U PD=0.675U
M$3864 VSS \$1863 \$2084 VSS nfet_03v3 L=0.28U W=0.36U AS=0.0567P AD=0.1584P
+ PS=0.675U PD=1.6U
M$3865 VSS \$1878 \$1879 VSS nfet_03v3 L=0.28U W=0.36U AS=0.1584P AD=0.0972P
+ PS=1.6U PD=0.9U
M$3866 \$1880 \$1878 VSS VSS nfet_03v3 L=0.28U W=0.36U AS=0.0972P AD=0.18P
+ PS=0.9U PD=1.72U
M$3867 \$1883 \$115 VSS VSS nfet_03v3 L=0.28U W=0.36U AS=0.1584P AD=0.1188P
+ PS=1.6U PD=1.02U
M$3868 \$1884 \$1862 \$1883 VSS nfet_03v3 L=0.28U W=0.36U AS=0.1188P AD=0.1278P
+ PS=1.02U PD=1.07U
M$3869 \$2092 \$1885 \$1884 VSS nfet_03v3 L=0.28U W=0.36U AS=0.1278P AD=0.0567P
+ PS=1.07U PD=0.675U
M$3870 VSS \$1863 \$2092 VSS nfet_03v3 L=0.28U W=0.36U AS=0.0567P AD=0.1584P
+ PS=0.675U PD=1.6U
M$3871 VSS \$1884 \$1885 VSS nfet_03v3 L=0.28U W=0.36U AS=0.1584P AD=0.0972P
+ PS=1.6U PD=0.9U
M$3872 \$1886 \$1884 VSS VSS nfet_03v3 L=0.28U W=0.36U AS=0.0972P AD=0.18P
+ PS=0.9U PD=1.72U
M$3873 \$1889 \$118 VSS VSS nfet_03v3 L=0.28U W=0.36U AS=0.1584P AD=0.1188P
+ PS=1.6U PD=1.02U
M$3874 \$1890 \$1862 \$1889 VSS nfet_03v3 L=0.28U W=0.36U AS=0.1188P AD=0.1278P
+ PS=1.02U PD=1.07U
M$3875 \$2098 \$1891 \$1890 VSS nfet_03v3 L=0.28U W=0.36U AS=0.1278P AD=0.0567P
+ PS=1.07U PD=0.675U
M$3876 VSS \$1863 \$2098 VSS nfet_03v3 L=0.28U W=0.36U AS=0.0567P AD=0.1584P
+ PS=0.675U PD=1.6U
M$3877 VSS \$1890 \$1891 VSS nfet_03v3 L=0.28U W=0.36U AS=0.1584P AD=0.0972P
+ PS=1.6U PD=0.9U
M$3878 \$1892 \$1890 VSS VSS nfet_03v3 L=0.28U W=0.36U AS=0.0972P AD=0.18P
+ PS=0.9U PD=1.72U
M$3879 \$1895 \$121 VSS VSS nfet_03v3 L=0.28U W=0.36U AS=0.1584P AD=0.1188P
+ PS=1.6U PD=1.02U
M$3880 \$1896 \$1862 \$1895 VSS nfet_03v3 L=0.28U W=0.36U AS=0.1188P AD=0.1278P
+ PS=1.02U PD=1.07U
M$3881 \$2106 \$1897 \$1896 VSS nfet_03v3 L=0.28U W=0.36U AS=0.1278P AD=0.0567P
+ PS=1.07U PD=0.675U
M$3882 VSS \$1863 \$2106 VSS nfet_03v3 L=0.28U W=0.36U AS=0.0567P AD=0.1584P
+ PS=0.675U PD=1.6U
M$3883 VSS \$1896 \$1897 VSS nfet_03v3 L=0.28U W=0.36U AS=0.1584P AD=0.0972P
+ PS=1.6U PD=0.9U
M$3884 \$1898 \$1896 VSS VSS nfet_03v3 L=0.28U W=0.36U AS=0.0972P AD=0.18P
+ PS=0.9U PD=1.72U
M$3885 \$1901 \$124 VSS VSS nfet_03v3 L=0.28U W=0.36U AS=0.1584P AD=0.1188P
+ PS=1.6U PD=1.02U
M$3886 \$1902 \$1862 \$1901 VSS nfet_03v3 L=0.28U W=0.36U AS=0.1188P AD=0.1278P
+ PS=1.02U PD=1.07U
M$3887 \$2113 \$1903 \$1902 VSS nfet_03v3 L=0.28U W=0.36U AS=0.1278P AD=0.0567P
+ PS=1.07U PD=0.675U
M$3888 VSS \$1863 \$2113 VSS nfet_03v3 L=0.28U W=0.36U AS=0.0567P AD=0.1584P
+ PS=0.675U PD=1.6U
M$3889 VSS \$1902 \$1903 VSS nfet_03v3 L=0.28U W=0.36U AS=0.1584P AD=0.0972P
+ PS=1.6U PD=0.9U
M$3890 \$1904 \$1902 VSS VSS nfet_03v3 L=0.28U W=0.36U AS=0.0972P AD=0.18P
+ PS=0.9U PD=1.72U
M$3891 \$1907 \$127 VSS VSS nfet_03v3 L=0.28U W=0.36U AS=0.1584P AD=0.1188P
+ PS=1.6U PD=1.02U
M$3892 \$1908 \$1862 \$1907 VSS nfet_03v3 L=0.28U W=0.36U AS=0.1188P AD=0.1278P
+ PS=1.02U PD=1.07U
M$3893 \$2120 \$1909 \$1908 VSS nfet_03v3 L=0.28U W=0.36U AS=0.1278P AD=0.0567P
+ PS=1.07U PD=0.675U
M$3894 VSS \$1863 \$2120 VSS nfet_03v3 L=0.28U W=0.36U AS=0.0567P AD=0.1584P
+ PS=0.675U PD=1.6U
M$3895 VSS \$1908 \$1909 VSS nfet_03v3 L=0.28U W=0.36U AS=0.1584P AD=0.0972P
+ PS=1.6U PD=0.9U
M$3896 \$1910 \$1908 VSS VSS nfet_03v3 L=0.28U W=0.36U AS=0.0972P AD=0.18P
+ PS=0.9U PD=1.72U
M$3897 \$1913 \$130 VSS VSS nfet_03v3 L=0.28U W=0.36U AS=0.1584P AD=0.1188P
+ PS=1.6U PD=1.02U
M$3898 \$1914 \$1862 \$1913 VSS nfet_03v3 L=0.28U W=0.36U AS=0.1188P AD=0.1278P
+ PS=1.02U PD=1.07U
M$3899 \$2128 \$1915 \$1914 VSS nfet_03v3 L=0.28U W=0.36U AS=0.1278P AD=0.0567P
+ PS=1.07U PD=0.675U
M$3900 VSS \$1863 \$2128 VSS nfet_03v3 L=0.28U W=0.36U AS=0.0567P AD=0.1584P
+ PS=0.675U PD=1.6U
M$3901 VSS \$1914 \$1915 VSS nfet_03v3 L=0.28U W=0.36U AS=0.1584P AD=0.0972P
+ PS=1.6U PD=0.9U
M$3902 \$1916 \$1914 VSS VSS nfet_03v3 L=0.28U W=0.36U AS=0.0972P AD=0.18P
+ PS=0.9U PD=1.72U
M$3903 \$1919 \$133 VSS VSS nfet_03v3 L=0.28U W=0.36U AS=0.1584P AD=0.1188P
+ PS=1.6U PD=1.02U
M$3904 \$1920 \$1862 \$1919 VSS nfet_03v3 L=0.28U W=0.36U AS=0.1188P AD=0.1278P
+ PS=1.02U PD=1.07U
M$3905 \$2134 \$1921 \$1920 VSS nfet_03v3 L=0.28U W=0.36U AS=0.1278P AD=0.0567P
+ PS=1.07U PD=0.675U
M$3906 VSS \$1863 \$2134 VSS nfet_03v3 L=0.28U W=0.36U AS=0.0567P AD=0.1584P
+ PS=0.675U PD=1.6U
M$3907 VSS \$1920 \$1921 VSS nfet_03v3 L=0.28U W=0.36U AS=0.1584P AD=0.0972P
+ PS=1.6U PD=0.9U
M$3908 \$1922 \$1920 VSS VSS nfet_03v3 L=0.28U W=0.36U AS=0.0972P AD=0.18P
+ PS=0.9U PD=1.72U
M$3909 \$1925 \$136 VSS VSS nfet_03v3 L=0.28U W=0.36U AS=0.1584P AD=0.1188P
+ PS=1.6U PD=1.02U
M$3910 \$1926 \$1862 \$1925 VSS nfet_03v3 L=0.28U W=0.36U AS=0.1188P AD=0.1278P
+ PS=1.02U PD=1.07U
M$3911 \$2142 \$1927 \$1926 VSS nfet_03v3 L=0.28U W=0.36U AS=0.1278P AD=0.0567P
+ PS=1.07U PD=0.675U
M$3912 VSS \$1863 \$2142 VSS nfet_03v3 L=0.28U W=0.36U AS=0.0567P AD=0.1584P
+ PS=0.675U PD=1.6U
M$3913 VSS \$1926 \$1927 VSS nfet_03v3 L=0.28U W=0.36U AS=0.1584P AD=0.0972P
+ PS=1.6U PD=0.9U
M$3914 \$1928 \$1926 VSS VSS nfet_03v3 L=0.28U W=0.36U AS=0.0972P AD=0.18P
+ PS=0.9U PD=1.72U
M$3915 \$1931 \$139 VSS VSS nfet_03v3 L=0.28U W=0.36U AS=0.1584P AD=0.1188P
+ PS=1.6U PD=1.02U
M$3916 \$1932 \$1862 \$1931 VSS nfet_03v3 L=0.28U W=0.36U AS=0.1188P AD=0.1278P
+ PS=1.02U PD=1.07U
M$3917 \$2149 \$1933 \$1932 VSS nfet_03v3 L=0.28U W=0.36U AS=0.1278P AD=0.0567P
+ PS=1.07U PD=0.675U
M$3918 VSS \$1863 \$2149 VSS nfet_03v3 L=0.28U W=0.36U AS=0.0567P AD=0.1584P
+ PS=0.675U PD=1.6U
M$3919 VSS \$1932 \$1933 VSS nfet_03v3 L=0.28U W=0.36U AS=0.1584P AD=0.0972P
+ PS=1.6U PD=0.9U
M$3920 \$1934 \$1932 VSS VSS nfet_03v3 L=0.28U W=0.36U AS=0.0972P AD=0.18P
+ PS=0.9U PD=1.72U
M$3921 \$1937 \$142 VSS VSS nfet_03v3 L=0.28U W=0.36U AS=0.1584P AD=0.1188P
+ PS=1.6U PD=1.02U
M$3922 \$1938 \$1862 \$1937 VSS nfet_03v3 L=0.28U W=0.36U AS=0.1188P AD=0.1278P
+ PS=1.02U PD=1.07U
M$3923 \$2156 \$1939 \$1938 VSS nfet_03v3 L=0.28U W=0.36U AS=0.1278P AD=0.0567P
+ PS=1.07U PD=0.675U
M$3924 VSS \$1863 \$2156 VSS nfet_03v3 L=0.28U W=0.36U AS=0.0567P AD=0.1584P
+ PS=0.675U PD=1.6U
M$3925 VSS \$1938 \$1939 VSS nfet_03v3 L=0.28U W=0.36U AS=0.1584P AD=0.0972P
+ PS=1.6U PD=0.9U
M$3926 \$1940 \$1938 VSS VSS nfet_03v3 L=0.28U W=0.36U AS=0.0972P AD=0.18P
+ PS=0.9U PD=1.72U
M$3927 \$1943 \$145 VSS VSS nfet_03v3 L=0.28U W=0.36U AS=0.1584P AD=0.1188P
+ PS=1.6U PD=1.02U
M$3928 \$1944 \$1862 \$1943 VSS nfet_03v3 L=0.28U W=0.36U AS=0.1188P AD=0.1278P
+ PS=1.02U PD=1.07U
M$3929 \$2159 \$1945 \$1944 VSS nfet_03v3 L=0.28U W=0.36U AS=0.1278P AD=0.0567P
+ PS=1.07U PD=0.675U
M$3930 VSS \$1863 \$2159 VSS nfet_03v3 L=0.28U W=0.36U AS=0.0567P AD=0.1584P
+ PS=0.675U PD=1.6U
M$3931 VSS \$1944 \$1945 VSS nfet_03v3 L=0.28U W=0.36U AS=0.1584P AD=0.0972P
+ PS=1.6U PD=0.9U
M$3932 \$1946 \$1944 VSS VSS nfet_03v3 L=0.28U W=0.36U AS=0.0972P AD=0.18P
+ PS=0.9U PD=1.72U
M$3933 \$1949 \$148 VSS VSS nfet_03v3 L=0.28U W=0.36U AS=0.1584P AD=0.1188P
+ PS=1.6U PD=1.02U
M$3934 \$1950 \$1862 \$1949 VSS nfet_03v3 L=0.28U W=0.36U AS=0.1188P AD=0.1278P
+ PS=1.02U PD=1.07U
M$3935 \$2125 \$1951 \$1950 VSS nfet_03v3 L=0.28U W=0.36U AS=0.1278P AD=0.0567P
+ PS=1.07U PD=0.675U
M$3936 VSS \$1863 \$2125 VSS nfet_03v3 L=0.28U W=0.36U AS=0.0567P AD=0.1584P
+ PS=0.675U PD=1.6U
M$3937 VSS \$1950 \$1951 VSS nfet_03v3 L=0.28U W=0.36U AS=0.1584P AD=0.0972P
+ PS=1.6U PD=0.9U
M$3938 \$1952 \$1950 VSS VSS nfet_03v3 L=0.28U W=0.36U AS=0.0972P AD=0.18P
+ PS=0.9U PD=1.72U
M$3939 \$1955 \$151 VSS VSS nfet_03v3 L=0.28U W=0.36U AS=0.1584P AD=0.1188P
+ PS=1.6U PD=1.02U
M$3940 \$1956 \$1862 \$1955 VSS nfet_03v3 L=0.28U W=0.36U AS=0.1188P AD=0.1278P
+ PS=1.02U PD=1.07U
M$3941 \$2091 \$1957 \$1956 VSS nfet_03v3 L=0.28U W=0.36U AS=0.1278P AD=0.0567P
+ PS=1.07U PD=0.675U
M$3942 VSS \$1863 \$2091 VSS nfet_03v3 L=0.28U W=0.36U AS=0.0567P AD=0.1584P
+ PS=0.675U PD=1.6U
M$3943 VSS \$1956 \$1957 VSS nfet_03v3 L=0.28U W=0.36U AS=0.1584P AD=0.0972P
+ PS=1.6U PD=0.9U
M$3944 \$1958 \$1956 VSS VSS nfet_03v3 L=0.28U W=0.36U AS=0.0972P AD=0.18P
+ PS=0.9U PD=1.72U
M$3945 \$2316 WE9 VSS VSS nfet_03v3 L=0.28U W=0.72U AS=0.3168P AD=0.1872P
+ PS=2.32U PD=1.24U
M$3946 \$2180 CLK \$2316 VSS nfet_03v3 L=0.28U W=0.72U AS=0.1872P AD=0.3168P
+ PS=1.24U PD=2.32U
M$3947 \$2181 \$2180 VSS VSS nfet_03v3 L=0.28U W=1.27U AS=0.4445P AD=0.3344P
+ PS=3.305U PD=2.345U
M$3949 \$2368 \$2181 VSS VSS nfet_03v3 L=0.28U W=1.34U AS=0.3636P AD=0.4891P
+ PS=2.44U PD=3.47U
M$3951 \$2182 \$106 VSS VSS nfet_03v3 L=0.28U W=0.36U AS=0.1584P AD=0.1188P
+ PS=1.6U PD=1.02U
M$3952 \$2183 \$2181 \$2182 VSS nfet_03v3 L=0.28U W=0.36U AS=0.1188P AD=0.1278P
+ PS=1.02U PD=1.07U
M$3953 \$2221 \$2266 \$2183 VSS nfet_03v3 L=0.28U W=0.36U AS=0.1278P AD=0.0567P
+ PS=1.07U PD=0.675U
M$3954 VSS \$2368 \$2221 VSS nfet_03v3 L=0.28U W=0.36U AS=0.0567P AD=0.1584P
+ PS=0.675U PD=1.6U
M$3955 VSS \$2183 \$2266 VSS nfet_03v3 L=0.28U W=0.36U AS=0.1584P AD=0.0972P
+ PS=1.6U PD=0.9U
M$3956 \$2164 \$2183 VSS VSS nfet_03v3 L=0.28U W=0.36U AS=0.0972P AD=0.18P
+ PS=0.9U PD=1.72U
M$3957 \$2184 \$109 VSS VSS nfet_03v3 L=0.28U W=0.36U AS=0.1584P AD=0.1188P
+ PS=1.6U PD=1.02U
M$3958 \$2185 \$2181 \$2184 VSS nfet_03v3 L=0.28U W=0.36U AS=0.1188P AD=0.1278P
+ PS=1.02U PD=1.07U
M$3959 \$2230 \$2270 \$2185 VSS nfet_03v3 L=0.28U W=0.36U AS=0.1278P AD=0.0567P
+ PS=1.07U PD=0.675U
M$3960 VSS \$2368 \$2230 VSS nfet_03v3 L=0.28U W=0.36U AS=0.0567P AD=0.1584P
+ PS=0.675U PD=1.6U
M$3961 VSS \$2185 \$2270 VSS nfet_03v3 L=0.28U W=0.36U AS=0.1584P AD=0.0972P
+ PS=1.6U PD=0.9U
M$3962 \$2165 \$2185 VSS VSS nfet_03v3 L=0.28U W=0.36U AS=0.0972P AD=0.18P
+ PS=0.9U PD=1.72U
M$3963 \$2186 \$112 VSS VSS nfet_03v3 L=0.28U W=0.36U AS=0.1584P AD=0.1188P
+ PS=1.6U PD=1.02U
M$3964 \$2187 \$2181 \$2186 VSS nfet_03v3 L=0.28U W=0.36U AS=0.1188P AD=0.1278P
+ PS=1.02U PD=1.07U
M$3965 \$2239 \$2273 \$2187 VSS nfet_03v3 L=0.28U W=0.36U AS=0.1278P AD=0.0567P
+ PS=1.07U PD=0.675U
M$3966 VSS \$2368 \$2239 VSS nfet_03v3 L=0.28U W=0.36U AS=0.0567P AD=0.1584P
+ PS=0.675U PD=1.6U
M$3967 VSS \$2187 \$2273 VSS nfet_03v3 L=0.28U W=0.36U AS=0.1584P AD=0.0972P
+ PS=1.6U PD=0.9U
M$3968 \$2166 \$2187 VSS VSS nfet_03v3 L=0.28U W=0.36U AS=0.0972P AD=0.18P
+ PS=0.9U PD=1.72U
M$3969 \$2188 \$115 VSS VSS nfet_03v3 L=0.28U W=0.36U AS=0.1584P AD=0.1188P
+ PS=1.6U PD=1.02U
M$3970 \$2189 \$2181 \$2188 VSS nfet_03v3 L=0.28U W=0.36U AS=0.1188P AD=0.1278P
+ PS=1.02U PD=1.07U
M$3971 \$2248 \$2276 \$2189 VSS nfet_03v3 L=0.28U W=0.36U AS=0.1278P AD=0.0567P
+ PS=1.07U PD=0.675U
M$3972 VSS \$2368 \$2248 VSS nfet_03v3 L=0.28U W=0.36U AS=0.0567P AD=0.1584P
+ PS=0.675U PD=1.6U
M$3973 VSS \$2189 \$2276 VSS nfet_03v3 L=0.28U W=0.36U AS=0.1584P AD=0.0972P
+ PS=1.6U PD=0.9U
M$3974 \$2167 \$2189 VSS VSS nfet_03v3 L=0.28U W=0.36U AS=0.0972P AD=0.18P
+ PS=0.9U PD=1.72U
M$3975 \$2190 \$118 VSS VSS nfet_03v3 L=0.28U W=0.36U AS=0.1584P AD=0.1188P
+ PS=1.6U PD=1.02U
M$3976 \$2191 \$2181 \$2190 VSS nfet_03v3 L=0.28U W=0.36U AS=0.1188P AD=0.1278P
+ PS=1.02U PD=1.07U
M$3977 \$2257 \$2279 \$2191 VSS nfet_03v3 L=0.28U W=0.36U AS=0.1278P AD=0.0567P
+ PS=1.07U PD=0.675U
M$3978 VSS \$2368 \$2257 VSS nfet_03v3 L=0.28U W=0.36U AS=0.0567P AD=0.1584P
+ PS=0.675U PD=1.6U
M$3979 VSS \$2191 \$2279 VSS nfet_03v3 L=0.28U W=0.36U AS=0.1584P AD=0.0972P
+ PS=1.6U PD=0.9U
M$3980 \$2168 \$2191 VSS VSS nfet_03v3 L=0.28U W=0.36U AS=0.0972P AD=0.18P
+ PS=0.9U PD=1.72U
M$3981 \$2192 \$121 VSS VSS nfet_03v3 L=0.28U W=0.36U AS=0.1584P AD=0.1188P
+ PS=1.6U PD=1.02U
M$3982 \$2193 \$2181 \$2192 VSS nfet_03v3 L=0.28U W=0.36U AS=0.1188P AD=0.1278P
+ PS=1.02U PD=1.07U
M$3983 \$2260 \$2282 \$2193 VSS nfet_03v3 L=0.28U W=0.36U AS=0.1278P AD=0.0567P
+ PS=1.07U PD=0.675U
M$3984 VSS \$2368 \$2260 VSS nfet_03v3 L=0.28U W=0.36U AS=0.0567P AD=0.1584P
+ PS=0.675U PD=1.6U
M$3985 VSS \$2193 \$2282 VSS nfet_03v3 L=0.28U W=0.36U AS=0.1584P AD=0.0972P
+ PS=1.6U PD=0.9U
M$3986 \$2169 \$2193 VSS VSS nfet_03v3 L=0.28U W=0.36U AS=0.0972P AD=0.18P
+ PS=0.9U PD=1.72U
M$3987 \$2194 \$124 VSS VSS nfet_03v3 L=0.28U W=0.36U AS=0.1584P AD=0.1188P
+ PS=1.6U PD=1.02U
M$3988 \$2195 \$2181 \$2194 VSS nfet_03v3 L=0.28U W=0.36U AS=0.1188P AD=0.1278P
+ PS=1.02U PD=1.07U
M$3989 \$2254 \$2285 \$2195 VSS nfet_03v3 L=0.28U W=0.36U AS=0.1278P AD=0.0567P
+ PS=1.07U PD=0.675U
M$3990 VSS \$2368 \$2254 VSS nfet_03v3 L=0.28U W=0.36U AS=0.0567P AD=0.1584P
+ PS=0.675U PD=1.6U
M$3991 VSS \$2195 \$2285 VSS nfet_03v3 L=0.28U W=0.36U AS=0.1584P AD=0.0972P
+ PS=1.6U PD=0.9U
M$3992 \$2170 \$2195 VSS VSS nfet_03v3 L=0.28U W=0.36U AS=0.0972P AD=0.18P
+ PS=0.9U PD=1.72U
M$3993 \$2196 \$127 VSS VSS nfet_03v3 L=0.28U W=0.36U AS=0.1584P AD=0.1188P
+ PS=1.6U PD=1.02U
M$3994 \$2197 \$2181 \$2196 VSS nfet_03v3 L=0.28U W=0.36U AS=0.1188P AD=0.1278P
+ PS=1.02U PD=1.07U
M$3995 \$2252 \$2288 \$2197 VSS nfet_03v3 L=0.28U W=0.36U AS=0.1278P AD=0.0567P
+ PS=1.07U PD=0.675U
M$3996 VSS \$2368 \$2252 VSS nfet_03v3 L=0.28U W=0.36U AS=0.0567P AD=0.1584P
+ PS=0.675U PD=1.6U
M$3997 VSS \$2197 \$2288 VSS nfet_03v3 L=0.28U W=0.36U AS=0.1584P AD=0.0972P
+ PS=1.6U PD=0.9U
M$3998 \$2171 \$2197 VSS VSS nfet_03v3 L=0.28U W=0.36U AS=0.0972P AD=0.18P
+ PS=0.9U PD=1.72U
M$3999 \$2198 \$130 VSS VSS nfet_03v3 L=0.28U W=0.36U AS=0.1584P AD=0.1188P
+ PS=1.6U PD=1.02U
M$4000 \$2199 \$2181 \$2198 VSS nfet_03v3 L=0.28U W=0.36U AS=0.1188P AD=0.1278P
+ PS=1.02U PD=1.07U
M$4001 \$2246 \$2291 \$2199 VSS nfet_03v3 L=0.28U W=0.36U AS=0.1278P AD=0.0567P
+ PS=1.07U PD=0.675U
M$4002 VSS \$2368 \$2246 VSS nfet_03v3 L=0.28U W=0.36U AS=0.0567P AD=0.1584P
+ PS=0.675U PD=1.6U
M$4003 VSS \$2199 \$2291 VSS nfet_03v3 L=0.28U W=0.36U AS=0.1584P AD=0.0972P
+ PS=1.6U PD=0.9U
M$4004 \$2172 \$2199 VSS VSS nfet_03v3 L=0.28U W=0.36U AS=0.0972P AD=0.18P
+ PS=0.9U PD=1.72U
M$4005 \$2200 \$133 VSS VSS nfet_03v3 L=0.28U W=0.36U AS=0.1584P AD=0.1188P
+ PS=1.6U PD=1.02U
M$4006 \$2201 \$2181 \$2200 VSS nfet_03v3 L=0.28U W=0.36U AS=0.1188P AD=0.1278P
+ PS=1.02U PD=1.07U
M$4007 \$2243 \$2294 \$2201 VSS nfet_03v3 L=0.28U W=0.36U AS=0.1278P AD=0.0567P
+ PS=1.07U PD=0.675U
M$4008 VSS \$2368 \$2243 VSS nfet_03v3 L=0.28U W=0.36U AS=0.0567P AD=0.1584P
+ PS=0.675U PD=1.6U
M$4009 VSS \$2201 \$2294 VSS nfet_03v3 L=0.28U W=0.36U AS=0.1584P AD=0.0972P
+ PS=1.6U PD=0.9U
M$4010 \$2173 \$2201 VSS VSS nfet_03v3 L=0.28U W=0.36U AS=0.0972P AD=0.18P
+ PS=0.9U PD=1.72U
M$4011 \$2202 \$136 VSS VSS nfet_03v3 L=0.28U W=0.36U AS=0.1584P AD=0.1188P
+ PS=1.6U PD=1.02U
M$4012 \$2203 \$2181 \$2202 VSS nfet_03v3 L=0.28U W=0.36U AS=0.1188P AD=0.1278P
+ PS=1.02U PD=1.07U
M$4013 \$2237 \$2297 \$2203 VSS nfet_03v3 L=0.28U W=0.36U AS=0.1278P AD=0.0567P
+ PS=1.07U PD=0.675U
M$4014 VSS \$2368 \$2237 VSS nfet_03v3 L=0.28U W=0.36U AS=0.0567P AD=0.1584P
+ PS=0.675U PD=1.6U
M$4015 VSS \$2203 \$2297 VSS nfet_03v3 L=0.28U W=0.36U AS=0.1584P AD=0.0972P
+ PS=1.6U PD=0.9U
M$4016 \$2174 \$2203 VSS VSS nfet_03v3 L=0.28U W=0.36U AS=0.0972P AD=0.18P
+ PS=0.9U PD=1.72U
M$4017 \$2204 \$139 VSS VSS nfet_03v3 L=0.28U W=0.36U AS=0.1584P AD=0.1188P
+ PS=1.6U PD=1.02U
M$4018 \$2205 \$2181 \$2204 VSS nfet_03v3 L=0.28U W=0.36U AS=0.1188P AD=0.1278P
+ PS=1.02U PD=1.07U
M$4019 \$2234 \$2300 \$2205 VSS nfet_03v3 L=0.28U W=0.36U AS=0.1278P AD=0.0567P
+ PS=1.07U PD=0.675U
M$4020 VSS \$2368 \$2234 VSS nfet_03v3 L=0.28U W=0.36U AS=0.0567P AD=0.1584P
+ PS=0.675U PD=1.6U
M$4021 VSS \$2205 \$2300 VSS nfet_03v3 L=0.28U W=0.36U AS=0.1584P AD=0.0972P
+ PS=1.6U PD=0.9U
M$4022 \$2175 \$2205 VSS VSS nfet_03v3 L=0.28U W=0.36U AS=0.0972P AD=0.18P
+ PS=0.9U PD=1.72U
M$4023 \$2206 \$142 VSS VSS nfet_03v3 L=0.28U W=0.36U AS=0.1584P AD=0.1188P
+ PS=1.6U PD=1.02U
M$4024 \$2207 \$2181 \$2206 VSS nfet_03v3 L=0.28U W=0.36U AS=0.1188P AD=0.1278P
+ PS=1.02U PD=1.07U
M$4025 \$2228 \$2303 \$2207 VSS nfet_03v3 L=0.28U W=0.36U AS=0.1278P AD=0.0567P
+ PS=1.07U PD=0.675U
M$4026 VSS \$2368 \$2228 VSS nfet_03v3 L=0.28U W=0.36U AS=0.0567P AD=0.1584P
+ PS=0.675U PD=1.6U
M$4027 VSS \$2207 \$2303 VSS nfet_03v3 L=0.28U W=0.36U AS=0.1584P AD=0.0972P
+ PS=1.6U PD=0.9U
M$4028 \$2176 \$2207 VSS VSS nfet_03v3 L=0.28U W=0.36U AS=0.0972P AD=0.18P
+ PS=0.9U PD=1.72U
M$4029 \$2208 \$145 VSS VSS nfet_03v3 L=0.28U W=0.36U AS=0.1584P AD=0.1188P
+ PS=1.6U PD=1.02U
M$4030 \$2209 \$2181 \$2208 VSS nfet_03v3 L=0.28U W=0.36U AS=0.1188P AD=0.1278P
+ PS=1.02U PD=1.07U
M$4031 \$2225 \$2306 \$2209 VSS nfet_03v3 L=0.28U W=0.36U AS=0.1278P AD=0.0567P
+ PS=1.07U PD=0.675U
M$4032 VSS \$2368 \$2225 VSS nfet_03v3 L=0.28U W=0.36U AS=0.0567P AD=0.1584P
+ PS=0.675U PD=1.6U
M$4033 VSS \$2209 \$2306 VSS nfet_03v3 L=0.28U W=0.36U AS=0.1584P AD=0.0972P
+ PS=1.6U PD=0.9U
M$4034 \$2177 \$2209 VSS VSS nfet_03v3 L=0.28U W=0.36U AS=0.0972P AD=0.18P
+ PS=0.9U PD=1.72U
M$4035 \$2210 \$148 VSS VSS nfet_03v3 L=0.28U W=0.36U AS=0.1584P AD=0.1188P
+ PS=1.6U PD=1.02U
M$4036 \$2211 \$2181 \$2210 VSS nfet_03v3 L=0.28U W=0.36U AS=0.1188P AD=0.1278P
+ PS=1.02U PD=1.07U
M$4037 \$2218 \$2309 \$2211 VSS nfet_03v3 L=0.28U W=0.36U AS=0.1278P AD=0.0567P
+ PS=1.07U PD=0.675U
M$4038 VSS \$2368 \$2218 VSS nfet_03v3 L=0.28U W=0.36U AS=0.0567P AD=0.1584P
+ PS=0.675U PD=1.6U
M$4039 VSS \$2211 \$2309 VSS nfet_03v3 L=0.28U W=0.36U AS=0.1584P AD=0.0972P
+ PS=1.6U PD=0.9U
M$4040 \$2178 \$2211 VSS VSS nfet_03v3 L=0.28U W=0.36U AS=0.0972P AD=0.18P
+ PS=0.9U PD=1.72U
M$4041 \$2212 \$151 VSS VSS nfet_03v3 L=0.28U W=0.36U AS=0.1584P AD=0.1188P
+ PS=1.6U PD=1.02U
M$4042 \$2213 \$2181 \$2212 VSS nfet_03v3 L=0.28U W=0.36U AS=0.1188P AD=0.1278P
+ PS=1.02U PD=1.07U
M$4043 \$2215 \$2312 \$2213 VSS nfet_03v3 L=0.28U W=0.36U AS=0.1278P AD=0.0567P
+ PS=1.07U PD=0.675U
M$4044 VSS \$2368 \$2215 VSS nfet_03v3 L=0.28U W=0.36U AS=0.0567P AD=0.1584P
+ PS=0.675U PD=1.6U
M$4045 VSS \$2213 \$2312 VSS nfet_03v3 L=0.28U W=0.36U AS=0.1584P AD=0.0972P
+ PS=1.6U PD=0.9U
M$4046 \$2179 \$2213 VSS VSS nfet_03v3 L=0.28U W=0.36U AS=0.0972P AD=0.18P
+ PS=0.9U PD=1.72U
M$4047 \$2482 RB8 VSS VSS nfet_03v3 L=0.28U W=0.36U AS=0.1656P AD=0.1944P
+ PS=1.64U PD=1.8U
M$4048 \$2268 RA9 VSS VSS nfet_03v3 L=0.28U W=0.36U AS=0.1656P AD=0.1944P
+ PS=1.64U PD=1.8U
M$4049 \$2480 RB8 \$51 VSS nfet_03v3 L=0.28U W=0.36U AS=0.1584P AD=0.1152P
+ PS=1.6U PD=1U
M$4050 \$52 RA8 \$2480 VSS nfet_03v3 L=0.28U W=0.36U AS=0.1152P AD=0.1584P
+ PS=1U PD=1.6U
M$4051 \$2164 RA9 \$51 VSS nfet_03v3 L=0.28U W=0.36U AS=0.1584P AD=0.1152P
+ PS=1.6U PD=1U
M$4052 \$52 RB9 \$2164 VSS nfet_03v3 L=0.28U W=0.36U AS=0.1152P AD=0.1584P
+ PS=1U PD=1.6U
M$4053 VSS RB9 \$2269 VSS nfet_03v3 L=0.28U W=0.36U AS=0.1854P AD=0.1584P
+ PS=1.75U PD=1.6U
M$4054 VSS RA8 \$2483 VSS nfet_03v3 L=0.28U W=0.36U AS=0.1854P AD=0.1584P
+ PS=1.75U PD=1.6U
M$4055 \$2271 RA9 VSS VSS nfet_03v3 L=0.28U W=0.36U AS=0.1656P AD=0.1944P
+ PS=1.64U PD=1.8U
M$4056 \$2488 RB8 VSS VSS nfet_03v3 L=0.28U W=0.36U AS=0.1656P AD=0.1944P
+ PS=1.64U PD=1.8U
M$4057 \$2487 RB8 \$53 VSS nfet_03v3 L=0.28U W=0.36U AS=0.1584P AD=0.1152P
+ PS=1.6U PD=1U
M$4058 \$54 RA8 \$2487 VSS nfet_03v3 L=0.28U W=0.36U AS=0.1152P AD=0.1584P
+ PS=1U PD=1.6U
M$4059 \$2165 RA9 \$53 VSS nfet_03v3 L=0.28U W=0.36U AS=0.1584P AD=0.1152P
+ PS=1.6U PD=1U
M$4060 \$54 RB9 \$2165 VSS nfet_03v3 L=0.28U W=0.36U AS=0.1152P AD=0.1584P
+ PS=1U PD=1.6U
M$4061 VSS RB9 \$2272 VSS nfet_03v3 L=0.28U W=0.36U AS=0.1854P AD=0.1584P
+ PS=1.75U PD=1.6U
M$4062 VSS RA8 \$2489 VSS nfet_03v3 L=0.28U W=0.36U AS=0.1854P AD=0.1584P
+ PS=1.75U PD=1.6U
M$4063 \$2274 RA9 VSS VSS nfet_03v3 L=0.28U W=0.36U AS=0.1656P AD=0.1944P
+ PS=1.64U PD=1.8U
M$4064 \$2494 RB8 VSS VSS nfet_03v3 L=0.28U W=0.36U AS=0.1656P AD=0.1944P
+ PS=1.64U PD=1.8U
M$4065 \$2493 RB8 \$55 VSS nfet_03v3 L=0.28U W=0.36U AS=0.1584P AD=0.1152P
+ PS=1.6U PD=1U
M$4066 \$56 RA8 \$2493 VSS nfet_03v3 L=0.28U W=0.36U AS=0.1152P AD=0.1584P
+ PS=1U PD=1.6U
M$4067 \$2166 RA9 \$55 VSS nfet_03v3 L=0.28U W=0.36U AS=0.1584P AD=0.1152P
+ PS=1.6U PD=1U
M$4068 \$56 RB9 \$2166 VSS nfet_03v3 L=0.28U W=0.36U AS=0.1152P AD=0.1584P
+ PS=1U PD=1.6U
M$4069 VSS RB9 \$2275 VSS nfet_03v3 L=0.28U W=0.36U AS=0.1854P AD=0.1584P
+ PS=1.75U PD=1.6U
M$4070 VSS RA8 \$2495 VSS nfet_03v3 L=0.28U W=0.36U AS=0.1854P AD=0.1584P
+ PS=1.75U PD=1.6U
M$4071 \$2277 RA9 VSS VSS nfet_03v3 L=0.28U W=0.36U AS=0.1656P AD=0.1944P
+ PS=1.64U PD=1.8U
M$4072 \$2500 RB8 VSS VSS nfet_03v3 L=0.28U W=0.36U AS=0.1656P AD=0.1944P
+ PS=1.64U PD=1.8U
M$4073 \$2499 RB8 \$57 VSS nfet_03v3 L=0.28U W=0.36U AS=0.1584P AD=0.1152P
+ PS=1.6U PD=1U
M$4074 \$58 RA8 \$2499 VSS nfet_03v3 L=0.28U W=0.36U AS=0.1152P AD=0.1584P
+ PS=1U PD=1.6U
M$4075 \$2167 RA9 \$57 VSS nfet_03v3 L=0.28U W=0.36U AS=0.1584P AD=0.1152P
+ PS=1.6U PD=1U
M$4076 \$58 RB9 \$2167 VSS nfet_03v3 L=0.28U W=0.36U AS=0.1152P AD=0.1584P
+ PS=1U PD=1.6U
M$4077 VSS RB9 \$2278 VSS nfet_03v3 L=0.28U W=0.36U AS=0.1854P AD=0.1584P
+ PS=1.75U PD=1.6U
M$4078 VSS RA8 \$2501 VSS nfet_03v3 L=0.28U W=0.36U AS=0.1854P AD=0.1584P
+ PS=1.75U PD=1.6U
M$4079 \$2280 RA9 VSS VSS nfet_03v3 L=0.28U W=0.36U AS=0.1656P AD=0.1944P
+ PS=1.64U PD=1.8U
M$4080 \$2506 RB8 VSS VSS nfet_03v3 L=0.28U W=0.36U AS=0.1656P AD=0.1944P
+ PS=1.64U PD=1.8U
M$4081 \$2505 RB8 \$59 VSS nfet_03v3 L=0.28U W=0.36U AS=0.1584P AD=0.1152P
+ PS=1.6U PD=1U
M$4082 \$60 RA8 \$2505 VSS nfet_03v3 L=0.28U W=0.36U AS=0.1152P AD=0.1584P
+ PS=1U PD=1.6U
M$4083 \$2168 RA9 \$59 VSS nfet_03v3 L=0.28U W=0.36U AS=0.1584P AD=0.1152P
+ PS=1.6U PD=1U
M$4084 \$60 RB9 \$2168 VSS nfet_03v3 L=0.28U W=0.36U AS=0.1152P AD=0.1584P
+ PS=1U PD=1.6U
M$4085 VSS RA8 \$2507 VSS nfet_03v3 L=0.28U W=0.36U AS=0.1854P AD=0.1584P
+ PS=1.75U PD=1.6U
M$4086 VSS RB9 \$2281 VSS nfet_03v3 L=0.28U W=0.36U AS=0.1854P AD=0.1584P
+ PS=1.75U PD=1.6U
M$4087 \$2512 RB8 VSS VSS nfet_03v3 L=0.28U W=0.36U AS=0.1656P AD=0.1944P
+ PS=1.64U PD=1.8U
M$4088 \$2283 RA9 VSS VSS nfet_03v3 L=0.28U W=0.36U AS=0.1656P AD=0.1944P
+ PS=1.64U PD=1.8U
M$4089 \$2511 RB8 \$61 VSS nfet_03v3 L=0.28U W=0.36U AS=0.1584P AD=0.1152P
+ PS=1.6U PD=1U
M$4090 \$62 RA8 \$2511 VSS nfet_03v3 L=0.28U W=0.36U AS=0.1152P AD=0.1584P
+ PS=1U PD=1.6U
M$4091 \$2169 RA9 \$61 VSS nfet_03v3 L=0.28U W=0.36U AS=0.1584P AD=0.1152P
+ PS=1.6U PD=1U
M$4092 \$62 RB9 \$2169 VSS nfet_03v3 L=0.28U W=0.36U AS=0.1152P AD=0.1584P
+ PS=1U PD=1.6U
M$4093 VSS RB9 \$2284 VSS nfet_03v3 L=0.28U W=0.36U AS=0.1854P AD=0.1584P
+ PS=1.75U PD=1.6U
M$4094 VSS RA8 \$2513 VSS nfet_03v3 L=0.28U W=0.36U AS=0.1854P AD=0.1584P
+ PS=1.75U PD=1.6U
M$4095 \$2286 RA9 VSS VSS nfet_03v3 L=0.28U W=0.36U AS=0.1656P AD=0.1944P
+ PS=1.64U PD=1.8U
M$4096 \$2518 RB8 VSS VSS nfet_03v3 L=0.28U W=0.36U AS=0.1656P AD=0.1944P
+ PS=1.64U PD=1.8U
M$4097 \$2517 RB8 \$63 VSS nfet_03v3 L=0.28U W=0.36U AS=0.1584P AD=0.1152P
+ PS=1.6U PD=1U
M$4098 \$64 RA8 \$2517 VSS nfet_03v3 L=0.28U W=0.36U AS=0.1152P AD=0.1584P
+ PS=1U PD=1.6U
M$4099 \$2170 RA9 \$63 VSS nfet_03v3 L=0.28U W=0.36U AS=0.1584P AD=0.1152P
+ PS=1.6U PD=1U
M$4100 \$64 RB9 \$2170 VSS nfet_03v3 L=0.28U W=0.36U AS=0.1152P AD=0.1584P
+ PS=1U PD=1.6U
M$4101 VSS RA8 \$2519 VSS nfet_03v3 L=0.28U W=0.36U AS=0.1854P AD=0.1584P
+ PS=1.75U PD=1.6U
M$4102 VSS RB9 \$2287 VSS nfet_03v3 L=0.28U W=0.36U AS=0.1854P AD=0.1584P
+ PS=1.75U PD=1.6U
M$4103 \$2289 RA9 VSS VSS nfet_03v3 L=0.28U W=0.36U AS=0.1656P AD=0.1944P
+ PS=1.64U PD=1.8U
M$4104 \$2524 RB8 VSS VSS nfet_03v3 L=0.28U W=0.36U AS=0.1656P AD=0.1944P
+ PS=1.64U PD=1.8U
M$4105 \$2523 RB8 \$65 VSS nfet_03v3 L=0.28U W=0.36U AS=0.1584P AD=0.1152P
+ PS=1.6U PD=1U
M$4106 \$66 RA8 \$2523 VSS nfet_03v3 L=0.28U W=0.36U AS=0.1152P AD=0.1584P
+ PS=1U PD=1.6U
M$4107 \$2171 RA9 \$65 VSS nfet_03v3 L=0.28U W=0.36U AS=0.1584P AD=0.1152P
+ PS=1.6U PD=1U
M$4108 \$66 RB9 \$2171 VSS nfet_03v3 L=0.28U W=0.36U AS=0.1152P AD=0.1584P
+ PS=1U PD=1.6U
M$4109 VSS RB9 \$2290 VSS nfet_03v3 L=0.28U W=0.36U AS=0.1854P AD=0.1584P
+ PS=1.75U PD=1.6U
M$4110 VSS RA8 \$2525 VSS nfet_03v3 L=0.28U W=0.36U AS=0.1854P AD=0.1584P
+ PS=1.75U PD=1.6U
M$4111 \$2530 RB8 VSS VSS nfet_03v3 L=0.28U W=0.36U AS=0.1656P AD=0.1944P
+ PS=1.64U PD=1.8U
M$4112 \$2292 RA9 VSS VSS nfet_03v3 L=0.28U W=0.36U AS=0.1656P AD=0.1944P
+ PS=1.64U PD=1.8U
M$4113 \$2529 RB8 \$67 VSS nfet_03v3 L=0.28U W=0.36U AS=0.1584P AD=0.1152P
+ PS=1.6U PD=1U
M$4114 \$68 RA8 \$2529 VSS nfet_03v3 L=0.28U W=0.36U AS=0.1152P AD=0.1584P
+ PS=1U PD=1.6U
M$4115 \$2172 RA9 \$67 VSS nfet_03v3 L=0.28U W=0.36U AS=0.1584P AD=0.1152P
+ PS=1.6U PD=1U
M$4116 \$68 RB9 \$2172 VSS nfet_03v3 L=0.28U W=0.36U AS=0.1152P AD=0.1584P
+ PS=1U PD=1.6U
M$4117 VSS RA8 \$2531 VSS nfet_03v3 L=0.28U W=0.36U AS=0.1854P AD=0.1584P
+ PS=1.75U PD=1.6U
M$4118 VSS RB9 \$2293 VSS nfet_03v3 L=0.28U W=0.36U AS=0.1854P AD=0.1584P
+ PS=1.75U PD=1.6U
M$4119 \$2536 RB8 VSS VSS nfet_03v3 L=0.28U W=0.36U AS=0.1656P AD=0.1944P
+ PS=1.64U PD=1.8U
M$4120 \$2295 RA9 VSS VSS nfet_03v3 L=0.28U W=0.36U AS=0.1656P AD=0.1944P
+ PS=1.64U PD=1.8U
M$4121 \$2535 RB8 \$69 VSS nfet_03v3 L=0.28U W=0.36U AS=0.1584P AD=0.1152P
+ PS=1.6U PD=1U
M$4122 \$70 RA8 \$2535 VSS nfet_03v3 L=0.28U W=0.36U AS=0.1152P AD=0.1584P
+ PS=1U PD=1.6U
M$4123 \$2173 RA9 \$69 VSS nfet_03v3 L=0.28U W=0.36U AS=0.1584P AD=0.1152P
+ PS=1.6U PD=1U
M$4124 \$70 RB9 \$2173 VSS nfet_03v3 L=0.28U W=0.36U AS=0.1152P AD=0.1584P
+ PS=1U PD=1.6U
M$4125 VSS RB9 \$2296 VSS nfet_03v3 L=0.28U W=0.36U AS=0.1854P AD=0.1584P
+ PS=1.75U PD=1.6U
M$4126 VSS RA8 \$2537 VSS nfet_03v3 L=0.28U W=0.36U AS=0.1854P AD=0.1584P
+ PS=1.75U PD=1.6U
M$4127 \$2542 RB8 VSS VSS nfet_03v3 L=0.28U W=0.36U AS=0.1656P AD=0.1944P
+ PS=1.64U PD=1.8U
M$4128 \$2298 RA9 VSS VSS nfet_03v3 L=0.28U W=0.36U AS=0.1656P AD=0.1944P
+ PS=1.64U PD=1.8U
M$4129 \$2174 RA9 \$71 VSS nfet_03v3 L=0.28U W=0.36U AS=0.1584P AD=0.1152P
+ PS=1.6U PD=1U
M$4130 \$72 RB9 \$2174 VSS nfet_03v3 L=0.28U W=0.36U AS=0.1152P AD=0.1584P
+ PS=1U PD=1.6U
M$4131 \$2541 RB8 \$71 VSS nfet_03v3 L=0.28U W=0.36U AS=0.1584P AD=0.1152P
+ PS=1.6U PD=1U
M$4132 \$72 RA8 \$2541 VSS nfet_03v3 L=0.28U W=0.36U AS=0.1152P AD=0.1584P
+ PS=1U PD=1.6U
M$4133 VSS RB9 \$2299 VSS nfet_03v3 L=0.28U W=0.36U AS=0.1854P AD=0.1584P
+ PS=1.75U PD=1.6U
M$4134 VSS RA8 \$2543 VSS nfet_03v3 L=0.28U W=0.36U AS=0.1854P AD=0.1584P
+ PS=1.75U PD=1.6U
M$4135 \$2548 RB8 VSS VSS nfet_03v3 L=0.28U W=0.36U AS=0.1656P AD=0.1944P
+ PS=1.64U PD=1.8U
M$4136 \$2301 RA9 VSS VSS nfet_03v3 L=0.28U W=0.36U AS=0.1656P AD=0.1944P
+ PS=1.64U PD=1.8U
M$4137 \$2175 RA9 \$73 VSS nfet_03v3 L=0.28U W=0.36U AS=0.1584P AD=0.1152P
+ PS=1.6U PD=1U
M$4138 \$74 RB9 \$2175 VSS nfet_03v3 L=0.28U W=0.36U AS=0.1152P AD=0.1584P
+ PS=1U PD=1.6U
M$4139 \$2547 RB8 \$73 VSS nfet_03v3 L=0.28U W=0.36U AS=0.1584P AD=0.1152P
+ PS=1.6U PD=1U
M$4140 \$74 RA8 \$2547 VSS nfet_03v3 L=0.28U W=0.36U AS=0.1152P AD=0.1584P
+ PS=1U PD=1.6U
M$4141 VSS RA8 \$2549 VSS nfet_03v3 L=0.28U W=0.36U AS=0.1854P AD=0.1584P
+ PS=1.75U PD=1.6U
M$4142 VSS RB9 \$2302 VSS nfet_03v3 L=0.28U W=0.36U AS=0.1854P AD=0.1584P
+ PS=1.75U PD=1.6U
M$4143 \$2304 RA9 VSS VSS nfet_03v3 L=0.28U W=0.36U AS=0.1656P AD=0.1944P
+ PS=1.64U PD=1.8U
M$4144 \$2554 RB8 VSS VSS nfet_03v3 L=0.28U W=0.36U AS=0.1656P AD=0.1944P
+ PS=1.64U PD=1.8U
M$4145 \$2176 RA9 \$75 VSS nfet_03v3 L=0.28U W=0.36U AS=0.1584P AD=0.1152P
+ PS=1.6U PD=1U
M$4146 \$76 RB9 \$2176 VSS nfet_03v3 L=0.28U W=0.36U AS=0.1152P AD=0.1584P
+ PS=1U PD=1.6U
M$4147 \$2553 RB8 \$75 VSS nfet_03v3 L=0.28U W=0.36U AS=0.1584P AD=0.1152P
+ PS=1.6U PD=1U
M$4148 \$76 RA8 \$2553 VSS nfet_03v3 L=0.28U W=0.36U AS=0.1152P AD=0.1584P
+ PS=1U PD=1.6U
M$4149 VSS RA8 \$2555 VSS nfet_03v3 L=0.28U W=0.36U AS=0.1854P AD=0.1584P
+ PS=1.75U PD=1.6U
M$4150 VSS RB9 \$2305 VSS nfet_03v3 L=0.28U W=0.36U AS=0.1854P AD=0.1584P
+ PS=1.75U PD=1.6U
M$4151 \$2307 RA9 VSS VSS nfet_03v3 L=0.28U W=0.36U AS=0.1656P AD=0.1944P
+ PS=1.64U PD=1.8U
M$4152 \$2560 RB8 VSS VSS nfet_03v3 L=0.28U W=0.36U AS=0.1656P AD=0.1944P
+ PS=1.64U PD=1.8U
M$4153 \$2559 RB8 \$77 VSS nfet_03v3 L=0.28U W=0.36U AS=0.1584P AD=0.1152P
+ PS=1.6U PD=1U
M$4154 \$78 RA8 \$2559 VSS nfet_03v3 L=0.28U W=0.36U AS=0.1152P AD=0.1584P
+ PS=1U PD=1.6U
M$4155 \$2177 RA9 \$77 VSS nfet_03v3 L=0.28U W=0.36U AS=0.1584P AD=0.1152P
+ PS=1.6U PD=1U
M$4156 \$78 RB9 \$2177 VSS nfet_03v3 L=0.28U W=0.36U AS=0.1152P AD=0.1584P
+ PS=1U PD=1.6U
M$4157 VSS RA8 \$2561 VSS nfet_03v3 L=0.28U W=0.36U AS=0.1854P AD=0.1584P
+ PS=1.75U PD=1.6U
M$4158 VSS RB9 \$2308 VSS nfet_03v3 L=0.28U W=0.36U AS=0.1854P AD=0.1584P
+ PS=1.75U PD=1.6U
M$4159 \$2566 RB8 VSS VSS nfet_03v3 L=0.28U W=0.36U AS=0.1656P AD=0.1944P
+ PS=1.64U PD=1.8U
M$4160 \$2310 RA9 VSS VSS nfet_03v3 L=0.28U W=0.36U AS=0.1656P AD=0.1944P
+ PS=1.64U PD=1.8U
M$4161 \$2178 RA9 \$79 VSS nfet_03v3 L=0.28U W=0.36U AS=0.1584P AD=0.1152P
+ PS=1.6U PD=1U
M$4162 \$80 RB9 \$2178 VSS nfet_03v3 L=0.28U W=0.36U AS=0.1152P AD=0.1584P
+ PS=1U PD=1.6U
M$4163 \$2565 RB8 \$79 VSS nfet_03v3 L=0.28U W=0.36U AS=0.1584P AD=0.1152P
+ PS=1.6U PD=1U
M$4164 \$80 RA8 \$2565 VSS nfet_03v3 L=0.28U W=0.36U AS=0.1152P AD=0.1584P
+ PS=1U PD=1.6U
M$4165 VSS RA8 \$2567 VSS nfet_03v3 L=0.28U W=0.36U AS=0.1854P AD=0.1584P
+ PS=1.75U PD=1.6U
M$4166 VSS RB9 \$2311 VSS nfet_03v3 L=0.28U W=0.36U AS=0.1854P AD=0.1584P
+ PS=1.75U PD=1.6U
M$4167 \$2572 RB8 VSS VSS nfet_03v3 L=0.28U W=0.36U AS=0.1656P AD=0.1944P
+ PS=1.64U PD=1.8U
M$4168 \$2313 RA9 VSS VSS nfet_03v3 L=0.28U W=0.36U AS=0.1656P AD=0.1944P
+ PS=1.64U PD=1.8U
M$4169 \$2571 RB8 \$81 VSS nfet_03v3 L=0.28U W=0.36U AS=0.1584P AD=0.1152P
+ PS=1.6U PD=1U
M$4170 \$82 RA8 \$2571 VSS nfet_03v3 L=0.28U W=0.36U AS=0.1152P AD=0.1584P
+ PS=1U PD=1.6U
M$4171 \$2179 RA9 \$81 VSS nfet_03v3 L=0.28U W=0.36U AS=0.1584P AD=0.1152P
+ PS=1.6U PD=1U
M$4172 \$82 RB9 \$2179 VSS nfet_03v3 L=0.28U W=0.36U AS=0.1152P AD=0.1584P
+ PS=1U PD=1.6U
M$4173 VSS RA8 \$2573 VSS nfet_03v3 L=0.28U W=0.36U AS=0.1854P AD=0.1584P
+ PS=1.75U PD=1.6U
M$4174 VSS RB9 \$2314 VSS nfet_03v3 L=0.28U W=0.36U AS=0.1854P AD=0.1584P
+ PS=1.75U PD=1.6U
M$4175 \$2678 WE8 VSS VSS nfet_03v3 L=0.28U W=0.72U AS=0.3168P AD=0.1872P
+ PS=2.32U PD=1.24U
M$4176 \$2474 CLK \$2678 VSS nfet_03v3 L=0.28U W=0.72U AS=0.1872P AD=0.3168P
+ PS=1.24U PD=2.32U
M$4177 \$2475 \$2474 VSS VSS nfet_03v3 L=0.28U W=1.27U AS=0.4487P AD=0.3302P
+ PS=3.34U PD=2.31U
M$4179 \$2476 \$2475 VSS VSS nfet_03v3 L=0.28U W=1.34U AS=0.3636P AD=0.4891P
+ PS=2.44U PD=3.47U
M$4181 \$2477 \$106 VSS VSS nfet_03v3 L=0.28U W=0.36U AS=0.1584P AD=0.1188P
+ PS=1.6U PD=1.02U
M$4182 \$2478 \$2475 \$2477 VSS nfet_03v3 L=0.28U W=0.36U AS=0.1188P AD=0.1278P
+ PS=1.02U PD=1.07U
M$4183 \$2683 \$2479 \$2478 VSS nfet_03v3 L=0.28U W=0.36U AS=0.1278P AD=0.0567P
+ PS=1.07U PD=0.675U
M$4184 VSS \$2476 \$2683 VSS nfet_03v3 L=0.28U W=0.36U AS=0.0567P AD=0.1584P
+ PS=0.675U PD=1.6U
M$4185 VSS \$2478 \$2479 VSS nfet_03v3 L=0.28U W=0.36U AS=0.1584P AD=0.0972P
+ PS=1.6U PD=0.9U
M$4186 \$2480 \$2478 VSS VSS nfet_03v3 L=0.28U W=0.36U AS=0.0972P AD=0.18P
+ PS=0.9U PD=1.72U
M$4187 \$2484 \$109 VSS VSS nfet_03v3 L=0.28U W=0.36U AS=0.1584P AD=0.1188P
+ PS=1.6U PD=1.02U
M$4188 \$2485 \$2475 \$2484 VSS nfet_03v3 L=0.28U W=0.36U AS=0.1188P AD=0.1278P
+ PS=1.02U PD=1.07U
M$4189 \$2690 \$2486 \$2485 VSS nfet_03v3 L=0.28U W=0.36U AS=0.1278P AD=0.0567P
+ PS=1.07U PD=0.675U
M$4190 VSS \$2476 \$2690 VSS nfet_03v3 L=0.28U W=0.36U AS=0.0567P AD=0.1584P
+ PS=0.675U PD=1.6U
M$4191 VSS \$2485 \$2486 VSS nfet_03v3 L=0.28U W=0.36U AS=0.1584P AD=0.0972P
+ PS=1.6U PD=0.9U
M$4192 \$2487 \$2485 VSS VSS nfet_03v3 L=0.28U W=0.36U AS=0.0972P AD=0.18P
+ PS=0.9U PD=1.72U
M$4193 \$2490 \$112 VSS VSS nfet_03v3 L=0.28U W=0.36U AS=0.1584P AD=0.1188P
+ PS=1.6U PD=1.02U
M$4194 \$2491 \$2475 \$2490 VSS nfet_03v3 L=0.28U W=0.36U AS=0.1188P AD=0.1278P
+ PS=1.02U PD=1.07U
M$4195 \$2697 \$2492 \$2491 VSS nfet_03v3 L=0.28U W=0.36U AS=0.1278P AD=0.0567P
+ PS=1.07U PD=0.675U
M$4196 VSS \$2476 \$2697 VSS nfet_03v3 L=0.28U W=0.36U AS=0.0567P AD=0.1584P
+ PS=0.675U PD=1.6U
M$4197 VSS \$2491 \$2492 VSS nfet_03v3 L=0.28U W=0.36U AS=0.1584P AD=0.0972P
+ PS=1.6U PD=0.9U
M$4198 \$2493 \$2491 VSS VSS nfet_03v3 L=0.28U W=0.36U AS=0.0972P AD=0.18P
+ PS=0.9U PD=1.72U
M$4199 \$2496 \$115 VSS VSS nfet_03v3 L=0.28U W=0.36U AS=0.1584P AD=0.1188P
+ PS=1.6U PD=1.02U
M$4200 \$2497 \$2475 \$2496 VSS nfet_03v3 L=0.28U W=0.36U AS=0.1188P AD=0.1278P
+ PS=1.02U PD=1.07U
M$4201 \$2705 \$2498 \$2497 VSS nfet_03v3 L=0.28U W=0.36U AS=0.1278P AD=0.0567P
+ PS=1.07U PD=0.675U
M$4202 VSS \$2476 \$2705 VSS nfet_03v3 L=0.28U W=0.36U AS=0.0567P AD=0.1584P
+ PS=0.675U PD=1.6U
M$4203 VSS \$2497 \$2498 VSS nfet_03v3 L=0.28U W=0.36U AS=0.1584P AD=0.0972P
+ PS=1.6U PD=0.9U
M$4204 \$2499 \$2497 VSS VSS nfet_03v3 L=0.28U W=0.36U AS=0.0972P AD=0.18P
+ PS=0.9U PD=1.72U
M$4205 \$2502 \$118 VSS VSS nfet_03v3 L=0.28U W=0.36U AS=0.1584P AD=0.1188P
+ PS=1.6U PD=1.02U
M$4206 \$2503 \$2475 \$2502 VSS nfet_03v3 L=0.28U W=0.36U AS=0.1188P AD=0.1278P
+ PS=1.02U PD=1.07U
M$4207 \$2711 \$2504 \$2503 VSS nfet_03v3 L=0.28U W=0.36U AS=0.1278P AD=0.0567P
+ PS=1.07U PD=0.675U
M$4208 VSS \$2476 \$2711 VSS nfet_03v3 L=0.28U W=0.36U AS=0.0567P AD=0.1584P
+ PS=0.675U PD=1.6U
M$4209 VSS \$2503 \$2504 VSS nfet_03v3 L=0.28U W=0.36U AS=0.1584P AD=0.0972P
+ PS=1.6U PD=0.9U
M$4210 \$2505 \$2503 VSS VSS nfet_03v3 L=0.28U W=0.36U AS=0.0972P AD=0.18P
+ PS=0.9U PD=1.72U
M$4211 \$2508 \$121 VSS VSS nfet_03v3 L=0.28U W=0.36U AS=0.1584P AD=0.1188P
+ PS=1.6U PD=1.02U
M$4212 \$2509 \$2475 \$2508 VSS nfet_03v3 L=0.28U W=0.36U AS=0.1188P AD=0.1278P
+ PS=1.02U PD=1.07U
M$4213 \$2719 \$2510 \$2509 VSS nfet_03v3 L=0.28U W=0.36U AS=0.1278P AD=0.0567P
+ PS=1.07U PD=0.675U
M$4214 VSS \$2476 \$2719 VSS nfet_03v3 L=0.28U W=0.36U AS=0.0567P AD=0.1584P
+ PS=0.675U PD=1.6U
M$4215 VSS \$2509 \$2510 VSS nfet_03v3 L=0.28U W=0.36U AS=0.1584P AD=0.0972P
+ PS=1.6U PD=0.9U
M$4216 \$2511 \$2509 VSS VSS nfet_03v3 L=0.28U W=0.36U AS=0.0972P AD=0.18P
+ PS=0.9U PD=1.72U
M$4217 \$2514 \$124 VSS VSS nfet_03v3 L=0.28U W=0.36U AS=0.1584P AD=0.1188P
+ PS=1.6U PD=1.02U
M$4218 \$2515 \$2475 \$2514 VSS nfet_03v3 L=0.28U W=0.36U AS=0.1188P AD=0.1278P
+ PS=1.02U PD=1.07U
M$4219 \$2726 \$2516 \$2515 VSS nfet_03v3 L=0.28U W=0.36U AS=0.1278P AD=0.0567P
+ PS=1.07U PD=0.675U
M$4220 VSS \$2476 \$2726 VSS nfet_03v3 L=0.28U W=0.36U AS=0.0567P AD=0.1584P
+ PS=0.675U PD=1.6U
M$4221 VSS \$2515 \$2516 VSS nfet_03v3 L=0.28U W=0.36U AS=0.1584P AD=0.0972P
+ PS=1.6U PD=0.9U
M$4222 \$2517 \$2515 VSS VSS nfet_03v3 L=0.28U W=0.36U AS=0.0972P AD=0.18P
+ PS=0.9U PD=1.72U
M$4223 \$2520 \$127 VSS VSS nfet_03v3 L=0.28U W=0.36U AS=0.1584P AD=0.1188P
+ PS=1.6U PD=1.02U
M$4224 \$2521 \$2475 \$2520 VSS nfet_03v3 L=0.28U W=0.36U AS=0.1188P AD=0.1278P
+ PS=1.02U PD=1.07U
M$4225 \$2733 \$2522 \$2521 VSS nfet_03v3 L=0.28U W=0.36U AS=0.1278P AD=0.0567P
+ PS=1.07U PD=0.675U
M$4226 VSS \$2476 \$2733 VSS nfet_03v3 L=0.28U W=0.36U AS=0.0567P AD=0.1584P
+ PS=0.675U PD=1.6U
M$4227 VSS \$2521 \$2522 VSS nfet_03v3 L=0.28U W=0.36U AS=0.1584P AD=0.0972P
+ PS=1.6U PD=0.9U
M$4228 \$2523 \$2521 VSS VSS nfet_03v3 L=0.28U W=0.36U AS=0.0972P AD=0.18P
+ PS=0.9U PD=1.72U
M$4229 \$2526 \$130 VSS VSS nfet_03v3 L=0.28U W=0.36U AS=0.1584P AD=0.1188P
+ PS=1.6U PD=1.02U
M$4230 \$2527 \$2475 \$2526 VSS nfet_03v3 L=0.28U W=0.36U AS=0.1188P AD=0.1278P
+ PS=1.02U PD=1.07U
M$4231 \$2741 \$2528 \$2527 VSS nfet_03v3 L=0.28U W=0.36U AS=0.1278P AD=0.0567P
+ PS=1.07U PD=0.675U
M$4232 VSS \$2476 \$2741 VSS nfet_03v3 L=0.28U W=0.36U AS=0.0567P AD=0.1584P
+ PS=0.675U PD=1.6U
M$4233 VSS \$2527 \$2528 VSS nfet_03v3 L=0.28U W=0.36U AS=0.1584P AD=0.0972P
+ PS=1.6U PD=0.9U
M$4234 \$2529 \$2527 VSS VSS nfet_03v3 L=0.28U W=0.36U AS=0.0972P AD=0.18P
+ PS=0.9U PD=1.72U
M$4235 \$2532 \$133 VSS VSS nfet_03v3 L=0.28U W=0.36U AS=0.1584P AD=0.1188P
+ PS=1.6U PD=1.02U
M$4236 \$2533 \$2475 \$2532 VSS nfet_03v3 L=0.28U W=0.36U AS=0.1188P AD=0.1278P
+ PS=1.02U PD=1.07U
M$4237 \$2747 \$2534 \$2533 VSS nfet_03v3 L=0.28U W=0.36U AS=0.1278P AD=0.0567P
+ PS=1.07U PD=0.675U
M$4238 VSS \$2476 \$2747 VSS nfet_03v3 L=0.28U W=0.36U AS=0.0567P AD=0.1584P
+ PS=0.675U PD=1.6U
M$4239 VSS \$2533 \$2534 VSS nfet_03v3 L=0.28U W=0.36U AS=0.1584P AD=0.0972P
+ PS=1.6U PD=0.9U
M$4240 \$2535 \$2533 VSS VSS nfet_03v3 L=0.28U W=0.36U AS=0.0972P AD=0.18P
+ PS=0.9U PD=1.72U
M$4241 \$2538 \$136 VSS VSS nfet_03v3 L=0.28U W=0.36U AS=0.1584P AD=0.1188P
+ PS=1.6U PD=1.02U
M$4242 \$2539 \$2475 \$2538 VSS nfet_03v3 L=0.28U W=0.36U AS=0.1188P AD=0.1278P
+ PS=1.02U PD=1.07U
M$4243 \$2755 \$2540 \$2539 VSS nfet_03v3 L=0.28U W=0.36U AS=0.1278P AD=0.0567P
+ PS=1.07U PD=0.675U
M$4244 VSS \$2476 \$2755 VSS nfet_03v3 L=0.28U W=0.36U AS=0.0567P AD=0.1584P
+ PS=0.675U PD=1.6U
M$4245 VSS \$2539 \$2540 VSS nfet_03v3 L=0.28U W=0.36U AS=0.1584P AD=0.0972P
+ PS=1.6U PD=0.9U
M$4246 \$2541 \$2539 VSS VSS nfet_03v3 L=0.28U W=0.36U AS=0.0972P AD=0.18P
+ PS=0.9U PD=1.72U
M$4247 \$2544 \$139 VSS VSS nfet_03v3 L=0.28U W=0.36U AS=0.1584P AD=0.1188P
+ PS=1.6U PD=1.02U
M$4248 \$2545 \$2475 \$2544 VSS nfet_03v3 L=0.28U W=0.36U AS=0.1188P AD=0.1278P
+ PS=1.02U PD=1.07U
M$4249 \$2762 \$2546 \$2545 VSS nfet_03v3 L=0.28U W=0.36U AS=0.1278P AD=0.0567P
+ PS=1.07U PD=0.675U
M$4250 VSS \$2476 \$2762 VSS nfet_03v3 L=0.28U W=0.36U AS=0.0567P AD=0.1584P
+ PS=0.675U PD=1.6U
M$4251 VSS \$2545 \$2546 VSS nfet_03v3 L=0.28U W=0.36U AS=0.1584P AD=0.0972P
+ PS=1.6U PD=0.9U
M$4252 \$2547 \$2545 VSS VSS nfet_03v3 L=0.28U W=0.36U AS=0.0972P AD=0.18P
+ PS=0.9U PD=1.72U
M$4253 \$2550 \$142 VSS VSS nfet_03v3 L=0.28U W=0.36U AS=0.1584P AD=0.1188P
+ PS=1.6U PD=1.02U
M$4254 \$2551 \$2475 \$2550 VSS nfet_03v3 L=0.28U W=0.36U AS=0.1188P AD=0.1278P
+ PS=1.02U PD=1.07U
M$4255 \$2769 \$2552 \$2551 VSS nfet_03v3 L=0.28U W=0.36U AS=0.1278P AD=0.0567P
+ PS=1.07U PD=0.675U
M$4256 VSS \$2476 \$2769 VSS nfet_03v3 L=0.28U W=0.36U AS=0.0567P AD=0.1584P
+ PS=0.675U PD=1.6U
M$4257 VSS \$2551 \$2552 VSS nfet_03v3 L=0.28U W=0.36U AS=0.1584P AD=0.0972P
+ PS=1.6U PD=0.9U
M$4258 \$2553 \$2551 VSS VSS nfet_03v3 L=0.28U W=0.36U AS=0.0972P AD=0.18P
+ PS=0.9U PD=1.72U
M$4259 \$2556 \$145 VSS VSS nfet_03v3 L=0.28U W=0.36U AS=0.1584P AD=0.1188P
+ PS=1.6U PD=1.02U
M$4260 \$2557 \$2475 \$2556 VSS nfet_03v3 L=0.28U W=0.36U AS=0.1188P AD=0.1278P
+ PS=1.02U PD=1.07U
M$4261 \$2774 \$2558 \$2557 VSS nfet_03v3 L=0.28U W=0.36U AS=0.1278P AD=0.0567P
+ PS=1.07U PD=0.675U
M$4262 VSS \$2476 \$2774 VSS nfet_03v3 L=0.28U W=0.36U AS=0.0567P AD=0.1584P
+ PS=0.675U PD=1.6U
M$4263 VSS \$2557 \$2558 VSS nfet_03v3 L=0.28U W=0.36U AS=0.1584P AD=0.0972P
+ PS=1.6U PD=0.9U
M$4264 \$2559 \$2557 VSS VSS nfet_03v3 L=0.28U W=0.36U AS=0.0972P AD=0.18P
+ PS=0.9U PD=1.72U
M$4265 \$2562 \$148 VSS VSS nfet_03v3 L=0.28U W=0.36U AS=0.1584P AD=0.1188P
+ PS=1.6U PD=1.02U
M$4266 \$2563 \$2475 \$2562 VSS nfet_03v3 L=0.28U W=0.36U AS=0.1188P AD=0.1278P
+ PS=1.02U PD=1.07U
M$4267 \$2739 \$2564 \$2563 VSS nfet_03v3 L=0.28U W=0.36U AS=0.1278P AD=0.0567P
+ PS=1.07U PD=0.675U
M$4268 VSS \$2476 \$2739 VSS nfet_03v3 L=0.28U W=0.36U AS=0.0567P AD=0.1584P
+ PS=0.675U PD=1.6U
M$4269 VSS \$2563 \$2564 VSS nfet_03v3 L=0.28U W=0.36U AS=0.1584P AD=0.0972P
+ PS=1.6U PD=0.9U
M$4270 \$2565 \$2563 VSS VSS nfet_03v3 L=0.28U W=0.36U AS=0.0972P AD=0.18P
+ PS=0.9U PD=1.72U
M$4271 \$2568 \$151 VSS VSS nfet_03v3 L=0.28U W=0.36U AS=0.1584P AD=0.1188P
+ PS=1.6U PD=1.02U
M$4272 \$2569 \$2475 \$2568 VSS nfet_03v3 L=0.28U W=0.36U AS=0.1188P AD=0.1278P
+ PS=1.02U PD=1.07U
M$4273 \$2704 \$2570 \$2569 VSS nfet_03v3 L=0.28U W=0.36U AS=0.1278P AD=0.0567P
+ PS=1.07U PD=0.675U
M$4274 VSS \$2476 \$2704 VSS nfet_03v3 L=0.28U W=0.36U AS=0.0567P AD=0.1584P
+ PS=0.675U PD=1.6U
M$4275 VSS \$2569 \$2570 VSS nfet_03v3 L=0.28U W=0.36U AS=0.1584P AD=0.0972P
+ PS=1.6U PD=0.9U
M$4276 \$2571 \$2569 VSS VSS nfet_03v3 L=0.28U W=0.36U AS=0.0972P AD=0.18P
+ PS=0.9U PD=1.72U
M$4277 \$2935 WE7 VSS VSS nfet_03v3 L=0.28U W=0.72U AS=0.3168P AD=0.1872P
+ PS=2.32U PD=1.24U
M$4278 \$2793 CLK \$2935 VSS nfet_03v3 L=0.28U W=0.72U AS=0.1872P AD=0.3168P
+ PS=1.24U PD=2.32U
M$4279 \$2794 \$2793 VSS VSS nfet_03v3 L=0.28U W=1.27U AS=0.4445P AD=0.3344P
+ PS=3.305U PD=2.345U
M$4281 \$2987 \$2794 VSS VSS nfet_03v3 L=0.28U W=1.34U AS=0.3636P AD=0.4891P
+ PS=2.44U PD=3.47U
M$4283 \$2795 \$106 VSS VSS nfet_03v3 L=0.28U W=0.36U AS=0.1584P AD=0.1188P
+ PS=1.6U PD=1.02U
M$4284 \$2796 \$2794 \$2795 VSS nfet_03v3 L=0.28U W=0.36U AS=0.1188P AD=0.1278P
+ PS=1.02U PD=1.07U
M$4285 \$2833 \$2885 \$2796 VSS nfet_03v3 L=0.28U W=0.36U AS=0.1278P AD=0.0567P
+ PS=1.07U PD=0.675U
M$4286 VSS \$2987 \$2833 VSS nfet_03v3 L=0.28U W=0.36U AS=0.0567P AD=0.1584P
+ PS=0.675U PD=1.6U
M$4287 VSS \$2796 \$2885 VSS nfet_03v3 L=0.28U W=0.36U AS=0.1584P AD=0.0972P
+ PS=1.6U PD=0.9U
M$4288 \$2777 \$2796 VSS VSS nfet_03v3 L=0.28U W=0.36U AS=0.0972P AD=0.18P
+ PS=0.9U PD=1.72U
M$4289 \$2797 \$109 VSS VSS nfet_03v3 L=0.28U W=0.36U AS=0.1584P AD=0.1188P
+ PS=1.6U PD=1.02U
M$4290 \$2798 \$2794 \$2797 VSS nfet_03v3 L=0.28U W=0.36U AS=0.1188P AD=0.1278P
+ PS=1.02U PD=1.07U
M$4291 \$2844 \$2889 \$2798 VSS nfet_03v3 L=0.28U W=0.36U AS=0.1278P AD=0.0567P
+ PS=1.07U PD=0.675U
M$4292 VSS \$2987 \$2844 VSS nfet_03v3 L=0.28U W=0.36U AS=0.0567P AD=0.1584P
+ PS=0.675U PD=1.6U
M$4293 VSS \$2798 \$2889 VSS nfet_03v3 L=0.28U W=0.36U AS=0.1584P AD=0.0972P
+ PS=1.6U PD=0.9U
M$4294 \$2778 \$2798 VSS VSS nfet_03v3 L=0.28U W=0.36U AS=0.0972P AD=0.18P
+ PS=0.9U PD=1.72U
M$4295 \$2799 \$112 VSS VSS nfet_03v3 L=0.28U W=0.36U AS=0.1584P AD=0.1188P
+ PS=1.6U PD=1.02U
M$4296 \$2800 \$2794 \$2799 VSS nfet_03v3 L=0.28U W=0.36U AS=0.1188P AD=0.1278P
+ PS=1.02U PD=1.07U
M$4297 \$2853 \$2892 \$2800 VSS nfet_03v3 L=0.28U W=0.36U AS=0.1278P AD=0.0567P
+ PS=1.07U PD=0.675U
M$4298 VSS \$2987 \$2853 VSS nfet_03v3 L=0.28U W=0.36U AS=0.0567P AD=0.1584P
+ PS=0.675U PD=1.6U
M$4299 VSS \$2800 \$2892 VSS nfet_03v3 L=0.28U W=0.36U AS=0.1584P AD=0.0972P
+ PS=1.6U PD=0.9U
M$4300 \$2779 \$2800 VSS VSS nfet_03v3 L=0.28U W=0.36U AS=0.0972P AD=0.18P
+ PS=0.9U PD=1.72U
M$4301 \$2801 \$115 VSS VSS nfet_03v3 L=0.28U W=0.36U AS=0.1584P AD=0.1188P
+ PS=1.6U PD=1.02U
M$4302 \$2802 \$2794 \$2801 VSS nfet_03v3 L=0.28U W=0.36U AS=0.1188P AD=0.1278P
+ PS=1.02U PD=1.07U
M$4303 \$2863 \$2895 \$2802 VSS nfet_03v3 L=0.28U W=0.36U AS=0.1278P AD=0.0567P
+ PS=1.07U PD=0.675U
M$4304 VSS \$2987 \$2863 VSS nfet_03v3 L=0.28U W=0.36U AS=0.0567P AD=0.1584P
+ PS=0.675U PD=1.6U
M$4305 VSS \$2802 \$2895 VSS nfet_03v3 L=0.28U W=0.36U AS=0.1584P AD=0.0972P
+ PS=1.6U PD=0.9U
M$4306 \$2780 \$2802 VSS VSS nfet_03v3 L=0.28U W=0.36U AS=0.0972P AD=0.18P
+ PS=0.9U PD=1.72U
M$4307 \$2803 \$118 VSS VSS nfet_03v3 L=0.28U W=0.36U AS=0.1584P AD=0.1188P
+ PS=1.6U PD=1.02U
M$4308 \$2804 \$2794 \$2803 VSS nfet_03v3 L=0.28U W=0.36U AS=0.1188P AD=0.1278P
+ PS=1.02U PD=1.07U
M$4309 \$2874 \$2898 \$2804 VSS nfet_03v3 L=0.28U W=0.36U AS=0.1278P AD=0.0567P
+ PS=1.07U PD=0.675U
M$4310 VSS \$2987 \$2874 VSS nfet_03v3 L=0.28U W=0.36U AS=0.0567P AD=0.1584P
+ PS=0.675U PD=1.6U
M$4311 VSS \$2804 \$2898 VSS nfet_03v3 L=0.28U W=0.36U AS=0.1584P AD=0.0972P
+ PS=1.6U PD=0.9U
M$4312 \$2781 \$2804 VSS VSS nfet_03v3 L=0.28U W=0.36U AS=0.0972P AD=0.18P
+ PS=0.9U PD=1.72U
M$4313 \$2805 \$121 VSS VSS nfet_03v3 L=0.28U W=0.36U AS=0.1584P AD=0.1188P
+ PS=1.6U PD=1.02U
M$4314 \$2806 \$2794 \$2805 VSS nfet_03v3 L=0.28U W=0.36U AS=0.1188P AD=0.1278P
+ PS=1.02U PD=1.07U
M$4315 \$2879 \$2901 \$2806 VSS nfet_03v3 L=0.28U W=0.36U AS=0.1278P AD=0.0567P
+ PS=1.07U PD=0.675U
M$4316 VSS \$2987 \$2879 VSS nfet_03v3 L=0.28U W=0.36U AS=0.0567P AD=0.1584P
+ PS=0.675U PD=1.6U
M$4317 VSS \$2806 \$2901 VSS nfet_03v3 L=0.28U W=0.36U AS=0.1584P AD=0.0972P
+ PS=1.6U PD=0.9U
M$4318 \$2782 \$2806 VSS VSS nfet_03v3 L=0.28U W=0.36U AS=0.0972P AD=0.18P
+ PS=0.9U PD=1.72U
M$4319 \$2807 \$124 VSS VSS nfet_03v3 L=0.28U W=0.36U AS=0.1584P AD=0.1188P
+ PS=1.6U PD=1.02U
M$4320 \$2808 \$2794 \$2807 VSS nfet_03v3 L=0.28U W=0.36U AS=0.1188P AD=0.1278P
+ PS=1.02U PD=1.07U
M$4321 \$2875 \$2904 \$2808 VSS nfet_03v3 L=0.28U W=0.36U AS=0.1278P AD=0.0567P
+ PS=1.07U PD=0.675U
M$4322 VSS \$2987 \$2875 VSS nfet_03v3 L=0.28U W=0.36U AS=0.0567P AD=0.1584P
+ PS=0.675U PD=1.6U
M$4323 VSS \$2808 \$2904 VSS nfet_03v3 L=0.28U W=0.36U AS=0.1584P AD=0.0972P
+ PS=1.6U PD=0.9U
M$4324 \$2783 \$2808 VSS VSS nfet_03v3 L=0.28U W=0.36U AS=0.0972P AD=0.18P
+ PS=0.9U PD=1.72U
M$4325 \$2809 \$127 VSS VSS nfet_03v3 L=0.28U W=0.36U AS=0.1584P AD=0.1188P
+ PS=1.6U PD=1.02U
M$4326 \$2810 \$2794 \$2809 VSS nfet_03v3 L=0.28U W=0.36U AS=0.1188P AD=0.1278P
+ PS=1.02U PD=1.07U
M$4327 \$2868 \$2907 \$2810 VSS nfet_03v3 L=0.28U W=0.36U AS=0.1278P AD=0.0567P
+ PS=1.07U PD=0.675U
M$4328 VSS \$2987 \$2868 VSS nfet_03v3 L=0.28U W=0.36U AS=0.0567P AD=0.1584P
+ PS=0.675U PD=1.6U
M$4329 VSS \$2810 \$2907 VSS nfet_03v3 L=0.28U W=0.36U AS=0.1584P AD=0.0972P
+ PS=1.6U PD=0.9U
M$4330 \$2784 \$2810 VSS VSS nfet_03v3 L=0.28U W=0.36U AS=0.0972P AD=0.18P
+ PS=0.9U PD=1.72U
M$4331 \$2811 \$130 VSS VSS nfet_03v3 L=0.28U W=0.36U AS=0.1584P AD=0.1188P
+ PS=1.6U PD=1.02U
M$4332 \$2812 \$2794 \$2811 VSS nfet_03v3 L=0.28U W=0.36U AS=0.1188P AD=0.1278P
+ PS=1.02U PD=1.07U
M$4333 \$2865 \$2910 \$2812 VSS nfet_03v3 L=0.28U W=0.36U AS=0.1278P AD=0.0567P
+ PS=1.07U PD=0.675U
M$4334 VSS \$2987 \$2865 VSS nfet_03v3 L=0.28U W=0.36U AS=0.0567P AD=0.1584P
+ PS=0.675U PD=1.6U
M$4335 VSS \$2812 \$2910 VSS nfet_03v3 L=0.28U W=0.36U AS=0.1584P AD=0.0972P
+ PS=1.6U PD=0.9U
M$4336 \$2785 \$2812 VSS VSS nfet_03v3 L=0.28U W=0.36U AS=0.0972P AD=0.18P
+ PS=0.9U PD=1.72U
M$4337 \$2813 \$133 VSS VSS nfet_03v3 L=0.28U W=0.36U AS=0.1584P AD=0.1188P
+ PS=1.6U PD=1.02U
M$4338 \$2814 \$2794 \$2813 VSS nfet_03v3 L=0.28U W=0.36U AS=0.1188P AD=0.1278P
+ PS=1.02U PD=1.07U
M$4339 \$2860 \$2913 \$2814 VSS nfet_03v3 L=0.28U W=0.36U AS=0.1278P AD=0.0567P
+ PS=1.07U PD=0.675U
M$4340 VSS \$2987 \$2860 VSS nfet_03v3 L=0.28U W=0.36U AS=0.0567P AD=0.1584P
+ PS=0.675U PD=1.6U
M$4341 VSS \$2814 \$2913 VSS nfet_03v3 L=0.28U W=0.36U AS=0.1584P AD=0.0972P
+ PS=1.6U PD=0.9U
M$4342 \$2786 \$2814 VSS VSS nfet_03v3 L=0.28U W=0.36U AS=0.0972P AD=0.18P
+ PS=0.9U PD=1.72U
M$4343 \$2815 \$136 VSS VSS nfet_03v3 L=0.28U W=0.36U AS=0.1584P AD=0.1188P
+ PS=1.6U PD=1.02U
M$4344 \$2816 \$2794 \$2815 VSS nfet_03v3 L=0.28U W=0.36U AS=0.1188P AD=0.1278P
+ PS=1.02U PD=1.07U
M$4345 \$2854 \$2916 \$2816 VSS nfet_03v3 L=0.28U W=0.36U AS=0.1278P AD=0.0567P
+ PS=1.07U PD=0.675U
M$4346 VSS \$2987 \$2854 VSS nfet_03v3 L=0.28U W=0.36U AS=0.0567P AD=0.1584P
+ PS=0.675U PD=1.6U
M$4347 VSS \$2816 \$2916 VSS nfet_03v3 L=0.28U W=0.36U AS=0.1584P AD=0.0972P
+ PS=1.6U PD=0.9U
M$4348 \$2787 \$2816 VSS VSS nfet_03v3 L=0.28U W=0.36U AS=0.0972P AD=0.18P
+ PS=0.9U PD=1.72U
M$4349 \$2817 \$139 VSS VSS nfet_03v3 L=0.28U W=0.36U AS=0.1584P AD=0.1188P
+ PS=1.6U PD=1.02U
M$4350 \$2818 \$2794 \$2817 VSS nfet_03v3 L=0.28U W=0.36U AS=0.1188P AD=0.1278P
+ PS=1.02U PD=1.07U
M$4351 \$2850 \$2919 \$2818 VSS nfet_03v3 L=0.28U W=0.36U AS=0.1278P AD=0.0567P
+ PS=1.07U PD=0.675U
M$4352 VSS \$2987 \$2850 VSS nfet_03v3 L=0.28U W=0.36U AS=0.0567P AD=0.1584P
+ PS=0.675U PD=1.6U
M$4353 VSS \$2818 \$2919 VSS nfet_03v3 L=0.28U W=0.36U AS=0.1584P AD=0.0972P
+ PS=1.6U PD=0.9U
M$4354 \$2788 \$2818 VSS VSS nfet_03v3 L=0.28U W=0.36U AS=0.0972P AD=0.18P
+ PS=0.9U PD=1.72U
M$4355 \$2819 \$142 VSS VSS nfet_03v3 L=0.28U W=0.36U AS=0.1584P AD=0.1188P
+ PS=1.6U PD=1.02U
M$4356 \$2820 \$2794 \$2819 VSS nfet_03v3 L=0.28U W=0.36U AS=0.1188P AD=0.1278P
+ PS=1.02U PD=1.07U
M$4357 \$2846 \$2922 \$2820 VSS nfet_03v3 L=0.28U W=0.36U AS=0.1278P AD=0.0567P
+ PS=1.07U PD=0.675U
M$4358 VSS \$2987 \$2846 VSS nfet_03v3 L=0.28U W=0.36U AS=0.0567P AD=0.1584P
+ PS=0.675U PD=1.6U
M$4359 VSS \$2820 \$2922 VSS nfet_03v3 L=0.28U W=0.36U AS=0.1584P AD=0.0972P
+ PS=1.6U PD=0.9U
M$4360 \$2789 \$2820 VSS VSS nfet_03v3 L=0.28U W=0.36U AS=0.0972P AD=0.18P
+ PS=0.9U PD=1.72U
M$4361 \$2821 \$145 VSS VSS nfet_03v3 L=0.28U W=0.36U AS=0.1584P AD=0.1188P
+ PS=1.6U PD=1.02U
M$4362 \$2822 \$2794 \$2821 VSS nfet_03v3 L=0.28U W=0.36U AS=0.1188P AD=0.1278P
+ PS=1.02U PD=1.07U
M$4363 \$2839 \$2925 \$2822 VSS nfet_03v3 L=0.28U W=0.36U AS=0.1278P AD=0.0567P
+ PS=1.07U PD=0.675U
M$4364 VSS \$2987 \$2839 VSS nfet_03v3 L=0.28U W=0.36U AS=0.0567P AD=0.1584P
+ PS=0.675U PD=1.6U
M$4365 VSS \$2822 \$2925 VSS nfet_03v3 L=0.28U W=0.36U AS=0.1584P AD=0.0972P
+ PS=1.6U PD=0.9U
M$4366 \$2790 \$2822 VSS VSS nfet_03v3 L=0.28U W=0.36U AS=0.0972P AD=0.18P
+ PS=0.9U PD=1.72U
M$4367 \$2823 \$148 VSS VSS nfet_03v3 L=0.28U W=0.36U AS=0.1584P AD=0.1188P
+ PS=1.6U PD=1.02U
M$4368 \$2824 \$2794 \$2823 VSS nfet_03v3 L=0.28U W=0.36U AS=0.1188P AD=0.1278P
+ PS=1.02U PD=1.07U
M$4369 \$2834 \$2928 \$2824 VSS nfet_03v3 L=0.28U W=0.36U AS=0.1278P AD=0.0567P
+ PS=1.07U PD=0.675U
M$4370 VSS \$2987 \$2834 VSS nfet_03v3 L=0.28U W=0.36U AS=0.0567P AD=0.1584P
+ PS=0.675U PD=1.6U
M$4371 VSS \$2824 \$2928 VSS nfet_03v3 L=0.28U W=0.36U AS=0.1584P AD=0.0972P
+ PS=1.6U PD=0.9U
M$4372 \$2791 \$2824 VSS VSS nfet_03v3 L=0.28U W=0.36U AS=0.0972P AD=0.18P
+ PS=0.9U PD=1.72U
M$4373 \$2825 \$151 VSS VSS nfet_03v3 L=0.28U W=0.36U AS=0.1584P AD=0.1188P
+ PS=1.6U PD=1.02U
M$4374 \$2826 \$2794 \$2825 VSS nfet_03v3 L=0.28U W=0.36U AS=0.1188P AD=0.1278P
+ PS=1.02U PD=1.07U
M$4375 \$2829 \$2931 \$2826 VSS nfet_03v3 L=0.28U W=0.36U AS=0.1278P AD=0.0567P
+ PS=1.07U PD=0.675U
M$4376 VSS \$2987 \$2829 VSS nfet_03v3 L=0.28U W=0.36U AS=0.0567P AD=0.1584P
+ PS=0.675U PD=1.6U
M$4377 VSS \$2826 \$2931 VSS nfet_03v3 L=0.28U W=0.36U AS=0.1584P AD=0.0972P
+ PS=1.6U PD=0.9U
M$4378 \$2792 \$2826 VSS VSS nfet_03v3 L=0.28U W=0.36U AS=0.0972P AD=0.18P
+ PS=0.9U PD=1.72U
M$4379 \$3101 RB6 VSS VSS nfet_03v3 L=0.28U W=0.36U AS=0.1656P AD=0.1944P
+ PS=1.64U PD=1.8U
M$4380 \$2887 RA7 VSS VSS nfet_03v3 L=0.28U W=0.36U AS=0.1656P AD=0.1944P
+ PS=1.64U PD=1.8U
M$4381 \$3099 RB6 \$51 VSS nfet_03v3 L=0.28U W=0.36U AS=0.1584P AD=0.1152P
+ PS=1.6U PD=1U
M$4382 \$52 RA6 \$3099 VSS nfet_03v3 L=0.28U W=0.36U AS=0.1152P AD=0.1584P
+ PS=1U PD=1.6U
M$4383 \$2777 RA7 \$51 VSS nfet_03v3 L=0.28U W=0.36U AS=0.1584P AD=0.1152P
+ PS=1.6U PD=1U
M$4384 \$52 RB7 \$2777 VSS nfet_03v3 L=0.28U W=0.36U AS=0.1152P AD=0.1584P
+ PS=1U PD=1.6U
M$4385 VSS RB7 \$2888 VSS nfet_03v3 L=0.28U W=0.36U AS=0.1854P AD=0.1584P
+ PS=1.75U PD=1.6U
M$4386 VSS RA6 \$3102 VSS nfet_03v3 L=0.28U W=0.36U AS=0.1854P AD=0.1584P
+ PS=1.75U PD=1.6U
M$4387 \$3107 RB6 VSS VSS nfet_03v3 L=0.28U W=0.36U AS=0.1656P AD=0.1944P
+ PS=1.64U PD=1.8U
M$4388 \$2890 RA7 VSS VSS nfet_03v3 L=0.28U W=0.36U AS=0.1656P AD=0.1944P
+ PS=1.64U PD=1.8U
M$4389 \$3106 RB6 \$53 VSS nfet_03v3 L=0.28U W=0.36U AS=0.1584P AD=0.1152P
+ PS=1.6U PD=1U
M$4390 \$54 RA6 \$3106 VSS nfet_03v3 L=0.28U W=0.36U AS=0.1152P AD=0.1584P
+ PS=1U PD=1.6U
M$4391 \$2778 RA7 \$53 VSS nfet_03v3 L=0.28U W=0.36U AS=0.1584P AD=0.1152P
+ PS=1.6U PD=1U
M$4392 \$54 RB7 \$2778 VSS nfet_03v3 L=0.28U W=0.36U AS=0.1152P AD=0.1584P
+ PS=1U PD=1.6U
M$4393 VSS RA6 \$3108 VSS nfet_03v3 L=0.28U W=0.36U AS=0.1854P AD=0.1584P
+ PS=1.75U PD=1.6U
M$4394 VSS RB7 \$2891 VSS nfet_03v3 L=0.28U W=0.36U AS=0.1854P AD=0.1584P
+ PS=1.75U PD=1.6U
M$4395 \$3113 RB6 VSS VSS nfet_03v3 L=0.28U W=0.36U AS=0.1656P AD=0.1944P
+ PS=1.64U PD=1.8U
M$4396 \$2893 RA7 VSS VSS nfet_03v3 L=0.28U W=0.36U AS=0.1656P AD=0.1944P
+ PS=1.64U PD=1.8U
M$4397 \$2779 RA7 \$55 VSS nfet_03v3 L=0.28U W=0.36U AS=0.1584P AD=0.1152P
+ PS=1.6U PD=1U
M$4398 \$56 RB7 \$2779 VSS nfet_03v3 L=0.28U W=0.36U AS=0.1152P AD=0.1584P
+ PS=1U PD=1.6U
M$4399 \$3112 RB6 \$55 VSS nfet_03v3 L=0.28U W=0.36U AS=0.1584P AD=0.1152P
+ PS=1.6U PD=1U
M$4400 \$56 RA6 \$3112 VSS nfet_03v3 L=0.28U W=0.36U AS=0.1152P AD=0.1584P
+ PS=1U PD=1.6U
M$4401 VSS RA6 \$3114 VSS nfet_03v3 L=0.28U W=0.36U AS=0.1854P AD=0.1584P
+ PS=1.75U PD=1.6U
M$4402 VSS RB7 \$2894 VSS nfet_03v3 L=0.28U W=0.36U AS=0.1854P AD=0.1584P
+ PS=1.75U PD=1.6U
M$4403 \$2896 RA7 VSS VSS nfet_03v3 L=0.28U W=0.36U AS=0.1656P AD=0.1944P
+ PS=1.64U PD=1.8U
M$4404 \$3119 RB6 VSS VSS nfet_03v3 L=0.28U W=0.36U AS=0.1656P AD=0.1944P
+ PS=1.64U PD=1.8U
M$4405 \$3118 RB6 \$57 VSS nfet_03v3 L=0.28U W=0.36U AS=0.1584P AD=0.1152P
+ PS=1.6U PD=1U
M$4406 \$58 RA6 \$3118 VSS nfet_03v3 L=0.28U W=0.36U AS=0.1152P AD=0.1584P
+ PS=1U PD=1.6U
M$4407 \$2780 RA7 \$57 VSS nfet_03v3 L=0.28U W=0.36U AS=0.1584P AD=0.1152P
+ PS=1.6U PD=1U
M$4408 \$58 RB7 \$2780 VSS nfet_03v3 L=0.28U W=0.36U AS=0.1152P AD=0.1584P
+ PS=1U PD=1.6U
M$4409 VSS RA6 \$3120 VSS nfet_03v3 L=0.28U W=0.36U AS=0.1854P AD=0.1584P
+ PS=1.75U PD=1.6U
M$4410 VSS RB7 \$2897 VSS nfet_03v3 L=0.28U W=0.36U AS=0.1854P AD=0.1584P
+ PS=1.75U PD=1.6U
M$4411 \$2899 RA7 VSS VSS nfet_03v3 L=0.28U W=0.36U AS=0.1656P AD=0.1944P
+ PS=1.64U PD=1.8U
M$4412 \$3125 RB6 VSS VSS nfet_03v3 L=0.28U W=0.36U AS=0.1656P AD=0.1944P
+ PS=1.64U PD=1.8U
M$4413 \$2781 RA7 \$59 VSS nfet_03v3 L=0.28U W=0.36U AS=0.1584P AD=0.1152P
+ PS=1.6U PD=1U
M$4414 \$60 RB7 \$2781 VSS nfet_03v3 L=0.28U W=0.36U AS=0.1152P AD=0.1584P
+ PS=1U PD=1.6U
M$4415 \$3124 RB6 \$59 VSS nfet_03v3 L=0.28U W=0.36U AS=0.1584P AD=0.1152P
+ PS=1.6U PD=1U
M$4416 \$60 RA6 \$3124 VSS nfet_03v3 L=0.28U W=0.36U AS=0.1152P AD=0.1584P
+ PS=1U PD=1.6U
M$4417 VSS RB7 \$2900 VSS nfet_03v3 L=0.28U W=0.36U AS=0.1854P AD=0.1584P
+ PS=1.75U PD=1.6U
M$4418 VSS RA6 \$3126 VSS nfet_03v3 L=0.28U W=0.36U AS=0.1854P AD=0.1584P
+ PS=1.75U PD=1.6U
M$4419 \$2902 RA7 VSS VSS nfet_03v3 L=0.28U W=0.36U AS=0.1656P AD=0.1944P
+ PS=1.64U PD=1.8U
M$4420 \$3131 RB6 VSS VSS nfet_03v3 L=0.28U W=0.36U AS=0.1656P AD=0.1944P
+ PS=1.64U PD=1.8U
M$4421 \$3130 RB6 \$61 VSS nfet_03v3 L=0.28U W=0.36U AS=0.1584P AD=0.1152P
+ PS=1.6U PD=1U
M$4422 \$62 RA6 \$3130 VSS nfet_03v3 L=0.28U W=0.36U AS=0.1152P AD=0.1584P
+ PS=1U PD=1.6U
M$4423 \$2782 RA7 \$61 VSS nfet_03v3 L=0.28U W=0.36U AS=0.1584P AD=0.1152P
+ PS=1.6U PD=1U
M$4424 \$62 RB7 \$2782 VSS nfet_03v3 L=0.28U W=0.36U AS=0.1152P AD=0.1584P
+ PS=1U PD=1.6U
M$4425 VSS RA6 \$3132 VSS nfet_03v3 L=0.28U W=0.36U AS=0.1854P AD=0.1584P
+ PS=1.75U PD=1.6U
M$4426 VSS RB7 \$2903 VSS nfet_03v3 L=0.28U W=0.36U AS=0.1854P AD=0.1584P
+ PS=1.75U PD=1.6U
M$4427 \$3137 RB6 VSS VSS nfet_03v3 L=0.28U W=0.36U AS=0.1656P AD=0.1944P
+ PS=1.64U PD=1.8U
M$4428 \$2905 RA7 VSS VSS nfet_03v3 L=0.28U W=0.36U AS=0.1656P AD=0.1944P
+ PS=1.64U PD=1.8U
M$4429 \$3136 RB6 \$63 VSS nfet_03v3 L=0.28U W=0.36U AS=0.1584P AD=0.1152P
+ PS=1.6U PD=1U
M$4430 \$64 RA6 \$3136 VSS nfet_03v3 L=0.28U W=0.36U AS=0.1152P AD=0.1584P
+ PS=1U PD=1.6U
M$4431 \$2783 RA7 \$63 VSS nfet_03v3 L=0.28U W=0.36U AS=0.1584P AD=0.1152P
+ PS=1.6U PD=1U
M$4432 \$64 RB7 \$2783 VSS nfet_03v3 L=0.28U W=0.36U AS=0.1152P AD=0.1584P
+ PS=1U PD=1.6U
M$4433 VSS RB7 \$2906 VSS nfet_03v3 L=0.28U W=0.36U AS=0.1854P AD=0.1584P
+ PS=1.75U PD=1.6U
M$4434 VSS RA6 \$3138 VSS nfet_03v3 L=0.28U W=0.36U AS=0.1854P AD=0.1584P
+ PS=1.75U PD=1.6U
M$4435 \$3143 RB6 VSS VSS nfet_03v3 L=0.28U W=0.36U AS=0.1656P AD=0.1944P
+ PS=1.64U PD=1.8U
M$4436 \$2908 RA7 VSS VSS nfet_03v3 L=0.28U W=0.36U AS=0.1656P AD=0.1944P
+ PS=1.64U PD=1.8U
M$4437 \$3142 RB6 \$65 VSS nfet_03v3 L=0.28U W=0.36U AS=0.1584P AD=0.1152P
+ PS=1.6U PD=1U
M$4438 \$66 RA6 \$3142 VSS nfet_03v3 L=0.28U W=0.36U AS=0.1152P AD=0.1584P
+ PS=1U PD=1.6U
M$4439 \$2784 RA7 \$65 VSS nfet_03v3 L=0.28U W=0.36U AS=0.1584P AD=0.1152P
+ PS=1.6U PD=1U
M$4440 \$66 RB7 \$2784 VSS nfet_03v3 L=0.28U W=0.36U AS=0.1152P AD=0.1584P
+ PS=1U PD=1.6U
M$4441 VSS RB7 \$2909 VSS nfet_03v3 L=0.28U W=0.36U AS=0.1854P AD=0.1584P
+ PS=1.75U PD=1.6U
M$4442 VSS RA6 \$3144 VSS nfet_03v3 L=0.28U W=0.36U AS=0.1854P AD=0.1584P
+ PS=1.75U PD=1.6U
M$4443 \$2911 RA7 VSS VSS nfet_03v3 L=0.28U W=0.36U AS=0.1656P AD=0.1944P
+ PS=1.64U PD=1.8U
M$4444 \$3149 RB6 VSS VSS nfet_03v3 L=0.28U W=0.36U AS=0.1656P AD=0.1944P
+ PS=1.64U PD=1.8U
M$4445 \$2785 RA7 \$67 VSS nfet_03v3 L=0.28U W=0.36U AS=0.1584P AD=0.1152P
+ PS=1.6U PD=1U
M$4446 \$68 RB7 \$2785 VSS nfet_03v3 L=0.28U W=0.36U AS=0.1152P AD=0.1584P
+ PS=1U PD=1.6U
M$4447 \$3148 RB6 \$67 VSS nfet_03v3 L=0.28U W=0.36U AS=0.1584P AD=0.1152P
+ PS=1.6U PD=1U
M$4448 \$68 RA6 \$3148 VSS nfet_03v3 L=0.28U W=0.36U AS=0.1152P AD=0.1584P
+ PS=1U PD=1.6U
M$4449 VSS RB7 \$2912 VSS nfet_03v3 L=0.28U W=0.36U AS=0.1854P AD=0.1584P
+ PS=1.75U PD=1.6U
M$4450 VSS RA6 \$3150 VSS nfet_03v3 L=0.28U W=0.36U AS=0.1854P AD=0.1584P
+ PS=1.75U PD=1.6U
M$4451 \$3155 RB6 VSS VSS nfet_03v3 L=0.28U W=0.36U AS=0.1656P AD=0.1944P
+ PS=1.64U PD=1.8U
M$4452 \$2914 RA7 VSS VSS nfet_03v3 L=0.28U W=0.36U AS=0.1656P AD=0.1944P
+ PS=1.64U PD=1.8U
M$4453 \$2786 RA7 \$69 VSS nfet_03v3 L=0.28U W=0.36U AS=0.1584P AD=0.1152P
+ PS=1.6U PD=1U
M$4454 \$70 RB7 \$2786 VSS nfet_03v3 L=0.28U W=0.36U AS=0.1152P AD=0.1584P
+ PS=1U PD=1.6U
M$4455 \$3154 RB6 \$69 VSS nfet_03v3 L=0.28U W=0.36U AS=0.1584P AD=0.1152P
+ PS=1.6U PD=1U
M$4456 \$70 RA6 \$3154 VSS nfet_03v3 L=0.28U W=0.36U AS=0.1152P AD=0.1584P
+ PS=1U PD=1.6U
M$4457 VSS RB7 \$2915 VSS nfet_03v3 L=0.28U W=0.36U AS=0.1854P AD=0.1584P
+ PS=1.75U PD=1.6U
M$4458 VSS RA6 \$3156 VSS nfet_03v3 L=0.28U W=0.36U AS=0.1854P AD=0.1584P
+ PS=1.75U PD=1.6U
M$4459 \$3161 RB6 VSS VSS nfet_03v3 L=0.28U W=0.36U AS=0.1656P AD=0.1944P
+ PS=1.64U PD=1.8U
M$4460 \$2917 RA7 VSS VSS nfet_03v3 L=0.28U W=0.36U AS=0.1656P AD=0.1944P
+ PS=1.64U PD=1.8U
M$4461 \$3160 RB6 \$71 VSS nfet_03v3 L=0.28U W=0.36U AS=0.1584P AD=0.1152P
+ PS=1.6U PD=1U
M$4462 \$72 RA6 \$3160 VSS nfet_03v3 L=0.28U W=0.36U AS=0.1152P AD=0.1584P
+ PS=1U PD=1.6U
M$4463 \$2787 RA7 \$71 VSS nfet_03v3 L=0.28U W=0.36U AS=0.1584P AD=0.1152P
+ PS=1.6U PD=1U
M$4464 \$72 RB7 \$2787 VSS nfet_03v3 L=0.28U W=0.36U AS=0.1152P AD=0.1584P
+ PS=1U PD=1.6U
M$4465 VSS RA6 \$3162 VSS nfet_03v3 L=0.28U W=0.36U AS=0.1854P AD=0.1584P
+ PS=1.75U PD=1.6U
M$4466 VSS RB7 \$2918 VSS nfet_03v3 L=0.28U W=0.36U AS=0.1854P AD=0.1584P
+ PS=1.75U PD=1.6U
M$4467 \$3167 RB6 VSS VSS nfet_03v3 L=0.28U W=0.36U AS=0.1656P AD=0.1944P
+ PS=1.64U PD=1.8U
M$4468 \$2920 RA7 VSS VSS nfet_03v3 L=0.28U W=0.36U AS=0.1656P AD=0.1944P
+ PS=1.64U PD=1.8U
M$4469 \$3166 RB6 \$73 VSS nfet_03v3 L=0.28U W=0.36U AS=0.1584P AD=0.1152P
+ PS=1.6U PD=1U
M$4470 \$74 RA6 \$3166 VSS nfet_03v3 L=0.28U W=0.36U AS=0.1152P AD=0.1584P
+ PS=1U PD=1.6U
M$4471 \$2788 RA7 \$73 VSS nfet_03v3 L=0.28U W=0.36U AS=0.1584P AD=0.1152P
+ PS=1.6U PD=1U
M$4472 \$74 RB7 \$2788 VSS nfet_03v3 L=0.28U W=0.36U AS=0.1152P AD=0.1584P
+ PS=1U PD=1.6U
M$4473 VSS RA6 \$3168 VSS nfet_03v3 L=0.28U W=0.36U AS=0.1854P AD=0.1584P
+ PS=1.75U PD=1.6U
M$4474 VSS RB7 \$2921 VSS nfet_03v3 L=0.28U W=0.36U AS=0.1854P AD=0.1584P
+ PS=1.75U PD=1.6U
M$4475 \$3173 RB6 VSS VSS nfet_03v3 L=0.28U W=0.36U AS=0.1656P AD=0.1944P
+ PS=1.64U PD=1.8U
M$4476 \$2923 RA7 VSS VSS nfet_03v3 L=0.28U W=0.36U AS=0.1656P AD=0.1944P
+ PS=1.64U PD=1.8U
M$4477 \$3172 RB6 \$75 VSS nfet_03v3 L=0.28U W=0.36U AS=0.1584P AD=0.1152P
+ PS=1.6U PD=1U
M$4478 \$76 RA6 \$3172 VSS nfet_03v3 L=0.28U W=0.36U AS=0.1152P AD=0.1584P
+ PS=1U PD=1.6U
M$4479 \$2789 RA7 \$75 VSS nfet_03v3 L=0.28U W=0.36U AS=0.1584P AD=0.1152P
+ PS=1.6U PD=1U
M$4480 \$76 RB7 \$2789 VSS nfet_03v3 L=0.28U W=0.36U AS=0.1152P AD=0.1584P
+ PS=1U PD=1.6U
M$4481 VSS RA6 \$3174 VSS nfet_03v3 L=0.28U W=0.36U AS=0.1854P AD=0.1584P
+ PS=1.75U PD=1.6U
M$4482 VSS RB7 \$2924 VSS nfet_03v3 L=0.28U W=0.36U AS=0.1854P AD=0.1584P
+ PS=1.75U PD=1.6U
M$4483 \$2926 RA7 VSS VSS nfet_03v3 L=0.28U W=0.36U AS=0.1656P AD=0.1944P
+ PS=1.64U PD=1.8U
M$4484 \$3179 RB6 VSS VSS nfet_03v3 L=0.28U W=0.36U AS=0.1656P AD=0.1944P
+ PS=1.64U PD=1.8U
M$4485 \$2790 RA7 \$77 VSS nfet_03v3 L=0.28U W=0.36U AS=0.1584P AD=0.1152P
+ PS=1.6U PD=1U
M$4486 \$78 RB7 \$2790 VSS nfet_03v3 L=0.28U W=0.36U AS=0.1152P AD=0.1584P
+ PS=1U PD=1.6U
M$4487 \$3178 RB6 \$77 VSS nfet_03v3 L=0.28U W=0.36U AS=0.1584P AD=0.1152P
+ PS=1.6U PD=1U
M$4488 \$78 RA6 \$3178 VSS nfet_03v3 L=0.28U W=0.36U AS=0.1152P AD=0.1584P
+ PS=1U PD=1.6U
M$4489 VSS RB7 \$2927 VSS nfet_03v3 L=0.28U W=0.36U AS=0.1854P AD=0.1584P
+ PS=1.75U PD=1.6U
M$4490 VSS RA6 \$3180 VSS nfet_03v3 L=0.28U W=0.36U AS=0.1854P AD=0.1584P
+ PS=1.75U PD=1.6U
M$4491 \$2929 RA7 VSS VSS nfet_03v3 L=0.28U W=0.36U AS=0.1656P AD=0.1944P
+ PS=1.64U PD=1.8U
M$4492 \$3185 RB6 VSS VSS nfet_03v3 L=0.28U W=0.36U AS=0.1656P AD=0.1944P
+ PS=1.64U PD=1.8U
M$4493 \$2791 RA7 \$79 VSS nfet_03v3 L=0.28U W=0.36U AS=0.1584P AD=0.1152P
+ PS=1.6U PD=1U
M$4494 \$80 RB7 \$2791 VSS nfet_03v3 L=0.28U W=0.36U AS=0.1152P AD=0.1584P
+ PS=1U PD=1.6U
M$4495 \$3184 RB6 \$79 VSS nfet_03v3 L=0.28U W=0.36U AS=0.1584P AD=0.1152P
+ PS=1.6U PD=1U
M$4496 \$80 RA6 \$3184 VSS nfet_03v3 L=0.28U W=0.36U AS=0.1152P AD=0.1584P
+ PS=1U PD=1.6U
M$4497 VSS RB7 \$2930 VSS nfet_03v3 L=0.28U W=0.36U AS=0.1854P AD=0.1584P
+ PS=1.75U PD=1.6U
M$4498 VSS RA6 \$3186 VSS nfet_03v3 L=0.28U W=0.36U AS=0.1854P AD=0.1584P
+ PS=1.75U PD=1.6U
M$4499 \$2932 RA7 VSS VSS nfet_03v3 L=0.28U W=0.36U AS=0.1656P AD=0.1944P
+ PS=1.64U PD=1.8U
M$4500 \$3191 RB6 VSS VSS nfet_03v3 L=0.28U W=0.36U AS=0.1656P AD=0.1944P
+ PS=1.64U PD=1.8U
M$4501 \$3190 RB6 \$81 VSS nfet_03v3 L=0.28U W=0.36U AS=0.1584P AD=0.1152P
+ PS=1.6U PD=1U
M$4502 \$82 RA6 \$3190 VSS nfet_03v3 L=0.28U W=0.36U AS=0.1152P AD=0.1584P
+ PS=1U PD=1.6U
M$4503 \$2792 RA7 \$81 VSS nfet_03v3 L=0.28U W=0.36U AS=0.1584P AD=0.1152P
+ PS=1.6U PD=1U
M$4504 \$82 RB7 \$2792 VSS nfet_03v3 L=0.28U W=0.36U AS=0.1152P AD=0.1584P
+ PS=1U PD=1.6U
M$4505 VSS RB7 \$2933 VSS nfet_03v3 L=0.28U W=0.36U AS=0.1854P AD=0.1584P
+ PS=1.75U PD=1.6U
M$4506 VSS RA6 \$3192 VSS nfet_03v3 L=0.28U W=0.36U AS=0.1854P AD=0.1584P
+ PS=1.75U PD=1.6U
M$4507 \$3297 WE6 VSS VSS nfet_03v3 L=0.28U W=0.72U AS=0.3168P AD=0.1872P
+ PS=2.32U PD=1.24U
M$4508 \$3093 CLK \$3297 VSS nfet_03v3 L=0.28U W=0.72U AS=0.1872P AD=0.3168P
+ PS=1.24U PD=2.32U
M$4509 \$3094 \$3093 VSS VSS nfet_03v3 L=0.28U W=1.27U AS=0.4487P AD=0.3302P
+ PS=3.34U PD=2.31U
M$4511 \$3095 \$3094 VSS VSS nfet_03v3 L=0.28U W=1.34U AS=0.3636P AD=0.4891P
+ PS=2.44U PD=3.47U
M$4513 \$3096 \$106 VSS VSS nfet_03v3 L=0.28U W=0.36U AS=0.1584P AD=0.1188P
+ PS=1.6U PD=1.02U
M$4514 \$3097 \$3094 \$3096 VSS nfet_03v3 L=0.28U W=0.36U AS=0.1188P AD=0.1278P
+ PS=1.02U PD=1.07U
M$4515 \$3302 \$3098 \$3097 VSS nfet_03v3 L=0.28U W=0.36U AS=0.1278P AD=0.0567P
+ PS=1.07U PD=0.675U
M$4516 VSS \$3095 \$3302 VSS nfet_03v3 L=0.28U W=0.36U AS=0.0567P AD=0.1584P
+ PS=0.675U PD=1.6U
M$4517 VSS \$3097 \$3098 VSS nfet_03v3 L=0.28U W=0.36U AS=0.1584P AD=0.0972P
+ PS=1.6U PD=0.9U
M$4518 \$3099 \$3097 VSS VSS nfet_03v3 L=0.28U W=0.36U AS=0.0972P AD=0.18P
+ PS=0.9U PD=1.72U
M$4519 \$3103 \$109 VSS VSS nfet_03v3 L=0.28U W=0.36U AS=0.1584P AD=0.1188P
+ PS=1.6U PD=1.02U
M$4520 \$3104 \$3094 \$3103 VSS nfet_03v3 L=0.28U W=0.36U AS=0.1188P AD=0.1278P
+ PS=1.02U PD=1.07U
M$4521 \$3309 \$3105 \$3104 VSS nfet_03v3 L=0.28U W=0.36U AS=0.1278P AD=0.0567P
+ PS=1.07U PD=0.675U
M$4522 VSS \$3095 \$3309 VSS nfet_03v3 L=0.28U W=0.36U AS=0.0567P AD=0.1584P
+ PS=0.675U PD=1.6U
M$4523 VSS \$3104 \$3105 VSS nfet_03v3 L=0.28U W=0.36U AS=0.1584P AD=0.0972P
+ PS=1.6U PD=0.9U
M$4524 \$3106 \$3104 VSS VSS nfet_03v3 L=0.28U W=0.36U AS=0.0972P AD=0.18P
+ PS=0.9U PD=1.72U
M$4525 \$3109 \$112 VSS VSS nfet_03v3 L=0.28U W=0.36U AS=0.1584P AD=0.1188P
+ PS=1.6U PD=1.02U
M$4526 \$3110 \$3094 \$3109 VSS nfet_03v3 L=0.28U W=0.36U AS=0.1188P AD=0.1278P
+ PS=1.02U PD=1.07U
M$4527 \$3316 \$3111 \$3110 VSS nfet_03v3 L=0.28U W=0.36U AS=0.1278P AD=0.0567P
+ PS=1.07U PD=0.675U
M$4528 VSS \$3095 \$3316 VSS nfet_03v3 L=0.28U W=0.36U AS=0.0567P AD=0.1584P
+ PS=0.675U PD=1.6U
M$4529 VSS \$3110 \$3111 VSS nfet_03v3 L=0.28U W=0.36U AS=0.1584P AD=0.0972P
+ PS=1.6U PD=0.9U
M$4530 \$3112 \$3110 VSS VSS nfet_03v3 L=0.28U W=0.36U AS=0.0972P AD=0.18P
+ PS=0.9U PD=1.72U
M$4531 \$3115 \$115 VSS VSS nfet_03v3 L=0.28U W=0.36U AS=0.1584P AD=0.1188P
+ PS=1.6U PD=1.02U
M$4532 \$3116 \$3094 \$3115 VSS nfet_03v3 L=0.28U W=0.36U AS=0.1188P AD=0.1278P
+ PS=1.02U PD=1.07U
M$4533 \$3324 \$3117 \$3116 VSS nfet_03v3 L=0.28U W=0.36U AS=0.1278P AD=0.0567P
+ PS=1.07U PD=0.675U
M$4534 VSS \$3095 \$3324 VSS nfet_03v3 L=0.28U W=0.36U AS=0.0567P AD=0.1584P
+ PS=0.675U PD=1.6U
M$4535 VSS \$3116 \$3117 VSS nfet_03v3 L=0.28U W=0.36U AS=0.1584P AD=0.0972P
+ PS=1.6U PD=0.9U
M$4536 \$3118 \$3116 VSS VSS nfet_03v3 L=0.28U W=0.36U AS=0.0972P AD=0.18P
+ PS=0.9U PD=1.72U
M$4537 \$3121 \$118 VSS VSS nfet_03v3 L=0.28U W=0.36U AS=0.1584P AD=0.1188P
+ PS=1.6U PD=1.02U
M$4538 \$3122 \$3094 \$3121 VSS nfet_03v3 L=0.28U W=0.36U AS=0.1188P AD=0.1278P
+ PS=1.02U PD=1.07U
M$4539 \$3330 \$3123 \$3122 VSS nfet_03v3 L=0.28U W=0.36U AS=0.1278P AD=0.0567P
+ PS=1.07U PD=0.675U
M$4540 VSS \$3095 \$3330 VSS nfet_03v3 L=0.28U W=0.36U AS=0.0567P AD=0.1584P
+ PS=0.675U PD=1.6U
M$4541 VSS \$3122 \$3123 VSS nfet_03v3 L=0.28U W=0.36U AS=0.1584P AD=0.0972P
+ PS=1.6U PD=0.9U
M$4542 \$3124 \$3122 VSS VSS nfet_03v3 L=0.28U W=0.36U AS=0.0972P AD=0.18P
+ PS=0.9U PD=1.72U
M$4543 \$3127 \$121 VSS VSS nfet_03v3 L=0.28U W=0.36U AS=0.1584P AD=0.1188P
+ PS=1.6U PD=1.02U
M$4544 \$3128 \$3094 \$3127 VSS nfet_03v3 L=0.28U W=0.36U AS=0.1188P AD=0.1278P
+ PS=1.02U PD=1.07U
M$4545 \$3338 \$3129 \$3128 VSS nfet_03v3 L=0.28U W=0.36U AS=0.1278P AD=0.0567P
+ PS=1.07U PD=0.675U
M$4546 VSS \$3095 \$3338 VSS nfet_03v3 L=0.28U W=0.36U AS=0.0567P AD=0.1584P
+ PS=0.675U PD=1.6U
M$4547 VSS \$3128 \$3129 VSS nfet_03v3 L=0.28U W=0.36U AS=0.1584P AD=0.0972P
+ PS=1.6U PD=0.9U
M$4548 \$3130 \$3128 VSS VSS nfet_03v3 L=0.28U W=0.36U AS=0.0972P AD=0.18P
+ PS=0.9U PD=1.72U
M$4549 \$3133 \$124 VSS VSS nfet_03v3 L=0.28U W=0.36U AS=0.1584P AD=0.1188P
+ PS=1.6U PD=1.02U
M$4550 \$3134 \$3094 \$3133 VSS nfet_03v3 L=0.28U W=0.36U AS=0.1188P AD=0.1278P
+ PS=1.02U PD=1.07U
M$4551 \$3345 \$3135 \$3134 VSS nfet_03v3 L=0.28U W=0.36U AS=0.1278P AD=0.0567P
+ PS=1.07U PD=0.675U
M$4552 VSS \$3095 \$3345 VSS nfet_03v3 L=0.28U W=0.36U AS=0.0567P AD=0.1584P
+ PS=0.675U PD=1.6U
M$4553 VSS \$3134 \$3135 VSS nfet_03v3 L=0.28U W=0.36U AS=0.1584P AD=0.0972P
+ PS=1.6U PD=0.9U
M$4554 \$3136 \$3134 VSS VSS nfet_03v3 L=0.28U W=0.36U AS=0.0972P AD=0.18P
+ PS=0.9U PD=1.72U
M$4555 \$3139 \$127 VSS VSS nfet_03v3 L=0.28U W=0.36U AS=0.1584P AD=0.1188P
+ PS=1.6U PD=1.02U
M$4556 \$3140 \$3094 \$3139 VSS nfet_03v3 L=0.28U W=0.36U AS=0.1188P AD=0.1278P
+ PS=1.02U PD=1.07U
M$4557 \$3352 \$3141 \$3140 VSS nfet_03v3 L=0.28U W=0.36U AS=0.1278P AD=0.0567P
+ PS=1.07U PD=0.675U
M$4558 VSS \$3095 \$3352 VSS nfet_03v3 L=0.28U W=0.36U AS=0.0567P AD=0.1584P
+ PS=0.675U PD=1.6U
M$4559 VSS \$3140 \$3141 VSS nfet_03v3 L=0.28U W=0.36U AS=0.1584P AD=0.0972P
+ PS=1.6U PD=0.9U
M$4560 \$3142 \$3140 VSS VSS nfet_03v3 L=0.28U W=0.36U AS=0.0972P AD=0.18P
+ PS=0.9U PD=1.72U
M$4561 \$3145 \$130 VSS VSS nfet_03v3 L=0.28U W=0.36U AS=0.1584P AD=0.1188P
+ PS=1.6U PD=1.02U
M$4562 \$3146 \$3094 \$3145 VSS nfet_03v3 L=0.28U W=0.36U AS=0.1188P AD=0.1278P
+ PS=1.02U PD=1.07U
M$4563 \$3360 \$3147 \$3146 VSS nfet_03v3 L=0.28U W=0.36U AS=0.1278P AD=0.0567P
+ PS=1.07U PD=0.675U
M$4564 VSS \$3095 \$3360 VSS nfet_03v3 L=0.28U W=0.36U AS=0.0567P AD=0.1584P
+ PS=0.675U PD=1.6U
M$4565 VSS \$3146 \$3147 VSS nfet_03v3 L=0.28U W=0.36U AS=0.1584P AD=0.0972P
+ PS=1.6U PD=0.9U
M$4566 \$3148 \$3146 VSS VSS nfet_03v3 L=0.28U W=0.36U AS=0.0972P AD=0.18P
+ PS=0.9U PD=1.72U
M$4567 \$3151 \$133 VSS VSS nfet_03v3 L=0.28U W=0.36U AS=0.1584P AD=0.1188P
+ PS=1.6U PD=1.02U
M$4568 \$3152 \$3094 \$3151 VSS nfet_03v3 L=0.28U W=0.36U AS=0.1188P AD=0.1278P
+ PS=1.02U PD=1.07U
M$4569 \$3366 \$3153 \$3152 VSS nfet_03v3 L=0.28U W=0.36U AS=0.1278P AD=0.0567P
+ PS=1.07U PD=0.675U
M$4570 VSS \$3095 \$3366 VSS nfet_03v3 L=0.28U W=0.36U AS=0.0567P AD=0.1584P
+ PS=0.675U PD=1.6U
M$4571 VSS \$3152 \$3153 VSS nfet_03v3 L=0.28U W=0.36U AS=0.1584P AD=0.0972P
+ PS=1.6U PD=0.9U
M$4572 \$3154 \$3152 VSS VSS nfet_03v3 L=0.28U W=0.36U AS=0.0972P AD=0.18P
+ PS=0.9U PD=1.72U
M$4573 \$3157 \$136 VSS VSS nfet_03v3 L=0.28U W=0.36U AS=0.1584P AD=0.1188P
+ PS=1.6U PD=1.02U
M$4574 \$3158 \$3094 \$3157 VSS nfet_03v3 L=0.28U W=0.36U AS=0.1188P AD=0.1278P
+ PS=1.02U PD=1.07U
M$4575 \$3374 \$3159 \$3158 VSS nfet_03v3 L=0.28U W=0.36U AS=0.1278P AD=0.0567P
+ PS=1.07U PD=0.675U
M$4576 VSS \$3095 \$3374 VSS nfet_03v3 L=0.28U W=0.36U AS=0.0567P AD=0.1584P
+ PS=0.675U PD=1.6U
M$4577 VSS \$3158 \$3159 VSS nfet_03v3 L=0.28U W=0.36U AS=0.1584P AD=0.0972P
+ PS=1.6U PD=0.9U
M$4578 \$3160 \$3158 VSS VSS nfet_03v3 L=0.28U W=0.36U AS=0.0972P AD=0.18P
+ PS=0.9U PD=1.72U
M$4579 \$3163 \$139 VSS VSS nfet_03v3 L=0.28U W=0.36U AS=0.1584P AD=0.1188P
+ PS=1.6U PD=1.02U
M$4580 \$3164 \$3094 \$3163 VSS nfet_03v3 L=0.28U W=0.36U AS=0.1188P AD=0.1278P
+ PS=1.02U PD=1.07U
M$4581 \$3381 \$3165 \$3164 VSS nfet_03v3 L=0.28U W=0.36U AS=0.1278P AD=0.0567P
+ PS=1.07U PD=0.675U
M$4582 VSS \$3095 \$3381 VSS nfet_03v3 L=0.28U W=0.36U AS=0.0567P AD=0.1584P
+ PS=0.675U PD=1.6U
M$4583 VSS \$3164 \$3165 VSS nfet_03v3 L=0.28U W=0.36U AS=0.1584P AD=0.0972P
+ PS=1.6U PD=0.9U
M$4584 \$3166 \$3164 VSS VSS nfet_03v3 L=0.28U W=0.36U AS=0.0972P AD=0.18P
+ PS=0.9U PD=1.72U
M$4585 \$3169 \$142 VSS VSS nfet_03v3 L=0.28U W=0.36U AS=0.1584P AD=0.1188P
+ PS=1.6U PD=1.02U
M$4586 \$3170 \$3094 \$3169 VSS nfet_03v3 L=0.28U W=0.36U AS=0.1188P AD=0.1278P
+ PS=1.02U PD=1.07U
M$4587 \$3388 \$3171 \$3170 VSS nfet_03v3 L=0.28U W=0.36U AS=0.1278P AD=0.0567P
+ PS=1.07U PD=0.675U
M$4588 VSS \$3095 \$3388 VSS nfet_03v3 L=0.28U W=0.36U AS=0.0567P AD=0.1584P
+ PS=0.675U PD=1.6U
M$4589 VSS \$3170 \$3171 VSS nfet_03v3 L=0.28U W=0.36U AS=0.1584P AD=0.0972P
+ PS=1.6U PD=0.9U
M$4590 \$3172 \$3170 VSS VSS nfet_03v3 L=0.28U W=0.36U AS=0.0972P AD=0.18P
+ PS=0.9U PD=1.72U
M$4591 \$3175 \$145 VSS VSS nfet_03v3 L=0.28U W=0.36U AS=0.1584P AD=0.1188P
+ PS=1.6U PD=1.02U
M$4592 \$3176 \$3094 \$3175 VSS nfet_03v3 L=0.28U W=0.36U AS=0.1188P AD=0.1278P
+ PS=1.02U PD=1.07U
M$4593 \$3391 \$3177 \$3176 VSS nfet_03v3 L=0.28U W=0.36U AS=0.1278P AD=0.0567P
+ PS=1.07U PD=0.675U
M$4594 VSS \$3095 \$3391 VSS nfet_03v3 L=0.28U W=0.36U AS=0.0567P AD=0.1584P
+ PS=0.675U PD=1.6U
M$4595 VSS \$3176 \$3177 VSS nfet_03v3 L=0.28U W=0.36U AS=0.1584P AD=0.0972P
+ PS=1.6U PD=0.9U
M$4596 \$3178 \$3176 VSS VSS nfet_03v3 L=0.28U W=0.36U AS=0.0972P AD=0.18P
+ PS=0.9U PD=1.72U
M$4597 \$3181 \$148 VSS VSS nfet_03v3 L=0.28U W=0.36U AS=0.1584P AD=0.1188P
+ PS=1.6U PD=1.02U
M$4598 \$3182 \$3094 \$3181 VSS nfet_03v3 L=0.28U W=0.36U AS=0.1188P AD=0.1278P
+ PS=1.02U PD=1.07U
M$4599 \$3357 \$3183 \$3182 VSS nfet_03v3 L=0.28U W=0.36U AS=0.1278P AD=0.0567P
+ PS=1.07U PD=0.675U
M$4600 VSS \$3095 \$3357 VSS nfet_03v3 L=0.28U W=0.36U AS=0.0567P AD=0.1584P
+ PS=0.675U PD=1.6U
M$4601 VSS \$3182 \$3183 VSS nfet_03v3 L=0.28U W=0.36U AS=0.1584P AD=0.0972P
+ PS=1.6U PD=0.9U
M$4602 \$3184 \$3182 VSS VSS nfet_03v3 L=0.28U W=0.36U AS=0.0972P AD=0.18P
+ PS=0.9U PD=1.72U
M$4603 \$3187 \$151 VSS VSS nfet_03v3 L=0.28U W=0.36U AS=0.1584P AD=0.1188P
+ PS=1.6U PD=1.02U
M$4604 \$3188 \$3094 \$3187 VSS nfet_03v3 L=0.28U W=0.36U AS=0.1188P AD=0.1278P
+ PS=1.02U PD=1.07U
M$4605 \$3323 \$3189 \$3188 VSS nfet_03v3 L=0.28U W=0.36U AS=0.1278P AD=0.0567P
+ PS=1.07U PD=0.675U
M$4606 VSS \$3095 \$3323 VSS nfet_03v3 L=0.28U W=0.36U AS=0.0567P AD=0.1584P
+ PS=0.675U PD=1.6U
M$4607 VSS \$3188 \$3189 VSS nfet_03v3 L=0.28U W=0.36U AS=0.1584P AD=0.0972P
+ PS=1.6U PD=0.9U
M$4608 \$3190 \$3188 VSS VSS nfet_03v3 L=0.28U W=0.36U AS=0.0972P AD=0.18P
+ PS=0.9U PD=1.72U
M$4609 \$3548 WE5 VSS VSS nfet_03v3 L=0.28U W=0.72U AS=0.3168P AD=0.1872P
+ PS=2.32U PD=1.24U
M$4610 \$3412 CLK \$3548 VSS nfet_03v3 L=0.28U W=0.72U AS=0.1872P AD=0.3168P
+ PS=1.24U PD=2.32U
M$4611 \$3413 \$3412 VSS VSS nfet_03v3 L=0.28U W=1.27U AS=0.4445P AD=0.3344P
+ PS=3.305U PD=2.345U
M$4613 \$3600 \$3413 VSS VSS nfet_03v3 L=0.28U W=1.34U AS=0.3636P AD=0.4891P
+ PS=2.44U PD=3.47U
M$4615 \$3414 \$106 VSS VSS nfet_03v3 L=0.28U W=0.36U AS=0.1584P AD=0.1188P
+ PS=1.6U PD=1.02U
M$4616 \$3415 \$3413 \$3414 VSS nfet_03v3 L=0.28U W=0.36U AS=0.1188P AD=0.1278P
+ PS=1.02U PD=1.07U
M$4617 \$3453 \$3498 \$3415 VSS nfet_03v3 L=0.28U W=0.36U AS=0.1278P AD=0.0567P
+ PS=1.07U PD=0.675U
M$4618 VSS \$3600 \$3453 VSS nfet_03v3 L=0.28U W=0.36U AS=0.0567P AD=0.1584P
+ PS=0.675U PD=1.6U
M$4619 VSS \$3415 \$3498 VSS nfet_03v3 L=0.28U W=0.36U AS=0.1584P AD=0.0972P
+ PS=1.6U PD=0.9U
M$4620 \$3396 \$3415 VSS VSS nfet_03v3 L=0.28U W=0.36U AS=0.0972P AD=0.18P
+ PS=0.9U PD=1.72U
M$4621 \$3416 \$109 VSS VSS nfet_03v3 L=0.28U W=0.36U AS=0.1584P AD=0.1188P
+ PS=1.6U PD=1.02U
M$4622 \$3417 \$3413 \$3416 VSS nfet_03v3 L=0.28U W=0.36U AS=0.1188P AD=0.1278P
+ PS=1.02U PD=1.07U
M$4623 \$3462 \$3502 \$3417 VSS nfet_03v3 L=0.28U W=0.36U AS=0.1278P AD=0.0567P
+ PS=1.07U PD=0.675U
M$4624 VSS \$3600 \$3462 VSS nfet_03v3 L=0.28U W=0.36U AS=0.0567P AD=0.1584P
+ PS=0.675U PD=1.6U
M$4625 VSS \$3417 \$3502 VSS nfet_03v3 L=0.28U W=0.36U AS=0.1584P AD=0.0972P
+ PS=1.6U PD=0.9U
M$4626 \$3397 \$3417 VSS VSS nfet_03v3 L=0.28U W=0.36U AS=0.0972P AD=0.18P
+ PS=0.9U PD=1.72U
M$4627 \$3418 \$112 VSS VSS nfet_03v3 L=0.28U W=0.36U AS=0.1584P AD=0.1188P
+ PS=1.6U PD=1.02U
M$4628 \$3419 \$3413 \$3418 VSS nfet_03v3 L=0.28U W=0.36U AS=0.1188P AD=0.1278P
+ PS=1.02U PD=1.07U
M$4629 \$3471 \$3505 \$3419 VSS nfet_03v3 L=0.28U W=0.36U AS=0.1278P AD=0.0567P
+ PS=1.07U PD=0.675U
M$4630 VSS \$3600 \$3471 VSS nfet_03v3 L=0.28U W=0.36U AS=0.0567P AD=0.1584P
+ PS=0.675U PD=1.6U
M$4631 VSS \$3419 \$3505 VSS nfet_03v3 L=0.28U W=0.36U AS=0.1584P AD=0.0972P
+ PS=1.6U PD=0.9U
M$4632 \$3398 \$3419 VSS VSS nfet_03v3 L=0.28U W=0.36U AS=0.0972P AD=0.18P
+ PS=0.9U PD=1.72U
M$4633 \$3420 \$115 VSS VSS nfet_03v3 L=0.28U W=0.36U AS=0.1584P AD=0.1188P
+ PS=1.6U PD=1.02U
M$4634 \$3421 \$3413 \$3420 VSS nfet_03v3 L=0.28U W=0.36U AS=0.1188P AD=0.1278P
+ PS=1.02U PD=1.07U
M$4635 \$3480 \$3508 \$3421 VSS nfet_03v3 L=0.28U W=0.36U AS=0.1278P AD=0.0567P
+ PS=1.07U PD=0.675U
M$4636 VSS \$3600 \$3480 VSS nfet_03v3 L=0.28U W=0.36U AS=0.0567P AD=0.1584P
+ PS=0.675U PD=1.6U
M$4637 VSS \$3421 \$3508 VSS nfet_03v3 L=0.28U W=0.36U AS=0.1584P AD=0.0972P
+ PS=1.6U PD=0.9U
M$4638 \$3399 \$3421 VSS VSS nfet_03v3 L=0.28U W=0.36U AS=0.0972P AD=0.18P
+ PS=0.9U PD=1.72U
M$4639 \$3422 \$118 VSS VSS nfet_03v3 L=0.28U W=0.36U AS=0.1584P AD=0.1188P
+ PS=1.6U PD=1.02U
M$4640 \$3423 \$3413 \$3422 VSS nfet_03v3 L=0.28U W=0.36U AS=0.1188P AD=0.1278P
+ PS=1.02U PD=1.07U
M$4641 \$3489 \$3511 \$3423 VSS nfet_03v3 L=0.28U W=0.36U AS=0.1278P AD=0.0567P
+ PS=1.07U PD=0.675U
M$4642 VSS \$3600 \$3489 VSS nfet_03v3 L=0.28U W=0.36U AS=0.0567P AD=0.1584P
+ PS=0.675U PD=1.6U
M$4643 VSS \$3423 \$3511 VSS nfet_03v3 L=0.28U W=0.36U AS=0.1584P AD=0.0972P
+ PS=1.6U PD=0.9U
M$4644 \$3400 \$3423 VSS VSS nfet_03v3 L=0.28U W=0.36U AS=0.0972P AD=0.18P
+ PS=0.9U PD=1.72U
M$4645 \$3424 \$121 VSS VSS nfet_03v3 L=0.28U W=0.36U AS=0.1584P AD=0.1188P
+ PS=1.6U PD=1.02U
M$4646 \$3425 \$3413 \$3424 VSS nfet_03v3 L=0.28U W=0.36U AS=0.1188P AD=0.1278P
+ PS=1.02U PD=1.07U
M$4647 \$3492 \$3514 \$3425 VSS nfet_03v3 L=0.28U W=0.36U AS=0.1278P AD=0.0567P
+ PS=1.07U PD=0.675U
M$4648 VSS \$3600 \$3492 VSS nfet_03v3 L=0.28U W=0.36U AS=0.0567P AD=0.1584P
+ PS=0.675U PD=1.6U
M$4649 VSS \$3425 \$3514 VSS nfet_03v3 L=0.28U W=0.36U AS=0.1584P AD=0.0972P
+ PS=1.6U PD=0.9U
M$4650 \$3401 \$3425 VSS VSS nfet_03v3 L=0.28U W=0.36U AS=0.0972P AD=0.18P
+ PS=0.9U PD=1.72U
M$4651 \$3426 \$124 VSS VSS nfet_03v3 L=0.28U W=0.36U AS=0.1584P AD=0.1188P
+ PS=1.6U PD=1.02U
M$4652 \$3427 \$3413 \$3426 VSS nfet_03v3 L=0.28U W=0.36U AS=0.1188P AD=0.1278P
+ PS=1.02U PD=1.07U
M$4653 \$3486 \$3517 \$3427 VSS nfet_03v3 L=0.28U W=0.36U AS=0.1278P AD=0.0567P
+ PS=1.07U PD=0.675U
M$4654 VSS \$3600 \$3486 VSS nfet_03v3 L=0.28U W=0.36U AS=0.0567P AD=0.1584P
+ PS=0.675U PD=1.6U
M$4655 VSS \$3427 \$3517 VSS nfet_03v3 L=0.28U W=0.36U AS=0.1584P AD=0.0972P
+ PS=1.6U PD=0.9U
M$4656 \$3402 \$3427 VSS VSS nfet_03v3 L=0.28U W=0.36U AS=0.0972P AD=0.18P
+ PS=0.9U PD=1.72U
M$4657 \$3428 \$127 VSS VSS nfet_03v3 L=0.28U W=0.36U AS=0.1584P AD=0.1188P
+ PS=1.6U PD=1.02U
M$4658 \$3429 \$3413 \$3428 VSS nfet_03v3 L=0.28U W=0.36U AS=0.1188P AD=0.1278P
+ PS=1.02U PD=1.07U
M$4659 \$3484 \$3520 \$3429 VSS nfet_03v3 L=0.28U W=0.36U AS=0.1278P AD=0.0567P
+ PS=1.07U PD=0.675U
M$4660 VSS \$3600 \$3484 VSS nfet_03v3 L=0.28U W=0.36U AS=0.0567P AD=0.1584P
+ PS=0.675U PD=1.6U
M$4661 VSS \$3429 \$3520 VSS nfet_03v3 L=0.28U W=0.36U AS=0.1584P AD=0.0972P
+ PS=1.6U PD=0.9U
M$4662 \$3403 \$3429 VSS VSS nfet_03v3 L=0.28U W=0.36U AS=0.0972P AD=0.18P
+ PS=0.9U PD=1.72U
M$4663 \$3430 \$130 VSS VSS nfet_03v3 L=0.28U W=0.36U AS=0.1584P AD=0.1188P
+ PS=1.6U PD=1.02U
M$4664 \$3431 \$3413 \$3430 VSS nfet_03v3 L=0.28U W=0.36U AS=0.1188P AD=0.1278P
+ PS=1.02U PD=1.07U
M$4665 \$3478 \$3523 \$3431 VSS nfet_03v3 L=0.28U W=0.36U AS=0.1278P AD=0.0567P
+ PS=1.07U PD=0.675U
M$4666 VSS \$3600 \$3478 VSS nfet_03v3 L=0.28U W=0.36U AS=0.0567P AD=0.1584P
+ PS=0.675U PD=1.6U
M$4667 VSS \$3431 \$3523 VSS nfet_03v3 L=0.28U W=0.36U AS=0.1584P AD=0.0972P
+ PS=1.6U PD=0.9U
M$4668 \$3404 \$3431 VSS VSS nfet_03v3 L=0.28U W=0.36U AS=0.0972P AD=0.18P
+ PS=0.9U PD=1.72U
M$4669 \$3432 \$133 VSS VSS nfet_03v3 L=0.28U W=0.36U AS=0.1584P AD=0.1188P
+ PS=1.6U PD=1.02U
M$4670 \$3433 \$3413 \$3432 VSS nfet_03v3 L=0.28U W=0.36U AS=0.1188P AD=0.1278P
+ PS=1.02U PD=1.07U
M$4671 \$3475 \$3526 \$3433 VSS nfet_03v3 L=0.28U W=0.36U AS=0.1278P AD=0.0567P
+ PS=1.07U PD=0.675U
M$4672 VSS \$3600 \$3475 VSS nfet_03v3 L=0.28U W=0.36U AS=0.0567P AD=0.1584P
+ PS=0.675U PD=1.6U
M$4673 VSS \$3433 \$3526 VSS nfet_03v3 L=0.28U W=0.36U AS=0.1584P AD=0.0972P
+ PS=1.6U PD=0.9U
M$4674 \$3405 \$3433 VSS VSS nfet_03v3 L=0.28U W=0.36U AS=0.0972P AD=0.18P
+ PS=0.9U PD=1.72U
M$4675 \$3434 \$136 VSS VSS nfet_03v3 L=0.28U W=0.36U AS=0.1584P AD=0.1188P
+ PS=1.6U PD=1.02U
M$4676 \$3435 \$3413 \$3434 VSS nfet_03v3 L=0.28U W=0.36U AS=0.1188P AD=0.1278P
+ PS=1.02U PD=1.07U
M$4677 \$3469 \$3529 \$3435 VSS nfet_03v3 L=0.28U W=0.36U AS=0.1278P AD=0.0567P
+ PS=1.07U PD=0.675U
M$4678 VSS \$3600 \$3469 VSS nfet_03v3 L=0.28U W=0.36U AS=0.0567P AD=0.1584P
+ PS=0.675U PD=1.6U
M$4679 VSS \$3435 \$3529 VSS nfet_03v3 L=0.28U W=0.36U AS=0.1584P AD=0.0972P
+ PS=1.6U PD=0.9U
M$4680 \$3406 \$3435 VSS VSS nfet_03v3 L=0.28U W=0.36U AS=0.0972P AD=0.18P
+ PS=0.9U PD=1.72U
M$4681 \$3436 \$139 VSS VSS nfet_03v3 L=0.28U W=0.36U AS=0.1584P AD=0.1188P
+ PS=1.6U PD=1.02U
M$4682 \$3437 \$3413 \$3436 VSS nfet_03v3 L=0.28U W=0.36U AS=0.1188P AD=0.1278P
+ PS=1.02U PD=1.07U
M$4683 \$3466 \$3532 \$3437 VSS nfet_03v3 L=0.28U W=0.36U AS=0.1278P AD=0.0567P
+ PS=1.07U PD=0.675U
M$4684 VSS \$3600 \$3466 VSS nfet_03v3 L=0.28U W=0.36U AS=0.0567P AD=0.1584P
+ PS=0.675U PD=1.6U
M$4685 VSS \$3437 \$3532 VSS nfet_03v3 L=0.28U W=0.36U AS=0.1584P AD=0.0972P
+ PS=1.6U PD=0.9U
M$4686 \$3407 \$3437 VSS VSS nfet_03v3 L=0.28U W=0.36U AS=0.0972P AD=0.18P
+ PS=0.9U PD=1.72U
M$4687 \$3438 \$142 VSS VSS nfet_03v3 L=0.28U W=0.36U AS=0.1584P AD=0.1188P
+ PS=1.6U PD=1.02U
M$4688 \$3439 \$3413 \$3438 VSS nfet_03v3 L=0.28U W=0.36U AS=0.1188P AD=0.1278P
+ PS=1.02U PD=1.07U
M$4689 \$3460 \$3535 \$3439 VSS nfet_03v3 L=0.28U W=0.36U AS=0.1278P AD=0.0567P
+ PS=1.07U PD=0.675U
M$4690 VSS \$3600 \$3460 VSS nfet_03v3 L=0.28U W=0.36U AS=0.0567P AD=0.1584P
+ PS=0.675U PD=1.6U
M$4691 VSS \$3439 \$3535 VSS nfet_03v3 L=0.28U W=0.36U AS=0.1584P AD=0.0972P
+ PS=1.6U PD=0.9U
M$4692 \$3408 \$3439 VSS VSS nfet_03v3 L=0.28U W=0.36U AS=0.0972P AD=0.18P
+ PS=0.9U PD=1.72U
M$4693 \$3440 \$145 VSS VSS nfet_03v3 L=0.28U W=0.36U AS=0.1584P AD=0.1188P
+ PS=1.6U PD=1.02U
M$4694 \$3441 \$3413 \$3440 VSS nfet_03v3 L=0.28U W=0.36U AS=0.1188P AD=0.1278P
+ PS=1.02U PD=1.07U
M$4695 \$3457 \$3538 \$3441 VSS nfet_03v3 L=0.28U W=0.36U AS=0.1278P AD=0.0567P
+ PS=1.07U PD=0.675U
M$4696 VSS \$3600 \$3457 VSS nfet_03v3 L=0.28U W=0.36U AS=0.0567P AD=0.1584P
+ PS=0.675U PD=1.6U
M$4697 VSS \$3441 \$3538 VSS nfet_03v3 L=0.28U W=0.36U AS=0.1584P AD=0.0972P
+ PS=1.6U PD=0.9U
M$4698 \$3409 \$3441 VSS VSS nfet_03v3 L=0.28U W=0.36U AS=0.0972P AD=0.18P
+ PS=0.9U PD=1.72U
M$4699 \$3442 \$148 VSS VSS nfet_03v3 L=0.28U W=0.36U AS=0.1584P AD=0.1188P
+ PS=1.6U PD=1.02U
M$4700 \$3443 \$3413 \$3442 VSS nfet_03v3 L=0.28U W=0.36U AS=0.1188P AD=0.1278P
+ PS=1.02U PD=1.07U
M$4701 \$3450 \$3541 \$3443 VSS nfet_03v3 L=0.28U W=0.36U AS=0.1278P AD=0.0567P
+ PS=1.07U PD=0.675U
M$4702 VSS \$3600 \$3450 VSS nfet_03v3 L=0.28U W=0.36U AS=0.0567P AD=0.1584P
+ PS=0.675U PD=1.6U
M$4703 VSS \$3443 \$3541 VSS nfet_03v3 L=0.28U W=0.36U AS=0.1584P AD=0.0972P
+ PS=1.6U PD=0.9U
M$4704 \$3410 \$3443 VSS VSS nfet_03v3 L=0.28U W=0.36U AS=0.0972P AD=0.18P
+ PS=0.9U PD=1.72U
M$4705 \$3444 \$151 VSS VSS nfet_03v3 L=0.28U W=0.36U AS=0.1584P AD=0.1188P
+ PS=1.6U PD=1.02U
M$4706 \$3445 \$3413 \$3444 VSS nfet_03v3 L=0.28U W=0.36U AS=0.1188P AD=0.1278P
+ PS=1.02U PD=1.07U
M$4707 \$3447 \$3544 \$3445 VSS nfet_03v3 L=0.28U W=0.36U AS=0.1278P AD=0.0567P
+ PS=1.07U PD=0.675U
M$4708 VSS \$3600 \$3447 VSS nfet_03v3 L=0.28U W=0.36U AS=0.0567P AD=0.1584P
+ PS=0.675U PD=1.6U
M$4709 VSS \$3445 \$3544 VSS nfet_03v3 L=0.28U W=0.36U AS=0.1584P AD=0.0972P
+ PS=1.6U PD=0.9U
M$4710 \$3411 \$3445 VSS VSS nfet_03v3 L=0.28U W=0.36U AS=0.0972P AD=0.18P
+ PS=0.9U PD=1.72U
M$4711 \$3500 RA5 VSS VSS nfet_03v3 L=0.28U W=0.36U AS=0.1656P AD=0.1944P
+ PS=1.64U PD=1.8U
M$4712 \$3714 RB4 VSS VSS nfet_03v3 L=0.28U W=0.36U AS=0.1656P AD=0.1944P
+ PS=1.64U PD=1.8U
M$4713 \$3712 RB4 \$51 VSS nfet_03v3 L=0.28U W=0.36U AS=0.1584P AD=0.1152P
+ PS=1.6U PD=1U
M$4714 \$52 RA4 \$3712 VSS nfet_03v3 L=0.28U W=0.36U AS=0.1152P AD=0.1584P
+ PS=1U PD=1.6U
M$4715 \$3396 RA5 \$51 VSS nfet_03v3 L=0.28U W=0.36U AS=0.1584P AD=0.1152P
+ PS=1.6U PD=1U
M$4716 \$52 RB5 \$3396 VSS nfet_03v3 L=0.28U W=0.36U AS=0.1152P AD=0.1584P
+ PS=1U PD=1.6U
M$4717 VSS RA4 \$3715 VSS nfet_03v3 L=0.28U W=0.36U AS=0.1854P AD=0.1584P
+ PS=1.75U PD=1.6U
M$4718 VSS RB5 \$3501 VSS nfet_03v3 L=0.28U W=0.36U AS=0.1854P AD=0.1584P
+ PS=1.75U PD=1.6U
M$4719 \$3720 RB4 VSS VSS nfet_03v3 L=0.28U W=0.36U AS=0.1656P AD=0.1944P
+ PS=1.64U PD=1.8U
M$4720 \$3503 RA5 VSS VSS nfet_03v3 L=0.28U W=0.36U AS=0.1656P AD=0.1944P
+ PS=1.64U PD=1.8U
M$4721 \$3397 RA5 \$53 VSS nfet_03v3 L=0.28U W=0.36U AS=0.1584P AD=0.1152P
+ PS=1.6U PD=1U
M$4722 \$54 RB5 \$3397 VSS nfet_03v3 L=0.28U W=0.36U AS=0.1152P AD=0.1584P
+ PS=1U PD=1.6U
M$4723 \$3719 RB4 \$53 VSS nfet_03v3 L=0.28U W=0.36U AS=0.1584P AD=0.1152P
+ PS=1.6U PD=1U
M$4724 \$54 RA4 \$3719 VSS nfet_03v3 L=0.28U W=0.36U AS=0.1152P AD=0.1584P
+ PS=1U PD=1.6U
M$4725 VSS RB5 \$3504 VSS nfet_03v3 L=0.28U W=0.36U AS=0.1854P AD=0.1584P
+ PS=1.75U PD=1.6U
M$4726 VSS RA4 \$3721 VSS nfet_03v3 L=0.28U W=0.36U AS=0.1854P AD=0.1584P
+ PS=1.75U PD=1.6U
M$4727 \$3726 RB4 VSS VSS nfet_03v3 L=0.28U W=0.36U AS=0.1656P AD=0.1944P
+ PS=1.64U PD=1.8U
M$4728 \$3506 RA5 VSS VSS nfet_03v3 L=0.28U W=0.36U AS=0.1656P AD=0.1944P
+ PS=1.64U PD=1.8U
M$4729 \$3398 RA5 \$55 VSS nfet_03v3 L=0.28U W=0.36U AS=0.1584P AD=0.1152P
+ PS=1.6U PD=1U
M$4730 \$56 RB5 \$3398 VSS nfet_03v3 L=0.28U W=0.36U AS=0.1152P AD=0.1584P
+ PS=1U PD=1.6U
M$4731 \$3725 RB4 \$55 VSS nfet_03v3 L=0.28U W=0.36U AS=0.1584P AD=0.1152P
+ PS=1.6U PD=1U
M$4732 \$56 RA4 \$3725 VSS nfet_03v3 L=0.28U W=0.36U AS=0.1152P AD=0.1584P
+ PS=1U PD=1.6U
M$4733 VSS RB5 \$3507 VSS nfet_03v3 L=0.28U W=0.36U AS=0.1854P AD=0.1584P
+ PS=1.75U PD=1.6U
M$4734 VSS RA4 \$3727 VSS nfet_03v3 L=0.28U W=0.36U AS=0.1854P AD=0.1584P
+ PS=1.75U PD=1.6U
M$4735 \$3732 RB4 VSS VSS nfet_03v3 L=0.28U W=0.36U AS=0.1656P AD=0.1944P
+ PS=1.64U PD=1.8U
M$4736 \$3509 RA5 VSS VSS nfet_03v3 L=0.28U W=0.36U AS=0.1656P AD=0.1944P
+ PS=1.64U PD=1.8U
M$4737 \$3731 RB4 \$57 VSS nfet_03v3 L=0.28U W=0.36U AS=0.1584P AD=0.1152P
+ PS=1.6U PD=1U
M$4738 \$58 RA4 \$3731 VSS nfet_03v3 L=0.28U W=0.36U AS=0.1152P AD=0.1584P
+ PS=1U PD=1.6U
M$4739 \$3399 RA5 \$57 VSS nfet_03v3 L=0.28U W=0.36U AS=0.1584P AD=0.1152P
+ PS=1.6U PD=1U
M$4740 \$58 RB5 \$3399 VSS nfet_03v3 L=0.28U W=0.36U AS=0.1152P AD=0.1584P
+ PS=1U PD=1.6U
M$4741 VSS RA4 \$3733 VSS nfet_03v3 L=0.28U W=0.36U AS=0.1854P AD=0.1584P
+ PS=1.75U PD=1.6U
M$4742 VSS RB5 \$3510 VSS nfet_03v3 L=0.28U W=0.36U AS=0.1854P AD=0.1584P
+ PS=1.75U PD=1.6U
M$4743 \$3738 RB4 VSS VSS nfet_03v3 L=0.28U W=0.36U AS=0.1656P AD=0.1944P
+ PS=1.64U PD=1.8U
M$4744 \$3512 RA5 VSS VSS nfet_03v3 L=0.28U W=0.36U AS=0.1656P AD=0.1944P
+ PS=1.64U PD=1.8U
M$4745 \$3737 RB4 \$59 VSS nfet_03v3 L=0.28U W=0.36U AS=0.1584P AD=0.1152P
+ PS=1.6U PD=1U
M$4746 \$60 RA4 \$3737 VSS nfet_03v3 L=0.28U W=0.36U AS=0.1152P AD=0.1584P
+ PS=1U PD=1.6U
M$4747 \$3400 RA5 \$59 VSS nfet_03v3 L=0.28U W=0.36U AS=0.1584P AD=0.1152P
+ PS=1.6U PD=1U
M$4748 \$60 RB5 \$3400 VSS nfet_03v3 L=0.28U W=0.36U AS=0.1152P AD=0.1584P
+ PS=1U PD=1.6U
M$4749 VSS RB5 \$3513 VSS nfet_03v3 L=0.28U W=0.36U AS=0.1854P AD=0.1584P
+ PS=1.75U PD=1.6U
M$4750 VSS RA4 \$3739 VSS nfet_03v3 L=0.28U W=0.36U AS=0.1854P AD=0.1584P
+ PS=1.75U PD=1.6U
M$4751 \$3515 RA5 VSS VSS nfet_03v3 L=0.28U W=0.36U AS=0.1656P AD=0.1944P
+ PS=1.64U PD=1.8U
M$4752 \$3744 RB4 VSS VSS nfet_03v3 L=0.28U W=0.36U AS=0.1656P AD=0.1944P
+ PS=1.64U PD=1.8U
M$4753 \$3743 RB4 \$61 VSS nfet_03v3 L=0.28U W=0.36U AS=0.1584P AD=0.1152P
+ PS=1.6U PD=1U
M$4754 \$62 RA4 \$3743 VSS nfet_03v3 L=0.28U W=0.36U AS=0.1152P AD=0.1584P
+ PS=1U PD=1.6U
M$4755 \$3401 RA5 \$61 VSS nfet_03v3 L=0.28U W=0.36U AS=0.1584P AD=0.1152P
+ PS=1.6U PD=1U
M$4756 \$62 RB5 \$3401 VSS nfet_03v3 L=0.28U W=0.36U AS=0.1152P AD=0.1584P
+ PS=1U PD=1.6U
M$4757 VSS RB5 \$3516 VSS nfet_03v3 L=0.28U W=0.36U AS=0.1854P AD=0.1584P
+ PS=1.75U PD=1.6U
M$4758 VSS RA4 \$3745 VSS nfet_03v3 L=0.28U W=0.36U AS=0.1854P AD=0.1584P
+ PS=1.75U PD=1.6U
M$4759 \$3518 RA5 VSS VSS nfet_03v3 L=0.28U W=0.36U AS=0.1656P AD=0.1944P
+ PS=1.64U PD=1.8U
M$4760 \$3750 RB4 VSS VSS nfet_03v3 L=0.28U W=0.36U AS=0.1656P AD=0.1944P
+ PS=1.64U PD=1.8U
M$4761 \$3402 RA5 \$63 VSS nfet_03v3 L=0.28U W=0.36U AS=0.1584P AD=0.1152P
+ PS=1.6U PD=1U
M$4762 \$64 RB5 \$3402 VSS nfet_03v3 L=0.28U W=0.36U AS=0.1152P AD=0.1584P
+ PS=1U PD=1.6U
M$4763 \$3749 RB4 \$63 VSS nfet_03v3 L=0.28U W=0.36U AS=0.1584P AD=0.1152P
+ PS=1.6U PD=1U
M$4764 \$64 RA4 \$3749 VSS nfet_03v3 L=0.28U W=0.36U AS=0.1152P AD=0.1584P
+ PS=1U PD=1.6U
M$4765 VSS RB5 \$3519 VSS nfet_03v3 L=0.28U W=0.36U AS=0.1854P AD=0.1584P
+ PS=1.75U PD=1.6U
M$4766 VSS RA4 \$3751 VSS nfet_03v3 L=0.28U W=0.36U AS=0.1854P AD=0.1584P
+ PS=1.75U PD=1.6U
M$4767 \$3521 RA5 VSS VSS nfet_03v3 L=0.28U W=0.36U AS=0.1656P AD=0.1944P
+ PS=1.64U PD=1.8U
M$4768 \$3756 RB4 VSS VSS nfet_03v3 L=0.28U W=0.36U AS=0.1656P AD=0.1944P
+ PS=1.64U PD=1.8U
M$4769 \$3755 RB4 \$65 VSS nfet_03v3 L=0.28U W=0.36U AS=0.1584P AD=0.1152P
+ PS=1.6U PD=1U
M$4770 \$66 RA4 \$3755 VSS nfet_03v3 L=0.28U W=0.36U AS=0.1152P AD=0.1584P
+ PS=1U PD=1.6U
M$4771 \$3403 RA5 \$65 VSS nfet_03v3 L=0.28U W=0.36U AS=0.1584P AD=0.1152P
+ PS=1.6U PD=1U
M$4772 \$66 RB5 \$3403 VSS nfet_03v3 L=0.28U W=0.36U AS=0.1152P AD=0.1584P
+ PS=1U PD=1.6U
M$4773 VSS RB5 \$3522 VSS nfet_03v3 L=0.28U W=0.36U AS=0.1854P AD=0.1584P
+ PS=1.75U PD=1.6U
M$4774 VSS RA4 \$3757 VSS nfet_03v3 L=0.28U W=0.36U AS=0.1854P AD=0.1584P
+ PS=1.75U PD=1.6U
M$4775 \$3524 RA5 VSS VSS nfet_03v3 L=0.28U W=0.36U AS=0.1656P AD=0.1944P
+ PS=1.64U PD=1.8U
M$4776 \$3762 RB4 VSS VSS nfet_03v3 L=0.28U W=0.36U AS=0.1656P AD=0.1944P
+ PS=1.64U PD=1.8U
M$4777 \$3404 RA5 \$67 VSS nfet_03v3 L=0.28U W=0.36U AS=0.1584P AD=0.1152P
+ PS=1.6U PD=1U
M$4778 \$68 RB5 \$3404 VSS nfet_03v3 L=0.28U W=0.36U AS=0.1152P AD=0.1584P
+ PS=1U PD=1.6U
M$4779 \$3761 RB4 \$67 VSS nfet_03v3 L=0.28U W=0.36U AS=0.1584P AD=0.1152P
+ PS=1.6U PD=1U
M$4780 \$68 RA4 \$3761 VSS nfet_03v3 L=0.28U W=0.36U AS=0.1152P AD=0.1584P
+ PS=1U PD=1.6U
M$4781 VSS RB5 \$3525 VSS nfet_03v3 L=0.28U W=0.36U AS=0.1854P AD=0.1584P
+ PS=1.75U PD=1.6U
M$4782 VSS RA4 \$3763 VSS nfet_03v3 L=0.28U W=0.36U AS=0.1854P AD=0.1584P
+ PS=1.75U PD=1.6U
M$4783 \$3768 RB4 VSS VSS nfet_03v3 L=0.28U W=0.36U AS=0.1656P AD=0.1944P
+ PS=1.64U PD=1.8U
M$4784 \$3527 RA5 VSS VSS nfet_03v3 L=0.28U W=0.36U AS=0.1656P AD=0.1944P
+ PS=1.64U PD=1.8U
M$4785 \$3405 RA5 \$69 VSS nfet_03v3 L=0.28U W=0.36U AS=0.1584P AD=0.1152P
+ PS=1.6U PD=1U
M$4786 \$70 RB5 \$3405 VSS nfet_03v3 L=0.28U W=0.36U AS=0.1152P AD=0.1584P
+ PS=1U PD=1.6U
M$4787 \$3767 RB4 \$69 VSS nfet_03v3 L=0.28U W=0.36U AS=0.1584P AD=0.1152P
+ PS=1.6U PD=1U
M$4788 \$70 RA4 \$3767 VSS nfet_03v3 L=0.28U W=0.36U AS=0.1152P AD=0.1584P
+ PS=1U PD=1.6U
M$4789 VSS RB5 \$3528 VSS nfet_03v3 L=0.28U W=0.36U AS=0.1854P AD=0.1584P
+ PS=1.75U PD=1.6U
M$4790 VSS RA4 \$3769 VSS nfet_03v3 L=0.28U W=0.36U AS=0.1854P AD=0.1584P
+ PS=1.75U PD=1.6U
M$4791 \$3774 RB4 VSS VSS nfet_03v3 L=0.28U W=0.36U AS=0.1656P AD=0.1944P
+ PS=1.64U PD=1.8U
M$4792 \$3530 RA5 VSS VSS nfet_03v3 L=0.28U W=0.36U AS=0.1656P AD=0.1944P
+ PS=1.64U PD=1.8U
M$4793 \$3406 RA5 \$71 VSS nfet_03v3 L=0.28U W=0.36U AS=0.1584P AD=0.1152P
+ PS=1.6U PD=1U
M$4794 \$72 RB5 \$3406 VSS nfet_03v3 L=0.28U W=0.36U AS=0.1152P AD=0.1584P
+ PS=1U PD=1.6U
M$4795 \$3773 RB4 \$71 VSS nfet_03v3 L=0.28U W=0.36U AS=0.1584P AD=0.1152P
+ PS=1.6U PD=1U
M$4796 \$72 RA4 \$3773 VSS nfet_03v3 L=0.28U W=0.36U AS=0.1152P AD=0.1584P
+ PS=1U PD=1.6U
M$4797 VSS RB5 \$3531 VSS nfet_03v3 L=0.28U W=0.36U AS=0.1854P AD=0.1584P
+ PS=1.75U PD=1.6U
M$4798 VSS RA4 \$3775 VSS nfet_03v3 L=0.28U W=0.36U AS=0.1854P AD=0.1584P
+ PS=1.75U PD=1.6U
M$4799 \$3780 RB4 VSS VSS nfet_03v3 L=0.28U W=0.36U AS=0.1656P AD=0.1944P
+ PS=1.64U PD=1.8U
M$4800 \$3533 RA5 VSS VSS nfet_03v3 L=0.28U W=0.36U AS=0.1656P AD=0.1944P
+ PS=1.64U PD=1.8U
M$4801 \$3407 RA5 \$73 VSS nfet_03v3 L=0.28U W=0.36U AS=0.1584P AD=0.1152P
+ PS=1.6U PD=1U
M$4802 \$74 RB5 \$3407 VSS nfet_03v3 L=0.28U W=0.36U AS=0.1152P AD=0.1584P
+ PS=1U PD=1.6U
M$4803 \$3779 RB4 \$73 VSS nfet_03v3 L=0.28U W=0.36U AS=0.1584P AD=0.1152P
+ PS=1.6U PD=1U
M$4804 \$74 RA4 \$3779 VSS nfet_03v3 L=0.28U W=0.36U AS=0.1152P AD=0.1584P
+ PS=1U PD=1.6U
M$4805 VSS RA4 \$3781 VSS nfet_03v3 L=0.28U W=0.36U AS=0.1854P AD=0.1584P
+ PS=1.75U PD=1.6U
M$4806 VSS RB5 \$3534 VSS nfet_03v3 L=0.28U W=0.36U AS=0.1854P AD=0.1584P
+ PS=1.75U PD=1.6U
M$4807 \$3786 RB4 VSS VSS nfet_03v3 L=0.28U W=0.36U AS=0.1656P AD=0.1944P
+ PS=1.64U PD=1.8U
M$4808 \$3536 RA5 VSS VSS nfet_03v3 L=0.28U W=0.36U AS=0.1656P AD=0.1944P
+ PS=1.64U PD=1.8U
M$4809 \$3785 RB4 \$75 VSS nfet_03v3 L=0.28U W=0.36U AS=0.1584P AD=0.1152P
+ PS=1.6U PD=1U
M$4810 \$76 RA4 \$3785 VSS nfet_03v3 L=0.28U W=0.36U AS=0.1152P AD=0.1584P
+ PS=1U PD=1.6U
M$4811 \$3408 RA5 \$75 VSS nfet_03v3 L=0.28U W=0.36U AS=0.1584P AD=0.1152P
+ PS=1.6U PD=1U
M$4812 \$76 RB5 \$3408 VSS nfet_03v3 L=0.28U W=0.36U AS=0.1152P AD=0.1584P
+ PS=1U PD=1.6U
M$4813 VSS RA4 \$3787 VSS nfet_03v3 L=0.28U W=0.36U AS=0.1854P AD=0.1584P
+ PS=1.75U PD=1.6U
M$4814 VSS RB5 \$3537 VSS nfet_03v3 L=0.28U W=0.36U AS=0.1854P AD=0.1584P
+ PS=1.75U PD=1.6U
M$4815 \$3539 RA5 VSS VSS nfet_03v3 L=0.28U W=0.36U AS=0.1656P AD=0.1944P
+ PS=1.64U PD=1.8U
M$4816 \$3792 RB4 VSS VSS nfet_03v3 L=0.28U W=0.36U AS=0.1656P AD=0.1944P
+ PS=1.64U PD=1.8U
M$4817 \$3791 RB4 \$77 VSS nfet_03v3 L=0.28U W=0.36U AS=0.1584P AD=0.1152P
+ PS=1.6U PD=1U
M$4818 \$78 RA4 \$3791 VSS nfet_03v3 L=0.28U W=0.36U AS=0.1152P AD=0.1584P
+ PS=1U PD=1.6U
M$4819 \$3409 RA5 \$77 VSS nfet_03v3 L=0.28U W=0.36U AS=0.1584P AD=0.1152P
+ PS=1.6U PD=1U
M$4820 \$78 RB5 \$3409 VSS nfet_03v3 L=0.28U W=0.36U AS=0.1152P AD=0.1584P
+ PS=1U PD=1.6U
M$4821 VSS RA4 \$3793 VSS nfet_03v3 L=0.28U W=0.36U AS=0.1854P AD=0.1584P
+ PS=1.75U PD=1.6U
M$4822 VSS RB5 \$3540 VSS nfet_03v3 L=0.28U W=0.36U AS=0.1854P AD=0.1584P
+ PS=1.75U PD=1.6U
M$4823 \$3798 RB4 VSS VSS nfet_03v3 L=0.28U W=0.36U AS=0.1656P AD=0.1944P
+ PS=1.64U PD=1.8U
M$4824 \$3542 RA5 VSS VSS nfet_03v3 L=0.28U W=0.36U AS=0.1656P AD=0.1944P
+ PS=1.64U PD=1.8U
M$4825 \$3797 RB4 \$79 VSS nfet_03v3 L=0.28U W=0.36U AS=0.1584P AD=0.1152P
+ PS=1.6U PD=1U
M$4826 \$80 RA4 \$3797 VSS nfet_03v3 L=0.28U W=0.36U AS=0.1152P AD=0.1584P
+ PS=1U PD=1.6U
M$4827 \$3410 RA5 \$79 VSS nfet_03v3 L=0.28U W=0.36U AS=0.1584P AD=0.1152P
+ PS=1.6U PD=1U
M$4828 \$80 RB5 \$3410 VSS nfet_03v3 L=0.28U W=0.36U AS=0.1152P AD=0.1584P
+ PS=1U PD=1.6U
M$4829 VSS RB5 \$3543 VSS nfet_03v3 L=0.28U W=0.36U AS=0.1854P AD=0.1584P
+ PS=1.75U PD=1.6U
M$4830 VSS RA4 \$3799 VSS nfet_03v3 L=0.28U W=0.36U AS=0.1854P AD=0.1584P
+ PS=1.75U PD=1.6U
M$4831 \$3545 RA5 VSS VSS nfet_03v3 L=0.28U W=0.36U AS=0.1656P AD=0.1944P
+ PS=1.64U PD=1.8U
M$4832 \$3804 RB4 VSS VSS nfet_03v3 L=0.28U W=0.36U AS=0.1656P AD=0.1944P
+ PS=1.64U PD=1.8U
M$4833 \$3803 RB4 \$81 VSS nfet_03v3 L=0.28U W=0.36U AS=0.1584P AD=0.1152P
+ PS=1.6U PD=1U
M$4834 \$82 RA4 \$3803 VSS nfet_03v3 L=0.28U W=0.36U AS=0.1152P AD=0.1584P
+ PS=1U PD=1.6U
M$4835 \$3411 RA5 \$81 VSS nfet_03v3 L=0.28U W=0.36U AS=0.1584P AD=0.1152P
+ PS=1.6U PD=1U
M$4836 \$82 RB5 \$3411 VSS nfet_03v3 L=0.28U W=0.36U AS=0.1152P AD=0.1584P
+ PS=1U PD=1.6U
M$4837 VSS RA4 \$3805 VSS nfet_03v3 L=0.28U W=0.36U AS=0.1854P AD=0.1584P
+ PS=1.75U PD=1.6U
M$4838 VSS RB5 \$3546 VSS nfet_03v3 L=0.28U W=0.36U AS=0.1854P AD=0.1584P
+ PS=1.75U PD=1.6U
M$4839 \$3910 WE4 VSS VSS nfet_03v3 L=0.28U W=0.72U AS=0.3168P AD=0.1872P
+ PS=2.32U PD=1.24U
M$4840 \$3706 CLK \$3910 VSS nfet_03v3 L=0.28U W=0.72U AS=0.1872P AD=0.3168P
+ PS=1.24U PD=2.32U
M$4841 \$3707 \$3706 VSS VSS nfet_03v3 L=0.28U W=1.27U AS=0.4487P AD=0.3302P
+ PS=3.34U PD=2.31U
M$4843 \$3708 \$3707 VSS VSS nfet_03v3 L=0.28U W=1.34U AS=0.3636P AD=0.4891P
+ PS=2.44U PD=3.47U
M$4845 \$3709 \$106 VSS VSS nfet_03v3 L=0.28U W=0.36U AS=0.1584P AD=0.1188P
+ PS=1.6U PD=1.02U
M$4846 \$3710 \$3707 \$3709 VSS nfet_03v3 L=0.28U W=0.36U AS=0.1188P AD=0.1278P
+ PS=1.02U PD=1.07U
M$4847 \$3915 \$3711 \$3710 VSS nfet_03v3 L=0.28U W=0.36U AS=0.1278P AD=0.0567P
+ PS=1.07U PD=0.675U
M$4848 VSS \$3708 \$3915 VSS nfet_03v3 L=0.28U W=0.36U AS=0.0567P AD=0.1584P
+ PS=0.675U PD=1.6U
M$4849 VSS \$3710 \$3711 VSS nfet_03v3 L=0.28U W=0.36U AS=0.1584P AD=0.0972P
+ PS=1.6U PD=0.9U
M$4850 \$3712 \$3710 VSS VSS nfet_03v3 L=0.28U W=0.36U AS=0.0972P AD=0.18P
+ PS=0.9U PD=1.72U
M$4851 \$3716 \$109 VSS VSS nfet_03v3 L=0.28U W=0.36U AS=0.1584P AD=0.1188P
+ PS=1.6U PD=1.02U
M$4852 \$3717 \$3707 \$3716 VSS nfet_03v3 L=0.28U W=0.36U AS=0.1188P AD=0.1278P
+ PS=1.02U PD=1.07U
M$4853 \$3922 \$3718 \$3717 VSS nfet_03v3 L=0.28U W=0.36U AS=0.1278P AD=0.0567P
+ PS=1.07U PD=0.675U
M$4854 VSS \$3708 \$3922 VSS nfet_03v3 L=0.28U W=0.36U AS=0.0567P AD=0.1584P
+ PS=0.675U PD=1.6U
M$4855 VSS \$3717 \$3718 VSS nfet_03v3 L=0.28U W=0.36U AS=0.1584P AD=0.0972P
+ PS=1.6U PD=0.9U
M$4856 \$3719 \$3717 VSS VSS nfet_03v3 L=0.28U W=0.36U AS=0.0972P AD=0.18P
+ PS=0.9U PD=1.72U
M$4857 \$3722 \$112 VSS VSS nfet_03v3 L=0.28U W=0.36U AS=0.1584P AD=0.1188P
+ PS=1.6U PD=1.02U
M$4858 \$3723 \$3707 \$3722 VSS nfet_03v3 L=0.28U W=0.36U AS=0.1188P AD=0.1278P
+ PS=1.02U PD=1.07U
M$4859 \$3929 \$3724 \$3723 VSS nfet_03v3 L=0.28U W=0.36U AS=0.1278P AD=0.0567P
+ PS=1.07U PD=0.675U
M$4860 VSS \$3708 \$3929 VSS nfet_03v3 L=0.28U W=0.36U AS=0.0567P AD=0.1584P
+ PS=0.675U PD=1.6U
M$4861 VSS \$3723 \$3724 VSS nfet_03v3 L=0.28U W=0.36U AS=0.1584P AD=0.0972P
+ PS=1.6U PD=0.9U
M$4862 \$3725 \$3723 VSS VSS nfet_03v3 L=0.28U W=0.36U AS=0.0972P AD=0.18P
+ PS=0.9U PD=1.72U
M$4863 \$3728 \$115 VSS VSS nfet_03v3 L=0.28U W=0.36U AS=0.1584P AD=0.1188P
+ PS=1.6U PD=1.02U
M$4864 \$3729 \$3707 \$3728 VSS nfet_03v3 L=0.28U W=0.36U AS=0.1188P AD=0.1278P
+ PS=1.02U PD=1.07U
M$4865 \$3937 \$3730 \$3729 VSS nfet_03v3 L=0.28U W=0.36U AS=0.1278P AD=0.0567P
+ PS=1.07U PD=0.675U
M$4866 VSS \$3708 \$3937 VSS nfet_03v3 L=0.28U W=0.36U AS=0.0567P AD=0.1584P
+ PS=0.675U PD=1.6U
M$4867 VSS \$3729 \$3730 VSS nfet_03v3 L=0.28U W=0.36U AS=0.1584P AD=0.0972P
+ PS=1.6U PD=0.9U
M$4868 \$3731 \$3729 VSS VSS nfet_03v3 L=0.28U W=0.36U AS=0.0972P AD=0.18P
+ PS=0.9U PD=1.72U
M$4869 \$3734 \$118 VSS VSS nfet_03v3 L=0.28U W=0.36U AS=0.1584P AD=0.1188P
+ PS=1.6U PD=1.02U
M$4870 \$3735 \$3707 \$3734 VSS nfet_03v3 L=0.28U W=0.36U AS=0.1188P AD=0.1278P
+ PS=1.02U PD=1.07U
M$4871 \$3943 \$3736 \$3735 VSS nfet_03v3 L=0.28U W=0.36U AS=0.1278P AD=0.0567P
+ PS=1.07U PD=0.675U
M$4872 VSS \$3708 \$3943 VSS nfet_03v3 L=0.28U W=0.36U AS=0.0567P AD=0.1584P
+ PS=0.675U PD=1.6U
M$4873 VSS \$3735 \$3736 VSS nfet_03v3 L=0.28U W=0.36U AS=0.1584P AD=0.0972P
+ PS=1.6U PD=0.9U
M$4874 \$3737 \$3735 VSS VSS nfet_03v3 L=0.28U W=0.36U AS=0.0972P AD=0.18P
+ PS=0.9U PD=1.72U
M$4875 \$3740 \$121 VSS VSS nfet_03v3 L=0.28U W=0.36U AS=0.1584P AD=0.1188P
+ PS=1.6U PD=1.02U
M$4876 \$3741 \$3707 \$3740 VSS nfet_03v3 L=0.28U W=0.36U AS=0.1188P AD=0.1278P
+ PS=1.02U PD=1.07U
M$4877 \$3951 \$3742 \$3741 VSS nfet_03v3 L=0.28U W=0.36U AS=0.1278P AD=0.0567P
+ PS=1.07U PD=0.675U
M$4878 VSS \$3708 \$3951 VSS nfet_03v3 L=0.28U W=0.36U AS=0.0567P AD=0.1584P
+ PS=0.675U PD=1.6U
M$4879 VSS \$3741 \$3742 VSS nfet_03v3 L=0.28U W=0.36U AS=0.1584P AD=0.0972P
+ PS=1.6U PD=0.9U
M$4880 \$3743 \$3741 VSS VSS nfet_03v3 L=0.28U W=0.36U AS=0.0972P AD=0.18P
+ PS=0.9U PD=1.72U
M$4881 \$3746 \$124 VSS VSS nfet_03v3 L=0.28U W=0.36U AS=0.1584P AD=0.1188P
+ PS=1.6U PD=1.02U
M$4882 \$3747 \$3707 \$3746 VSS nfet_03v3 L=0.28U W=0.36U AS=0.1188P AD=0.1278P
+ PS=1.02U PD=1.07U
M$4883 \$3958 \$3748 \$3747 VSS nfet_03v3 L=0.28U W=0.36U AS=0.1278P AD=0.0567P
+ PS=1.07U PD=0.675U
M$4884 VSS \$3708 \$3958 VSS nfet_03v3 L=0.28U W=0.36U AS=0.0567P AD=0.1584P
+ PS=0.675U PD=1.6U
M$4885 VSS \$3747 \$3748 VSS nfet_03v3 L=0.28U W=0.36U AS=0.1584P AD=0.0972P
+ PS=1.6U PD=0.9U
M$4886 \$3749 \$3747 VSS VSS nfet_03v3 L=0.28U W=0.36U AS=0.0972P AD=0.18P
+ PS=0.9U PD=1.72U
M$4887 \$3752 \$127 VSS VSS nfet_03v3 L=0.28U W=0.36U AS=0.1584P AD=0.1188P
+ PS=1.6U PD=1.02U
M$4888 \$3753 \$3707 \$3752 VSS nfet_03v3 L=0.28U W=0.36U AS=0.1188P AD=0.1278P
+ PS=1.02U PD=1.07U
M$4889 \$3965 \$3754 \$3753 VSS nfet_03v3 L=0.28U W=0.36U AS=0.1278P AD=0.0567P
+ PS=1.07U PD=0.675U
M$4890 VSS \$3708 \$3965 VSS nfet_03v3 L=0.28U W=0.36U AS=0.0567P AD=0.1584P
+ PS=0.675U PD=1.6U
M$4891 VSS \$3753 \$3754 VSS nfet_03v3 L=0.28U W=0.36U AS=0.1584P AD=0.0972P
+ PS=1.6U PD=0.9U
M$4892 \$3755 \$3753 VSS VSS nfet_03v3 L=0.28U W=0.36U AS=0.0972P AD=0.18P
+ PS=0.9U PD=1.72U
M$4893 \$3758 \$130 VSS VSS nfet_03v3 L=0.28U W=0.36U AS=0.1584P AD=0.1188P
+ PS=1.6U PD=1.02U
M$4894 \$3759 \$3707 \$3758 VSS nfet_03v3 L=0.28U W=0.36U AS=0.1188P AD=0.1278P
+ PS=1.02U PD=1.07U
M$4895 \$3973 \$3760 \$3759 VSS nfet_03v3 L=0.28U W=0.36U AS=0.1278P AD=0.0567P
+ PS=1.07U PD=0.675U
M$4896 VSS \$3708 \$3973 VSS nfet_03v3 L=0.28U W=0.36U AS=0.0567P AD=0.1584P
+ PS=0.675U PD=1.6U
M$4897 VSS \$3759 \$3760 VSS nfet_03v3 L=0.28U W=0.36U AS=0.1584P AD=0.0972P
+ PS=1.6U PD=0.9U
M$4898 \$3761 \$3759 VSS VSS nfet_03v3 L=0.28U W=0.36U AS=0.0972P AD=0.18P
+ PS=0.9U PD=1.72U
M$4899 \$3764 \$133 VSS VSS nfet_03v3 L=0.28U W=0.36U AS=0.1584P AD=0.1188P
+ PS=1.6U PD=1.02U
M$4900 \$3765 \$3707 \$3764 VSS nfet_03v3 L=0.28U W=0.36U AS=0.1188P AD=0.1278P
+ PS=1.02U PD=1.07U
M$4901 \$3979 \$3766 \$3765 VSS nfet_03v3 L=0.28U W=0.36U AS=0.1278P AD=0.0567P
+ PS=1.07U PD=0.675U
M$4902 VSS \$3708 \$3979 VSS nfet_03v3 L=0.28U W=0.36U AS=0.0567P AD=0.1584P
+ PS=0.675U PD=1.6U
M$4903 VSS \$3765 \$3766 VSS nfet_03v3 L=0.28U W=0.36U AS=0.1584P AD=0.0972P
+ PS=1.6U PD=0.9U
M$4904 \$3767 \$3765 VSS VSS nfet_03v3 L=0.28U W=0.36U AS=0.0972P AD=0.18P
+ PS=0.9U PD=1.72U
M$4905 \$3770 \$136 VSS VSS nfet_03v3 L=0.28U W=0.36U AS=0.1584P AD=0.1188P
+ PS=1.6U PD=1.02U
M$4906 \$3771 \$3707 \$3770 VSS nfet_03v3 L=0.28U W=0.36U AS=0.1188P AD=0.1278P
+ PS=1.02U PD=1.07U
M$4907 \$3987 \$3772 \$3771 VSS nfet_03v3 L=0.28U W=0.36U AS=0.1278P AD=0.0567P
+ PS=1.07U PD=0.675U
M$4908 VSS \$3708 \$3987 VSS nfet_03v3 L=0.28U W=0.36U AS=0.0567P AD=0.1584P
+ PS=0.675U PD=1.6U
M$4909 VSS \$3771 \$3772 VSS nfet_03v3 L=0.28U W=0.36U AS=0.1584P AD=0.0972P
+ PS=1.6U PD=0.9U
M$4910 \$3773 \$3771 VSS VSS nfet_03v3 L=0.28U W=0.36U AS=0.0972P AD=0.18P
+ PS=0.9U PD=1.72U
M$4911 \$3776 \$139 VSS VSS nfet_03v3 L=0.28U W=0.36U AS=0.1584P AD=0.1188P
+ PS=1.6U PD=1.02U
M$4912 \$3777 \$3707 \$3776 VSS nfet_03v3 L=0.28U W=0.36U AS=0.1188P AD=0.1278P
+ PS=1.02U PD=1.07U
M$4913 \$3994 \$3778 \$3777 VSS nfet_03v3 L=0.28U W=0.36U AS=0.1278P AD=0.0567P
+ PS=1.07U PD=0.675U
M$4914 VSS \$3708 \$3994 VSS nfet_03v3 L=0.28U W=0.36U AS=0.0567P AD=0.1584P
+ PS=0.675U PD=1.6U
M$4915 VSS \$3777 \$3778 VSS nfet_03v3 L=0.28U W=0.36U AS=0.1584P AD=0.0972P
+ PS=1.6U PD=0.9U
M$4916 \$3779 \$3777 VSS VSS nfet_03v3 L=0.28U W=0.36U AS=0.0972P AD=0.18P
+ PS=0.9U PD=1.72U
M$4917 \$3782 \$142 VSS VSS nfet_03v3 L=0.28U W=0.36U AS=0.1584P AD=0.1188P
+ PS=1.6U PD=1.02U
M$4918 \$3783 \$3707 \$3782 VSS nfet_03v3 L=0.28U W=0.36U AS=0.1188P AD=0.1278P
+ PS=1.02U PD=1.07U
M$4919 \$4001 \$3784 \$3783 VSS nfet_03v3 L=0.28U W=0.36U AS=0.1278P AD=0.0567P
+ PS=1.07U PD=0.675U
M$4920 VSS \$3708 \$4001 VSS nfet_03v3 L=0.28U W=0.36U AS=0.0567P AD=0.1584P
+ PS=0.675U PD=1.6U
M$4921 VSS \$3783 \$3784 VSS nfet_03v3 L=0.28U W=0.36U AS=0.1584P AD=0.0972P
+ PS=1.6U PD=0.9U
M$4922 \$3785 \$3783 VSS VSS nfet_03v3 L=0.28U W=0.36U AS=0.0972P AD=0.18P
+ PS=0.9U PD=1.72U
M$4923 \$3788 \$145 VSS VSS nfet_03v3 L=0.28U W=0.36U AS=0.1584P AD=0.1188P
+ PS=1.6U PD=1.02U
M$4924 \$3789 \$3707 \$3788 VSS nfet_03v3 L=0.28U W=0.36U AS=0.1188P AD=0.1278P
+ PS=1.02U PD=1.07U
M$4925 \$4004 \$3790 \$3789 VSS nfet_03v3 L=0.28U W=0.36U AS=0.1278P AD=0.0567P
+ PS=1.07U PD=0.675U
M$4926 VSS \$3708 \$4004 VSS nfet_03v3 L=0.28U W=0.36U AS=0.0567P AD=0.1584P
+ PS=0.675U PD=1.6U
M$4927 VSS \$3789 \$3790 VSS nfet_03v3 L=0.28U W=0.36U AS=0.1584P AD=0.0972P
+ PS=1.6U PD=0.9U
M$4928 \$3791 \$3789 VSS VSS nfet_03v3 L=0.28U W=0.36U AS=0.0972P AD=0.18P
+ PS=0.9U PD=1.72U
M$4929 \$3794 \$148 VSS VSS nfet_03v3 L=0.28U W=0.36U AS=0.1584P AD=0.1188P
+ PS=1.6U PD=1.02U
M$4930 \$3795 \$3707 \$3794 VSS nfet_03v3 L=0.28U W=0.36U AS=0.1188P AD=0.1278P
+ PS=1.02U PD=1.07U
M$4931 \$3970 \$3796 \$3795 VSS nfet_03v3 L=0.28U W=0.36U AS=0.1278P AD=0.0567P
+ PS=1.07U PD=0.675U
M$4932 VSS \$3708 \$3970 VSS nfet_03v3 L=0.28U W=0.36U AS=0.0567P AD=0.1584P
+ PS=0.675U PD=1.6U
M$4933 VSS \$3795 \$3796 VSS nfet_03v3 L=0.28U W=0.36U AS=0.1584P AD=0.0972P
+ PS=1.6U PD=0.9U
M$4934 \$3797 \$3795 VSS VSS nfet_03v3 L=0.28U W=0.36U AS=0.0972P AD=0.18P
+ PS=0.9U PD=1.72U
M$4935 \$3800 \$151 VSS VSS nfet_03v3 L=0.28U W=0.36U AS=0.1584P AD=0.1188P
+ PS=1.6U PD=1.02U
M$4936 \$3801 \$3707 \$3800 VSS nfet_03v3 L=0.28U W=0.36U AS=0.1188P AD=0.1278P
+ PS=1.02U PD=1.07U
M$4937 \$3936 \$3802 \$3801 VSS nfet_03v3 L=0.28U W=0.36U AS=0.1278P AD=0.0567P
+ PS=1.07U PD=0.675U
M$4938 VSS \$3708 \$3936 VSS nfet_03v3 L=0.28U W=0.36U AS=0.0567P AD=0.1584P
+ PS=0.675U PD=1.6U
M$4939 VSS \$3801 \$3802 VSS nfet_03v3 L=0.28U W=0.36U AS=0.1584P AD=0.0972P
+ PS=1.6U PD=0.9U
M$4940 \$3803 \$3801 VSS VSS nfet_03v3 L=0.28U W=0.36U AS=0.0972P AD=0.18P
+ PS=0.9U PD=1.72U
M$4941 \$4161 WE3 VSS VSS nfet_03v3 L=0.28U W=0.72U AS=0.3168P AD=0.1872P
+ PS=2.32U PD=1.24U
M$4942 \$4025 CLK \$4161 VSS nfet_03v3 L=0.28U W=0.72U AS=0.1872P AD=0.3168P
+ PS=1.24U PD=2.32U
M$4943 \$4026 \$4025 VSS VSS nfet_03v3 L=0.28U W=1.27U AS=0.4445P AD=0.3344P
+ PS=3.305U PD=2.345U
M$4945 \$4213 \$4026 VSS VSS nfet_03v3 L=0.28U W=1.34U AS=0.3636P AD=0.4891P
+ PS=2.44U PD=3.47U
M$4947 \$4027 \$106 VSS VSS nfet_03v3 L=0.28U W=0.36U AS=0.1584P AD=0.1188P
+ PS=1.6U PD=1.02U
M$4948 \$4028 \$4026 \$4027 VSS nfet_03v3 L=0.28U W=0.36U AS=0.1188P AD=0.1278P
+ PS=1.02U PD=1.07U
M$4949 \$4066 \$4111 \$4028 VSS nfet_03v3 L=0.28U W=0.36U AS=0.1278P AD=0.0567P
+ PS=1.07U PD=0.675U
M$4950 VSS \$4213 \$4066 VSS nfet_03v3 L=0.28U W=0.36U AS=0.0567P AD=0.1584P
+ PS=0.675U PD=1.6U
M$4951 VSS \$4028 \$4111 VSS nfet_03v3 L=0.28U W=0.36U AS=0.1584P AD=0.0972P
+ PS=1.6U PD=0.9U
M$4952 \$4009 \$4028 VSS VSS nfet_03v3 L=0.28U W=0.36U AS=0.0972P AD=0.18P
+ PS=0.9U PD=1.72U
M$4953 \$4029 \$109 VSS VSS nfet_03v3 L=0.28U W=0.36U AS=0.1584P AD=0.1188P
+ PS=1.6U PD=1.02U
M$4954 \$4030 \$4026 \$4029 VSS nfet_03v3 L=0.28U W=0.36U AS=0.1188P AD=0.1278P
+ PS=1.02U PD=1.07U
M$4955 \$4075 \$4115 \$4030 VSS nfet_03v3 L=0.28U W=0.36U AS=0.1278P AD=0.0567P
+ PS=1.07U PD=0.675U
M$4956 VSS \$4213 \$4075 VSS nfet_03v3 L=0.28U W=0.36U AS=0.0567P AD=0.1584P
+ PS=0.675U PD=1.6U
M$4957 VSS \$4030 \$4115 VSS nfet_03v3 L=0.28U W=0.36U AS=0.1584P AD=0.0972P
+ PS=1.6U PD=0.9U
M$4958 \$4010 \$4030 VSS VSS nfet_03v3 L=0.28U W=0.36U AS=0.0972P AD=0.18P
+ PS=0.9U PD=1.72U
M$4959 \$4031 \$112 VSS VSS nfet_03v3 L=0.28U W=0.36U AS=0.1584P AD=0.1188P
+ PS=1.6U PD=1.02U
M$4960 \$4032 \$4026 \$4031 VSS nfet_03v3 L=0.28U W=0.36U AS=0.1188P AD=0.1278P
+ PS=1.02U PD=1.07U
M$4961 \$4084 \$4118 \$4032 VSS nfet_03v3 L=0.28U W=0.36U AS=0.1278P AD=0.0567P
+ PS=1.07U PD=0.675U
M$4962 VSS \$4213 \$4084 VSS nfet_03v3 L=0.28U W=0.36U AS=0.0567P AD=0.1584P
+ PS=0.675U PD=1.6U
M$4963 VSS \$4032 \$4118 VSS nfet_03v3 L=0.28U W=0.36U AS=0.1584P AD=0.0972P
+ PS=1.6U PD=0.9U
M$4964 \$4011 \$4032 VSS VSS nfet_03v3 L=0.28U W=0.36U AS=0.0972P AD=0.18P
+ PS=0.9U PD=1.72U
M$4965 \$4033 \$115 VSS VSS nfet_03v3 L=0.28U W=0.36U AS=0.1584P AD=0.1188P
+ PS=1.6U PD=1.02U
M$4966 \$4034 \$4026 \$4033 VSS nfet_03v3 L=0.28U W=0.36U AS=0.1188P AD=0.1278P
+ PS=1.02U PD=1.07U
M$4967 \$4093 \$4121 \$4034 VSS nfet_03v3 L=0.28U W=0.36U AS=0.1278P AD=0.0567P
+ PS=1.07U PD=0.675U
M$4968 VSS \$4213 \$4093 VSS nfet_03v3 L=0.28U W=0.36U AS=0.0567P AD=0.1584P
+ PS=0.675U PD=1.6U
M$4969 VSS \$4034 \$4121 VSS nfet_03v3 L=0.28U W=0.36U AS=0.1584P AD=0.0972P
+ PS=1.6U PD=0.9U
M$4970 \$4012 \$4034 VSS VSS nfet_03v3 L=0.28U W=0.36U AS=0.0972P AD=0.18P
+ PS=0.9U PD=1.72U
M$4971 \$4035 \$118 VSS VSS nfet_03v3 L=0.28U W=0.36U AS=0.1584P AD=0.1188P
+ PS=1.6U PD=1.02U
M$4972 \$4036 \$4026 \$4035 VSS nfet_03v3 L=0.28U W=0.36U AS=0.1188P AD=0.1278P
+ PS=1.02U PD=1.07U
M$4973 \$4102 \$4124 \$4036 VSS nfet_03v3 L=0.28U W=0.36U AS=0.1278P AD=0.0567P
+ PS=1.07U PD=0.675U
M$4974 VSS \$4213 \$4102 VSS nfet_03v3 L=0.28U W=0.36U AS=0.0567P AD=0.1584P
+ PS=0.675U PD=1.6U
M$4975 VSS \$4036 \$4124 VSS nfet_03v3 L=0.28U W=0.36U AS=0.1584P AD=0.0972P
+ PS=1.6U PD=0.9U
M$4976 \$4013 \$4036 VSS VSS nfet_03v3 L=0.28U W=0.36U AS=0.0972P AD=0.18P
+ PS=0.9U PD=1.72U
M$4977 \$4037 \$121 VSS VSS nfet_03v3 L=0.28U W=0.36U AS=0.1584P AD=0.1188P
+ PS=1.6U PD=1.02U
M$4978 \$4038 \$4026 \$4037 VSS nfet_03v3 L=0.28U W=0.36U AS=0.1188P AD=0.1278P
+ PS=1.02U PD=1.07U
M$4979 \$4105 \$4127 \$4038 VSS nfet_03v3 L=0.28U W=0.36U AS=0.1278P AD=0.0567P
+ PS=1.07U PD=0.675U
M$4980 VSS \$4213 \$4105 VSS nfet_03v3 L=0.28U W=0.36U AS=0.0567P AD=0.1584P
+ PS=0.675U PD=1.6U
M$4981 VSS \$4038 \$4127 VSS nfet_03v3 L=0.28U W=0.36U AS=0.1584P AD=0.0972P
+ PS=1.6U PD=0.9U
M$4982 \$4014 \$4038 VSS VSS nfet_03v3 L=0.28U W=0.36U AS=0.0972P AD=0.18P
+ PS=0.9U PD=1.72U
M$4983 \$4039 \$124 VSS VSS nfet_03v3 L=0.28U W=0.36U AS=0.1584P AD=0.1188P
+ PS=1.6U PD=1.02U
M$4984 \$4040 \$4026 \$4039 VSS nfet_03v3 L=0.28U W=0.36U AS=0.1188P AD=0.1278P
+ PS=1.02U PD=1.07U
M$4985 \$4099 \$4130 \$4040 VSS nfet_03v3 L=0.28U W=0.36U AS=0.1278P AD=0.0567P
+ PS=1.07U PD=0.675U
M$4986 VSS \$4213 \$4099 VSS nfet_03v3 L=0.28U W=0.36U AS=0.0567P AD=0.1584P
+ PS=0.675U PD=1.6U
M$4987 VSS \$4040 \$4130 VSS nfet_03v3 L=0.28U W=0.36U AS=0.1584P AD=0.0972P
+ PS=1.6U PD=0.9U
M$4988 \$4015 \$4040 VSS VSS nfet_03v3 L=0.28U W=0.36U AS=0.0972P AD=0.18P
+ PS=0.9U PD=1.72U
M$4989 \$4041 \$127 VSS VSS nfet_03v3 L=0.28U W=0.36U AS=0.1584P AD=0.1188P
+ PS=1.6U PD=1.02U
M$4990 \$4042 \$4026 \$4041 VSS nfet_03v3 L=0.28U W=0.36U AS=0.1188P AD=0.1278P
+ PS=1.02U PD=1.07U
M$4991 \$4097 \$4133 \$4042 VSS nfet_03v3 L=0.28U W=0.36U AS=0.1278P AD=0.0567P
+ PS=1.07U PD=0.675U
M$4992 VSS \$4213 \$4097 VSS nfet_03v3 L=0.28U W=0.36U AS=0.0567P AD=0.1584P
+ PS=0.675U PD=1.6U
M$4993 VSS \$4042 \$4133 VSS nfet_03v3 L=0.28U W=0.36U AS=0.1584P AD=0.0972P
+ PS=1.6U PD=0.9U
M$4994 \$4016 \$4042 VSS VSS nfet_03v3 L=0.28U W=0.36U AS=0.0972P AD=0.18P
+ PS=0.9U PD=1.72U
M$4995 \$4043 \$130 VSS VSS nfet_03v3 L=0.28U W=0.36U AS=0.1584P AD=0.1188P
+ PS=1.6U PD=1.02U
M$4996 \$4044 \$4026 \$4043 VSS nfet_03v3 L=0.28U W=0.36U AS=0.1188P AD=0.1278P
+ PS=1.02U PD=1.07U
M$4997 \$4091 \$4136 \$4044 VSS nfet_03v3 L=0.28U W=0.36U AS=0.1278P AD=0.0567P
+ PS=1.07U PD=0.675U
M$4998 VSS \$4213 \$4091 VSS nfet_03v3 L=0.28U W=0.36U AS=0.0567P AD=0.1584P
+ PS=0.675U PD=1.6U
M$4999 VSS \$4044 \$4136 VSS nfet_03v3 L=0.28U W=0.36U AS=0.1584P AD=0.0972P
+ PS=1.6U PD=0.9U
M$5000 \$4017 \$4044 VSS VSS nfet_03v3 L=0.28U W=0.36U AS=0.0972P AD=0.18P
+ PS=0.9U PD=1.72U
M$5001 \$4045 \$133 VSS VSS nfet_03v3 L=0.28U W=0.36U AS=0.1584P AD=0.1188P
+ PS=1.6U PD=1.02U
M$5002 \$4046 \$4026 \$4045 VSS nfet_03v3 L=0.28U W=0.36U AS=0.1188P AD=0.1278P
+ PS=1.02U PD=1.07U
M$5003 \$4088 \$4139 \$4046 VSS nfet_03v3 L=0.28U W=0.36U AS=0.1278P AD=0.0567P
+ PS=1.07U PD=0.675U
M$5004 VSS \$4213 \$4088 VSS nfet_03v3 L=0.28U W=0.36U AS=0.0567P AD=0.1584P
+ PS=0.675U PD=1.6U
M$5005 VSS \$4046 \$4139 VSS nfet_03v3 L=0.28U W=0.36U AS=0.1584P AD=0.0972P
+ PS=1.6U PD=0.9U
M$5006 \$4018 \$4046 VSS VSS nfet_03v3 L=0.28U W=0.36U AS=0.0972P AD=0.18P
+ PS=0.9U PD=1.72U
M$5007 \$4047 \$136 VSS VSS nfet_03v3 L=0.28U W=0.36U AS=0.1584P AD=0.1188P
+ PS=1.6U PD=1.02U
M$5008 \$4048 \$4026 \$4047 VSS nfet_03v3 L=0.28U W=0.36U AS=0.1188P AD=0.1278P
+ PS=1.02U PD=1.07U
M$5009 \$4082 \$4142 \$4048 VSS nfet_03v3 L=0.28U W=0.36U AS=0.1278P AD=0.0567P
+ PS=1.07U PD=0.675U
M$5010 VSS \$4213 \$4082 VSS nfet_03v3 L=0.28U W=0.36U AS=0.0567P AD=0.1584P
+ PS=0.675U PD=1.6U
M$5011 VSS \$4048 \$4142 VSS nfet_03v3 L=0.28U W=0.36U AS=0.1584P AD=0.0972P
+ PS=1.6U PD=0.9U
M$5012 \$4019 \$4048 VSS VSS nfet_03v3 L=0.28U W=0.36U AS=0.0972P AD=0.18P
+ PS=0.9U PD=1.72U
M$5013 \$4049 \$139 VSS VSS nfet_03v3 L=0.28U W=0.36U AS=0.1584P AD=0.1188P
+ PS=1.6U PD=1.02U
M$5014 \$4050 \$4026 \$4049 VSS nfet_03v3 L=0.28U W=0.36U AS=0.1188P AD=0.1278P
+ PS=1.02U PD=1.07U
M$5015 \$4079 \$4145 \$4050 VSS nfet_03v3 L=0.28U W=0.36U AS=0.1278P AD=0.0567P
+ PS=1.07U PD=0.675U
M$5016 VSS \$4213 \$4079 VSS nfet_03v3 L=0.28U W=0.36U AS=0.0567P AD=0.1584P
+ PS=0.675U PD=1.6U
M$5017 VSS \$4050 \$4145 VSS nfet_03v3 L=0.28U W=0.36U AS=0.1584P AD=0.0972P
+ PS=1.6U PD=0.9U
M$5018 \$4020 \$4050 VSS VSS nfet_03v3 L=0.28U W=0.36U AS=0.0972P AD=0.18P
+ PS=0.9U PD=1.72U
M$5019 \$4051 \$142 VSS VSS nfet_03v3 L=0.28U W=0.36U AS=0.1584P AD=0.1188P
+ PS=1.6U PD=1.02U
M$5020 \$4052 \$4026 \$4051 VSS nfet_03v3 L=0.28U W=0.36U AS=0.1188P AD=0.1278P
+ PS=1.02U PD=1.07U
M$5021 \$4073 \$4148 \$4052 VSS nfet_03v3 L=0.28U W=0.36U AS=0.1278P AD=0.0567P
+ PS=1.07U PD=0.675U
M$5022 VSS \$4213 \$4073 VSS nfet_03v3 L=0.28U W=0.36U AS=0.0567P AD=0.1584P
+ PS=0.675U PD=1.6U
M$5023 VSS \$4052 \$4148 VSS nfet_03v3 L=0.28U W=0.36U AS=0.1584P AD=0.0972P
+ PS=1.6U PD=0.9U
M$5024 \$4021 \$4052 VSS VSS nfet_03v3 L=0.28U W=0.36U AS=0.0972P AD=0.18P
+ PS=0.9U PD=1.72U
M$5025 \$4053 \$145 VSS VSS nfet_03v3 L=0.28U W=0.36U AS=0.1584P AD=0.1188P
+ PS=1.6U PD=1.02U
M$5026 \$4054 \$4026 \$4053 VSS nfet_03v3 L=0.28U W=0.36U AS=0.1188P AD=0.1278P
+ PS=1.02U PD=1.07U
M$5027 \$4070 \$4151 \$4054 VSS nfet_03v3 L=0.28U W=0.36U AS=0.1278P AD=0.0567P
+ PS=1.07U PD=0.675U
M$5028 VSS \$4213 \$4070 VSS nfet_03v3 L=0.28U W=0.36U AS=0.0567P AD=0.1584P
+ PS=0.675U PD=1.6U
M$5029 VSS \$4054 \$4151 VSS nfet_03v3 L=0.28U W=0.36U AS=0.1584P AD=0.0972P
+ PS=1.6U PD=0.9U
M$5030 \$4022 \$4054 VSS VSS nfet_03v3 L=0.28U W=0.36U AS=0.0972P AD=0.18P
+ PS=0.9U PD=1.72U
M$5031 \$4055 \$148 VSS VSS nfet_03v3 L=0.28U W=0.36U AS=0.1584P AD=0.1188P
+ PS=1.6U PD=1.02U
M$5032 \$4056 \$4026 \$4055 VSS nfet_03v3 L=0.28U W=0.36U AS=0.1188P AD=0.1278P
+ PS=1.02U PD=1.07U
M$5033 \$4063 \$4154 \$4056 VSS nfet_03v3 L=0.28U W=0.36U AS=0.1278P AD=0.0567P
+ PS=1.07U PD=0.675U
M$5034 VSS \$4213 \$4063 VSS nfet_03v3 L=0.28U W=0.36U AS=0.0567P AD=0.1584P
+ PS=0.675U PD=1.6U
M$5035 VSS \$4056 \$4154 VSS nfet_03v3 L=0.28U W=0.36U AS=0.1584P AD=0.0972P
+ PS=1.6U PD=0.9U
M$5036 \$4023 \$4056 VSS VSS nfet_03v3 L=0.28U W=0.36U AS=0.0972P AD=0.18P
+ PS=0.9U PD=1.72U
M$5037 \$4057 \$151 VSS VSS nfet_03v3 L=0.28U W=0.36U AS=0.1584P AD=0.1188P
+ PS=1.6U PD=1.02U
M$5038 \$4058 \$4026 \$4057 VSS nfet_03v3 L=0.28U W=0.36U AS=0.1188P AD=0.1278P
+ PS=1.02U PD=1.07U
M$5039 \$4060 \$4157 \$4058 VSS nfet_03v3 L=0.28U W=0.36U AS=0.1278P AD=0.0567P
+ PS=1.07U PD=0.675U
M$5040 VSS \$4213 \$4060 VSS nfet_03v3 L=0.28U W=0.36U AS=0.0567P AD=0.1584P
+ PS=0.675U PD=1.6U
M$5041 VSS \$4058 \$4157 VSS nfet_03v3 L=0.28U W=0.36U AS=0.1584P AD=0.0972P
+ PS=1.6U PD=0.9U
M$5042 \$4024 \$4058 VSS VSS nfet_03v3 L=0.28U W=0.36U AS=0.0972P AD=0.18P
+ PS=0.9U PD=1.72U
M$5043 \$4113 RA3 VSS VSS nfet_03v3 L=0.28U W=0.36U AS=0.1656P AD=0.1944P
+ PS=1.64U PD=1.8U
M$5044 \$4327 RB2 VSS VSS nfet_03v3 L=0.28U W=0.36U AS=0.1656P AD=0.1944P
+ PS=1.64U PD=1.8U
M$5045 \$4325 RB2 \$51 VSS nfet_03v3 L=0.28U W=0.36U AS=0.1584P AD=0.1152P
+ PS=1.6U PD=1U
M$5046 \$52 RA2 \$4325 VSS nfet_03v3 L=0.28U W=0.36U AS=0.1152P AD=0.1584P
+ PS=1U PD=1.6U
M$5047 \$4009 RA3 \$51 VSS nfet_03v3 L=0.28U W=0.36U AS=0.1584P AD=0.1152P
+ PS=1.6U PD=1U
M$5048 \$52 RB3 \$4009 VSS nfet_03v3 L=0.28U W=0.36U AS=0.1152P AD=0.1584P
+ PS=1U PD=1.6U
M$5049 VSS RA2 \$4328 VSS nfet_03v3 L=0.28U W=0.36U AS=0.1854P AD=0.1584P
+ PS=1.75U PD=1.6U
M$5050 VSS RB3 \$4114 VSS nfet_03v3 L=0.28U W=0.36U AS=0.1854P AD=0.1584P
+ PS=1.75U PD=1.6U
M$5051 \$4116 RA3 VSS VSS nfet_03v3 L=0.28U W=0.36U AS=0.1656P AD=0.1944P
+ PS=1.64U PD=1.8U
M$5052 \$4333 RB2 VSS VSS nfet_03v3 L=0.28U W=0.36U AS=0.1656P AD=0.1944P
+ PS=1.64U PD=1.8U
M$5053 \$4332 RB2 \$53 VSS nfet_03v3 L=0.28U W=0.36U AS=0.1584P AD=0.1152P
+ PS=1.6U PD=1U
M$5054 \$54 RA2 \$4332 VSS nfet_03v3 L=0.28U W=0.36U AS=0.1152P AD=0.1584P
+ PS=1U PD=1.6U
M$5055 \$4010 RA3 \$53 VSS nfet_03v3 L=0.28U W=0.36U AS=0.1584P AD=0.1152P
+ PS=1.6U PD=1U
M$5056 \$54 RB3 \$4010 VSS nfet_03v3 L=0.28U W=0.36U AS=0.1152P AD=0.1584P
+ PS=1U PD=1.6U
M$5057 VSS RB3 \$4117 VSS nfet_03v3 L=0.28U W=0.36U AS=0.1854P AD=0.1584P
+ PS=1.75U PD=1.6U
M$5058 VSS RA2 \$4334 VSS nfet_03v3 L=0.28U W=0.36U AS=0.1854P AD=0.1584P
+ PS=1.75U PD=1.6U
M$5059 \$4119 RA3 VSS VSS nfet_03v3 L=0.28U W=0.36U AS=0.1656P AD=0.1944P
+ PS=1.64U PD=1.8U
M$5060 \$4339 RB2 VSS VSS nfet_03v3 L=0.28U W=0.36U AS=0.1656P AD=0.1944P
+ PS=1.64U PD=1.8U
M$5061 \$4011 RA3 \$55 VSS nfet_03v3 L=0.28U W=0.36U AS=0.1584P AD=0.1152P
+ PS=1.6U PD=1U
M$5062 \$56 RB3 \$4011 VSS nfet_03v3 L=0.28U W=0.36U AS=0.1152P AD=0.1584P
+ PS=1U PD=1.6U
M$5063 \$4338 RB2 \$55 VSS nfet_03v3 L=0.28U W=0.36U AS=0.1584P AD=0.1152P
+ PS=1.6U PD=1U
M$5064 \$56 RA2 \$4338 VSS nfet_03v3 L=0.28U W=0.36U AS=0.1152P AD=0.1584P
+ PS=1U PD=1.6U
M$5065 VSS RA2 \$4340 VSS nfet_03v3 L=0.28U W=0.36U AS=0.1854P AD=0.1584P
+ PS=1.75U PD=1.6U
M$5066 VSS RB3 \$4120 VSS nfet_03v3 L=0.28U W=0.36U AS=0.1854P AD=0.1584P
+ PS=1.75U PD=1.6U
M$5067 \$4122 RA3 VSS VSS nfet_03v3 L=0.28U W=0.36U AS=0.1656P AD=0.1944P
+ PS=1.64U PD=1.8U
M$5068 \$4345 RB2 VSS VSS nfet_03v3 L=0.28U W=0.36U AS=0.1656P AD=0.1944P
+ PS=1.64U PD=1.8U
M$5069 \$4012 RA3 \$57 VSS nfet_03v3 L=0.28U W=0.36U AS=0.1584P AD=0.1152P
+ PS=1.6U PD=1U
M$5070 \$58 RB3 \$4012 VSS nfet_03v3 L=0.28U W=0.36U AS=0.1152P AD=0.1584P
+ PS=1U PD=1.6U
M$5071 \$4344 RB2 \$57 VSS nfet_03v3 L=0.28U W=0.36U AS=0.1584P AD=0.1152P
+ PS=1.6U PD=1U
M$5072 \$58 RA2 \$4344 VSS nfet_03v3 L=0.28U W=0.36U AS=0.1152P AD=0.1584P
+ PS=1U PD=1.6U
M$5073 VSS RA2 \$4346 VSS nfet_03v3 L=0.28U W=0.36U AS=0.1854P AD=0.1584P
+ PS=1.75U PD=1.6U
M$5074 VSS RB3 \$4123 VSS nfet_03v3 L=0.28U W=0.36U AS=0.1854P AD=0.1584P
+ PS=1.75U PD=1.6U
M$5075 \$4351 RB2 VSS VSS nfet_03v3 L=0.28U W=0.36U AS=0.1656P AD=0.1944P
+ PS=1.64U PD=1.8U
M$5076 \$4125 RA3 VSS VSS nfet_03v3 L=0.28U W=0.36U AS=0.1656P AD=0.1944P
+ PS=1.64U PD=1.8U
M$5077 \$4350 RB2 \$59 VSS nfet_03v3 L=0.28U W=0.36U AS=0.1584P AD=0.1152P
+ PS=1.6U PD=1U
M$5078 \$60 RA2 \$4350 VSS nfet_03v3 L=0.28U W=0.36U AS=0.1152P AD=0.1584P
+ PS=1U PD=1.6U
M$5079 \$4013 RA3 \$59 VSS nfet_03v3 L=0.28U W=0.36U AS=0.1584P AD=0.1152P
+ PS=1.6U PD=1U
M$5080 \$60 RB3 \$4013 VSS nfet_03v3 L=0.28U W=0.36U AS=0.1152P AD=0.1584P
+ PS=1U PD=1.6U
M$5081 VSS RB3 \$4126 VSS nfet_03v3 L=0.28U W=0.36U AS=0.1854P AD=0.1584P
+ PS=1.75U PD=1.6U
M$5082 VSS RA2 \$4352 VSS nfet_03v3 L=0.28U W=0.36U AS=0.1854P AD=0.1584P
+ PS=1.75U PD=1.6U
M$5083 \$4128 RA3 VSS VSS nfet_03v3 L=0.28U W=0.36U AS=0.1656P AD=0.1944P
+ PS=1.64U PD=1.8U
M$5084 \$4357 RB2 VSS VSS nfet_03v3 L=0.28U W=0.36U AS=0.1656P AD=0.1944P
+ PS=1.64U PD=1.8U
M$5085 \$4356 RB2 \$61 VSS nfet_03v3 L=0.28U W=0.36U AS=0.1584P AD=0.1152P
+ PS=1.6U PD=1U
M$5086 \$62 RA2 \$4356 VSS nfet_03v3 L=0.28U W=0.36U AS=0.1152P AD=0.1584P
+ PS=1U PD=1.6U
M$5087 \$4014 RA3 \$61 VSS nfet_03v3 L=0.28U W=0.36U AS=0.1584P AD=0.1152P
+ PS=1.6U PD=1U
M$5088 \$62 RB3 \$4014 VSS nfet_03v3 L=0.28U W=0.36U AS=0.1152P AD=0.1584P
+ PS=1U PD=1.6U
M$5089 VSS RB3 \$4129 VSS nfet_03v3 L=0.28U W=0.36U AS=0.1854P AD=0.1584P
+ PS=1.75U PD=1.6U
M$5090 VSS RA2 \$4358 VSS nfet_03v3 L=0.28U W=0.36U AS=0.1854P AD=0.1584P
+ PS=1.75U PD=1.6U
M$5091 \$4363 RB2 VSS VSS nfet_03v3 L=0.28U W=0.36U AS=0.1656P AD=0.1944P
+ PS=1.64U PD=1.8U
M$5092 \$4131 RA3 VSS VSS nfet_03v3 L=0.28U W=0.36U AS=0.1656P AD=0.1944P
+ PS=1.64U PD=1.8U
M$5093 \$4015 RA3 \$63 VSS nfet_03v3 L=0.28U W=0.36U AS=0.1584P AD=0.1152P
+ PS=1.6U PD=1U
M$5094 \$64 RB3 \$4015 VSS nfet_03v3 L=0.28U W=0.36U AS=0.1152P AD=0.1584P
+ PS=1U PD=1.6U
M$5095 \$4362 RB2 \$63 VSS nfet_03v3 L=0.28U W=0.36U AS=0.1584P AD=0.1152P
+ PS=1.6U PD=1U
M$5096 \$64 RA2 \$4362 VSS nfet_03v3 L=0.28U W=0.36U AS=0.1152P AD=0.1584P
+ PS=1U PD=1.6U
M$5097 VSS RB3 \$4132 VSS nfet_03v3 L=0.28U W=0.36U AS=0.1854P AD=0.1584P
+ PS=1.75U PD=1.6U
M$5098 VSS RA2 \$4364 VSS nfet_03v3 L=0.28U W=0.36U AS=0.1854P AD=0.1584P
+ PS=1.75U PD=1.6U
M$5099 \$4369 RB2 VSS VSS nfet_03v3 L=0.28U W=0.36U AS=0.1656P AD=0.1944P
+ PS=1.64U PD=1.8U
M$5100 \$4134 RA3 VSS VSS nfet_03v3 L=0.28U W=0.36U AS=0.1656P AD=0.1944P
+ PS=1.64U PD=1.8U
M$5101 \$4016 RA3 \$65 VSS nfet_03v3 L=0.28U W=0.36U AS=0.1584P AD=0.1152P
+ PS=1.6U PD=1U
M$5102 \$66 RB3 \$4016 VSS nfet_03v3 L=0.28U W=0.36U AS=0.1152P AD=0.1584P
+ PS=1U PD=1.6U
M$5103 \$4368 RB2 \$65 VSS nfet_03v3 L=0.28U W=0.36U AS=0.1584P AD=0.1152P
+ PS=1.6U PD=1U
M$5104 \$66 RA2 \$4368 VSS nfet_03v3 L=0.28U W=0.36U AS=0.1152P AD=0.1584P
+ PS=1U PD=1.6U
M$5105 VSS RB3 \$4135 VSS nfet_03v3 L=0.28U W=0.36U AS=0.1854P AD=0.1584P
+ PS=1.75U PD=1.6U
M$5106 VSS RA2 \$4370 VSS nfet_03v3 L=0.28U W=0.36U AS=0.1854P AD=0.1584P
+ PS=1.75U PD=1.6U
M$5107 \$4137 RA3 VSS VSS nfet_03v3 L=0.28U W=0.36U AS=0.1656P AD=0.1944P
+ PS=1.64U PD=1.8U
M$5108 \$4375 RB2 VSS VSS nfet_03v3 L=0.28U W=0.36U AS=0.1656P AD=0.1944P
+ PS=1.64U PD=1.8U
M$5109 \$4374 RB2 \$67 VSS nfet_03v3 L=0.28U W=0.36U AS=0.1584P AD=0.1152P
+ PS=1.6U PD=1U
M$5110 \$68 RA2 \$4374 VSS nfet_03v3 L=0.28U W=0.36U AS=0.1152P AD=0.1584P
+ PS=1U PD=1.6U
M$5111 \$4017 RA3 \$67 VSS nfet_03v3 L=0.28U W=0.36U AS=0.1584P AD=0.1152P
+ PS=1.6U PD=1U
M$5112 \$68 RB3 \$4017 VSS nfet_03v3 L=0.28U W=0.36U AS=0.1152P AD=0.1584P
+ PS=1U PD=1.6U
M$5113 VSS RA2 \$4376 VSS nfet_03v3 L=0.28U W=0.36U AS=0.1854P AD=0.1584P
+ PS=1.75U PD=1.6U
M$5114 VSS RB3 \$4138 VSS nfet_03v3 L=0.28U W=0.36U AS=0.1854P AD=0.1584P
+ PS=1.75U PD=1.6U
M$5115 \$4140 RA3 VSS VSS nfet_03v3 L=0.28U W=0.36U AS=0.1656P AD=0.1944P
+ PS=1.64U PD=1.8U
M$5116 \$4381 RB2 VSS VSS nfet_03v3 L=0.28U W=0.36U AS=0.1656P AD=0.1944P
+ PS=1.64U PD=1.8U
M$5117 \$4018 RA3 \$69 VSS nfet_03v3 L=0.28U W=0.36U AS=0.1584P AD=0.1152P
+ PS=1.6U PD=1U
M$5118 \$70 RB3 \$4018 VSS nfet_03v3 L=0.28U W=0.36U AS=0.1152P AD=0.1584P
+ PS=1U PD=1.6U
M$5119 \$4380 RB2 \$69 VSS nfet_03v3 L=0.28U W=0.36U AS=0.1584P AD=0.1152P
+ PS=1.6U PD=1U
M$5120 \$70 RA2 \$4380 VSS nfet_03v3 L=0.28U W=0.36U AS=0.1152P AD=0.1584P
+ PS=1U PD=1.6U
M$5121 VSS RB3 \$4141 VSS nfet_03v3 L=0.28U W=0.36U AS=0.1854P AD=0.1584P
+ PS=1.75U PD=1.6U
M$5122 VSS RA2 \$4382 VSS nfet_03v3 L=0.28U W=0.36U AS=0.1854P AD=0.1584P
+ PS=1.75U PD=1.6U
M$5123 \$4387 RB2 VSS VSS nfet_03v3 L=0.28U W=0.36U AS=0.1656P AD=0.1944P
+ PS=1.64U PD=1.8U
M$5124 \$4143 RA3 VSS VSS nfet_03v3 L=0.28U W=0.36U AS=0.1656P AD=0.1944P
+ PS=1.64U PD=1.8U
M$5125 \$4386 RB2 \$71 VSS nfet_03v3 L=0.28U W=0.36U AS=0.1584P AD=0.1152P
+ PS=1.6U PD=1U
M$5126 \$72 RA2 \$4386 VSS nfet_03v3 L=0.28U W=0.36U AS=0.1152P AD=0.1584P
+ PS=1U PD=1.6U
M$5127 \$4019 RA3 \$71 VSS nfet_03v3 L=0.28U W=0.36U AS=0.1584P AD=0.1152P
+ PS=1.6U PD=1U
M$5128 \$72 RB3 \$4019 VSS nfet_03v3 L=0.28U W=0.36U AS=0.1152P AD=0.1584P
+ PS=1U PD=1.6U
M$5129 VSS RB3 \$4144 VSS nfet_03v3 L=0.28U W=0.36U AS=0.1854P AD=0.1584P
+ PS=1.75U PD=1.6U
M$5130 VSS RA2 \$4388 VSS nfet_03v3 L=0.28U W=0.36U AS=0.1854P AD=0.1584P
+ PS=1.75U PD=1.6U
M$5131 \$4393 RB2 VSS VSS nfet_03v3 L=0.28U W=0.36U AS=0.1656P AD=0.1944P
+ PS=1.64U PD=1.8U
M$5132 \$4146 RA3 VSS VSS nfet_03v3 L=0.28U W=0.36U AS=0.1656P AD=0.1944P
+ PS=1.64U PD=1.8U
M$5133 \$4020 RA3 \$73 VSS nfet_03v3 L=0.28U W=0.36U AS=0.1584P AD=0.1152P
+ PS=1.6U PD=1U
M$5134 \$74 RB3 \$4020 VSS nfet_03v3 L=0.28U W=0.36U AS=0.1152P AD=0.1584P
+ PS=1U PD=1.6U
M$5135 \$4392 RB2 \$73 VSS nfet_03v3 L=0.28U W=0.36U AS=0.1584P AD=0.1152P
+ PS=1.6U PD=1U
M$5136 \$74 RA2 \$4392 VSS nfet_03v3 L=0.28U W=0.36U AS=0.1152P AD=0.1584P
+ PS=1U PD=1.6U
M$5137 VSS RB3 \$4147 VSS nfet_03v3 L=0.28U W=0.36U AS=0.1854P AD=0.1584P
+ PS=1.75U PD=1.6U
M$5138 VSS RA2 \$4394 VSS nfet_03v3 L=0.28U W=0.36U AS=0.1854P AD=0.1584P
+ PS=1.75U PD=1.6U
M$5139 \$4149 RA3 VSS VSS nfet_03v3 L=0.28U W=0.36U AS=0.1656P AD=0.1944P
+ PS=1.64U PD=1.8U
M$5140 \$4399 RB2 VSS VSS nfet_03v3 L=0.28U W=0.36U AS=0.1656P AD=0.1944P
+ PS=1.64U PD=1.8U
M$5141 \$4398 RB2 \$75 VSS nfet_03v3 L=0.28U W=0.36U AS=0.1584P AD=0.1152P
+ PS=1.6U PD=1U
M$5142 \$76 RA2 \$4398 VSS nfet_03v3 L=0.28U W=0.36U AS=0.1152P AD=0.1584P
+ PS=1U PD=1.6U
M$5143 \$4021 RA3 \$75 VSS nfet_03v3 L=0.28U W=0.36U AS=0.1584P AD=0.1152P
+ PS=1.6U PD=1U
M$5144 \$76 RB3 \$4021 VSS nfet_03v3 L=0.28U W=0.36U AS=0.1152P AD=0.1584P
+ PS=1U PD=1.6U
M$5145 VSS RA2 \$4400 VSS nfet_03v3 L=0.28U W=0.36U AS=0.1854P AD=0.1584P
+ PS=1.75U PD=1.6U
M$5146 VSS RB3 \$4150 VSS nfet_03v3 L=0.28U W=0.36U AS=0.1854P AD=0.1584P
+ PS=1.75U PD=1.6U
M$5147 \$4405 RB2 VSS VSS nfet_03v3 L=0.28U W=0.36U AS=0.1656P AD=0.1944P
+ PS=1.64U PD=1.8U
M$5148 \$4152 RA3 VSS VSS nfet_03v3 L=0.28U W=0.36U AS=0.1656P AD=0.1944P
+ PS=1.64U PD=1.8U
M$5149 \$4404 RB2 \$77 VSS nfet_03v3 L=0.28U W=0.36U AS=0.1584P AD=0.1152P
+ PS=1.6U PD=1U
M$5150 \$78 RA2 \$4404 VSS nfet_03v3 L=0.28U W=0.36U AS=0.1152P AD=0.1584P
+ PS=1U PD=1.6U
M$5151 \$4022 RA3 \$77 VSS nfet_03v3 L=0.28U W=0.36U AS=0.1584P AD=0.1152P
+ PS=1.6U PD=1U
M$5152 \$78 RB3 \$4022 VSS nfet_03v3 L=0.28U W=0.36U AS=0.1152P AD=0.1584P
+ PS=1U PD=1.6U
M$5153 VSS RB3 \$4153 VSS nfet_03v3 L=0.28U W=0.36U AS=0.1854P AD=0.1584P
+ PS=1.75U PD=1.6U
M$5154 VSS RA2 \$4406 VSS nfet_03v3 L=0.28U W=0.36U AS=0.1854P AD=0.1584P
+ PS=1.75U PD=1.6U
M$5155 \$4411 RB2 VSS VSS nfet_03v3 L=0.28U W=0.36U AS=0.1656P AD=0.1944P
+ PS=1.64U PD=1.8U
M$5156 \$4155 RA3 VSS VSS nfet_03v3 L=0.28U W=0.36U AS=0.1656P AD=0.1944P
+ PS=1.64U PD=1.8U
M$5157 \$4023 RA3 \$79 VSS nfet_03v3 L=0.28U W=0.36U AS=0.1584P AD=0.1152P
+ PS=1.6U PD=1U
M$5158 \$80 RB3 \$4023 VSS nfet_03v3 L=0.28U W=0.36U AS=0.1152P AD=0.1584P
+ PS=1U PD=1.6U
M$5159 \$4410 RB2 \$79 VSS nfet_03v3 L=0.28U W=0.36U AS=0.1584P AD=0.1152P
+ PS=1.6U PD=1U
M$5160 \$80 RA2 \$4410 VSS nfet_03v3 L=0.28U W=0.36U AS=0.1152P AD=0.1584P
+ PS=1U PD=1.6U
M$5161 VSS RA2 \$4412 VSS nfet_03v3 L=0.28U W=0.36U AS=0.1854P AD=0.1584P
+ PS=1.75U PD=1.6U
M$5162 VSS RB3 \$4156 VSS nfet_03v3 L=0.28U W=0.36U AS=0.1854P AD=0.1584P
+ PS=1.75U PD=1.6U
M$5163 \$4158 RA3 VSS VSS nfet_03v3 L=0.28U W=0.36U AS=0.1656P AD=0.1944P
+ PS=1.64U PD=1.8U
M$5164 \$4417 RB2 VSS VSS nfet_03v3 L=0.28U W=0.36U AS=0.1656P AD=0.1944P
+ PS=1.64U PD=1.8U
M$5165 \$4024 RA3 \$81 VSS nfet_03v3 L=0.28U W=0.36U AS=0.1584P AD=0.1152P
+ PS=1.6U PD=1U
M$5166 \$82 RB3 \$4024 VSS nfet_03v3 L=0.28U W=0.36U AS=0.1152P AD=0.1584P
+ PS=1U PD=1.6U
M$5167 \$4416 RB2 \$81 VSS nfet_03v3 L=0.28U W=0.36U AS=0.1584P AD=0.1152P
+ PS=1.6U PD=1U
M$5168 \$82 RA2 \$4416 VSS nfet_03v3 L=0.28U W=0.36U AS=0.1152P AD=0.1584P
+ PS=1U PD=1.6U
M$5169 VSS RB3 \$4159 VSS nfet_03v3 L=0.28U W=0.36U AS=0.1854P AD=0.1584P
+ PS=1.75U PD=1.6U
M$5170 VSS RA2 \$4418 VSS nfet_03v3 L=0.28U W=0.36U AS=0.1854P AD=0.1584P
+ PS=1.75U PD=1.6U
M$5171 \$4523 WE2 VSS VSS nfet_03v3 L=0.28U W=0.72U AS=0.3168P AD=0.1872P
+ PS=2.32U PD=1.24U
M$5172 \$4319 CLK \$4523 VSS nfet_03v3 L=0.28U W=0.72U AS=0.1872P AD=0.3168P
+ PS=1.24U PD=2.32U
M$5173 \$4320 \$4319 VSS VSS nfet_03v3 L=0.28U W=1.27U AS=0.4487P AD=0.3302P
+ PS=3.34U PD=2.31U
M$5175 \$4321 \$4320 VSS VSS nfet_03v3 L=0.28U W=1.34U AS=0.3636P AD=0.4891P
+ PS=2.44U PD=3.47U
M$5177 \$4322 \$106 VSS VSS nfet_03v3 L=0.28U W=0.36U AS=0.1584P AD=0.1188P
+ PS=1.6U PD=1.02U
M$5178 \$4323 \$4320 \$4322 VSS nfet_03v3 L=0.28U W=0.36U AS=0.1188P AD=0.1278P
+ PS=1.02U PD=1.07U
M$5179 \$4528 \$4324 \$4323 VSS nfet_03v3 L=0.28U W=0.36U AS=0.1278P AD=0.0567P
+ PS=1.07U PD=0.675U
M$5180 VSS \$4321 \$4528 VSS nfet_03v3 L=0.28U W=0.36U AS=0.0567P AD=0.1584P
+ PS=0.675U PD=1.6U
M$5181 VSS \$4323 \$4324 VSS nfet_03v3 L=0.28U W=0.36U AS=0.1584P AD=0.0972P
+ PS=1.6U PD=0.9U
M$5182 \$4325 \$4323 VSS VSS nfet_03v3 L=0.28U W=0.36U AS=0.0972P AD=0.18P
+ PS=0.9U PD=1.72U
M$5183 \$4329 \$109 VSS VSS nfet_03v3 L=0.28U W=0.36U AS=0.1584P AD=0.1188P
+ PS=1.6U PD=1.02U
M$5184 \$4330 \$4320 \$4329 VSS nfet_03v3 L=0.28U W=0.36U AS=0.1188P AD=0.1278P
+ PS=1.02U PD=1.07U
M$5185 \$4535 \$4331 \$4330 VSS nfet_03v3 L=0.28U W=0.36U AS=0.1278P AD=0.0567P
+ PS=1.07U PD=0.675U
M$5186 VSS \$4321 \$4535 VSS nfet_03v3 L=0.28U W=0.36U AS=0.0567P AD=0.1584P
+ PS=0.675U PD=1.6U
M$5187 VSS \$4330 \$4331 VSS nfet_03v3 L=0.28U W=0.36U AS=0.1584P AD=0.0972P
+ PS=1.6U PD=0.9U
M$5188 \$4332 \$4330 VSS VSS nfet_03v3 L=0.28U W=0.36U AS=0.0972P AD=0.18P
+ PS=0.9U PD=1.72U
M$5189 \$4335 \$112 VSS VSS nfet_03v3 L=0.28U W=0.36U AS=0.1584P AD=0.1188P
+ PS=1.6U PD=1.02U
M$5190 \$4336 \$4320 \$4335 VSS nfet_03v3 L=0.28U W=0.36U AS=0.1188P AD=0.1278P
+ PS=1.02U PD=1.07U
M$5191 \$4542 \$4337 \$4336 VSS nfet_03v3 L=0.28U W=0.36U AS=0.1278P AD=0.0567P
+ PS=1.07U PD=0.675U
M$5192 VSS \$4321 \$4542 VSS nfet_03v3 L=0.28U W=0.36U AS=0.0567P AD=0.1584P
+ PS=0.675U PD=1.6U
M$5193 VSS \$4336 \$4337 VSS nfet_03v3 L=0.28U W=0.36U AS=0.1584P AD=0.0972P
+ PS=1.6U PD=0.9U
M$5194 \$4338 \$4336 VSS VSS nfet_03v3 L=0.28U W=0.36U AS=0.0972P AD=0.18P
+ PS=0.9U PD=1.72U
M$5195 \$4341 \$115 VSS VSS nfet_03v3 L=0.28U W=0.36U AS=0.1584P AD=0.1188P
+ PS=1.6U PD=1.02U
M$5196 \$4342 \$4320 \$4341 VSS nfet_03v3 L=0.28U W=0.36U AS=0.1188P AD=0.1278P
+ PS=1.02U PD=1.07U
M$5197 \$4550 \$4343 \$4342 VSS nfet_03v3 L=0.28U W=0.36U AS=0.1278P AD=0.0567P
+ PS=1.07U PD=0.675U
M$5198 VSS \$4321 \$4550 VSS nfet_03v3 L=0.28U W=0.36U AS=0.0567P AD=0.1584P
+ PS=0.675U PD=1.6U
M$5199 VSS \$4342 \$4343 VSS nfet_03v3 L=0.28U W=0.36U AS=0.1584P AD=0.0972P
+ PS=1.6U PD=0.9U
M$5200 \$4344 \$4342 VSS VSS nfet_03v3 L=0.28U W=0.36U AS=0.0972P AD=0.18P
+ PS=0.9U PD=1.72U
M$5201 \$4347 \$118 VSS VSS nfet_03v3 L=0.28U W=0.36U AS=0.1584P AD=0.1188P
+ PS=1.6U PD=1.02U
M$5202 \$4348 \$4320 \$4347 VSS nfet_03v3 L=0.28U W=0.36U AS=0.1188P AD=0.1278P
+ PS=1.02U PD=1.07U
M$5203 \$4556 \$4349 \$4348 VSS nfet_03v3 L=0.28U W=0.36U AS=0.1278P AD=0.0567P
+ PS=1.07U PD=0.675U
M$5204 VSS \$4321 \$4556 VSS nfet_03v3 L=0.28U W=0.36U AS=0.0567P AD=0.1584P
+ PS=0.675U PD=1.6U
M$5205 VSS \$4348 \$4349 VSS nfet_03v3 L=0.28U W=0.36U AS=0.1584P AD=0.0972P
+ PS=1.6U PD=0.9U
M$5206 \$4350 \$4348 VSS VSS nfet_03v3 L=0.28U W=0.36U AS=0.0972P AD=0.18P
+ PS=0.9U PD=1.72U
M$5207 \$4353 \$121 VSS VSS nfet_03v3 L=0.28U W=0.36U AS=0.1584P AD=0.1188P
+ PS=1.6U PD=1.02U
M$5208 \$4354 \$4320 \$4353 VSS nfet_03v3 L=0.28U W=0.36U AS=0.1188P AD=0.1278P
+ PS=1.02U PD=1.07U
M$5209 \$4564 \$4355 \$4354 VSS nfet_03v3 L=0.28U W=0.36U AS=0.1278P AD=0.0567P
+ PS=1.07U PD=0.675U
M$5210 VSS \$4321 \$4564 VSS nfet_03v3 L=0.28U W=0.36U AS=0.0567P AD=0.1584P
+ PS=0.675U PD=1.6U
M$5211 VSS \$4354 \$4355 VSS nfet_03v3 L=0.28U W=0.36U AS=0.1584P AD=0.0972P
+ PS=1.6U PD=0.9U
M$5212 \$4356 \$4354 VSS VSS nfet_03v3 L=0.28U W=0.36U AS=0.0972P AD=0.18P
+ PS=0.9U PD=1.72U
M$5213 \$4359 \$124 VSS VSS nfet_03v3 L=0.28U W=0.36U AS=0.1584P AD=0.1188P
+ PS=1.6U PD=1.02U
M$5214 \$4360 \$4320 \$4359 VSS nfet_03v3 L=0.28U W=0.36U AS=0.1188P AD=0.1278P
+ PS=1.02U PD=1.07U
M$5215 \$4571 \$4361 \$4360 VSS nfet_03v3 L=0.28U W=0.36U AS=0.1278P AD=0.0567P
+ PS=1.07U PD=0.675U
M$5216 VSS \$4321 \$4571 VSS nfet_03v3 L=0.28U W=0.36U AS=0.0567P AD=0.1584P
+ PS=0.675U PD=1.6U
M$5217 VSS \$4360 \$4361 VSS nfet_03v3 L=0.28U W=0.36U AS=0.1584P AD=0.0972P
+ PS=1.6U PD=0.9U
M$5218 \$4362 \$4360 VSS VSS nfet_03v3 L=0.28U W=0.36U AS=0.0972P AD=0.18P
+ PS=0.9U PD=1.72U
M$5219 \$4365 \$127 VSS VSS nfet_03v3 L=0.28U W=0.36U AS=0.1584P AD=0.1188P
+ PS=1.6U PD=1.02U
M$5220 \$4366 \$4320 \$4365 VSS nfet_03v3 L=0.28U W=0.36U AS=0.1188P AD=0.1278P
+ PS=1.02U PD=1.07U
M$5221 \$4578 \$4367 \$4366 VSS nfet_03v3 L=0.28U W=0.36U AS=0.1278P AD=0.0567P
+ PS=1.07U PD=0.675U
M$5222 VSS \$4321 \$4578 VSS nfet_03v3 L=0.28U W=0.36U AS=0.0567P AD=0.1584P
+ PS=0.675U PD=1.6U
M$5223 VSS \$4366 \$4367 VSS nfet_03v3 L=0.28U W=0.36U AS=0.1584P AD=0.0972P
+ PS=1.6U PD=0.9U
M$5224 \$4368 \$4366 VSS VSS nfet_03v3 L=0.28U W=0.36U AS=0.0972P AD=0.18P
+ PS=0.9U PD=1.72U
M$5225 \$4371 \$130 VSS VSS nfet_03v3 L=0.28U W=0.36U AS=0.1584P AD=0.1188P
+ PS=1.6U PD=1.02U
M$5226 \$4372 \$4320 \$4371 VSS nfet_03v3 L=0.28U W=0.36U AS=0.1188P AD=0.1278P
+ PS=1.02U PD=1.07U
M$5227 \$4586 \$4373 \$4372 VSS nfet_03v3 L=0.28U W=0.36U AS=0.1278P AD=0.0567P
+ PS=1.07U PD=0.675U
M$5228 VSS \$4321 \$4586 VSS nfet_03v3 L=0.28U W=0.36U AS=0.0567P AD=0.1584P
+ PS=0.675U PD=1.6U
M$5229 VSS \$4372 \$4373 VSS nfet_03v3 L=0.28U W=0.36U AS=0.1584P AD=0.0972P
+ PS=1.6U PD=0.9U
M$5230 \$4374 \$4372 VSS VSS nfet_03v3 L=0.28U W=0.36U AS=0.0972P AD=0.18P
+ PS=0.9U PD=1.72U
M$5231 \$4377 \$133 VSS VSS nfet_03v3 L=0.28U W=0.36U AS=0.1584P AD=0.1188P
+ PS=1.6U PD=1.02U
M$5232 \$4378 \$4320 \$4377 VSS nfet_03v3 L=0.28U W=0.36U AS=0.1188P AD=0.1278P
+ PS=1.02U PD=1.07U
M$5233 \$4592 \$4379 \$4378 VSS nfet_03v3 L=0.28U W=0.36U AS=0.1278P AD=0.0567P
+ PS=1.07U PD=0.675U
M$5234 VSS \$4321 \$4592 VSS nfet_03v3 L=0.28U W=0.36U AS=0.0567P AD=0.1584P
+ PS=0.675U PD=1.6U
M$5235 VSS \$4378 \$4379 VSS nfet_03v3 L=0.28U W=0.36U AS=0.1584P AD=0.0972P
+ PS=1.6U PD=0.9U
M$5236 \$4380 \$4378 VSS VSS nfet_03v3 L=0.28U W=0.36U AS=0.0972P AD=0.18P
+ PS=0.9U PD=1.72U
M$5237 \$4383 \$136 VSS VSS nfet_03v3 L=0.28U W=0.36U AS=0.1584P AD=0.1188P
+ PS=1.6U PD=1.02U
M$5238 \$4384 \$4320 \$4383 VSS nfet_03v3 L=0.28U W=0.36U AS=0.1188P AD=0.1278P
+ PS=1.02U PD=1.07U
M$5239 \$4600 \$4385 \$4384 VSS nfet_03v3 L=0.28U W=0.36U AS=0.1278P AD=0.0567P
+ PS=1.07U PD=0.675U
M$5240 VSS \$4321 \$4600 VSS nfet_03v3 L=0.28U W=0.36U AS=0.0567P AD=0.1584P
+ PS=0.675U PD=1.6U
M$5241 VSS \$4384 \$4385 VSS nfet_03v3 L=0.28U W=0.36U AS=0.1584P AD=0.0972P
+ PS=1.6U PD=0.9U
M$5242 \$4386 \$4384 VSS VSS nfet_03v3 L=0.28U W=0.36U AS=0.0972P AD=0.18P
+ PS=0.9U PD=1.72U
M$5243 \$4389 \$139 VSS VSS nfet_03v3 L=0.28U W=0.36U AS=0.1584P AD=0.1188P
+ PS=1.6U PD=1.02U
M$5244 \$4390 \$4320 \$4389 VSS nfet_03v3 L=0.28U W=0.36U AS=0.1188P AD=0.1278P
+ PS=1.02U PD=1.07U
M$5245 \$4607 \$4391 \$4390 VSS nfet_03v3 L=0.28U W=0.36U AS=0.1278P AD=0.0567P
+ PS=1.07U PD=0.675U
M$5246 VSS \$4321 \$4607 VSS nfet_03v3 L=0.28U W=0.36U AS=0.0567P AD=0.1584P
+ PS=0.675U PD=1.6U
M$5247 VSS \$4390 \$4391 VSS nfet_03v3 L=0.28U W=0.36U AS=0.1584P AD=0.0972P
+ PS=1.6U PD=0.9U
M$5248 \$4392 \$4390 VSS VSS nfet_03v3 L=0.28U W=0.36U AS=0.0972P AD=0.18P
+ PS=0.9U PD=1.72U
M$5249 \$4395 \$142 VSS VSS nfet_03v3 L=0.28U W=0.36U AS=0.1584P AD=0.1188P
+ PS=1.6U PD=1.02U
M$5250 \$4396 \$4320 \$4395 VSS nfet_03v3 L=0.28U W=0.36U AS=0.1188P AD=0.1278P
+ PS=1.02U PD=1.07U
M$5251 \$4614 \$4397 \$4396 VSS nfet_03v3 L=0.28U W=0.36U AS=0.1278P AD=0.0567P
+ PS=1.07U PD=0.675U
M$5252 VSS \$4321 \$4614 VSS nfet_03v3 L=0.28U W=0.36U AS=0.0567P AD=0.1584P
+ PS=0.675U PD=1.6U
M$5253 VSS \$4396 \$4397 VSS nfet_03v3 L=0.28U W=0.36U AS=0.1584P AD=0.0972P
+ PS=1.6U PD=0.9U
M$5254 \$4398 \$4396 VSS VSS nfet_03v3 L=0.28U W=0.36U AS=0.0972P AD=0.18P
+ PS=0.9U PD=1.72U
M$5255 \$4401 \$145 VSS VSS nfet_03v3 L=0.28U W=0.36U AS=0.1584P AD=0.1188P
+ PS=1.6U PD=1.02U
M$5256 \$4402 \$4320 \$4401 VSS nfet_03v3 L=0.28U W=0.36U AS=0.1188P AD=0.1278P
+ PS=1.02U PD=1.07U
M$5257 \$4619 \$4403 \$4402 VSS nfet_03v3 L=0.28U W=0.36U AS=0.1278P AD=0.0567P
+ PS=1.07U PD=0.675U
M$5258 VSS \$4321 \$4619 VSS nfet_03v3 L=0.28U W=0.36U AS=0.0567P AD=0.1584P
+ PS=0.675U PD=1.6U
M$5259 VSS \$4402 \$4403 VSS nfet_03v3 L=0.28U W=0.36U AS=0.1584P AD=0.0972P
+ PS=1.6U PD=0.9U
M$5260 \$4404 \$4402 VSS VSS nfet_03v3 L=0.28U W=0.36U AS=0.0972P AD=0.18P
+ PS=0.9U PD=1.72U
M$5261 \$4407 \$148 VSS VSS nfet_03v3 L=0.28U W=0.36U AS=0.1584P AD=0.1188P
+ PS=1.6U PD=1.02U
M$5262 \$4408 \$4320 \$4407 VSS nfet_03v3 L=0.28U W=0.36U AS=0.1188P AD=0.1278P
+ PS=1.02U PD=1.07U
M$5263 \$4584 \$4409 \$4408 VSS nfet_03v3 L=0.28U W=0.36U AS=0.1278P AD=0.0567P
+ PS=1.07U PD=0.675U
M$5264 VSS \$4321 \$4584 VSS nfet_03v3 L=0.28U W=0.36U AS=0.0567P AD=0.1584P
+ PS=0.675U PD=1.6U
M$5265 VSS \$4408 \$4409 VSS nfet_03v3 L=0.28U W=0.36U AS=0.1584P AD=0.0972P
+ PS=1.6U PD=0.9U
M$5266 \$4410 \$4408 VSS VSS nfet_03v3 L=0.28U W=0.36U AS=0.0972P AD=0.18P
+ PS=0.9U PD=1.72U
M$5267 \$4413 \$151 VSS VSS nfet_03v3 L=0.28U W=0.36U AS=0.1584P AD=0.1188P
+ PS=1.6U PD=1.02U
M$5268 \$4414 \$4320 \$4413 VSS nfet_03v3 L=0.28U W=0.36U AS=0.1188P AD=0.1278P
+ PS=1.02U PD=1.07U
M$5269 \$4549 \$4415 \$4414 VSS nfet_03v3 L=0.28U W=0.36U AS=0.1278P AD=0.0567P
+ PS=1.07U PD=0.675U
M$5270 VSS \$4321 \$4549 VSS nfet_03v3 L=0.28U W=0.36U AS=0.0567P AD=0.1584P
+ PS=0.675U PD=1.6U
M$5271 VSS \$4414 \$4415 VSS nfet_03v3 L=0.28U W=0.36U AS=0.1584P AD=0.0972P
+ PS=1.6U PD=0.9U
M$5272 \$4416 \$4414 VSS VSS nfet_03v3 L=0.28U W=0.36U AS=0.0972P AD=0.18P
+ PS=0.9U PD=1.72U
M$5273 \$4780 WE1 VSS VSS nfet_03v3 L=0.28U W=0.72U AS=0.3168P AD=0.1872P
+ PS=2.32U PD=1.24U
M$5274 \$4638 CLK \$4780 VSS nfet_03v3 L=0.28U W=0.72U AS=0.1872P AD=0.3168P
+ PS=1.24U PD=2.32U
M$5275 \$4639 \$4638 VSS VSS nfet_03v3 L=0.28U W=1.27U AS=0.4445P AD=0.3344P
+ PS=3.305U PD=2.345U
M$5277 \$4832 \$4639 VSS VSS nfet_03v3 L=0.28U W=1.34U AS=0.3636P AD=0.4891P
+ PS=2.44U PD=3.47U
M$5279 \$4640 \$106 VSS VSS nfet_03v3 L=0.28U W=0.36U AS=0.1584P AD=0.1188P
+ PS=1.6U PD=1.02U
M$5280 \$4641 \$4639 \$4640 VSS nfet_03v3 L=0.28U W=0.36U AS=0.1188P AD=0.1278P
+ PS=1.02U PD=1.07U
M$5281 \$4678 \$4730 \$4641 VSS nfet_03v3 L=0.28U W=0.36U AS=0.1278P AD=0.0567P
+ PS=1.07U PD=0.675U
M$5282 VSS \$4832 \$4678 VSS nfet_03v3 L=0.28U W=0.36U AS=0.0567P AD=0.1584P
+ PS=0.675U PD=1.6U
M$5283 VSS \$4641 \$4730 VSS nfet_03v3 L=0.28U W=0.36U AS=0.1584P AD=0.0972P
+ PS=1.6U PD=0.9U
M$5284 \$4622 \$4641 VSS VSS nfet_03v3 L=0.28U W=0.36U AS=0.0972P AD=0.18P
+ PS=0.9U PD=1.72U
M$5285 \$4642 \$109 VSS VSS nfet_03v3 L=0.28U W=0.36U AS=0.1584P AD=0.1188P
+ PS=1.6U PD=1.02U
M$5286 \$4643 \$4639 \$4642 VSS nfet_03v3 L=0.28U W=0.36U AS=0.1188P AD=0.1278P
+ PS=1.02U PD=1.07U
M$5287 \$4689 \$4734 \$4643 VSS nfet_03v3 L=0.28U W=0.36U AS=0.1278P AD=0.0567P
+ PS=1.07U PD=0.675U
M$5288 VSS \$4832 \$4689 VSS nfet_03v3 L=0.28U W=0.36U AS=0.0567P AD=0.1584P
+ PS=0.675U PD=1.6U
M$5289 VSS \$4643 \$4734 VSS nfet_03v3 L=0.28U W=0.36U AS=0.1584P AD=0.0972P
+ PS=1.6U PD=0.9U
M$5290 \$4623 \$4643 VSS VSS nfet_03v3 L=0.28U W=0.36U AS=0.0972P AD=0.18P
+ PS=0.9U PD=1.72U
M$5291 \$4644 \$112 VSS VSS nfet_03v3 L=0.28U W=0.36U AS=0.1584P AD=0.1188P
+ PS=1.6U PD=1.02U
M$5292 \$4645 \$4639 \$4644 VSS nfet_03v3 L=0.28U W=0.36U AS=0.1188P AD=0.1278P
+ PS=1.02U PD=1.07U
M$5293 \$4698 \$4737 \$4645 VSS nfet_03v3 L=0.28U W=0.36U AS=0.1278P AD=0.0567P
+ PS=1.07U PD=0.675U
M$5294 VSS \$4832 \$4698 VSS nfet_03v3 L=0.28U W=0.36U AS=0.0567P AD=0.1584P
+ PS=0.675U PD=1.6U
M$5295 VSS \$4645 \$4737 VSS nfet_03v3 L=0.28U W=0.36U AS=0.1584P AD=0.0972P
+ PS=1.6U PD=0.9U
M$5296 \$4624 \$4645 VSS VSS nfet_03v3 L=0.28U W=0.36U AS=0.0972P AD=0.18P
+ PS=0.9U PD=1.72U
M$5297 \$4646 \$115 VSS VSS nfet_03v3 L=0.28U W=0.36U AS=0.1584P AD=0.1188P
+ PS=1.6U PD=1.02U
M$5298 \$4647 \$4639 \$4646 VSS nfet_03v3 L=0.28U W=0.36U AS=0.1188P AD=0.1278P
+ PS=1.02U PD=1.07U
M$5299 \$4708 \$4740 \$4647 VSS nfet_03v3 L=0.28U W=0.36U AS=0.1278P AD=0.0567P
+ PS=1.07U PD=0.675U
M$5300 VSS \$4832 \$4708 VSS nfet_03v3 L=0.28U W=0.36U AS=0.0567P AD=0.1584P
+ PS=0.675U PD=1.6U
M$5301 VSS \$4647 \$4740 VSS nfet_03v3 L=0.28U W=0.36U AS=0.1584P AD=0.0972P
+ PS=1.6U PD=0.9U
M$5302 \$4625 \$4647 VSS VSS nfet_03v3 L=0.28U W=0.36U AS=0.0972P AD=0.18P
+ PS=0.9U PD=1.72U
M$5303 \$4648 \$118 VSS VSS nfet_03v3 L=0.28U W=0.36U AS=0.1584P AD=0.1188P
+ PS=1.6U PD=1.02U
M$5304 \$4649 \$4639 \$4648 VSS nfet_03v3 L=0.28U W=0.36U AS=0.1188P AD=0.1278P
+ PS=1.02U PD=1.07U
M$5305 \$4719 \$4743 \$4649 VSS nfet_03v3 L=0.28U W=0.36U AS=0.1278P AD=0.0567P
+ PS=1.07U PD=0.675U
M$5306 VSS \$4832 \$4719 VSS nfet_03v3 L=0.28U W=0.36U AS=0.0567P AD=0.1584P
+ PS=0.675U PD=1.6U
M$5307 VSS \$4649 \$4743 VSS nfet_03v3 L=0.28U W=0.36U AS=0.1584P AD=0.0972P
+ PS=1.6U PD=0.9U
M$5308 \$4626 \$4649 VSS VSS nfet_03v3 L=0.28U W=0.36U AS=0.0972P AD=0.18P
+ PS=0.9U PD=1.72U
M$5309 \$4650 \$121 VSS VSS nfet_03v3 L=0.28U W=0.36U AS=0.1584P AD=0.1188P
+ PS=1.6U PD=1.02U
M$5310 \$4651 \$4639 \$4650 VSS nfet_03v3 L=0.28U W=0.36U AS=0.1188P AD=0.1278P
+ PS=1.02U PD=1.07U
M$5311 \$4724 \$4746 \$4651 VSS nfet_03v3 L=0.28U W=0.36U AS=0.1278P AD=0.0567P
+ PS=1.07U PD=0.675U
M$5312 VSS \$4832 \$4724 VSS nfet_03v3 L=0.28U W=0.36U AS=0.0567P AD=0.1584P
+ PS=0.675U PD=1.6U
M$5313 VSS \$4651 \$4746 VSS nfet_03v3 L=0.28U W=0.36U AS=0.1584P AD=0.0972P
+ PS=1.6U PD=0.9U
M$5314 \$4627 \$4651 VSS VSS nfet_03v3 L=0.28U W=0.36U AS=0.0972P AD=0.18P
+ PS=0.9U PD=1.72U
M$5315 \$4652 \$124 VSS VSS nfet_03v3 L=0.28U W=0.36U AS=0.1584P AD=0.1188P
+ PS=1.6U PD=1.02U
M$5316 \$4653 \$4639 \$4652 VSS nfet_03v3 L=0.28U W=0.36U AS=0.1188P AD=0.1278P
+ PS=1.02U PD=1.07U
M$5317 \$4720 \$4749 \$4653 VSS nfet_03v3 L=0.28U W=0.36U AS=0.1278P AD=0.0567P
+ PS=1.07U PD=0.675U
M$5318 VSS \$4832 \$4720 VSS nfet_03v3 L=0.28U W=0.36U AS=0.0567P AD=0.1584P
+ PS=0.675U PD=1.6U
M$5319 VSS \$4653 \$4749 VSS nfet_03v3 L=0.28U W=0.36U AS=0.1584P AD=0.0972P
+ PS=1.6U PD=0.9U
M$5320 \$4628 \$4653 VSS VSS nfet_03v3 L=0.28U W=0.36U AS=0.0972P AD=0.18P
+ PS=0.9U PD=1.72U
M$5321 \$4654 \$127 VSS VSS nfet_03v3 L=0.28U W=0.36U AS=0.1584P AD=0.1188P
+ PS=1.6U PD=1.02U
M$5322 \$4655 \$4639 \$4654 VSS nfet_03v3 L=0.28U W=0.36U AS=0.1188P AD=0.1278P
+ PS=1.02U PD=1.07U
M$5323 \$4713 \$4752 \$4655 VSS nfet_03v3 L=0.28U W=0.36U AS=0.1278P AD=0.0567P
+ PS=1.07U PD=0.675U
M$5324 VSS \$4832 \$4713 VSS nfet_03v3 L=0.28U W=0.36U AS=0.0567P AD=0.1584P
+ PS=0.675U PD=1.6U
M$5325 VSS \$4655 \$4752 VSS nfet_03v3 L=0.28U W=0.36U AS=0.1584P AD=0.0972P
+ PS=1.6U PD=0.9U
M$5326 \$4629 \$4655 VSS VSS nfet_03v3 L=0.28U W=0.36U AS=0.0972P AD=0.18P
+ PS=0.9U PD=1.72U
M$5327 \$4656 \$130 VSS VSS nfet_03v3 L=0.28U W=0.36U AS=0.1584P AD=0.1188P
+ PS=1.6U PD=1.02U
M$5328 \$4657 \$4639 \$4656 VSS nfet_03v3 L=0.28U W=0.36U AS=0.1188P AD=0.1278P
+ PS=1.02U PD=1.07U
M$5329 \$4710 \$4755 \$4657 VSS nfet_03v3 L=0.28U W=0.36U AS=0.1278P AD=0.0567P
+ PS=1.07U PD=0.675U
M$5330 VSS \$4832 \$4710 VSS nfet_03v3 L=0.28U W=0.36U AS=0.0567P AD=0.1584P
+ PS=0.675U PD=1.6U
M$5331 VSS \$4657 \$4755 VSS nfet_03v3 L=0.28U W=0.36U AS=0.1584P AD=0.0972P
+ PS=1.6U PD=0.9U
M$5332 \$4630 \$4657 VSS VSS nfet_03v3 L=0.28U W=0.36U AS=0.0972P AD=0.18P
+ PS=0.9U PD=1.72U
M$5333 \$4658 \$133 VSS VSS nfet_03v3 L=0.28U W=0.36U AS=0.1584P AD=0.1188P
+ PS=1.6U PD=1.02U
M$5334 \$4659 \$4639 \$4658 VSS nfet_03v3 L=0.28U W=0.36U AS=0.1188P AD=0.1278P
+ PS=1.02U PD=1.07U
M$5335 \$4705 \$4758 \$4659 VSS nfet_03v3 L=0.28U W=0.36U AS=0.1278P AD=0.0567P
+ PS=1.07U PD=0.675U
M$5336 VSS \$4832 \$4705 VSS nfet_03v3 L=0.28U W=0.36U AS=0.0567P AD=0.1584P
+ PS=0.675U PD=1.6U
M$5337 VSS \$4659 \$4758 VSS nfet_03v3 L=0.28U W=0.36U AS=0.1584P AD=0.0972P
+ PS=1.6U PD=0.9U
M$5338 \$4631 \$4659 VSS VSS nfet_03v3 L=0.28U W=0.36U AS=0.0972P AD=0.18P
+ PS=0.9U PD=1.72U
M$5339 \$4660 \$136 VSS VSS nfet_03v3 L=0.28U W=0.36U AS=0.1584P AD=0.1188P
+ PS=1.6U PD=1.02U
M$5340 \$4661 \$4639 \$4660 VSS nfet_03v3 L=0.28U W=0.36U AS=0.1188P AD=0.1278P
+ PS=1.02U PD=1.07U
M$5341 \$4699 \$4761 \$4661 VSS nfet_03v3 L=0.28U W=0.36U AS=0.1278P AD=0.0567P
+ PS=1.07U PD=0.675U
M$5342 VSS \$4832 \$4699 VSS nfet_03v3 L=0.28U W=0.36U AS=0.0567P AD=0.1584P
+ PS=0.675U PD=1.6U
M$5343 VSS \$4661 \$4761 VSS nfet_03v3 L=0.28U W=0.36U AS=0.1584P AD=0.0972P
+ PS=1.6U PD=0.9U
M$5344 \$4632 \$4661 VSS VSS nfet_03v3 L=0.28U W=0.36U AS=0.0972P AD=0.18P
+ PS=0.9U PD=1.72U
M$5345 \$4662 \$139 VSS VSS nfet_03v3 L=0.28U W=0.36U AS=0.1584P AD=0.1188P
+ PS=1.6U PD=1.02U
M$5346 \$4663 \$4639 \$4662 VSS nfet_03v3 L=0.28U W=0.36U AS=0.1188P AD=0.1278P
+ PS=1.02U PD=1.07U
M$5347 \$4695 \$4764 \$4663 VSS nfet_03v3 L=0.28U W=0.36U AS=0.1278P AD=0.0567P
+ PS=1.07U PD=0.675U
M$5348 VSS \$4832 \$4695 VSS nfet_03v3 L=0.28U W=0.36U AS=0.0567P AD=0.1584P
+ PS=0.675U PD=1.6U
M$5349 VSS \$4663 \$4764 VSS nfet_03v3 L=0.28U W=0.36U AS=0.1584P AD=0.0972P
+ PS=1.6U PD=0.9U
M$5350 \$4633 \$4663 VSS VSS nfet_03v3 L=0.28U W=0.36U AS=0.0972P AD=0.18P
+ PS=0.9U PD=1.72U
M$5351 \$4664 \$142 VSS VSS nfet_03v3 L=0.28U W=0.36U AS=0.1584P AD=0.1188P
+ PS=1.6U PD=1.02U
M$5352 \$4665 \$4639 \$4664 VSS nfet_03v3 L=0.28U W=0.36U AS=0.1188P AD=0.1278P
+ PS=1.02U PD=1.07U
M$5353 \$4691 \$4767 \$4665 VSS nfet_03v3 L=0.28U W=0.36U AS=0.1278P AD=0.0567P
+ PS=1.07U PD=0.675U
M$5354 VSS \$4832 \$4691 VSS nfet_03v3 L=0.28U W=0.36U AS=0.0567P AD=0.1584P
+ PS=0.675U PD=1.6U
M$5355 VSS \$4665 \$4767 VSS nfet_03v3 L=0.28U W=0.36U AS=0.1584P AD=0.0972P
+ PS=1.6U PD=0.9U
M$5356 \$4634 \$4665 VSS VSS nfet_03v3 L=0.28U W=0.36U AS=0.0972P AD=0.18P
+ PS=0.9U PD=1.72U
M$5357 \$4666 \$145 VSS VSS nfet_03v3 L=0.28U W=0.36U AS=0.1584P AD=0.1188P
+ PS=1.6U PD=1.02U
M$5358 \$4667 \$4639 \$4666 VSS nfet_03v3 L=0.28U W=0.36U AS=0.1188P AD=0.1278P
+ PS=1.02U PD=1.07U
M$5359 \$4684 \$4770 \$4667 VSS nfet_03v3 L=0.28U W=0.36U AS=0.1278P AD=0.0567P
+ PS=1.07U PD=0.675U
M$5360 VSS \$4832 \$4684 VSS nfet_03v3 L=0.28U W=0.36U AS=0.0567P AD=0.1584P
+ PS=0.675U PD=1.6U
M$5361 VSS \$4667 \$4770 VSS nfet_03v3 L=0.28U W=0.36U AS=0.1584P AD=0.0972P
+ PS=1.6U PD=0.9U
M$5362 \$4635 \$4667 VSS VSS nfet_03v3 L=0.28U W=0.36U AS=0.0972P AD=0.18P
+ PS=0.9U PD=1.72U
M$5363 \$4668 \$148 VSS VSS nfet_03v3 L=0.28U W=0.36U AS=0.1584P AD=0.1188P
+ PS=1.6U PD=1.02U
M$5364 \$4669 \$4639 \$4668 VSS nfet_03v3 L=0.28U W=0.36U AS=0.1188P AD=0.1278P
+ PS=1.02U PD=1.07U
M$5365 \$4679 \$4773 \$4669 VSS nfet_03v3 L=0.28U W=0.36U AS=0.1278P AD=0.0567P
+ PS=1.07U PD=0.675U
M$5366 VSS \$4832 \$4679 VSS nfet_03v3 L=0.28U W=0.36U AS=0.0567P AD=0.1584P
+ PS=0.675U PD=1.6U
M$5367 VSS \$4669 \$4773 VSS nfet_03v3 L=0.28U W=0.36U AS=0.1584P AD=0.0972P
+ PS=1.6U PD=0.9U
M$5368 \$4636 \$4669 VSS VSS nfet_03v3 L=0.28U W=0.36U AS=0.0972P AD=0.18P
+ PS=0.9U PD=1.72U
M$5369 \$4670 \$151 VSS VSS nfet_03v3 L=0.28U W=0.36U AS=0.1584P AD=0.1188P
+ PS=1.6U PD=1.02U
M$5370 \$4671 \$4639 \$4670 VSS nfet_03v3 L=0.28U W=0.36U AS=0.1188P AD=0.1278P
+ PS=1.02U PD=1.07U
M$5371 \$4674 \$4776 \$4671 VSS nfet_03v3 L=0.28U W=0.36U AS=0.1278P AD=0.0567P
+ PS=1.07U PD=0.675U
M$5372 VSS \$4832 \$4674 VSS nfet_03v3 L=0.28U W=0.36U AS=0.0567P AD=0.1584P
+ PS=0.675U PD=1.6U
M$5373 VSS \$4671 \$4776 VSS nfet_03v3 L=0.28U W=0.36U AS=0.1584P AD=0.0972P
+ PS=1.6U PD=0.9U
M$5374 \$4637 \$4671 VSS VSS nfet_03v3 L=0.28U W=0.36U AS=0.0972P AD=0.18P
+ PS=0.9U PD=1.72U
M$5375 \$4946 RB0 VSS VSS nfet_03v3 L=0.28U W=0.36U AS=0.1656P AD=0.1944P
+ PS=1.64U PD=1.8U
M$5376 \$4732 RA1 VSS VSS nfet_03v3 L=0.28U W=0.36U AS=0.1656P AD=0.1944P
+ PS=1.64U PD=1.8U
M$5377 \$4944 RB0 \$51 VSS nfet_03v3 L=0.28U W=0.36U AS=0.1584P AD=0.1152P
+ PS=1.6U PD=1U
M$5378 \$52 RA0 \$4944 VSS nfet_03v3 L=0.28U W=0.36U AS=0.1152P AD=0.1584P
+ PS=1U PD=1.6U
M$5379 \$4622 RA1 \$51 VSS nfet_03v3 L=0.28U W=0.36U AS=0.1584P AD=0.1152P
+ PS=1.6U PD=1U
M$5380 \$52 RB1 \$4622 VSS nfet_03v3 L=0.28U W=0.36U AS=0.1152P AD=0.1584P
+ PS=1U PD=1.6U
M$5381 VSS RA0 \$4947 VSS nfet_03v3 L=0.28U W=0.36U AS=0.1854P AD=0.1584P
+ PS=1.75U PD=1.6U
M$5382 VSS RB1 \$4733 VSS nfet_03v3 L=0.28U W=0.36U AS=0.1854P AD=0.1584P
+ PS=1.75U PD=1.6U
M$5383 \$4952 RB0 VSS VSS nfet_03v3 L=0.28U W=0.36U AS=0.1656P AD=0.1944P
+ PS=1.64U PD=1.8U
M$5384 \$4735 RA1 VSS VSS nfet_03v3 L=0.28U W=0.36U AS=0.1656P AD=0.1944P
+ PS=1.64U PD=1.8U
M$5385 \$4623 RA1 \$53 VSS nfet_03v3 L=0.28U W=0.36U AS=0.1584P AD=0.1152P
+ PS=1.6U PD=1U
M$5386 \$54 RB1 \$4623 VSS nfet_03v3 L=0.28U W=0.36U AS=0.1152P AD=0.1584P
+ PS=1U PD=1.6U
M$5387 \$4951 RB0 \$53 VSS nfet_03v3 L=0.28U W=0.36U AS=0.1584P AD=0.1152P
+ PS=1.6U PD=1U
M$5388 \$54 RA0 \$4951 VSS nfet_03v3 L=0.28U W=0.36U AS=0.1152P AD=0.1584P
+ PS=1U PD=1.6U
M$5389 VSS RB1 \$4736 VSS nfet_03v3 L=0.28U W=0.36U AS=0.1854P AD=0.1584P
+ PS=1.75U PD=1.6U
M$5390 VSS RA0 \$4953 VSS nfet_03v3 L=0.28U W=0.36U AS=0.1854P AD=0.1584P
+ PS=1.75U PD=1.6U
M$5391 \$4958 RB0 VSS VSS nfet_03v3 L=0.28U W=0.36U AS=0.1656P AD=0.1944P
+ PS=1.64U PD=1.8U
M$5392 \$4738 RA1 VSS VSS nfet_03v3 L=0.28U W=0.36U AS=0.1656P AD=0.1944P
+ PS=1.64U PD=1.8U
M$5393 \$4624 RA1 \$55 VSS nfet_03v3 L=0.28U W=0.36U AS=0.1584P AD=0.1152P
+ PS=1.6U PD=1U
M$5394 \$56 RB1 \$4624 VSS nfet_03v3 L=0.28U W=0.36U AS=0.1152P AD=0.1584P
+ PS=1U PD=1.6U
M$5395 \$4957 RB0 \$55 VSS nfet_03v3 L=0.28U W=0.36U AS=0.1584P AD=0.1152P
+ PS=1.6U PD=1U
M$5396 \$56 RA0 \$4957 VSS nfet_03v3 L=0.28U W=0.36U AS=0.1152P AD=0.1584P
+ PS=1U PD=1.6U
M$5397 VSS RB1 \$4739 VSS nfet_03v3 L=0.28U W=0.36U AS=0.1854P AD=0.1584P
+ PS=1.75U PD=1.6U
M$5398 VSS RA0 \$4959 VSS nfet_03v3 L=0.28U W=0.36U AS=0.1854P AD=0.1584P
+ PS=1.75U PD=1.6U
M$5399 \$4964 RB0 VSS VSS nfet_03v3 L=0.28U W=0.36U AS=0.1656P AD=0.1944P
+ PS=1.64U PD=1.8U
M$5400 \$4741 RA1 VSS VSS nfet_03v3 L=0.28U W=0.36U AS=0.1656P AD=0.1944P
+ PS=1.64U PD=1.8U
M$5401 \$4963 RB0 \$57 VSS nfet_03v3 L=0.28U W=0.36U AS=0.1584P AD=0.1152P
+ PS=1.6U PD=1U
M$5402 \$58 RA0 \$4963 VSS nfet_03v3 L=0.28U W=0.36U AS=0.1152P AD=0.1584P
+ PS=1U PD=1.6U
M$5403 \$4625 RA1 \$57 VSS nfet_03v3 L=0.28U W=0.36U AS=0.1584P AD=0.1152P
+ PS=1.6U PD=1U
M$5404 \$58 RB1 \$4625 VSS nfet_03v3 L=0.28U W=0.36U AS=0.1152P AD=0.1584P
+ PS=1U PD=1.6U
M$5405 VSS RB1 \$4742 VSS nfet_03v3 L=0.28U W=0.36U AS=0.1854P AD=0.1584P
+ PS=1.75U PD=1.6U
M$5406 VSS RA0 \$4965 VSS nfet_03v3 L=0.28U W=0.36U AS=0.1854P AD=0.1584P
+ PS=1.75U PD=1.6U
M$5407 \$4744 RA1 VSS VSS nfet_03v3 L=0.28U W=0.36U AS=0.1656P AD=0.1944P
+ PS=1.64U PD=1.8U
M$5408 \$4970 RB0 VSS VSS nfet_03v3 L=0.28U W=0.36U AS=0.1656P AD=0.1944P
+ PS=1.64U PD=1.8U
M$5409 \$4969 RB0 \$59 VSS nfet_03v3 L=0.28U W=0.36U AS=0.1584P AD=0.1152P
+ PS=1.6U PD=1U
M$5410 \$60 RA0 \$4969 VSS nfet_03v3 L=0.28U W=0.36U AS=0.1152P AD=0.1584P
+ PS=1U PD=1.6U
M$5411 \$4626 RA1 \$59 VSS nfet_03v3 L=0.28U W=0.36U AS=0.1584P AD=0.1152P
+ PS=1.6U PD=1U
M$5412 \$60 RB1 \$4626 VSS nfet_03v3 L=0.28U W=0.36U AS=0.1152P AD=0.1584P
+ PS=1U PD=1.6U
M$5413 VSS RB1 \$4745 VSS nfet_03v3 L=0.28U W=0.36U AS=0.1854P AD=0.1584P
+ PS=1.75U PD=1.6U
M$5414 VSS RA0 \$4971 VSS nfet_03v3 L=0.28U W=0.36U AS=0.1854P AD=0.1584P
+ PS=1.75U PD=1.6U
M$5415 \$4976 RB0 VSS VSS nfet_03v3 L=0.28U W=0.36U AS=0.1656P AD=0.1944P
+ PS=1.64U PD=1.8U
M$5416 \$4747 RA1 VSS VSS nfet_03v3 L=0.28U W=0.36U AS=0.1656P AD=0.1944P
+ PS=1.64U PD=1.8U
M$5417 \$4975 RB0 \$61 VSS nfet_03v3 L=0.28U W=0.36U AS=0.1584P AD=0.1152P
+ PS=1.6U PD=1U
M$5418 \$62 RA0 \$4975 VSS nfet_03v3 L=0.28U W=0.36U AS=0.1152P AD=0.1584P
+ PS=1U PD=1.6U
M$5419 \$4627 RA1 \$61 VSS nfet_03v3 L=0.28U W=0.36U AS=0.1584P AD=0.1152P
+ PS=1.6U PD=1U
M$5420 \$62 RB1 \$4627 VSS nfet_03v3 L=0.28U W=0.36U AS=0.1152P AD=0.1584P
+ PS=1U PD=1.6U
M$5421 VSS RB1 \$4748 VSS nfet_03v3 L=0.28U W=0.36U AS=0.1854P AD=0.1584P
+ PS=1.75U PD=1.6U
M$5422 VSS RA0 \$4977 VSS nfet_03v3 L=0.28U W=0.36U AS=0.1854P AD=0.1584P
+ PS=1.75U PD=1.6U
M$5423 \$4750 RA1 VSS VSS nfet_03v3 L=0.28U W=0.36U AS=0.1656P AD=0.1944P
+ PS=1.64U PD=1.8U
M$5424 \$4982 RB0 VSS VSS nfet_03v3 L=0.28U W=0.36U AS=0.1656P AD=0.1944P
+ PS=1.64U PD=1.8U
M$5425 \$4981 RB0 \$63 VSS nfet_03v3 L=0.28U W=0.36U AS=0.1584P AD=0.1152P
+ PS=1.6U PD=1U
M$5426 \$64 RA0 \$4981 VSS nfet_03v3 L=0.28U W=0.36U AS=0.1152P AD=0.1584P
+ PS=1U PD=1.6U
M$5427 \$4628 RA1 \$63 VSS nfet_03v3 L=0.28U W=0.36U AS=0.1584P AD=0.1152P
+ PS=1.6U PD=1U
M$5428 \$64 RB1 \$4628 VSS nfet_03v3 L=0.28U W=0.36U AS=0.1152P AD=0.1584P
+ PS=1U PD=1.6U
M$5429 VSS RA0 \$4983 VSS nfet_03v3 L=0.28U W=0.36U AS=0.1854P AD=0.1584P
+ PS=1.75U PD=1.6U
M$5430 VSS RB1 \$4751 VSS nfet_03v3 L=0.28U W=0.36U AS=0.1854P AD=0.1584P
+ PS=1.75U PD=1.6U
M$5431 \$4753 RA1 VSS VSS nfet_03v3 L=0.28U W=0.36U AS=0.1656P AD=0.1944P
+ PS=1.64U PD=1.8U
M$5432 \$4988 RB0 VSS VSS nfet_03v3 L=0.28U W=0.36U AS=0.1656P AD=0.1944P
+ PS=1.64U PD=1.8U
M$5433 \$4987 RB0 \$65 VSS nfet_03v3 L=0.28U W=0.36U AS=0.1584P AD=0.1152P
+ PS=1.6U PD=1U
M$5434 \$66 RA0 \$4987 VSS nfet_03v3 L=0.28U W=0.36U AS=0.1152P AD=0.1584P
+ PS=1U PD=1.6U
M$5435 \$4629 RA1 \$65 VSS nfet_03v3 L=0.28U W=0.36U AS=0.1584P AD=0.1152P
+ PS=1.6U PD=1U
M$5436 \$66 RB1 \$4629 VSS nfet_03v3 L=0.28U W=0.36U AS=0.1152P AD=0.1584P
+ PS=1U PD=1.6U
M$5437 VSS RB1 \$4754 VSS nfet_03v3 L=0.28U W=0.36U AS=0.1854P AD=0.1584P
+ PS=1.75U PD=1.6U
M$5438 VSS RA0 \$4989 VSS nfet_03v3 L=0.28U W=0.36U AS=0.1854P AD=0.1584P
+ PS=1.75U PD=1.6U
M$5439 \$4994 RB0 VSS VSS nfet_03v3 L=0.28U W=0.36U AS=0.1656P AD=0.1944P
+ PS=1.64U PD=1.8U
M$5440 \$4756 RA1 VSS VSS nfet_03v3 L=0.28U W=0.36U AS=0.1656P AD=0.1944P
+ PS=1.64U PD=1.8U
M$5441 \$4993 RB0 \$67 VSS nfet_03v3 L=0.28U W=0.36U AS=0.1584P AD=0.1152P
+ PS=1.6U PD=1U
M$5442 \$68 RA0 \$4993 VSS nfet_03v3 L=0.28U W=0.36U AS=0.1152P AD=0.1584P
+ PS=1U PD=1.6U
M$5443 \$4630 RA1 \$67 VSS nfet_03v3 L=0.28U W=0.36U AS=0.1584P AD=0.1152P
+ PS=1.6U PD=1U
M$5444 \$68 RB1 \$4630 VSS nfet_03v3 L=0.28U W=0.36U AS=0.1152P AD=0.1584P
+ PS=1U PD=1.6U
M$5445 VSS RB1 \$4757 VSS nfet_03v3 L=0.28U W=0.36U AS=0.1854P AD=0.1584P
+ PS=1.75U PD=1.6U
M$5446 VSS RA0 \$4995 VSS nfet_03v3 L=0.28U W=0.36U AS=0.1854P AD=0.1584P
+ PS=1.75U PD=1.6U
M$5447 \$5000 RB0 VSS VSS nfet_03v3 L=0.28U W=0.36U AS=0.1656P AD=0.1944P
+ PS=1.64U PD=1.8U
M$5448 \$4759 RA1 VSS VSS nfet_03v3 L=0.28U W=0.36U AS=0.1656P AD=0.1944P
+ PS=1.64U PD=1.8U
M$5449 \$4999 RB0 \$69 VSS nfet_03v3 L=0.28U W=0.36U AS=0.1584P AD=0.1152P
+ PS=1.6U PD=1U
M$5450 \$70 RA0 \$4999 VSS nfet_03v3 L=0.28U W=0.36U AS=0.1152P AD=0.1584P
+ PS=1U PD=1.6U
M$5451 \$4631 RA1 \$69 VSS nfet_03v3 L=0.28U W=0.36U AS=0.1584P AD=0.1152P
+ PS=1.6U PD=1U
M$5452 \$70 RB1 \$4631 VSS nfet_03v3 L=0.28U W=0.36U AS=0.1152P AD=0.1584P
+ PS=1U PD=1.6U
M$5453 VSS RA0 \$5001 VSS nfet_03v3 L=0.28U W=0.36U AS=0.1854P AD=0.1584P
+ PS=1.75U PD=1.6U
M$5454 VSS RB1 \$4760 VSS nfet_03v3 L=0.28U W=0.36U AS=0.1854P AD=0.1584P
+ PS=1.75U PD=1.6U
M$5455 \$5006 RB0 VSS VSS nfet_03v3 L=0.28U W=0.36U AS=0.1656P AD=0.1944P
+ PS=1.64U PD=1.8U
M$5456 \$4762 RA1 VSS VSS nfet_03v3 L=0.28U W=0.36U AS=0.1656P AD=0.1944P
+ PS=1.64U PD=1.8U
M$5457 \$4632 RA1 \$71 VSS nfet_03v3 L=0.28U W=0.36U AS=0.1584P AD=0.1152P
+ PS=1.6U PD=1U
M$5458 \$72 RB1 \$4632 VSS nfet_03v3 L=0.28U W=0.36U AS=0.1152P AD=0.1584P
+ PS=1U PD=1.6U
M$5459 \$5005 RB0 \$71 VSS nfet_03v3 L=0.28U W=0.36U AS=0.1584P AD=0.1152P
+ PS=1.6U PD=1U
M$5460 \$72 RA0 \$5005 VSS nfet_03v3 L=0.28U W=0.36U AS=0.1152P AD=0.1584P
+ PS=1U PD=1.6U
M$5461 VSS RB1 \$4763 VSS nfet_03v3 L=0.28U W=0.36U AS=0.1854P AD=0.1584P
+ PS=1.75U PD=1.6U
M$5462 VSS RA0 \$5007 VSS nfet_03v3 L=0.28U W=0.36U AS=0.1854P AD=0.1584P
+ PS=1.75U PD=1.6U
M$5463 \$4765 RA1 VSS VSS nfet_03v3 L=0.28U W=0.36U AS=0.1656P AD=0.1944P
+ PS=1.64U PD=1.8U
M$5464 \$5012 RB0 VSS VSS nfet_03v3 L=0.28U W=0.36U AS=0.1656P AD=0.1944P
+ PS=1.64U PD=1.8U
M$5465 \$4633 RA1 \$73 VSS nfet_03v3 L=0.28U W=0.36U AS=0.1584P AD=0.1152P
+ PS=1.6U PD=1U
M$5466 \$74 RB1 \$4633 VSS nfet_03v3 L=0.28U W=0.36U AS=0.1152P AD=0.1584P
+ PS=1U PD=1.6U
M$5467 \$5011 RB0 \$73 VSS nfet_03v3 L=0.28U W=0.36U AS=0.1584P AD=0.1152P
+ PS=1.6U PD=1U
M$5468 \$74 RA0 \$5011 VSS nfet_03v3 L=0.28U W=0.36U AS=0.1152P AD=0.1584P
+ PS=1U PD=1.6U
M$5469 VSS RB1 \$4766 VSS nfet_03v3 L=0.28U W=0.36U AS=0.1854P AD=0.1584P
+ PS=1.75U PD=1.6U
M$5470 VSS RA0 \$5013 VSS nfet_03v3 L=0.28U W=0.36U AS=0.1854P AD=0.1584P
+ PS=1.75U PD=1.6U
M$5471 \$5018 RB0 VSS VSS nfet_03v3 L=0.28U W=0.36U AS=0.1656P AD=0.1944P
+ PS=1.64U PD=1.8U
M$5472 \$4768 RA1 VSS VSS nfet_03v3 L=0.28U W=0.36U AS=0.1656P AD=0.1944P
+ PS=1.64U PD=1.8U
M$5473 \$4634 RA1 \$75 VSS nfet_03v3 L=0.28U W=0.36U AS=0.1584P AD=0.1152P
+ PS=1.6U PD=1U
M$5474 \$76 RB1 \$4634 VSS nfet_03v3 L=0.28U W=0.36U AS=0.1152P AD=0.1584P
+ PS=1U PD=1.6U
M$5475 \$5017 RB0 \$75 VSS nfet_03v3 L=0.28U W=0.36U AS=0.1584P AD=0.1152P
+ PS=1.6U PD=1U
M$5476 \$76 RA0 \$5017 VSS nfet_03v3 L=0.28U W=0.36U AS=0.1152P AD=0.1584P
+ PS=1U PD=1.6U
M$5477 VSS RB1 \$4769 VSS nfet_03v3 L=0.28U W=0.36U AS=0.1854P AD=0.1584P
+ PS=1.75U PD=1.6U
M$5478 VSS RA0 \$5019 VSS nfet_03v3 L=0.28U W=0.36U AS=0.1854P AD=0.1584P
+ PS=1.75U PD=1.6U
M$5479 \$5024 RB0 VSS VSS nfet_03v3 L=0.28U W=0.36U AS=0.1656P AD=0.1944P
+ PS=1.64U PD=1.8U
M$5480 \$4771 RA1 VSS VSS nfet_03v3 L=0.28U W=0.36U AS=0.1656P AD=0.1944P
+ PS=1.64U PD=1.8U
M$5481 \$5023 RB0 \$77 VSS nfet_03v3 L=0.28U W=0.36U AS=0.1584P AD=0.1152P
+ PS=1.6U PD=1U
M$5482 \$78 RA0 \$5023 VSS nfet_03v3 L=0.28U W=0.36U AS=0.1152P AD=0.1584P
+ PS=1U PD=1.6U
M$5483 \$4635 RA1 \$77 VSS nfet_03v3 L=0.28U W=0.36U AS=0.1584P AD=0.1152P
+ PS=1.6U PD=1U
M$5484 \$78 RB1 \$4635 VSS nfet_03v3 L=0.28U W=0.36U AS=0.1152P AD=0.1584P
+ PS=1U PD=1.6U
M$5485 VSS RA0 \$5025 VSS nfet_03v3 L=0.28U W=0.36U AS=0.1854P AD=0.1584P
+ PS=1.75U PD=1.6U
M$5486 VSS RB1 \$4772 VSS nfet_03v3 L=0.28U W=0.36U AS=0.1854P AD=0.1584P
+ PS=1.75U PD=1.6U
M$5487 \$5030 RB0 VSS VSS nfet_03v3 L=0.28U W=0.36U AS=0.1656P AD=0.1944P
+ PS=1.64U PD=1.8U
M$5488 \$4774 RA1 VSS VSS nfet_03v3 L=0.28U W=0.36U AS=0.1656P AD=0.1944P
+ PS=1.64U PD=1.8U
M$5489 \$5029 RB0 \$79 VSS nfet_03v3 L=0.28U W=0.36U AS=0.1584P AD=0.1152P
+ PS=1.6U PD=1U
M$5490 \$80 RA0 \$5029 VSS nfet_03v3 L=0.28U W=0.36U AS=0.1152P AD=0.1584P
+ PS=1U PD=1.6U
M$5491 \$4636 RA1 \$79 VSS nfet_03v3 L=0.28U W=0.36U AS=0.1584P AD=0.1152P
+ PS=1.6U PD=1U
M$5492 \$80 RB1 \$4636 VSS nfet_03v3 L=0.28U W=0.36U AS=0.1152P AD=0.1584P
+ PS=1U PD=1.6U
M$5493 VSS RA0 \$5031 VSS nfet_03v3 L=0.28U W=0.36U AS=0.1854P AD=0.1584P
+ PS=1.75U PD=1.6U
M$5494 VSS RB1 \$4775 VSS nfet_03v3 L=0.28U W=0.36U AS=0.1854P AD=0.1584P
+ PS=1.75U PD=1.6U
M$5495 \$4777 RA1 VSS VSS nfet_03v3 L=0.28U W=0.36U AS=0.1656P AD=0.1944P
+ PS=1.64U PD=1.8U
M$5496 \$5036 RB0 VSS VSS nfet_03v3 L=0.28U W=0.36U AS=0.1656P AD=0.1944P
+ PS=1.64U PD=1.8U
M$5497 \$5035 RB0 \$81 VSS nfet_03v3 L=0.28U W=0.36U AS=0.1584P AD=0.1152P
+ PS=1.6U PD=1U
M$5498 \$82 RA0 \$5035 VSS nfet_03v3 L=0.28U W=0.36U AS=0.1152P AD=0.1584P
+ PS=1U PD=1.6U
M$5499 \$4637 RA1 \$81 VSS nfet_03v3 L=0.28U W=0.36U AS=0.1584P AD=0.1152P
+ PS=1.6U PD=1U
M$5500 \$82 RB1 \$4637 VSS nfet_03v3 L=0.28U W=0.36U AS=0.1152P AD=0.1584P
+ PS=1U PD=1.6U
M$5501 VSS RB1 \$4778 VSS nfet_03v3 L=0.28U W=0.36U AS=0.1854P AD=0.1584P
+ PS=1.75U PD=1.6U
M$5502 VSS RA0 \$5037 VSS nfet_03v3 L=0.28U W=0.36U AS=0.1854P AD=0.1584P
+ PS=1.75U PD=1.6U
M$5503 \$5142 WE0 VSS VSS nfet_03v3 L=0.28U W=0.72U AS=0.3168P AD=0.1872P
+ PS=2.32U PD=1.24U
M$5504 \$4938 CLK \$5142 VSS nfet_03v3 L=0.28U W=0.72U AS=0.1872P AD=0.3168P
+ PS=1.24U PD=2.32U
M$5505 \$4939 \$4938 VSS VSS nfet_03v3 L=0.28U W=1.27U AS=0.4487P AD=0.3302P
+ PS=3.34U PD=2.31U
M$5507 \$4940 \$4939 VSS VSS nfet_03v3 L=0.28U W=1.34U AS=0.3636P AD=0.4891P
+ PS=2.44U PD=3.47U
M$5509 \$4941 \$106 VSS VSS nfet_03v3 L=0.28U W=0.36U AS=0.1584P AD=0.1188P
+ PS=1.6U PD=1.02U
M$5510 \$4942 \$4939 \$4941 VSS nfet_03v3 L=0.28U W=0.36U AS=0.1188P AD=0.1278P
+ PS=1.02U PD=1.07U
M$5511 \$5145 \$4943 \$4942 VSS nfet_03v3 L=0.28U W=0.36U AS=0.1278P AD=0.0567P
+ PS=1.07U PD=0.675U
M$5512 VSS \$4940 \$5145 VSS nfet_03v3 L=0.28U W=0.36U AS=0.0567P AD=0.1584P
+ PS=0.675U PD=1.6U
M$5513 VSS \$4942 \$4943 VSS nfet_03v3 L=0.28U W=0.36U AS=0.1584P AD=0.0972P
+ PS=1.6U PD=0.9U
M$5514 \$4944 \$4942 VSS VSS nfet_03v3 L=0.28U W=0.36U AS=0.0972P AD=0.18P
+ PS=0.9U PD=1.72U
M$5515 \$4948 \$109 VSS VSS nfet_03v3 L=0.28U W=0.36U AS=0.1584P AD=0.1188P
+ PS=1.6U PD=1.02U
M$5516 \$4949 \$4939 \$4948 VSS nfet_03v3 L=0.28U W=0.36U AS=0.1188P AD=0.1278P
+ PS=1.02U PD=1.07U
M$5517 \$5152 \$4950 \$4949 VSS nfet_03v3 L=0.28U W=0.36U AS=0.1278P AD=0.0567P
+ PS=1.07U PD=0.675U
M$5518 VSS \$4940 \$5152 VSS nfet_03v3 L=0.28U W=0.36U AS=0.0567P AD=0.1584P
+ PS=0.675U PD=1.6U
M$5519 VSS \$4949 \$4950 VSS nfet_03v3 L=0.28U W=0.36U AS=0.1584P AD=0.0972P
+ PS=1.6U PD=0.9U
M$5520 \$4951 \$4949 VSS VSS nfet_03v3 L=0.28U W=0.36U AS=0.0972P AD=0.18P
+ PS=0.9U PD=1.72U
M$5521 \$4954 \$112 VSS VSS nfet_03v3 L=0.28U W=0.36U AS=0.1584P AD=0.1188P
+ PS=1.6U PD=1.02U
M$5522 \$4955 \$4939 \$4954 VSS nfet_03v3 L=0.28U W=0.36U AS=0.1188P AD=0.1278P
+ PS=1.02U PD=1.07U
M$5523 \$5157 \$4956 \$4955 VSS nfet_03v3 L=0.28U W=0.36U AS=0.1278P AD=0.0567P
+ PS=1.07U PD=0.675U
M$5524 VSS \$4940 \$5157 VSS nfet_03v3 L=0.28U W=0.36U AS=0.0567P AD=0.1584P
+ PS=0.675U PD=1.6U
M$5525 VSS \$4955 \$4956 VSS nfet_03v3 L=0.28U W=0.36U AS=0.1584P AD=0.0972P
+ PS=1.6U PD=0.9U
M$5526 \$4957 \$4955 VSS VSS nfet_03v3 L=0.28U W=0.36U AS=0.0972P AD=0.18P
+ PS=0.9U PD=1.72U
M$5527 \$4960 \$115 VSS VSS nfet_03v3 L=0.28U W=0.36U AS=0.1584P AD=0.1188P
+ PS=1.6U PD=1.02U
M$5528 \$4961 \$4939 \$4960 VSS nfet_03v3 L=0.28U W=0.36U AS=0.1188P AD=0.1278P
+ PS=1.02U PD=1.07U
M$5529 \$5164 \$4962 \$4961 VSS nfet_03v3 L=0.28U W=0.36U AS=0.1278P AD=0.0567P
+ PS=1.07U PD=0.675U
M$5530 VSS \$4940 \$5164 VSS nfet_03v3 L=0.28U W=0.36U AS=0.0567P AD=0.1584P
+ PS=0.675U PD=1.6U
M$5531 VSS \$4961 \$4962 VSS nfet_03v3 L=0.28U W=0.36U AS=0.1584P AD=0.0972P
+ PS=1.6U PD=0.9U
M$5532 \$4963 \$4961 VSS VSS nfet_03v3 L=0.28U W=0.36U AS=0.0972P AD=0.18P
+ PS=0.9U PD=1.72U
M$5533 \$4966 \$118 VSS VSS nfet_03v3 L=0.28U W=0.36U AS=0.1584P AD=0.1188P
+ PS=1.6U PD=1.02U
M$5534 \$4967 \$4939 \$4966 VSS nfet_03v3 L=0.28U W=0.36U AS=0.1188P AD=0.1278P
+ PS=1.02U PD=1.07U
M$5535 \$5169 \$4968 \$4967 VSS nfet_03v3 L=0.28U W=0.36U AS=0.1278P AD=0.0567P
+ PS=1.07U PD=0.675U
M$5536 VSS \$4940 \$5169 VSS nfet_03v3 L=0.28U W=0.36U AS=0.0567P AD=0.1584P
+ PS=0.675U PD=1.6U
M$5537 VSS \$4967 \$4968 VSS nfet_03v3 L=0.28U W=0.36U AS=0.1584P AD=0.0972P
+ PS=1.6U PD=0.9U
M$5538 \$4969 \$4967 VSS VSS nfet_03v3 L=0.28U W=0.36U AS=0.0972P AD=0.18P
+ PS=0.9U PD=1.72U
M$5539 \$4972 \$121 VSS VSS nfet_03v3 L=0.28U W=0.36U AS=0.1584P AD=0.1188P
+ PS=1.6U PD=1.02U
M$5540 \$4973 \$4939 \$4972 VSS nfet_03v3 L=0.28U W=0.36U AS=0.1188P AD=0.1278P
+ PS=1.02U PD=1.07U
M$5541 \$5176 \$4974 \$4973 VSS nfet_03v3 L=0.28U W=0.36U AS=0.1278P AD=0.0567P
+ PS=1.07U PD=0.675U
M$5542 VSS \$4940 \$5176 VSS nfet_03v3 L=0.28U W=0.36U AS=0.0567P AD=0.1584P
+ PS=0.675U PD=1.6U
M$5543 VSS \$4973 \$4974 VSS nfet_03v3 L=0.28U W=0.36U AS=0.1584P AD=0.0972P
+ PS=1.6U PD=0.9U
M$5544 \$4975 \$4973 VSS VSS nfet_03v3 L=0.28U W=0.36U AS=0.0972P AD=0.18P
+ PS=0.9U PD=1.72U
M$5545 \$4978 \$124 VSS VSS nfet_03v3 L=0.28U W=0.36U AS=0.1584P AD=0.1188P
+ PS=1.6U PD=1.02U
M$5546 \$4979 \$4939 \$4978 VSS nfet_03v3 L=0.28U W=0.36U AS=0.1188P AD=0.1278P
+ PS=1.02U PD=1.07U
M$5547 \$5181 \$4980 \$4979 VSS nfet_03v3 L=0.28U W=0.36U AS=0.1278P AD=0.0567P
+ PS=1.07U PD=0.675U
M$5548 VSS \$4940 \$5181 VSS nfet_03v3 L=0.28U W=0.36U AS=0.0567P AD=0.1584P
+ PS=0.675U PD=1.6U
M$5549 VSS \$4979 \$4980 VSS nfet_03v3 L=0.28U W=0.36U AS=0.1584P AD=0.0972P
+ PS=1.6U PD=0.9U
M$5550 \$4981 \$4979 VSS VSS nfet_03v3 L=0.28U W=0.36U AS=0.0972P AD=0.18P
+ PS=0.9U PD=1.72U
M$5551 \$4984 \$127 VSS VSS nfet_03v3 L=0.28U W=0.36U AS=0.1584P AD=0.1188P
+ PS=1.6U PD=1.02U
M$5552 \$4985 \$4939 \$4984 VSS nfet_03v3 L=0.28U W=0.36U AS=0.1188P AD=0.1278P
+ PS=1.02U PD=1.07U
M$5553 \$5188 \$4986 \$4985 VSS nfet_03v3 L=0.28U W=0.36U AS=0.1278P AD=0.0567P
+ PS=1.07U PD=0.675U
M$5554 VSS \$4940 \$5188 VSS nfet_03v3 L=0.28U W=0.36U AS=0.0567P AD=0.1584P
+ PS=0.675U PD=1.6U
M$5555 VSS \$4985 \$4986 VSS nfet_03v3 L=0.28U W=0.36U AS=0.1584P AD=0.0972P
+ PS=1.6U PD=0.9U
M$5556 \$4987 \$4985 VSS VSS nfet_03v3 L=0.28U W=0.36U AS=0.0972P AD=0.18P
+ PS=0.9U PD=1.72U
M$5557 \$4990 \$130 VSS VSS nfet_03v3 L=0.28U W=0.36U AS=0.1584P AD=0.1188P
+ PS=1.6U PD=1.02U
M$5558 \$4991 \$4939 \$4990 VSS nfet_03v3 L=0.28U W=0.36U AS=0.1188P AD=0.1278P
+ PS=1.02U PD=1.07U
M$5559 \$5193 \$4992 \$4991 VSS nfet_03v3 L=0.28U W=0.36U AS=0.1278P AD=0.0567P
+ PS=1.07U PD=0.675U
M$5560 VSS \$4940 \$5193 VSS nfet_03v3 L=0.28U W=0.36U AS=0.0567P AD=0.1584P
+ PS=0.675U PD=1.6U
M$5561 VSS \$4991 \$4992 VSS nfet_03v3 L=0.28U W=0.36U AS=0.1584P AD=0.0972P
+ PS=1.6U PD=0.9U
M$5562 \$4993 \$4991 VSS VSS nfet_03v3 L=0.28U W=0.36U AS=0.0972P AD=0.18P
+ PS=0.9U PD=1.72U
M$5563 \$4996 \$133 VSS VSS nfet_03v3 L=0.28U W=0.36U AS=0.1584P AD=0.1188P
+ PS=1.6U PD=1.02U
M$5564 \$4997 \$4939 \$4996 VSS nfet_03v3 L=0.28U W=0.36U AS=0.1188P AD=0.1278P
+ PS=1.02U PD=1.07U
M$5565 \$5200 \$4998 \$4997 VSS nfet_03v3 L=0.28U W=0.36U AS=0.1278P AD=0.0567P
+ PS=1.07U PD=0.675U
M$5566 VSS \$4940 \$5200 VSS nfet_03v3 L=0.28U W=0.36U AS=0.0567P AD=0.1584P
+ PS=0.675U PD=1.6U
M$5567 VSS \$4997 \$4998 VSS nfet_03v3 L=0.28U W=0.36U AS=0.1584P AD=0.0972P
+ PS=1.6U PD=0.9U
M$5568 \$4999 \$4997 VSS VSS nfet_03v3 L=0.28U W=0.36U AS=0.0972P AD=0.18P
+ PS=0.9U PD=1.72U
M$5569 \$5002 \$136 VSS VSS nfet_03v3 L=0.28U W=0.36U AS=0.1584P AD=0.1188P
+ PS=1.6U PD=1.02U
M$5570 \$5003 \$4939 \$5002 VSS nfet_03v3 L=0.28U W=0.36U AS=0.1188P AD=0.1278P
+ PS=1.02U PD=1.07U
M$5571 \$5205 \$5004 \$5003 VSS nfet_03v3 L=0.28U W=0.36U AS=0.1278P AD=0.0567P
+ PS=1.07U PD=0.675U
M$5572 VSS \$4940 \$5205 VSS nfet_03v3 L=0.28U W=0.36U AS=0.0567P AD=0.1584P
+ PS=0.675U PD=1.6U
M$5573 VSS \$5003 \$5004 VSS nfet_03v3 L=0.28U W=0.36U AS=0.1584P AD=0.0972P
+ PS=1.6U PD=0.9U
M$5574 \$5005 \$5003 VSS VSS nfet_03v3 L=0.28U W=0.36U AS=0.0972P AD=0.18P
+ PS=0.9U PD=1.72U
M$5575 \$5008 \$139 VSS VSS nfet_03v3 L=0.28U W=0.36U AS=0.1584P AD=0.1188P
+ PS=1.6U PD=1.02U
M$5576 \$5009 \$4939 \$5008 VSS nfet_03v3 L=0.28U W=0.36U AS=0.1188P AD=0.1278P
+ PS=1.02U PD=1.07U
M$5577 \$5211 \$5010 \$5009 VSS nfet_03v3 L=0.28U W=0.36U AS=0.1278P AD=0.0567P
+ PS=1.07U PD=0.675U
M$5578 VSS \$4940 \$5211 VSS nfet_03v3 L=0.28U W=0.36U AS=0.0567P AD=0.1584P
+ PS=0.675U PD=1.6U
M$5579 VSS \$5009 \$5010 VSS nfet_03v3 L=0.28U W=0.36U AS=0.1584P AD=0.0972P
+ PS=1.6U PD=0.9U
M$5580 \$5011 \$5009 VSS VSS nfet_03v3 L=0.28U W=0.36U AS=0.0972P AD=0.18P
+ PS=0.9U PD=1.72U
M$5581 \$5014 \$142 VSS VSS nfet_03v3 L=0.28U W=0.36U AS=0.1584P AD=0.1188P
+ PS=1.6U PD=1.02U
M$5582 \$5015 \$4939 \$5014 VSS nfet_03v3 L=0.28U W=0.36U AS=0.1188P AD=0.1278P
+ PS=1.02U PD=1.07U
M$5583 \$5217 \$5016 \$5015 VSS nfet_03v3 L=0.28U W=0.36U AS=0.1278P AD=0.0567P
+ PS=1.07U PD=0.675U
M$5584 VSS \$4940 \$5217 VSS nfet_03v3 L=0.28U W=0.36U AS=0.0567P AD=0.1584P
+ PS=0.675U PD=1.6U
M$5585 VSS \$5015 \$5016 VSS nfet_03v3 L=0.28U W=0.36U AS=0.1584P AD=0.0972P
+ PS=1.6U PD=0.9U
M$5586 \$5017 \$5015 VSS VSS nfet_03v3 L=0.28U W=0.36U AS=0.0972P AD=0.18P
+ PS=0.9U PD=1.72U
M$5587 \$5020 \$145 VSS VSS nfet_03v3 L=0.28U W=0.36U AS=0.1584P AD=0.1188P
+ PS=1.6U PD=1.02U
M$5588 \$5021 \$4939 \$5020 VSS nfet_03v3 L=0.28U W=0.36U AS=0.1188P AD=0.1278P
+ PS=1.02U PD=1.07U
M$5589 \$5223 \$5022 \$5021 VSS nfet_03v3 L=0.28U W=0.36U AS=0.1278P AD=0.0567P
+ PS=1.07U PD=0.675U
M$5590 VSS \$4940 \$5223 VSS nfet_03v3 L=0.28U W=0.36U AS=0.0567P AD=0.1584P
+ PS=0.675U PD=1.6U
M$5591 VSS \$5021 \$5022 VSS nfet_03v3 L=0.28U W=0.36U AS=0.1584P AD=0.0972P
+ PS=1.6U PD=0.9U
M$5592 \$5023 \$5021 VSS VSS nfet_03v3 L=0.28U W=0.36U AS=0.0972P AD=0.18P
+ PS=0.9U PD=1.72U
M$5593 \$5026 \$148 VSS VSS nfet_03v3 L=0.28U W=0.36U AS=0.1584P AD=0.1188P
+ PS=1.6U PD=1.02U
M$5594 \$5027 \$4939 \$5026 VSS nfet_03v3 L=0.28U W=0.36U AS=0.1188P AD=0.1278P
+ PS=1.02U PD=1.07U
M$5595 \$5229 \$5028 \$5027 VSS nfet_03v3 L=0.28U W=0.36U AS=0.1278P AD=0.0567P
+ PS=1.07U PD=0.675U
M$5596 VSS \$4940 \$5229 VSS nfet_03v3 L=0.28U W=0.36U AS=0.0567P AD=0.1584P
+ PS=0.675U PD=1.6U
M$5597 VSS \$5027 \$5028 VSS nfet_03v3 L=0.28U W=0.36U AS=0.1584P AD=0.0972P
+ PS=1.6U PD=0.9U
M$5598 \$5029 \$5027 VSS VSS nfet_03v3 L=0.28U W=0.36U AS=0.0972P AD=0.18P
+ PS=0.9U PD=1.72U
M$5599 \$5032 \$151 VSS VSS nfet_03v3 L=0.28U W=0.36U AS=0.1584P AD=0.1188P
+ PS=1.6U PD=1.02U
M$5600 \$5033 \$4939 \$5032 VSS nfet_03v3 L=0.28U W=0.36U AS=0.1188P AD=0.1278P
+ PS=1.02U PD=1.07U
M$5601 \$5235 \$5034 \$5033 VSS nfet_03v3 L=0.28U W=0.36U AS=0.1278P AD=0.0567P
+ PS=1.07U PD=0.675U
M$5602 VSS \$4940 \$5235 VSS nfet_03v3 L=0.28U W=0.36U AS=0.0567P AD=0.1584P
+ PS=0.675U PD=1.6U
M$5603 VSS \$5033 \$5034 VSS nfet_03v3 L=0.28U W=0.36U AS=0.1584P AD=0.0972P
+ PS=1.6U PD=0.9U
M$5604 \$5035 \$5033 VSS VSS nfet_03v3 L=0.28U W=0.36U AS=0.0972P AD=0.18P
+ PS=0.9U PD=1.72U
.ENDS rf
