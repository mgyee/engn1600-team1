* Extracted by KLayout with GF180MCU LVS runset on : 26/02/2026 21:00

.SUBCKT rf VSS QB0 QB1 QB4 QB7 QB9 QB10 QB12 QB13 QB14 QB15 VDD QA0 QA1 QA2 QB2
+ QA3 QB3 QA4 QA5 QB5 QA6 QB6 QA7 QA8 QB8 QA9 QA10 QA11 QB11 QA12 QA13 QA14
+ QA15 WEM D0 D1 D2 D3 D4 D5 D6 D7 D8 D9 D10 D11 D12 D13 D14 D15 WE15 CLK RB15
+ RA15 WE14 RB14 RA14 WE13 RB13 RA13 WE12 RA12 RB12 RB11 WE11 RA11 WE10 RA10
+ RB10 RB9 WE9 RA9 WE8 RA8 RB8 RB7 WE7 RA7 WE6 RA6 RB6 RB5 WE5 RA5 WE4 RA4 RB4
+ RB3 WE3 RA3 WE2 RA2 RB2 RB1 WE1 RA1 WE0 RA0 RB0
M$1 VDD \$51 QA0 VDD pfet_03v3 L=0.28U W=0.72U AS=0.4104P AD=0.2484P PS=2.58U
+ PD=1.41U
M$2 QB0 \$52 VDD VDD pfet_03v3 L=0.28U W=0.72U AS=0.2484P AD=0.4104P PS=1.41U
+ PD=2.58U
M$3 VDD \$53 QA1 VDD pfet_03v3 L=0.28U W=0.72U AS=0.4104P AD=0.2484P PS=2.58U
+ PD=1.41U
M$4 QB1 \$54 VDD VDD pfet_03v3 L=0.28U W=0.72U AS=0.2484P AD=0.4104P PS=1.41U
+ PD=2.58U
M$5 VDD \$55 QA2 VDD pfet_03v3 L=0.28U W=0.72U AS=0.4104P AD=0.2484P PS=2.58U
+ PD=1.41U
M$6 QB2 \$56 VDD VDD pfet_03v3 L=0.28U W=0.72U AS=0.2484P AD=0.4104P PS=1.41U
+ PD=2.58U
M$7 VDD \$57 QA3 VDD pfet_03v3 L=0.28U W=0.72U AS=0.4104P AD=0.2484P PS=2.58U
+ PD=1.41U
M$8 QB3 \$58 VDD VDD pfet_03v3 L=0.28U W=0.72U AS=0.2484P AD=0.4104P PS=1.41U
+ PD=2.58U
M$9 VDD \$59 QA4 VDD pfet_03v3 L=0.28U W=0.72U AS=0.4104P AD=0.2484P PS=2.58U
+ PD=1.41U
M$10 QB4 \$60 VDD VDD pfet_03v3 L=0.28U W=0.72U AS=0.2484P AD=0.4104P PS=1.41U
+ PD=2.58U
M$11 VDD \$61 QA5 VDD pfet_03v3 L=0.28U W=0.72U AS=0.4104P AD=0.2484P PS=2.58U
+ PD=1.41U
M$12 QB5 \$62 VDD VDD pfet_03v3 L=0.28U W=0.72U AS=0.2484P AD=0.4104P PS=1.41U
+ PD=2.58U
M$13 VDD \$63 QA6 VDD pfet_03v3 L=0.28U W=0.72U AS=0.4104P AD=0.2484P PS=2.58U
+ PD=1.41U
M$14 QB6 \$64 VDD VDD pfet_03v3 L=0.28U W=0.72U AS=0.2484P AD=0.4104P PS=1.41U
+ PD=2.58U
M$15 VDD \$65 QA7 VDD pfet_03v3 L=0.28U W=0.72U AS=0.4104P AD=0.2484P PS=2.58U
+ PD=1.41U
M$16 QB7 \$66 VDD VDD pfet_03v3 L=0.28U W=0.72U AS=0.2484P AD=0.4104P PS=1.41U
+ PD=2.58U
M$17 VDD \$67 QA8 VDD pfet_03v3 L=0.28U W=0.72U AS=0.4104P AD=0.2484P PS=2.58U
+ PD=1.41U
M$18 QB8 \$68 VDD VDD pfet_03v3 L=0.28U W=0.72U AS=0.2484P AD=0.4104P PS=1.41U
+ PD=2.58U
M$19 VDD \$69 QA9 VDD pfet_03v3 L=0.28U W=0.72U AS=0.4104P AD=0.2484P PS=2.58U
+ PD=1.41U
M$20 QB9 \$70 VDD VDD pfet_03v3 L=0.28U W=0.72U AS=0.2484P AD=0.4104P PS=1.41U
+ PD=2.58U
M$21 VDD \$71 QA10 VDD pfet_03v3 L=0.28U W=0.72U AS=0.4104P AD=0.2484P PS=2.58U
+ PD=1.41U
M$22 QB10 \$72 VDD VDD pfet_03v3 L=0.28U W=0.72U AS=0.2484P AD=0.4104P PS=1.41U
+ PD=2.58U
M$23 VDD \$73 QA11 VDD pfet_03v3 L=0.28U W=0.72U AS=0.4104P AD=0.2484P PS=2.58U
+ PD=1.41U
M$24 QB11 \$74 VDD VDD pfet_03v3 L=0.28U W=0.72U AS=0.2484P AD=0.4104P PS=1.41U
+ PD=2.58U
M$25 VDD \$75 QA12 VDD pfet_03v3 L=0.28U W=0.72U AS=0.4104P AD=0.2484P PS=2.58U
+ PD=1.41U
M$26 QB12 \$76 VDD VDD pfet_03v3 L=0.28U W=0.72U AS=0.2484P AD=0.4104P PS=1.41U
+ PD=2.58U
M$27 VDD \$77 QA13 VDD pfet_03v3 L=0.28U W=0.72U AS=0.4104P AD=0.2484P PS=2.58U
+ PD=1.41U
M$28 QB13 \$78 VDD VDD pfet_03v3 L=0.28U W=0.72U AS=0.2484P AD=0.4104P PS=1.41U
+ PD=2.58U
M$29 VDD \$79 QA14 VDD pfet_03v3 L=0.28U W=0.72U AS=0.4104P AD=0.2484P PS=2.58U
+ PD=1.41U
M$30 QB14 \$80 VDD VDD pfet_03v3 L=0.28U W=0.72U AS=0.2484P AD=0.4104P PS=1.41U
+ PD=2.58U
M$31 VDD \$81 QA15 VDD pfet_03v3 L=0.28U W=0.72U AS=0.4104P AD=0.2484P PS=2.58U
+ PD=1.41U
M$32 QB15 \$82 VDD VDD pfet_03v3 L=0.28U W=0.72U AS=0.2484P AD=0.4104P PS=1.41U
+ PD=2.58U
M$33 \$105 WEM VDD VDD pfet_03v3 L=0.28U W=1.26U AS=0.5544P AD=0.3654P PS=3.4U
+ PD=1.84U
M$34 VDD WEM \$105 VDD pfet_03v3 L=0.28U W=1.26U AS=0.3654P AD=0.5544P PS=1.84U
+ PD=3.4U
M$35 \$106 \$220 VDD VDD pfet_03v3 L=0.28U W=1.24U AS=0.5456P AD=0.3224P
+ PS=3.36U PD=1.76U
M$36 VDD \$220 \$106 VDD pfet_03v3 L=0.28U W=1.24U AS=0.3224P AD=0.5456P
+ PS=1.76U PD=3.36U
M$37 \$107 \$220 VDD VDD pfet_03v3 L=0.28U W=0.36U AS=0.1584P AD=0.1584P
+ PS=1.6U PD=1.6U
M$38 \$158 WEM VDD VDD pfet_03v3 L=0.28U W=0.36U AS=0.1584P AD=0.0567P PS=1.6U
+ PD=0.675U
M$39 \$220 \$107 \$158 VDD pfet_03v3 L=0.28U W=0.36U AS=0.0567P AD=0.1278P
+ PS=0.675U PD=1.07U
M$40 \$108 \$105 \$220 VDD pfet_03v3 L=0.28U W=0.36U AS=0.1278P AD=0.2097P
+ PS=1.07U PD=1.38U
M$41 VDD D0 \$108 VDD pfet_03v3 L=0.28U W=0.72U AS=0.2097P AD=0.3168P PS=1.38U
+ PD=2.32U
M$42 \$109 \$222 VDD VDD pfet_03v3 L=0.28U W=1.24U AS=0.5456P AD=0.3224P
+ PS=3.36U PD=1.76U
M$43 VDD \$222 \$109 VDD pfet_03v3 L=0.28U W=1.24U AS=0.3224P AD=0.5456P
+ PS=1.76U PD=3.36U
M$44 \$110 \$222 VDD VDD pfet_03v3 L=0.28U W=0.36U AS=0.1584P AD=0.1584P
+ PS=1.6U PD=1.6U
M$45 \$163 WEM VDD VDD pfet_03v3 L=0.28U W=0.36U AS=0.1584P AD=0.0567P PS=1.6U
+ PD=0.675U
M$46 \$222 \$110 \$163 VDD pfet_03v3 L=0.28U W=0.36U AS=0.0567P AD=0.1278P
+ PS=0.675U PD=1.07U
M$47 \$111 \$105 \$222 VDD pfet_03v3 L=0.28U W=0.36U AS=0.1278P AD=0.2097P
+ PS=1.07U PD=1.38U
M$48 VDD D1 \$111 VDD pfet_03v3 L=0.28U W=0.72U AS=0.2097P AD=0.3168P PS=1.38U
+ PD=2.32U
M$49 \$112 \$224 VDD VDD pfet_03v3 L=0.28U W=1.24U AS=0.5456P AD=0.3224P
+ PS=3.36U PD=1.76U
M$50 VDD \$224 \$112 VDD pfet_03v3 L=0.28U W=1.24U AS=0.3224P AD=0.5456P
+ PS=1.76U PD=3.36U
M$51 \$113 \$224 VDD VDD pfet_03v3 L=0.28U W=0.36U AS=0.1584P AD=0.1584P
+ PS=1.6U PD=1.6U
M$52 \$169 WEM VDD VDD pfet_03v3 L=0.28U W=0.36U AS=0.1584P AD=0.0567P PS=1.6U
+ PD=0.675U
M$53 \$224 \$113 \$169 VDD pfet_03v3 L=0.28U W=0.36U AS=0.0567P AD=0.1278P
+ PS=0.675U PD=1.07U
M$54 \$114 \$105 \$224 VDD pfet_03v3 L=0.28U W=0.36U AS=0.1278P AD=0.2097P
+ PS=1.07U PD=1.38U
M$55 VDD D2 \$114 VDD pfet_03v3 L=0.28U W=0.72U AS=0.2097P AD=0.3168P PS=1.38U
+ PD=2.32U
M$56 \$115 \$226 VDD VDD pfet_03v3 L=0.28U W=1.24U AS=0.5456P AD=0.3224P
+ PS=3.36U PD=1.76U
M$57 VDD \$226 \$115 VDD pfet_03v3 L=0.28U W=1.24U AS=0.3224P AD=0.5456P
+ PS=1.76U PD=3.36U
M$58 \$116 \$226 VDD VDD pfet_03v3 L=0.28U W=0.36U AS=0.1584P AD=0.1584P
+ PS=1.6U PD=1.6U
M$59 \$175 WEM VDD VDD pfet_03v3 L=0.28U W=0.36U AS=0.1584P AD=0.0567P PS=1.6U
+ PD=0.675U
M$60 \$226 \$116 \$175 VDD pfet_03v3 L=0.28U W=0.36U AS=0.0567P AD=0.1278P
+ PS=0.675U PD=1.07U
M$61 \$117 \$105 \$226 VDD pfet_03v3 L=0.28U W=0.36U AS=0.1278P AD=0.2097P
+ PS=1.07U PD=1.38U
M$62 VDD D3 \$117 VDD pfet_03v3 L=0.28U W=0.72U AS=0.2097P AD=0.3168P PS=1.38U
+ PD=2.32U
M$63 \$118 \$228 VDD VDD pfet_03v3 L=0.28U W=1.24U AS=0.5456P AD=0.3224P
+ PS=3.36U PD=1.76U
M$64 VDD \$228 \$118 VDD pfet_03v3 L=0.28U W=1.24U AS=0.3224P AD=0.5456P
+ PS=1.76U PD=3.36U
M$65 \$119 \$228 VDD VDD pfet_03v3 L=0.28U W=0.36U AS=0.1584P AD=0.1584P
+ PS=1.6U PD=1.6U
M$66 \$181 WEM VDD VDD pfet_03v3 L=0.28U W=0.36U AS=0.1584P AD=0.0567P PS=1.6U
+ PD=0.675U
M$67 \$228 \$119 \$181 VDD pfet_03v3 L=0.28U W=0.36U AS=0.0567P AD=0.1278P
+ PS=0.675U PD=1.07U
M$68 \$120 \$105 \$228 VDD pfet_03v3 L=0.28U W=0.36U AS=0.1278P AD=0.2097P
+ PS=1.07U PD=1.38U
M$69 VDD D4 \$120 VDD pfet_03v3 L=0.28U W=0.72U AS=0.2097P AD=0.3168P PS=1.38U
+ PD=2.32U
M$70 \$121 \$230 VDD VDD pfet_03v3 L=0.28U W=1.24U AS=0.5456P AD=0.3224P
+ PS=3.36U PD=1.76U
M$71 VDD \$230 \$121 VDD pfet_03v3 L=0.28U W=1.24U AS=0.3224P AD=0.5456P
+ PS=1.76U PD=3.36U
M$72 \$122 \$230 VDD VDD pfet_03v3 L=0.28U W=0.36U AS=0.1584P AD=0.1584P
+ PS=1.6U PD=1.6U
M$73 \$186 WEM VDD VDD pfet_03v3 L=0.28U W=0.36U AS=0.1584P AD=0.0567P PS=1.6U
+ PD=0.675U
M$74 \$230 \$122 \$186 VDD pfet_03v3 L=0.28U W=0.36U AS=0.0567P AD=0.1278P
+ PS=0.675U PD=1.07U
M$75 \$123 \$105 \$230 VDD pfet_03v3 L=0.28U W=0.36U AS=0.1278P AD=0.2097P
+ PS=1.07U PD=1.38U
M$76 VDD D5 \$123 VDD pfet_03v3 L=0.28U W=0.72U AS=0.2097P AD=0.3168P PS=1.38U
+ PD=2.32U
M$77 \$124 \$232 VDD VDD pfet_03v3 L=0.28U W=1.24U AS=0.5456P AD=0.3224P
+ PS=3.36U PD=1.76U
M$78 VDD \$232 \$124 VDD pfet_03v3 L=0.28U W=1.24U AS=0.3224P AD=0.5456P
+ PS=1.76U PD=3.36U
M$79 \$125 \$232 VDD VDD pfet_03v3 L=0.28U W=0.36U AS=0.1584P AD=0.1584P
+ PS=1.6U PD=1.6U
M$80 \$192 WEM VDD VDD pfet_03v3 L=0.28U W=0.36U AS=0.1584P AD=0.0567P PS=1.6U
+ PD=0.675U
M$81 \$232 \$125 \$192 VDD pfet_03v3 L=0.28U W=0.36U AS=0.0567P AD=0.1278P
+ PS=0.675U PD=1.07U
M$82 \$126 \$105 \$232 VDD pfet_03v3 L=0.28U W=0.36U AS=0.1278P AD=0.2097P
+ PS=1.07U PD=1.38U
M$83 VDD D6 \$126 VDD pfet_03v3 L=0.28U W=0.72U AS=0.2097P AD=0.3168P PS=1.38U
+ PD=2.32U
M$84 \$127 \$234 VDD VDD pfet_03v3 L=0.28U W=1.24U AS=0.5456P AD=0.3224P
+ PS=3.36U PD=1.76U
M$85 VDD \$234 \$127 VDD pfet_03v3 L=0.28U W=1.24U AS=0.3224P AD=0.5456P
+ PS=1.76U PD=3.36U
M$86 \$128 \$234 VDD VDD pfet_03v3 L=0.28U W=0.36U AS=0.1584P AD=0.1584P
+ PS=1.6U PD=1.6U
M$87 \$198 WEM VDD VDD pfet_03v3 L=0.28U W=0.36U AS=0.1584P AD=0.0567P PS=1.6U
+ PD=0.675U
M$88 \$234 \$128 \$198 VDD pfet_03v3 L=0.28U W=0.36U AS=0.0567P AD=0.1278P
+ PS=0.675U PD=1.07U
M$89 \$129 \$105 \$234 VDD pfet_03v3 L=0.28U W=0.36U AS=0.1278P AD=0.2097P
+ PS=1.07U PD=1.38U
M$90 VDD D7 \$129 VDD pfet_03v3 L=0.28U W=0.72U AS=0.2097P AD=0.3168P PS=1.38U
+ PD=2.32U
M$91 \$130 \$236 VDD VDD pfet_03v3 L=0.28U W=1.24U AS=0.5456P AD=0.3224P
+ PS=3.36U PD=1.76U
M$92 VDD \$236 \$130 VDD pfet_03v3 L=0.28U W=1.24U AS=0.3224P AD=0.5456P
+ PS=1.76U PD=3.36U
M$93 \$131 \$236 VDD VDD pfet_03v3 L=0.28U W=0.36U AS=0.1584P AD=0.1584P
+ PS=1.6U PD=1.6U
M$94 \$204 WEM VDD VDD pfet_03v3 L=0.28U W=0.36U AS=0.1584P AD=0.0567P PS=1.6U
+ PD=0.675U
M$95 \$236 \$131 \$204 VDD pfet_03v3 L=0.28U W=0.36U AS=0.0567P AD=0.1278P
+ PS=0.675U PD=1.07U
M$96 \$132 \$105 \$236 VDD pfet_03v3 L=0.28U W=0.36U AS=0.1278P AD=0.2097P
+ PS=1.07U PD=1.38U
M$97 VDD D8 \$132 VDD pfet_03v3 L=0.28U W=0.72U AS=0.2097P AD=0.3168P PS=1.38U
+ PD=2.32U
M$98 \$133 \$238 VDD VDD pfet_03v3 L=0.28U W=1.24U AS=0.5456P AD=0.3224P
+ PS=3.36U PD=1.76U
M$99 VDD \$238 \$133 VDD pfet_03v3 L=0.28U W=1.24U AS=0.3224P AD=0.5456P
+ PS=1.76U PD=3.36U
M$100 \$134 \$238 VDD VDD pfet_03v3 L=0.28U W=0.36U AS=0.1584P AD=0.1584P
+ PS=1.6U PD=1.6U
M$101 \$209 WEM VDD VDD pfet_03v3 L=0.28U W=0.36U AS=0.1584P AD=0.0567P PS=1.6U
+ PD=0.675U
M$102 \$238 \$134 \$209 VDD pfet_03v3 L=0.28U W=0.36U AS=0.0567P AD=0.1278P
+ PS=0.675U PD=1.07U
M$103 \$135 \$105 \$238 VDD pfet_03v3 L=0.28U W=0.36U AS=0.1278P AD=0.2097P
+ PS=1.07U PD=1.38U
M$104 VDD D9 \$135 VDD pfet_03v3 L=0.28U W=0.72U AS=0.2097P AD=0.3168P PS=1.38U
+ PD=2.32U
M$105 \$136 \$240 VDD VDD pfet_03v3 L=0.28U W=1.24U AS=0.5456P AD=0.3224P
+ PS=3.36U PD=1.76U
M$106 VDD \$240 \$136 VDD pfet_03v3 L=0.28U W=1.24U AS=0.3224P AD=0.5456P
+ PS=1.76U PD=3.36U
M$107 \$137 \$240 VDD VDD pfet_03v3 L=0.28U W=0.36U AS=0.1584P AD=0.1584P
+ PS=1.6U PD=1.6U
M$108 \$215 WEM VDD VDD pfet_03v3 L=0.28U W=0.36U AS=0.1584P AD=0.0567P PS=1.6U
+ PD=0.675U
M$109 \$240 \$137 \$215 VDD pfet_03v3 L=0.28U W=0.36U AS=0.0567P AD=0.1278P
+ PS=0.675U PD=1.07U
M$110 \$138 \$105 \$240 VDD pfet_03v3 L=0.28U W=0.36U AS=0.1278P AD=0.2097P
+ PS=1.07U PD=1.38U
M$111 VDD D10 \$138 VDD pfet_03v3 L=0.28U W=0.72U AS=0.2097P AD=0.3168P
+ PS=1.38U PD=2.32U
M$112 \$139 \$242 VDD VDD pfet_03v3 L=0.28U W=1.24U AS=0.5456P AD=0.3224P
+ PS=3.36U PD=1.76U
M$113 VDD \$242 \$139 VDD pfet_03v3 L=0.28U W=1.24U AS=0.3224P AD=0.5456P
+ PS=1.76U PD=3.36U
M$114 \$140 \$242 VDD VDD pfet_03v3 L=0.28U W=0.36U AS=0.1584P AD=0.1584P
+ PS=1.6U PD=1.6U
M$115 \$212 WEM VDD VDD pfet_03v3 L=0.28U W=0.36U AS=0.1584P AD=0.0567P PS=1.6U
+ PD=0.675U
M$116 \$242 \$140 \$212 VDD pfet_03v3 L=0.28U W=0.36U AS=0.0567P AD=0.1278P
+ PS=0.675U PD=1.07U
M$117 \$141 \$105 \$242 VDD pfet_03v3 L=0.28U W=0.36U AS=0.1278P AD=0.2097P
+ PS=1.07U PD=1.38U
M$118 VDD D11 \$141 VDD pfet_03v3 L=0.28U W=0.72U AS=0.2097P AD=0.3168P
+ PS=1.38U PD=2.32U
M$119 \$142 \$244 VDD VDD pfet_03v3 L=0.28U W=1.24U AS=0.5456P AD=0.3224P
+ PS=3.36U PD=1.76U
M$120 VDD \$244 \$142 VDD pfet_03v3 L=0.28U W=1.24U AS=0.3224P AD=0.5456P
+ PS=1.76U PD=3.36U
M$121 \$143 \$244 VDD VDD pfet_03v3 L=0.28U W=0.36U AS=0.1584P AD=0.1584P
+ PS=1.6U PD=1.6U
M$122 \$200 WEM VDD VDD pfet_03v3 L=0.28U W=0.36U AS=0.1584P AD=0.0567P PS=1.6U
+ PD=0.675U
M$123 \$244 \$143 \$200 VDD pfet_03v3 L=0.28U W=0.36U AS=0.0567P AD=0.1278P
+ PS=0.675U PD=1.07U
M$124 \$144 \$105 \$244 VDD pfet_03v3 L=0.28U W=0.36U AS=0.1278P AD=0.2097P
+ PS=1.07U PD=1.38U
M$125 VDD D12 \$144 VDD pfet_03v3 L=0.28U W=0.72U AS=0.2097P AD=0.3168P
+ PS=1.38U PD=2.32U
M$126 \$145 \$246 VDD VDD pfet_03v3 L=0.28U W=1.24U AS=0.5456P AD=0.3224P
+ PS=3.36U PD=1.76U
M$127 VDD \$246 \$145 VDD pfet_03v3 L=0.28U W=1.24U AS=0.3224P AD=0.5456P
+ PS=1.76U PD=3.36U
M$128 \$146 \$246 VDD VDD pfet_03v3 L=0.28U W=0.36U AS=0.1584P AD=0.1584P
+ PS=1.6U PD=1.6U
M$129 \$188 WEM VDD VDD pfet_03v3 L=0.28U W=0.36U AS=0.1584P AD=0.0567P PS=1.6U
+ PD=0.675U
M$130 \$246 \$146 \$188 VDD pfet_03v3 L=0.28U W=0.36U AS=0.0567P AD=0.1278P
+ PS=0.675U PD=1.07U
M$131 \$147 \$105 \$246 VDD pfet_03v3 L=0.28U W=0.36U AS=0.1278P AD=0.2097P
+ PS=1.07U PD=1.38U
M$132 VDD D13 \$147 VDD pfet_03v3 L=0.28U W=0.72U AS=0.2097P AD=0.3168P
+ PS=1.38U PD=2.32U
M$133 \$148 \$248 VDD VDD pfet_03v3 L=0.28U W=1.24U AS=0.5456P AD=0.3224P
+ PS=3.36U PD=1.76U
M$134 VDD \$248 \$148 VDD pfet_03v3 L=0.28U W=1.24U AS=0.3224P AD=0.5456P
+ PS=1.76U PD=3.36U
M$135 \$149 \$248 VDD VDD pfet_03v3 L=0.28U W=0.36U AS=0.1584P AD=0.1584P
+ PS=1.6U PD=1.6U
M$136 \$173 WEM VDD VDD pfet_03v3 L=0.28U W=0.36U AS=0.1584P AD=0.0567P PS=1.6U
+ PD=0.675U
M$137 \$248 \$149 \$173 VDD pfet_03v3 L=0.28U W=0.36U AS=0.0567P AD=0.1278P
+ PS=0.675U PD=1.07U
M$138 \$150 \$105 \$248 VDD pfet_03v3 L=0.28U W=0.36U AS=0.1278P AD=0.2097P
+ PS=1.07U PD=1.38U
M$139 VDD D14 \$150 VDD pfet_03v3 L=0.28U W=0.72U AS=0.2097P AD=0.3168P
+ PS=1.38U PD=2.32U
M$140 \$151 \$250 VDD VDD pfet_03v3 L=0.28U W=1.24U AS=0.5456P AD=0.3224P
+ PS=3.36U PD=1.76U
M$141 VDD \$250 \$151 VDD pfet_03v3 L=0.28U W=1.24U AS=0.3224P AD=0.5456P
+ PS=1.76U PD=3.36U
M$142 \$152 \$250 VDD VDD pfet_03v3 L=0.28U W=0.36U AS=0.1584P AD=0.1584P
+ PS=1.6U PD=1.6U
M$143 \$160 WEM VDD VDD pfet_03v3 L=0.28U W=0.36U AS=0.1584P AD=0.0567P PS=1.6U
+ PD=0.675U
M$144 \$250 \$152 \$160 VDD pfet_03v3 L=0.28U W=0.36U AS=0.0567P AD=0.1278P
+ PS=0.675U PD=1.07U
M$145 \$153 \$105 \$250 VDD pfet_03v3 L=0.28U W=0.36U AS=0.1278P AD=0.2097P
+ PS=1.07U PD=1.38U
M$146 VDD D15 \$153 VDD pfet_03v3 L=0.28U W=0.72U AS=0.2097P AD=0.3168P
+ PS=1.38U PD=2.32U
M$147 \$254 WE15 VDD VDD pfet_03v3 L=0.28U W=0.72U AS=0.3168P AD=0.1872P
+ PS=2.32U PD=1.24U
M$148 VDD CLK \$254 VDD pfet_03v3 L=0.28U W=0.72U AS=0.1872P AD=0.3168P
+ PS=1.24U PD=2.32U
M$149 \$255 \$254 VDD VDD pfet_03v3 L=0.28U W=1.27U AS=0.5588P AD=0.3302P
+ PS=3.42U PD=1.79U
M$150 \$255 \$254 VDD VDD pfet_03v3 L=0.28U W=1.27U AS=0.3386P AD=0.3302P
+ PS=1.86U PD=1.79U
M$151 \$523 \$255 VDD VDD pfet_03v3 L=0.28U W=1.34U AS=0.3386P AD=0.3886P
+ PS=1.86U PD=1.92U
M$152 VDD \$255 \$523 VDD pfet_03v3 L=0.28U W=1.34U AS=0.3886P AD=0.5896P
+ PS=1.92U PD=3.56U
M$153 \$256 \$106 VDD VDD pfet_03v3 L=0.28U W=0.72U AS=0.3168P AD=0.2097P
+ PS=2.32U PD=1.38U
M$154 \$257 \$523 \$256 VDD pfet_03v3 L=0.28U W=0.36U AS=0.2097P AD=0.1278P
+ PS=1.38U PD=1.07U
M$155 \$531 \$258 \$257 VDD pfet_03v3 L=0.28U W=0.36U AS=0.1278P AD=0.0567P
+ PS=1.07U PD=0.675U
M$156 VDD \$255 \$531 VDD pfet_03v3 L=0.28U W=0.36U AS=0.0567P AD=0.1584P
+ PS=0.675U PD=1.6U
M$157 \$258 \$257 VDD VDD pfet_03v3 L=0.28U W=0.36U AS=0.1764P AD=0.1584P
+ PS=1.26U PD=1.6U
M$158 \$259 \$257 VDD VDD pfet_03v3 L=0.28U W=0.72U AS=0.1764P AD=0.36P
+ PS=1.26U PD=2.44U
M$159 \$385 RA15 VDD VDD pfet_03v3 L=0.28U W=0.72U AS=0.3312P AD=0.3888P
+ PS=2.36U PD=2.52U
M$160 \$259 \$385 \$51 VDD pfet_03v3 L=0.28U W=0.36U AS=0.1584P AD=0.1152P
+ PS=1.6U PD=1U
M$161 \$52 \$386 \$259 VDD pfet_03v3 L=0.28U W=0.36U AS=0.1152P AD=0.1584P
+ PS=1U PD=1.6U
M$162 VDD RB15 \$386 VDD pfet_03v3 L=0.28U W=0.72U AS=0.3708P AD=0.3168P
+ PS=2.47U PD=2.32U
M$163 \$260 \$109 VDD VDD pfet_03v3 L=0.28U W=0.72U AS=0.3168P AD=0.2097P
+ PS=2.32U PD=1.38U
M$164 \$261 \$523 \$260 VDD pfet_03v3 L=0.28U W=0.36U AS=0.2097P AD=0.1278P
+ PS=1.38U PD=1.07U
M$165 \$541 \$262 \$261 VDD pfet_03v3 L=0.28U W=0.36U AS=0.1278P AD=0.0567P
+ PS=1.07U PD=0.675U
M$166 VDD \$255 \$541 VDD pfet_03v3 L=0.28U W=0.36U AS=0.0567P AD=0.1584P
+ PS=0.675U PD=1.6U
M$167 \$262 \$261 VDD VDD pfet_03v3 L=0.28U W=0.36U AS=0.1764P AD=0.1584P
+ PS=1.26U PD=1.6U
M$168 \$263 \$261 VDD VDD pfet_03v3 L=0.28U W=0.72U AS=0.1764P AD=0.36P
+ PS=1.26U PD=2.44U
M$169 \$387 RA15 VDD VDD pfet_03v3 L=0.28U W=0.72U AS=0.3312P AD=0.3888P
+ PS=2.36U PD=2.52U
M$170 \$263 \$387 \$53 VDD pfet_03v3 L=0.28U W=0.36U AS=0.1584P AD=0.1152P
+ PS=1.6U PD=1U
M$171 \$54 \$388 \$263 VDD pfet_03v3 L=0.28U W=0.36U AS=0.1152P AD=0.1584P
+ PS=1U PD=1.6U
M$172 VDD RB15 \$388 VDD pfet_03v3 L=0.28U W=0.72U AS=0.3708P AD=0.3168P
+ PS=2.47U PD=2.32U
M$173 \$264 \$112 VDD VDD pfet_03v3 L=0.28U W=0.72U AS=0.3168P AD=0.2097P
+ PS=2.32U PD=1.38U
M$174 \$265 \$523 \$264 VDD pfet_03v3 L=0.28U W=0.36U AS=0.2097P AD=0.1278P
+ PS=1.38U PD=1.07U
M$175 \$550 \$266 \$265 VDD pfet_03v3 L=0.28U W=0.36U AS=0.1278P AD=0.0567P
+ PS=1.07U PD=0.675U
M$176 VDD \$255 \$550 VDD pfet_03v3 L=0.28U W=0.36U AS=0.0567P AD=0.1584P
+ PS=0.675U PD=1.6U
M$177 \$266 \$265 VDD VDD pfet_03v3 L=0.28U W=0.36U AS=0.1764P AD=0.1584P
+ PS=1.26U PD=1.6U
M$178 \$267 \$265 VDD VDD pfet_03v3 L=0.28U W=0.72U AS=0.1764P AD=0.36P
+ PS=1.26U PD=2.44U
M$179 \$389 RA15 VDD VDD pfet_03v3 L=0.28U W=0.72U AS=0.3312P AD=0.3888P
+ PS=2.36U PD=2.52U
M$180 \$267 \$389 \$55 VDD pfet_03v3 L=0.28U W=0.36U AS=0.1584P AD=0.1152P
+ PS=1.6U PD=1U
M$181 \$56 \$390 \$267 VDD pfet_03v3 L=0.28U W=0.36U AS=0.1152P AD=0.1584P
+ PS=1U PD=1.6U
M$182 VDD RB15 \$390 VDD pfet_03v3 L=0.28U W=0.72U AS=0.3708P AD=0.3168P
+ PS=2.47U PD=2.32U
M$183 \$268 \$115 VDD VDD pfet_03v3 L=0.28U W=0.72U AS=0.3168P AD=0.2097P
+ PS=2.32U PD=1.38U
M$184 \$269 \$523 \$268 VDD pfet_03v3 L=0.28U W=0.36U AS=0.2097P AD=0.1278P
+ PS=1.38U PD=1.07U
M$185 \$561 \$270 \$269 VDD pfet_03v3 L=0.28U W=0.36U AS=0.1278P AD=0.0567P
+ PS=1.07U PD=0.675U
M$186 VDD \$255 \$561 VDD pfet_03v3 L=0.28U W=0.36U AS=0.0567P AD=0.1584P
+ PS=0.675U PD=1.6U
M$187 \$270 \$269 VDD VDD pfet_03v3 L=0.28U W=0.36U AS=0.1764P AD=0.1584P
+ PS=1.26U PD=1.6U
M$188 \$271 \$269 VDD VDD pfet_03v3 L=0.28U W=0.72U AS=0.1764P AD=0.36P
+ PS=1.26U PD=2.44U
M$189 \$391 RA15 VDD VDD pfet_03v3 L=0.28U W=0.72U AS=0.3312P AD=0.3888P
+ PS=2.36U PD=2.52U
M$190 \$271 \$391 \$57 VDD pfet_03v3 L=0.28U W=0.36U AS=0.1584P AD=0.1152P
+ PS=1.6U PD=1U
M$191 \$58 \$392 \$271 VDD pfet_03v3 L=0.28U W=0.36U AS=0.1152P AD=0.1584P
+ PS=1U PD=1.6U
M$192 VDD RB15 \$392 VDD pfet_03v3 L=0.28U W=0.72U AS=0.3708P AD=0.3168P
+ PS=2.47U PD=2.32U
M$193 \$272 \$118 VDD VDD pfet_03v3 L=0.28U W=0.72U AS=0.3168P AD=0.2097P
+ PS=2.32U PD=1.38U
M$194 \$273 \$523 \$272 VDD pfet_03v3 L=0.28U W=0.36U AS=0.2097P AD=0.1278P
+ PS=1.38U PD=1.07U
M$195 \$570 \$274 \$273 VDD pfet_03v3 L=0.28U W=0.36U AS=0.1278P AD=0.0567P
+ PS=1.07U PD=0.675U
M$196 VDD \$255 \$570 VDD pfet_03v3 L=0.28U W=0.36U AS=0.0567P AD=0.1584P
+ PS=0.675U PD=1.6U
M$197 \$274 \$273 VDD VDD pfet_03v3 L=0.28U W=0.36U AS=0.1764P AD=0.1584P
+ PS=1.26U PD=1.6U
M$198 \$275 \$273 VDD VDD pfet_03v3 L=0.28U W=0.72U AS=0.1764P AD=0.36P
+ PS=1.26U PD=2.44U
M$199 \$393 RA15 VDD VDD pfet_03v3 L=0.28U W=0.72U AS=0.3312P AD=0.3888P
+ PS=2.36U PD=2.52U
M$200 \$275 \$393 \$59 VDD pfet_03v3 L=0.28U W=0.36U AS=0.1584P AD=0.1152P
+ PS=1.6U PD=1U
M$201 \$60 \$394 \$275 VDD pfet_03v3 L=0.28U W=0.36U AS=0.1152P AD=0.1584P
+ PS=1U PD=1.6U
M$202 VDD RB15 \$394 VDD pfet_03v3 L=0.28U W=0.72U AS=0.3708P AD=0.3168P
+ PS=2.47U PD=2.32U
M$203 \$276 \$121 VDD VDD pfet_03v3 L=0.28U W=0.72U AS=0.3168P AD=0.2097P
+ PS=2.32U PD=1.38U
M$204 \$277 \$523 \$276 VDD pfet_03v3 L=0.28U W=0.36U AS=0.2097P AD=0.1278P
+ PS=1.38U PD=1.07U
M$205 \$581 \$278 \$277 VDD pfet_03v3 L=0.28U W=0.36U AS=0.1278P AD=0.0567P
+ PS=1.07U PD=0.675U
M$206 VDD \$255 \$581 VDD pfet_03v3 L=0.28U W=0.36U AS=0.0567P AD=0.1584P
+ PS=0.675U PD=1.6U
M$207 \$278 \$277 VDD VDD pfet_03v3 L=0.28U W=0.36U AS=0.1764P AD=0.1584P
+ PS=1.26U PD=1.6U
M$208 \$279 \$277 VDD VDD pfet_03v3 L=0.28U W=0.72U AS=0.1764P AD=0.36P
+ PS=1.26U PD=2.44U
M$209 \$395 RA15 VDD VDD pfet_03v3 L=0.28U W=0.72U AS=0.3312P AD=0.3888P
+ PS=2.36U PD=2.52U
M$210 \$279 \$395 \$61 VDD pfet_03v3 L=0.28U W=0.36U AS=0.1584P AD=0.1152P
+ PS=1.6U PD=1U
M$211 \$62 \$396 \$279 VDD pfet_03v3 L=0.28U W=0.36U AS=0.1152P AD=0.1584P
+ PS=1U PD=1.6U
M$212 VDD RB15 \$396 VDD pfet_03v3 L=0.28U W=0.72U AS=0.3708P AD=0.3168P
+ PS=2.47U PD=2.32U
M$213 \$280 \$124 VDD VDD pfet_03v3 L=0.28U W=0.72U AS=0.3168P AD=0.2097P
+ PS=2.32U PD=1.38U
M$214 \$281 \$523 \$280 VDD pfet_03v3 L=0.28U W=0.36U AS=0.2097P AD=0.1278P
+ PS=1.38U PD=1.07U
M$215 \$591 \$282 \$281 VDD pfet_03v3 L=0.28U W=0.36U AS=0.1278P AD=0.0567P
+ PS=1.07U PD=0.675U
M$216 VDD \$255 \$591 VDD pfet_03v3 L=0.28U W=0.36U AS=0.0567P AD=0.1584P
+ PS=0.675U PD=1.6U
M$217 \$282 \$281 VDD VDD pfet_03v3 L=0.28U W=0.36U AS=0.1764P AD=0.1584P
+ PS=1.26U PD=1.6U
M$218 \$283 \$281 VDD VDD pfet_03v3 L=0.28U W=0.72U AS=0.1764P AD=0.36P
+ PS=1.26U PD=2.44U
M$219 \$397 RA15 VDD VDD pfet_03v3 L=0.28U W=0.72U AS=0.3312P AD=0.3888P
+ PS=2.36U PD=2.52U
M$220 \$283 \$397 \$63 VDD pfet_03v3 L=0.28U W=0.36U AS=0.1584P AD=0.1152P
+ PS=1.6U PD=1U
M$221 \$64 \$398 \$283 VDD pfet_03v3 L=0.28U W=0.36U AS=0.1152P AD=0.1584P
+ PS=1U PD=1.6U
M$222 VDD RB15 \$398 VDD pfet_03v3 L=0.28U W=0.72U AS=0.3708P AD=0.3168P
+ PS=2.47U PD=2.32U
M$223 \$284 \$127 VDD VDD pfet_03v3 L=0.28U W=0.72U AS=0.3168P AD=0.2097P
+ PS=2.32U PD=1.38U
M$224 \$285 \$523 \$284 VDD pfet_03v3 L=0.28U W=0.36U AS=0.2097P AD=0.1278P
+ PS=1.38U PD=1.07U
M$225 \$600 \$286 \$285 VDD pfet_03v3 L=0.28U W=0.36U AS=0.1278P AD=0.0567P
+ PS=1.07U PD=0.675U
M$226 VDD \$255 \$600 VDD pfet_03v3 L=0.28U W=0.36U AS=0.0567P AD=0.1584P
+ PS=0.675U PD=1.6U
M$227 \$286 \$285 VDD VDD pfet_03v3 L=0.28U W=0.36U AS=0.1764P AD=0.1584P
+ PS=1.26U PD=1.6U
M$228 \$287 \$285 VDD VDD pfet_03v3 L=0.28U W=0.72U AS=0.1764P AD=0.36P
+ PS=1.26U PD=2.44U
M$229 \$399 RA15 VDD VDD pfet_03v3 L=0.28U W=0.72U AS=0.3312P AD=0.3888P
+ PS=2.36U PD=2.52U
M$230 \$287 \$399 \$65 VDD pfet_03v3 L=0.28U W=0.36U AS=0.1584P AD=0.1152P
+ PS=1.6U PD=1U
M$231 \$66 \$400 \$287 VDD pfet_03v3 L=0.28U W=0.36U AS=0.1152P AD=0.1584P
+ PS=1U PD=1.6U
M$232 VDD RB15 \$400 VDD pfet_03v3 L=0.28U W=0.72U AS=0.3708P AD=0.3168P
+ PS=2.47U PD=2.32U
M$233 \$288 \$130 VDD VDD pfet_03v3 L=0.28U W=0.72U AS=0.3168P AD=0.2097P
+ PS=2.32U PD=1.38U
M$234 \$289 \$523 \$288 VDD pfet_03v3 L=0.28U W=0.36U AS=0.2097P AD=0.1278P
+ PS=1.38U PD=1.07U
M$235 \$610 \$290 \$289 VDD pfet_03v3 L=0.28U W=0.36U AS=0.1278P AD=0.0567P
+ PS=1.07U PD=0.675U
M$236 VDD \$255 \$610 VDD pfet_03v3 L=0.28U W=0.36U AS=0.0567P AD=0.1584P
+ PS=0.675U PD=1.6U
M$237 \$290 \$289 VDD VDD pfet_03v3 L=0.28U W=0.36U AS=0.1764P AD=0.1584P
+ PS=1.26U PD=1.6U
M$238 \$291 \$289 VDD VDD pfet_03v3 L=0.28U W=0.72U AS=0.1764P AD=0.36P
+ PS=1.26U PD=2.44U
M$239 \$401 RA15 VDD VDD pfet_03v3 L=0.28U W=0.72U AS=0.3312P AD=0.3888P
+ PS=2.36U PD=2.52U
M$240 \$291 \$401 \$67 VDD pfet_03v3 L=0.28U W=0.36U AS=0.1584P AD=0.1152P
+ PS=1.6U PD=1U
M$241 \$68 \$402 \$291 VDD pfet_03v3 L=0.28U W=0.36U AS=0.1152P AD=0.1584P
+ PS=1U PD=1.6U
M$242 VDD RB15 \$402 VDD pfet_03v3 L=0.28U W=0.72U AS=0.3708P AD=0.3168P
+ PS=2.47U PD=2.32U
M$243 \$292 \$133 VDD VDD pfet_03v3 L=0.28U W=0.72U AS=0.3168P AD=0.2097P
+ PS=2.32U PD=1.38U
M$244 \$293 \$523 \$292 VDD pfet_03v3 L=0.28U W=0.36U AS=0.2097P AD=0.1278P
+ PS=1.38U PD=1.07U
M$245 \$620 \$294 \$293 VDD pfet_03v3 L=0.28U W=0.36U AS=0.1278P AD=0.0567P
+ PS=1.07U PD=0.675U
M$246 VDD \$255 \$620 VDD pfet_03v3 L=0.28U W=0.36U AS=0.0567P AD=0.1584P
+ PS=0.675U PD=1.6U
M$247 \$294 \$293 VDD VDD pfet_03v3 L=0.28U W=0.36U AS=0.1764P AD=0.1584P
+ PS=1.26U PD=1.6U
M$248 \$295 \$293 VDD VDD pfet_03v3 L=0.28U W=0.72U AS=0.1764P AD=0.36P
+ PS=1.26U PD=2.44U
M$249 \$403 RA15 VDD VDD pfet_03v3 L=0.28U W=0.72U AS=0.3312P AD=0.3888P
+ PS=2.36U PD=2.52U
M$250 \$295 \$403 \$69 VDD pfet_03v3 L=0.28U W=0.36U AS=0.1584P AD=0.1152P
+ PS=1.6U PD=1U
M$251 \$70 \$404 \$295 VDD pfet_03v3 L=0.28U W=0.36U AS=0.1152P AD=0.1584P
+ PS=1U PD=1.6U
M$252 VDD RB15 \$404 VDD pfet_03v3 L=0.28U W=0.72U AS=0.3708P AD=0.3168P
+ PS=2.47U PD=2.32U
M$253 \$296 \$136 VDD VDD pfet_03v3 L=0.28U W=0.72U AS=0.3168P AD=0.2097P
+ PS=2.32U PD=1.38U
M$254 \$297 \$523 \$296 VDD pfet_03v3 L=0.28U W=0.36U AS=0.2097P AD=0.1278P
+ PS=1.38U PD=1.07U
M$255 \$623 \$298 \$297 VDD pfet_03v3 L=0.28U W=0.36U AS=0.1278P AD=0.0567P
+ PS=1.07U PD=0.675U
M$256 VDD \$255 \$623 VDD pfet_03v3 L=0.28U W=0.36U AS=0.0567P AD=0.1584P
+ PS=0.675U PD=1.6U
M$257 \$298 \$297 VDD VDD pfet_03v3 L=0.28U W=0.36U AS=0.1764P AD=0.1584P
+ PS=1.26U PD=1.6U
M$258 \$299 \$297 VDD VDD pfet_03v3 L=0.28U W=0.72U AS=0.1764P AD=0.36P
+ PS=1.26U PD=2.44U
M$259 \$405 RA15 VDD VDD pfet_03v3 L=0.28U W=0.72U AS=0.3312P AD=0.3888P
+ PS=2.36U PD=2.52U
M$260 \$299 \$405 \$71 VDD pfet_03v3 L=0.28U W=0.36U AS=0.1584P AD=0.1152P
+ PS=1.6U PD=1U
M$261 \$72 \$406 \$299 VDD pfet_03v3 L=0.28U W=0.36U AS=0.1152P AD=0.1584P
+ PS=1U PD=1.6U
M$262 VDD RB15 \$406 VDD pfet_03v3 L=0.28U W=0.72U AS=0.3708P AD=0.3168P
+ PS=2.47U PD=2.32U
M$263 \$300 \$139 VDD VDD pfet_03v3 L=0.28U W=0.72U AS=0.3168P AD=0.2097P
+ PS=2.32U PD=1.38U
M$264 \$301 \$523 \$300 VDD pfet_03v3 L=0.28U W=0.36U AS=0.2097P AD=0.1278P
+ PS=1.38U PD=1.07U
M$265 \$605 \$302 \$301 VDD pfet_03v3 L=0.28U W=0.36U AS=0.1278P AD=0.0567P
+ PS=1.07U PD=0.675U
M$266 VDD \$255 \$605 VDD pfet_03v3 L=0.28U W=0.36U AS=0.0567P AD=0.1584P
+ PS=0.675U PD=1.6U
M$267 \$302 \$301 VDD VDD pfet_03v3 L=0.28U W=0.36U AS=0.1764P AD=0.1584P
+ PS=1.26U PD=1.6U
M$268 \$303 \$301 VDD VDD pfet_03v3 L=0.28U W=0.72U AS=0.1764P AD=0.36P
+ PS=1.26U PD=2.44U
M$269 \$407 RA15 VDD VDD pfet_03v3 L=0.28U W=0.72U AS=0.3312P AD=0.3888P
+ PS=2.36U PD=2.52U
M$270 \$303 \$407 \$73 VDD pfet_03v3 L=0.28U W=0.36U AS=0.1584P AD=0.1152P
+ PS=1.6U PD=1U
M$271 \$74 \$408 \$303 VDD pfet_03v3 L=0.28U W=0.36U AS=0.1152P AD=0.1584P
+ PS=1U PD=1.6U
M$272 VDD RB15 \$408 VDD pfet_03v3 L=0.28U W=0.72U AS=0.3708P AD=0.3168P
+ PS=2.47U PD=2.32U
M$273 \$304 \$142 VDD VDD pfet_03v3 L=0.28U W=0.72U AS=0.3168P AD=0.2097P
+ PS=2.32U PD=1.38U
M$274 \$305 \$523 \$304 VDD pfet_03v3 L=0.28U W=0.36U AS=0.2097P AD=0.1278P
+ PS=1.38U PD=1.07U
M$275 \$587 \$306 \$305 VDD pfet_03v3 L=0.28U W=0.36U AS=0.1278P AD=0.0567P
+ PS=1.07U PD=0.675U
M$276 VDD \$255 \$587 VDD pfet_03v3 L=0.28U W=0.36U AS=0.0567P AD=0.1584P
+ PS=0.675U PD=1.6U
M$277 \$306 \$305 VDD VDD pfet_03v3 L=0.28U W=0.36U AS=0.1764P AD=0.1584P
+ PS=1.26U PD=1.6U
M$278 \$307 \$305 VDD VDD pfet_03v3 L=0.28U W=0.72U AS=0.1764P AD=0.36P
+ PS=1.26U PD=2.44U
M$279 \$409 RA15 VDD VDD pfet_03v3 L=0.28U W=0.72U AS=0.3312P AD=0.3888P
+ PS=2.36U PD=2.52U
M$280 \$307 \$409 \$75 VDD pfet_03v3 L=0.28U W=0.36U AS=0.1584P AD=0.1152P
+ PS=1.6U PD=1U
M$281 \$76 \$410 \$307 VDD pfet_03v3 L=0.28U W=0.36U AS=0.1152P AD=0.1584P
+ PS=1U PD=1.6U
M$282 VDD RB15 \$410 VDD pfet_03v3 L=0.28U W=0.72U AS=0.3708P AD=0.3168P
+ PS=2.47U PD=2.32U
M$283 \$308 \$145 VDD VDD pfet_03v3 L=0.28U W=0.72U AS=0.3168P AD=0.2097P
+ PS=2.32U PD=1.38U
M$284 \$309 \$523 \$308 VDD pfet_03v3 L=0.28U W=0.36U AS=0.2097P AD=0.1278P
+ PS=1.38U PD=1.07U
M$285 \$569 \$310 \$309 VDD pfet_03v3 L=0.28U W=0.36U AS=0.1278P AD=0.0567P
+ PS=1.07U PD=0.675U
M$286 VDD \$255 \$569 VDD pfet_03v3 L=0.28U W=0.36U AS=0.0567P AD=0.1584P
+ PS=0.675U PD=1.6U
M$287 \$310 \$309 VDD VDD pfet_03v3 L=0.28U W=0.36U AS=0.1764P AD=0.1584P
+ PS=1.26U PD=1.6U
M$288 \$311 \$309 VDD VDD pfet_03v3 L=0.28U W=0.72U AS=0.1764P AD=0.36P
+ PS=1.26U PD=2.44U
M$289 \$411 RA15 VDD VDD pfet_03v3 L=0.28U W=0.72U AS=0.3312P AD=0.3888P
+ PS=2.36U PD=2.52U
M$290 \$311 \$411 \$77 VDD pfet_03v3 L=0.28U W=0.36U AS=0.1584P AD=0.1152P
+ PS=1.6U PD=1U
M$291 \$78 \$412 \$311 VDD pfet_03v3 L=0.28U W=0.36U AS=0.1152P AD=0.1584P
+ PS=1U PD=1.6U
M$292 VDD RB15 \$412 VDD pfet_03v3 L=0.28U W=0.72U AS=0.3708P AD=0.3168P
+ PS=2.47U PD=2.32U
M$293 \$312 \$148 VDD VDD pfet_03v3 L=0.28U W=0.72U AS=0.3168P AD=0.2097P
+ PS=2.32U PD=1.38U
M$294 \$313 \$523 \$312 VDD pfet_03v3 L=0.28U W=0.36U AS=0.2097P AD=0.1278P
+ PS=1.38U PD=1.07U
M$295 \$552 \$314 \$313 VDD pfet_03v3 L=0.28U W=0.36U AS=0.1278P AD=0.0567P
+ PS=1.07U PD=0.675U
M$296 VDD \$255 \$552 VDD pfet_03v3 L=0.28U W=0.36U AS=0.0567P AD=0.1584P
+ PS=0.675U PD=1.6U
M$297 \$314 \$313 VDD VDD pfet_03v3 L=0.28U W=0.36U AS=0.1764P AD=0.1584P
+ PS=1.26U PD=1.6U
M$298 \$315 \$313 VDD VDD pfet_03v3 L=0.28U W=0.72U AS=0.1764P AD=0.36P
+ PS=1.26U PD=2.44U
M$299 \$413 RA15 VDD VDD pfet_03v3 L=0.28U W=0.72U AS=0.3312P AD=0.3888P
+ PS=2.36U PD=2.52U
M$300 \$315 \$413 \$79 VDD pfet_03v3 L=0.28U W=0.36U AS=0.1584P AD=0.1152P
+ PS=1.6U PD=1U
M$301 \$80 \$414 \$315 VDD pfet_03v3 L=0.28U W=0.36U AS=0.1152P AD=0.1584P
+ PS=1U PD=1.6U
M$302 VDD RB15 \$414 VDD pfet_03v3 L=0.28U W=0.72U AS=0.3708P AD=0.3168P
+ PS=2.47U PD=2.32U
M$303 \$316 \$151 VDD VDD pfet_03v3 L=0.28U W=0.72U AS=0.3168P AD=0.2097P
+ PS=2.32U PD=1.38U
M$304 \$317 \$523 \$316 VDD pfet_03v3 L=0.28U W=0.36U AS=0.2097P AD=0.1278P
+ PS=1.38U PD=1.07U
M$305 \$533 \$318 \$317 VDD pfet_03v3 L=0.28U W=0.36U AS=0.1278P AD=0.0567P
+ PS=1.07U PD=0.675U
M$306 VDD \$255 \$533 VDD pfet_03v3 L=0.28U W=0.36U AS=0.0567P AD=0.1584P
+ PS=0.675U PD=1.6U
M$307 \$318 \$317 VDD VDD pfet_03v3 L=0.28U W=0.36U AS=0.1764P AD=0.1584P
+ PS=1.26U PD=1.6U
M$308 \$319 \$317 VDD VDD pfet_03v3 L=0.28U W=0.72U AS=0.1764P AD=0.36P
+ PS=1.26U PD=2.44U
M$309 \$415 RA15 VDD VDD pfet_03v3 L=0.28U W=0.72U AS=0.3312P AD=0.3888P
+ PS=2.36U PD=2.52U
M$310 \$319 \$415 \$81 VDD pfet_03v3 L=0.28U W=0.36U AS=0.1584P AD=0.1152P
+ PS=1.6U PD=1U
M$311 \$82 \$416 \$319 VDD pfet_03v3 L=0.28U W=0.36U AS=0.1152P AD=0.1584P
+ PS=1U PD=1.6U
M$312 VDD RB15 \$416 VDD pfet_03v3 L=0.28U W=0.72U AS=0.3708P AD=0.3168P
+ PS=2.47U PD=2.32U
M$313 \$629 WE14 VDD VDD pfet_03v3 L=0.28U W=0.72U AS=0.3168P AD=0.1872P
+ PS=2.32U PD=1.24U
M$314 VDD CLK \$629 VDD pfet_03v3 L=0.28U W=0.72U AS=0.1872P AD=0.3168P
+ PS=1.24U PD=2.32U
M$315 \$630 \$629 VDD VDD pfet_03v3 L=0.28U W=1.27U AS=0.5588P AD=0.3302P
+ PS=3.42U PD=1.79U
M$316 VDD \$629 \$630 VDD pfet_03v3 L=0.28U W=1.27U AS=0.3302P AD=0.3386P
+ PS=1.79U PD=1.86U
M$317 \$631 \$630 VDD VDD pfet_03v3 L=0.28U W=1.34U AS=0.3386P AD=0.3886P
+ PS=1.86U PD=1.92U
M$318 VDD \$630 \$631 VDD pfet_03v3 L=0.28U W=1.34U AS=0.3886P AD=0.5896P
+ PS=1.92U PD=3.56U
M$319 \$633 \$631 \$632 VDD pfet_03v3 L=0.28U W=0.36U AS=0.2097P AD=0.1278P
+ PS=1.38U PD=1.07U
M$320 \$734 \$634 \$633 VDD pfet_03v3 L=0.28U W=0.36U AS=0.1278P AD=0.0567P
+ PS=1.07U PD=0.675U
M$321 VDD \$630 \$734 VDD pfet_03v3 L=0.28U W=0.36U AS=0.0567P AD=0.1584P
+ PS=0.675U PD=1.6U
M$322 \$632 \$106 VDD VDD pfet_03v3 L=0.28U W=0.72U AS=0.3168P AD=0.2097P
+ PS=2.32U PD=1.38U
M$323 VDD \$633 \$634 VDD pfet_03v3 L=0.28U W=0.36U AS=0.1584P AD=0.1764P
+ PS=1.6U PD=1.26U
M$324 \$635 \$633 VDD VDD pfet_03v3 L=0.28U W=0.72U AS=0.1764P AD=0.36P
+ PS=1.26U PD=2.44U
M$325 \$637 RB14 VDD VDD pfet_03v3 L=0.28U W=0.72U AS=0.3312P AD=0.3888P
+ PS=2.36U PD=2.52U
M$326 \$635 \$637 \$51 VDD pfet_03v3 L=0.28U W=0.36U AS=0.1584P AD=0.1152P
+ PS=1.6U PD=1U
M$327 \$52 \$638 \$635 VDD pfet_03v3 L=0.28U W=0.36U AS=0.1152P AD=0.1584P
+ PS=1U PD=1.6U
M$328 VDD RA14 \$638 VDD pfet_03v3 L=0.28U W=0.72U AS=0.3708P AD=0.3168P
+ PS=2.47U PD=2.32U
M$329 \$640 \$631 \$639 VDD pfet_03v3 L=0.28U W=0.36U AS=0.2097P AD=0.1278P
+ PS=1.38U PD=1.07U
M$330 \$743 \$641 \$640 VDD pfet_03v3 L=0.28U W=0.36U AS=0.1278P AD=0.0567P
+ PS=1.07U PD=0.675U
M$331 VDD \$630 \$743 VDD pfet_03v3 L=0.28U W=0.36U AS=0.0567P AD=0.1584P
+ PS=0.675U PD=1.6U
M$332 \$639 \$109 VDD VDD pfet_03v3 L=0.28U W=0.72U AS=0.3168P AD=0.2097P
+ PS=2.32U PD=1.38U
M$333 VDD \$640 \$641 VDD pfet_03v3 L=0.28U W=0.36U AS=0.1584P AD=0.1764P
+ PS=1.6U PD=1.26U
M$334 \$642 \$640 VDD VDD pfet_03v3 L=0.28U W=0.72U AS=0.1764P AD=0.36P
+ PS=1.26U PD=2.44U
M$335 \$643 RB14 VDD VDD pfet_03v3 L=0.28U W=0.72U AS=0.3312P AD=0.3888P
+ PS=2.36U PD=2.52U
M$336 \$642 \$643 \$53 VDD pfet_03v3 L=0.28U W=0.36U AS=0.1584P AD=0.1152P
+ PS=1.6U PD=1U
M$337 \$54 \$644 \$642 VDD pfet_03v3 L=0.28U W=0.36U AS=0.1152P AD=0.1584P
+ PS=1U PD=1.6U
M$338 VDD RA14 \$644 VDD pfet_03v3 L=0.28U W=0.72U AS=0.3708P AD=0.3168P
+ PS=2.47U PD=2.32U
M$339 \$646 \$631 \$645 VDD pfet_03v3 L=0.28U W=0.36U AS=0.2097P AD=0.1278P
+ PS=1.38U PD=1.07U
M$340 \$754 \$647 \$646 VDD pfet_03v3 L=0.28U W=0.36U AS=0.1278P AD=0.0567P
+ PS=1.07U PD=0.675U
M$341 VDD \$630 \$754 VDD pfet_03v3 L=0.28U W=0.36U AS=0.0567P AD=0.1584P
+ PS=0.675U PD=1.6U
M$342 \$645 \$112 VDD VDD pfet_03v3 L=0.28U W=0.72U AS=0.3168P AD=0.2097P
+ PS=2.32U PD=1.38U
M$343 VDD \$646 \$647 VDD pfet_03v3 L=0.28U W=0.36U AS=0.1584P AD=0.1764P
+ PS=1.6U PD=1.26U
M$344 \$648 \$646 VDD VDD pfet_03v3 L=0.28U W=0.72U AS=0.1764P AD=0.36P
+ PS=1.26U PD=2.44U
M$345 \$649 RB14 VDD VDD pfet_03v3 L=0.28U W=0.72U AS=0.3312P AD=0.3888P
+ PS=2.36U PD=2.52U
M$346 \$648 \$649 \$55 VDD pfet_03v3 L=0.28U W=0.36U AS=0.1584P AD=0.1152P
+ PS=1.6U PD=1U
M$347 \$56 \$650 \$648 VDD pfet_03v3 L=0.28U W=0.36U AS=0.1152P AD=0.1584P
+ PS=1U PD=1.6U
M$348 VDD RA14 \$650 VDD pfet_03v3 L=0.28U W=0.72U AS=0.3708P AD=0.3168P
+ PS=2.47U PD=2.32U
M$349 \$652 \$631 \$651 VDD pfet_03v3 L=0.28U W=0.36U AS=0.2097P AD=0.1278P
+ PS=1.38U PD=1.07U
M$350 \$764 \$653 \$652 VDD pfet_03v3 L=0.28U W=0.36U AS=0.1278P AD=0.0567P
+ PS=1.07U PD=0.675U
M$351 VDD \$630 \$764 VDD pfet_03v3 L=0.28U W=0.36U AS=0.0567P AD=0.1584P
+ PS=0.675U PD=1.6U
M$352 \$651 \$115 VDD VDD pfet_03v3 L=0.28U W=0.72U AS=0.3168P AD=0.2097P
+ PS=2.32U PD=1.38U
M$353 VDD \$652 \$653 VDD pfet_03v3 L=0.28U W=0.36U AS=0.1584P AD=0.1764P
+ PS=1.6U PD=1.26U
M$354 \$654 \$652 VDD VDD pfet_03v3 L=0.28U W=0.72U AS=0.1764P AD=0.36P
+ PS=1.26U PD=2.44U
M$355 \$655 RB14 VDD VDD pfet_03v3 L=0.28U W=0.72U AS=0.3312P AD=0.3888P
+ PS=2.36U PD=2.52U
M$356 \$654 \$655 \$57 VDD pfet_03v3 L=0.28U W=0.36U AS=0.1584P AD=0.1152P
+ PS=1.6U PD=1U
M$357 \$58 \$656 \$654 VDD pfet_03v3 L=0.28U W=0.36U AS=0.1152P AD=0.1584P
+ PS=1U PD=1.6U
M$358 VDD RA14 \$656 VDD pfet_03v3 L=0.28U W=0.72U AS=0.3708P AD=0.3168P
+ PS=2.47U PD=2.32U
M$359 \$658 \$631 \$657 VDD pfet_03v3 L=0.28U W=0.36U AS=0.2097P AD=0.1278P
+ PS=1.38U PD=1.07U
M$360 \$775 \$659 \$658 VDD pfet_03v3 L=0.28U W=0.36U AS=0.1278P AD=0.0567P
+ PS=1.07U PD=0.675U
M$361 VDD \$630 \$775 VDD pfet_03v3 L=0.28U W=0.36U AS=0.0567P AD=0.1584P
+ PS=0.675U PD=1.6U
M$362 \$657 \$118 VDD VDD pfet_03v3 L=0.28U W=0.72U AS=0.3168P AD=0.2097P
+ PS=2.32U PD=1.38U
M$363 VDD \$658 \$659 VDD pfet_03v3 L=0.28U W=0.36U AS=0.1584P AD=0.1764P
+ PS=1.6U PD=1.26U
M$364 \$660 \$658 VDD VDD pfet_03v3 L=0.28U W=0.72U AS=0.1764P AD=0.36P
+ PS=1.26U PD=2.44U
M$365 \$661 RB14 VDD VDD pfet_03v3 L=0.28U W=0.72U AS=0.3312P AD=0.3888P
+ PS=2.36U PD=2.52U
M$366 \$660 \$661 \$59 VDD pfet_03v3 L=0.28U W=0.36U AS=0.1584P AD=0.1152P
+ PS=1.6U PD=1U
M$367 \$60 \$662 \$660 VDD pfet_03v3 L=0.28U W=0.36U AS=0.1152P AD=0.1584P
+ PS=1U PD=1.6U
M$368 VDD RA14 \$662 VDD pfet_03v3 L=0.28U W=0.72U AS=0.3708P AD=0.3168P
+ PS=2.47U PD=2.32U
M$369 \$664 \$631 \$663 VDD pfet_03v3 L=0.28U W=0.36U AS=0.2097P AD=0.1278P
+ PS=1.38U PD=1.07U
M$370 \$784 \$665 \$664 VDD pfet_03v3 L=0.28U W=0.36U AS=0.1278P AD=0.0567P
+ PS=1.07U PD=0.675U
M$371 VDD \$630 \$784 VDD pfet_03v3 L=0.28U W=0.36U AS=0.0567P AD=0.1584P
+ PS=0.675U PD=1.6U
M$372 \$663 \$121 VDD VDD pfet_03v3 L=0.28U W=0.72U AS=0.3168P AD=0.2097P
+ PS=2.32U PD=1.38U
M$373 VDD \$664 \$665 VDD pfet_03v3 L=0.28U W=0.36U AS=0.1584P AD=0.1764P
+ PS=1.6U PD=1.26U
M$374 \$666 \$664 VDD VDD pfet_03v3 L=0.28U W=0.72U AS=0.1764P AD=0.36P
+ PS=1.26U PD=2.44U
M$375 \$667 RB14 VDD VDD pfet_03v3 L=0.28U W=0.72U AS=0.3312P AD=0.3888P
+ PS=2.36U PD=2.52U
M$376 \$666 \$667 \$61 VDD pfet_03v3 L=0.28U W=0.36U AS=0.1584P AD=0.1152P
+ PS=1.6U PD=1U
M$377 \$62 \$668 \$666 VDD pfet_03v3 L=0.28U W=0.36U AS=0.1152P AD=0.1584P
+ PS=1U PD=1.6U
M$378 VDD RA14 \$668 VDD pfet_03v3 L=0.28U W=0.72U AS=0.3708P AD=0.3168P
+ PS=2.47U PD=2.32U
M$379 \$670 \$631 \$669 VDD pfet_03v3 L=0.28U W=0.36U AS=0.2097P AD=0.1278P
+ PS=1.38U PD=1.07U
M$380 \$794 \$671 \$670 VDD pfet_03v3 L=0.28U W=0.36U AS=0.1278P AD=0.0567P
+ PS=1.07U PD=0.675U
M$381 VDD \$630 \$794 VDD pfet_03v3 L=0.28U W=0.36U AS=0.0567P AD=0.1584P
+ PS=0.675U PD=1.6U
M$382 \$669 \$124 VDD VDD pfet_03v3 L=0.28U W=0.72U AS=0.3168P AD=0.2097P
+ PS=2.32U PD=1.38U
M$383 VDD \$670 \$671 VDD pfet_03v3 L=0.28U W=0.36U AS=0.1584P AD=0.1764P
+ PS=1.6U PD=1.26U
M$384 \$672 \$670 VDD VDD pfet_03v3 L=0.28U W=0.72U AS=0.1764P AD=0.36P
+ PS=1.26U PD=2.44U
M$385 \$673 RB14 VDD VDD pfet_03v3 L=0.28U W=0.72U AS=0.3312P AD=0.3888P
+ PS=2.36U PD=2.52U
M$386 \$672 \$673 \$63 VDD pfet_03v3 L=0.28U W=0.36U AS=0.1584P AD=0.1152P
+ PS=1.6U PD=1U
M$387 \$64 \$674 \$672 VDD pfet_03v3 L=0.28U W=0.36U AS=0.1152P AD=0.1584P
+ PS=1U PD=1.6U
M$388 VDD RA14 \$674 VDD pfet_03v3 L=0.28U W=0.72U AS=0.3708P AD=0.3168P
+ PS=2.47U PD=2.32U
M$389 \$676 \$631 \$675 VDD pfet_03v3 L=0.28U W=0.36U AS=0.2097P AD=0.1278P
+ PS=1.38U PD=1.07U
M$390 \$804 \$677 \$676 VDD pfet_03v3 L=0.28U W=0.36U AS=0.1278P AD=0.0567P
+ PS=1.07U PD=0.675U
M$391 VDD \$630 \$804 VDD pfet_03v3 L=0.28U W=0.36U AS=0.0567P AD=0.1584P
+ PS=0.675U PD=1.6U
M$392 \$675 \$127 VDD VDD pfet_03v3 L=0.28U W=0.72U AS=0.3168P AD=0.2097P
+ PS=2.32U PD=1.38U
M$393 VDD \$676 \$677 VDD pfet_03v3 L=0.28U W=0.36U AS=0.1584P AD=0.1764P
+ PS=1.6U PD=1.26U
M$394 \$678 \$676 VDD VDD pfet_03v3 L=0.28U W=0.72U AS=0.1764P AD=0.36P
+ PS=1.26U PD=2.44U
M$395 \$679 RB14 VDD VDD pfet_03v3 L=0.28U W=0.72U AS=0.3312P AD=0.3888P
+ PS=2.36U PD=2.52U
M$396 \$678 \$679 \$65 VDD pfet_03v3 L=0.28U W=0.36U AS=0.1584P AD=0.1152P
+ PS=1.6U PD=1U
M$397 \$66 \$680 \$678 VDD pfet_03v3 L=0.28U W=0.36U AS=0.1152P AD=0.1584P
+ PS=1U PD=1.6U
M$398 VDD RA14 \$680 VDD pfet_03v3 L=0.28U W=0.72U AS=0.3708P AD=0.3168P
+ PS=2.47U PD=2.32U
M$399 \$682 \$631 \$681 VDD pfet_03v3 L=0.28U W=0.36U AS=0.2097P AD=0.1278P
+ PS=1.38U PD=1.07U
M$400 \$814 \$683 \$682 VDD pfet_03v3 L=0.28U W=0.36U AS=0.1278P AD=0.0567P
+ PS=1.07U PD=0.675U
M$401 VDD \$630 \$814 VDD pfet_03v3 L=0.28U W=0.36U AS=0.0567P AD=0.1584P
+ PS=0.675U PD=1.6U
M$402 \$681 \$130 VDD VDD pfet_03v3 L=0.28U W=0.72U AS=0.3168P AD=0.2097P
+ PS=2.32U PD=1.38U
M$403 VDD \$682 \$683 VDD pfet_03v3 L=0.28U W=0.36U AS=0.1584P AD=0.1764P
+ PS=1.6U PD=1.26U
M$404 \$684 \$682 VDD VDD pfet_03v3 L=0.28U W=0.72U AS=0.1764P AD=0.36P
+ PS=1.26U PD=2.44U
M$405 \$685 RB14 VDD VDD pfet_03v3 L=0.28U W=0.72U AS=0.3312P AD=0.3888P
+ PS=2.36U PD=2.52U
M$406 \$684 \$685 \$67 VDD pfet_03v3 L=0.28U W=0.36U AS=0.1584P AD=0.1152P
+ PS=1.6U PD=1U
M$407 \$68 \$686 \$684 VDD pfet_03v3 L=0.28U W=0.36U AS=0.1152P AD=0.1584P
+ PS=1U PD=1.6U
M$408 VDD RA14 \$686 VDD pfet_03v3 L=0.28U W=0.72U AS=0.3708P AD=0.3168P
+ PS=2.47U PD=2.32U
M$409 \$688 \$631 \$687 VDD pfet_03v3 L=0.28U W=0.36U AS=0.2097P AD=0.1278P
+ PS=1.38U PD=1.07U
M$410 \$824 \$689 \$688 VDD pfet_03v3 L=0.28U W=0.36U AS=0.1278P AD=0.0567P
+ PS=1.07U PD=0.675U
M$411 VDD \$630 \$824 VDD pfet_03v3 L=0.28U W=0.36U AS=0.0567P AD=0.1584P
+ PS=0.675U PD=1.6U
M$412 \$687 \$133 VDD VDD pfet_03v3 L=0.28U W=0.72U AS=0.3168P AD=0.2097P
+ PS=2.32U PD=1.38U
M$413 VDD \$688 \$689 VDD pfet_03v3 L=0.28U W=0.36U AS=0.1584P AD=0.1764P
+ PS=1.6U PD=1.26U
M$414 \$690 \$688 VDD VDD pfet_03v3 L=0.28U W=0.72U AS=0.1764P AD=0.36P
+ PS=1.26U PD=2.44U
M$415 \$691 RB14 VDD VDD pfet_03v3 L=0.28U W=0.72U AS=0.3312P AD=0.3888P
+ PS=2.36U PD=2.52U
M$416 \$690 \$691 \$69 VDD pfet_03v3 L=0.28U W=0.36U AS=0.1584P AD=0.1152P
+ PS=1.6U PD=1U
M$417 \$70 \$692 \$690 VDD pfet_03v3 L=0.28U W=0.36U AS=0.1152P AD=0.1584P
+ PS=1U PD=1.6U
M$418 VDD RA14 \$692 VDD pfet_03v3 L=0.28U W=0.72U AS=0.3708P AD=0.3168P
+ PS=2.47U PD=2.32U
M$419 \$694 \$631 \$693 VDD pfet_03v3 L=0.28U W=0.36U AS=0.2097P AD=0.1278P
+ PS=1.38U PD=1.07U
M$420 \$810 \$695 \$694 VDD pfet_03v3 L=0.28U W=0.36U AS=0.1278P AD=0.0567P
+ PS=1.07U PD=0.675U
M$421 VDD \$630 \$810 VDD pfet_03v3 L=0.28U W=0.36U AS=0.0567P AD=0.1584P
+ PS=0.675U PD=1.6U
M$422 \$693 \$136 VDD VDD pfet_03v3 L=0.28U W=0.72U AS=0.3168P AD=0.2097P
+ PS=2.32U PD=1.38U
M$423 VDD \$694 \$695 VDD pfet_03v3 L=0.28U W=0.36U AS=0.1584P AD=0.1764P
+ PS=1.6U PD=1.26U
M$424 \$696 \$694 VDD VDD pfet_03v3 L=0.28U W=0.72U AS=0.1764P AD=0.36P
+ PS=1.26U PD=2.44U
M$425 \$697 RB14 VDD VDD pfet_03v3 L=0.28U W=0.72U AS=0.3312P AD=0.3888P
+ PS=2.36U PD=2.52U
M$426 \$696 \$697 \$71 VDD pfet_03v3 L=0.28U W=0.36U AS=0.1584P AD=0.1152P
+ PS=1.6U PD=1U
M$427 \$72 \$698 \$696 VDD pfet_03v3 L=0.28U W=0.36U AS=0.1152P AD=0.1584P
+ PS=1U PD=1.6U
M$428 VDD RA14 \$698 VDD pfet_03v3 L=0.28U W=0.72U AS=0.3708P AD=0.3168P
+ PS=2.47U PD=2.32U
M$429 \$700 \$631 \$699 VDD pfet_03v3 L=0.28U W=0.36U AS=0.2097P AD=0.1278P
+ PS=1.38U PD=1.07U
M$430 \$796 \$701 \$700 VDD pfet_03v3 L=0.28U W=0.36U AS=0.1278P AD=0.0567P
+ PS=1.07U PD=0.675U
M$431 VDD \$630 \$796 VDD pfet_03v3 L=0.28U W=0.36U AS=0.0567P AD=0.1584P
+ PS=0.675U PD=1.6U
M$432 \$699 \$139 VDD VDD pfet_03v3 L=0.28U W=0.72U AS=0.3168P AD=0.2097P
+ PS=2.32U PD=1.38U
M$433 VDD \$700 \$701 VDD pfet_03v3 L=0.28U W=0.36U AS=0.1584P AD=0.1764P
+ PS=1.6U PD=1.26U
M$434 \$702 \$700 VDD VDD pfet_03v3 L=0.28U W=0.72U AS=0.1764P AD=0.36P
+ PS=1.26U PD=2.44U
M$435 \$703 RB14 VDD VDD pfet_03v3 L=0.28U W=0.72U AS=0.3312P AD=0.3888P
+ PS=2.36U PD=2.52U
M$436 \$702 \$703 \$73 VDD pfet_03v3 L=0.28U W=0.36U AS=0.1584P AD=0.1152P
+ PS=1.6U PD=1U
M$437 \$74 \$704 \$702 VDD pfet_03v3 L=0.28U W=0.36U AS=0.1152P AD=0.1584P
+ PS=1U PD=1.6U
M$438 VDD RA14 \$704 VDD pfet_03v3 L=0.28U W=0.72U AS=0.3708P AD=0.3168P
+ PS=2.47U PD=2.32U
M$439 \$706 \$631 \$705 VDD pfet_03v3 L=0.28U W=0.36U AS=0.2097P AD=0.1278P
+ PS=1.38U PD=1.07U
M$440 \$780 \$707 \$706 VDD pfet_03v3 L=0.28U W=0.36U AS=0.1278P AD=0.0567P
+ PS=1.07U PD=0.675U
M$441 VDD \$630 \$780 VDD pfet_03v3 L=0.28U W=0.36U AS=0.0567P AD=0.1584P
+ PS=0.675U PD=1.6U
M$442 \$705 \$142 VDD VDD pfet_03v3 L=0.28U W=0.72U AS=0.3168P AD=0.2097P
+ PS=2.32U PD=1.38U
M$443 VDD \$706 \$707 VDD pfet_03v3 L=0.28U W=0.36U AS=0.1584P AD=0.1764P
+ PS=1.6U PD=1.26U
M$444 \$708 \$706 VDD VDD pfet_03v3 L=0.28U W=0.72U AS=0.1764P AD=0.36P
+ PS=1.26U PD=2.44U
M$445 \$709 RB14 VDD VDD pfet_03v3 L=0.28U W=0.72U AS=0.3312P AD=0.3888P
+ PS=2.36U PD=2.52U
M$446 \$708 \$709 \$75 VDD pfet_03v3 L=0.28U W=0.36U AS=0.1584P AD=0.1152P
+ PS=1.6U PD=1U
M$447 \$76 \$710 \$708 VDD pfet_03v3 L=0.28U W=0.36U AS=0.1152P AD=0.1584P
+ PS=1U PD=1.6U
M$448 VDD RA14 \$710 VDD pfet_03v3 L=0.28U W=0.72U AS=0.3708P AD=0.3168P
+ PS=2.47U PD=2.32U
M$449 \$712 \$631 \$711 VDD pfet_03v3 L=0.28U W=0.36U AS=0.2097P AD=0.1278P
+ PS=1.38U PD=1.07U
M$450 \$769 \$713 \$712 VDD pfet_03v3 L=0.28U W=0.36U AS=0.1278P AD=0.0567P
+ PS=1.07U PD=0.675U
M$451 VDD \$630 \$769 VDD pfet_03v3 L=0.28U W=0.36U AS=0.0567P AD=0.1584P
+ PS=0.675U PD=1.6U
M$452 \$711 \$145 VDD VDD pfet_03v3 L=0.28U W=0.72U AS=0.3168P AD=0.2097P
+ PS=2.32U PD=1.38U
M$453 VDD \$712 \$713 VDD pfet_03v3 L=0.28U W=0.36U AS=0.1584P AD=0.1764P
+ PS=1.6U PD=1.26U
M$454 \$714 \$712 VDD VDD pfet_03v3 L=0.28U W=0.72U AS=0.1764P AD=0.36P
+ PS=1.26U PD=2.44U
M$455 \$715 RB14 VDD VDD pfet_03v3 L=0.28U W=0.72U AS=0.3312P AD=0.3888P
+ PS=2.36U PD=2.52U
M$456 \$714 \$715 \$77 VDD pfet_03v3 L=0.28U W=0.36U AS=0.1584P AD=0.1152P
+ PS=1.6U PD=1U
M$457 \$78 \$716 \$714 VDD pfet_03v3 L=0.28U W=0.36U AS=0.1152P AD=0.1584P
+ PS=1U PD=1.6U
M$458 VDD RA14 \$716 VDD pfet_03v3 L=0.28U W=0.72U AS=0.3708P AD=0.3168P
+ PS=2.47U PD=2.32U
M$459 \$718 \$631 \$717 VDD pfet_03v3 L=0.28U W=0.36U AS=0.2097P AD=0.1278P
+ PS=1.38U PD=1.07U
M$460 \$753 \$719 \$718 VDD pfet_03v3 L=0.28U W=0.36U AS=0.1278P AD=0.0567P
+ PS=1.07U PD=0.675U
M$461 VDD \$630 \$753 VDD pfet_03v3 L=0.28U W=0.36U AS=0.0567P AD=0.1584P
+ PS=0.675U PD=1.6U
M$462 \$717 \$148 VDD VDD pfet_03v3 L=0.28U W=0.72U AS=0.3168P AD=0.2097P
+ PS=2.32U PD=1.38U
M$463 VDD \$718 \$719 VDD pfet_03v3 L=0.28U W=0.36U AS=0.1584P AD=0.1764P
+ PS=1.6U PD=1.26U
M$464 \$720 \$718 VDD VDD pfet_03v3 L=0.28U W=0.72U AS=0.1764P AD=0.36P
+ PS=1.26U PD=2.44U
M$465 \$721 RB14 VDD VDD pfet_03v3 L=0.28U W=0.72U AS=0.3312P AD=0.3888P
+ PS=2.36U PD=2.52U
M$466 \$720 \$721 \$79 VDD pfet_03v3 L=0.28U W=0.36U AS=0.1584P AD=0.1152P
+ PS=1.6U PD=1U
M$467 \$80 \$722 \$720 VDD pfet_03v3 L=0.28U W=0.36U AS=0.1152P AD=0.1584P
+ PS=1U PD=1.6U
M$468 VDD RA14 \$722 VDD pfet_03v3 L=0.28U W=0.72U AS=0.3708P AD=0.3168P
+ PS=2.47U PD=2.32U
M$469 \$724 \$631 \$723 VDD pfet_03v3 L=0.28U W=0.36U AS=0.2097P AD=0.1278P
+ PS=1.38U PD=1.07U
M$470 \$739 \$725 \$724 VDD pfet_03v3 L=0.28U W=0.36U AS=0.1278P AD=0.0567P
+ PS=1.07U PD=0.675U
M$471 VDD \$630 \$739 VDD pfet_03v3 L=0.28U W=0.36U AS=0.0567P AD=0.1584P
+ PS=0.675U PD=1.6U
M$472 \$723 \$151 VDD VDD pfet_03v3 L=0.28U W=0.72U AS=0.3168P AD=0.2097P
+ PS=2.32U PD=1.38U
M$473 VDD \$724 \$725 VDD pfet_03v3 L=0.28U W=0.36U AS=0.1584P AD=0.1764P
+ PS=1.6U PD=1.26U
M$474 \$726 \$724 VDD VDD pfet_03v3 L=0.28U W=0.72U AS=0.1764P AD=0.36P
+ PS=1.26U PD=2.44U
M$475 \$727 RB14 VDD VDD pfet_03v3 L=0.28U W=0.72U AS=0.3312P AD=0.3888P
+ PS=2.36U PD=2.52U
M$476 \$726 \$727 \$81 VDD pfet_03v3 L=0.28U W=0.36U AS=0.1584P AD=0.1152P
+ PS=1.6U PD=1U
M$477 \$82 \$728 \$726 VDD pfet_03v3 L=0.28U W=0.36U AS=0.1152P AD=0.1584P
+ PS=1U PD=1.6U
M$478 VDD RA14 \$728 VDD pfet_03v3 L=0.28U W=0.72U AS=0.3708P AD=0.3168P
+ PS=2.47U PD=2.32U
M$479 \$948 WE13 VDD VDD pfet_03v3 L=0.28U W=0.72U AS=0.3168P AD=0.1872P
+ PS=2.32U PD=1.24U
M$480 VDD CLK \$948 VDD pfet_03v3 L=0.28U W=0.72U AS=0.1872P AD=0.3168P
+ PS=1.24U PD=2.32U
M$481 \$949 \$948 VDD VDD pfet_03v3 L=0.28U W=1.27U AS=0.5588P AD=0.3302P
+ PS=3.42U PD=1.79U
M$482 \$949 \$948 VDD VDD pfet_03v3 L=0.28U W=1.27U AS=0.3386P AD=0.3302P
+ PS=1.86U PD=1.79U
M$483 \$1142 \$949 VDD VDD pfet_03v3 L=0.28U W=1.34U AS=0.3386P AD=0.3886P
+ PS=1.86U PD=1.92U
M$484 VDD \$949 \$1142 VDD pfet_03v3 L=0.28U W=1.34U AS=0.3886P AD=0.5896P
+ PS=1.92U PD=3.56U
M$485 \$950 \$106 VDD VDD pfet_03v3 L=0.28U W=0.72U AS=0.3168P AD=0.2097P
+ PS=2.32U PD=1.38U
M$486 \$951 \$1142 \$950 VDD pfet_03v3 L=0.28U W=0.36U AS=0.2097P AD=0.1278P
+ PS=1.38U PD=1.07U
M$487 \$1148 \$1039 \$951 VDD pfet_03v3 L=0.28U W=0.36U AS=0.1278P AD=0.0567P
+ PS=1.07U PD=0.675U
M$488 VDD \$949 \$1148 VDD pfet_03v3 L=0.28U W=0.36U AS=0.0567P AD=0.1584P
+ PS=0.675U PD=1.6U
M$489 \$1039 \$951 VDD VDD pfet_03v3 L=0.28U W=0.36U AS=0.1764P AD=0.1584P
+ PS=1.26U PD=1.6U
M$490 \$932 \$951 VDD VDD pfet_03v3 L=0.28U W=0.72U AS=0.1764P AD=0.36P
+ PS=1.26U PD=2.44U
M$491 \$1041 RA13 VDD VDD pfet_03v3 L=0.28U W=0.72U AS=0.3312P AD=0.3888P
+ PS=2.36U PD=2.52U
M$492 \$932 \$1041 \$51 VDD pfet_03v3 L=0.28U W=0.36U AS=0.1584P AD=0.1152P
+ PS=1.6U PD=1U
M$493 \$52 \$1042 \$932 VDD pfet_03v3 L=0.28U W=0.36U AS=0.1152P AD=0.1584P
+ PS=1U PD=1.6U
M$494 VDD RB13 \$1042 VDD pfet_03v3 L=0.28U W=0.72U AS=0.3708P AD=0.3168P
+ PS=2.47U PD=2.32U
M$495 \$952 \$109 VDD VDD pfet_03v3 L=0.28U W=0.72U AS=0.3168P AD=0.2097P
+ PS=2.32U PD=1.38U
M$496 \$953 \$1142 \$952 VDD pfet_03v3 L=0.28U W=0.36U AS=0.2097P AD=0.1278P
+ PS=1.38U PD=1.07U
M$497 \$1158 \$1043 \$953 VDD pfet_03v3 L=0.28U W=0.36U AS=0.1278P AD=0.0567P
+ PS=1.07U PD=0.675U
M$498 VDD \$949 \$1158 VDD pfet_03v3 L=0.28U W=0.36U AS=0.0567P AD=0.1584P
+ PS=0.675U PD=1.6U
M$499 \$1043 \$953 VDD VDD pfet_03v3 L=0.28U W=0.36U AS=0.1764P AD=0.1584P
+ PS=1.26U PD=1.6U
M$500 \$933 \$953 VDD VDD pfet_03v3 L=0.28U W=0.72U AS=0.1764P AD=0.36P
+ PS=1.26U PD=2.44U
M$501 \$1044 RA13 VDD VDD pfet_03v3 L=0.28U W=0.72U AS=0.3312P AD=0.3888P
+ PS=2.36U PD=2.52U
M$502 \$933 \$1044 \$53 VDD pfet_03v3 L=0.28U W=0.36U AS=0.1584P AD=0.1152P
+ PS=1.6U PD=1U
M$503 \$54 \$1045 \$933 VDD pfet_03v3 L=0.28U W=0.36U AS=0.1152P AD=0.1584P
+ PS=1U PD=1.6U
M$504 VDD RB13 \$1045 VDD pfet_03v3 L=0.28U W=0.72U AS=0.3708P AD=0.3168P
+ PS=2.47U PD=2.32U
M$505 \$954 \$112 VDD VDD pfet_03v3 L=0.28U W=0.72U AS=0.3168P AD=0.2097P
+ PS=2.32U PD=1.38U
M$506 \$955 \$1142 \$954 VDD pfet_03v3 L=0.28U W=0.36U AS=0.2097P AD=0.1278P
+ PS=1.38U PD=1.07U
M$507 \$1164 \$1046 \$955 VDD pfet_03v3 L=0.28U W=0.36U AS=0.1278P AD=0.0567P
+ PS=1.07U PD=0.675U
M$508 VDD \$949 \$1164 VDD pfet_03v3 L=0.28U W=0.36U AS=0.0567P AD=0.1584P
+ PS=0.675U PD=1.6U
M$509 \$1046 \$955 VDD VDD pfet_03v3 L=0.28U W=0.36U AS=0.1764P AD=0.1584P
+ PS=1.26U PD=1.6U
M$510 \$934 \$955 VDD VDD pfet_03v3 L=0.28U W=0.72U AS=0.1764P AD=0.36P
+ PS=1.26U PD=2.44U
M$511 \$1047 RA13 VDD VDD pfet_03v3 L=0.28U W=0.72U AS=0.3312P AD=0.3888P
+ PS=2.36U PD=2.52U
M$512 \$934 \$1047 \$55 VDD pfet_03v3 L=0.28U W=0.36U AS=0.1584P AD=0.1152P
+ PS=1.6U PD=1U
M$513 \$56 \$1048 \$934 VDD pfet_03v3 L=0.28U W=0.36U AS=0.1152P AD=0.1584P
+ PS=1U PD=1.6U
M$514 VDD RB13 \$1048 VDD pfet_03v3 L=0.28U W=0.72U AS=0.3708P AD=0.3168P
+ PS=2.47U PD=2.32U
M$515 \$956 \$115 VDD VDD pfet_03v3 L=0.28U W=0.72U AS=0.3168P AD=0.2097P
+ PS=2.32U PD=1.38U
M$516 \$957 \$1142 \$956 VDD pfet_03v3 L=0.28U W=0.36U AS=0.2097P AD=0.1278P
+ PS=1.38U PD=1.07U
M$517 \$1174 \$1049 \$957 VDD pfet_03v3 L=0.28U W=0.36U AS=0.1278P AD=0.0567P
+ PS=1.07U PD=0.675U
M$518 VDD \$949 \$1174 VDD pfet_03v3 L=0.28U W=0.36U AS=0.0567P AD=0.1584P
+ PS=0.675U PD=1.6U
M$519 \$1049 \$957 VDD VDD pfet_03v3 L=0.28U W=0.36U AS=0.1764P AD=0.1584P
+ PS=1.26U PD=1.6U
M$520 \$935 \$957 VDD VDD pfet_03v3 L=0.28U W=0.72U AS=0.1764P AD=0.36P
+ PS=1.26U PD=2.44U
M$521 \$1050 RA13 VDD VDD pfet_03v3 L=0.28U W=0.72U AS=0.3312P AD=0.3888P
+ PS=2.36U PD=2.52U
M$522 \$935 \$1050 \$57 VDD pfet_03v3 L=0.28U W=0.36U AS=0.1584P AD=0.1152P
+ PS=1.6U PD=1U
M$523 \$58 \$1051 \$935 VDD pfet_03v3 L=0.28U W=0.36U AS=0.1152P AD=0.1584P
+ PS=1U PD=1.6U
M$524 VDD RB13 \$1051 VDD pfet_03v3 L=0.28U W=0.72U AS=0.3708P AD=0.3168P
+ PS=2.47U PD=2.32U
M$525 \$958 \$118 VDD VDD pfet_03v3 L=0.28U W=0.72U AS=0.3168P AD=0.2097P
+ PS=2.32U PD=1.38U
M$526 \$959 \$1142 \$958 VDD pfet_03v3 L=0.28U W=0.36U AS=0.2097P AD=0.1278P
+ PS=1.38U PD=1.07U
M$527 \$1183 \$1052 \$959 VDD pfet_03v3 L=0.28U W=0.36U AS=0.1278P AD=0.0567P
+ PS=1.07U PD=0.675U
M$528 VDD \$949 \$1183 VDD pfet_03v3 L=0.28U W=0.36U AS=0.0567P AD=0.1584P
+ PS=0.675U PD=1.6U
M$529 \$1052 \$959 VDD VDD pfet_03v3 L=0.28U W=0.36U AS=0.1764P AD=0.1584P
+ PS=1.26U PD=1.6U
M$530 \$936 \$959 VDD VDD pfet_03v3 L=0.28U W=0.72U AS=0.1764P AD=0.36P
+ PS=1.26U PD=2.44U
M$531 \$1053 RA13 VDD VDD pfet_03v3 L=0.28U W=0.72U AS=0.3312P AD=0.3888P
+ PS=2.36U PD=2.52U
M$532 \$936 \$1053 \$59 VDD pfet_03v3 L=0.28U W=0.36U AS=0.1584P AD=0.1152P
+ PS=1.6U PD=1U
M$533 \$60 \$1054 \$936 VDD pfet_03v3 L=0.28U W=0.36U AS=0.1152P AD=0.1584P
+ PS=1U PD=1.6U
M$534 VDD RB13 \$1054 VDD pfet_03v3 L=0.28U W=0.72U AS=0.3708P AD=0.3168P
+ PS=2.47U PD=2.32U
M$535 \$960 \$121 VDD VDD pfet_03v3 L=0.28U W=0.72U AS=0.3168P AD=0.2097P
+ PS=2.32U PD=1.38U
M$536 \$961 \$1142 \$960 VDD pfet_03v3 L=0.28U W=0.36U AS=0.2097P AD=0.1278P
+ PS=1.38U PD=1.07U
M$537 \$1192 \$1055 \$961 VDD pfet_03v3 L=0.28U W=0.36U AS=0.1278P AD=0.0567P
+ PS=1.07U PD=0.675U
M$538 VDD \$949 \$1192 VDD pfet_03v3 L=0.28U W=0.36U AS=0.0567P AD=0.1584P
+ PS=0.675U PD=1.6U
M$539 \$1055 \$961 VDD VDD pfet_03v3 L=0.28U W=0.36U AS=0.1764P AD=0.1584P
+ PS=1.26U PD=1.6U
M$540 \$937 \$961 VDD VDD pfet_03v3 L=0.28U W=0.72U AS=0.1764P AD=0.36P
+ PS=1.26U PD=2.44U
M$541 \$1056 RA13 VDD VDD pfet_03v3 L=0.28U W=0.72U AS=0.3312P AD=0.3888P
+ PS=2.36U PD=2.52U
M$542 \$937 \$1056 \$61 VDD pfet_03v3 L=0.28U W=0.36U AS=0.1584P AD=0.1152P
+ PS=1.6U PD=1U
M$543 \$62 \$1057 \$937 VDD pfet_03v3 L=0.28U W=0.36U AS=0.1152P AD=0.1584P
+ PS=1U PD=1.6U
M$544 VDD RB13 \$1057 VDD pfet_03v3 L=0.28U W=0.72U AS=0.3708P AD=0.3168P
+ PS=2.47U PD=2.32U
M$545 \$962 \$124 VDD VDD pfet_03v3 L=0.28U W=0.72U AS=0.3168P AD=0.2097P
+ PS=2.32U PD=1.38U
M$546 \$963 \$1142 \$962 VDD pfet_03v3 L=0.28U W=0.36U AS=0.2097P AD=0.1278P
+ PS=1.38U PD=1.07U
M$547 \$1200 \$1058 \$963 VDD pfet_03v3 L=0.28U W=0.36U AS=0.1278P AD=0.0567P
+ PS=1.07U PD=0.675U
M$548 VDD \$949 \$1200 VDD pfet_03v3 L=0.28U W=0.36U AS=0.0567P AD=0.1584P
+ PS=0.675U PD=1.6U
M$549 \$1058 \$963 VDD VDD pfet_03v3 L=0.28U W=0.36U AS=0.1764P AD=0.1584P
+ PS=1.26U PD=1.6U
M$550 \$938 \$963 VDD VDD pfet_03v3 L=0.28U W=0.72U AS=0.1764P AD=0.36P
+ PS=1.26U PD=2.44U
M$551 \$1059 RA13 VDD VDD pfet_03v3 L=0.28U W=0.72U AS=0.3312P AD=0.3888P
+ PS=2.36U PD=2.52U
M$552 \$938 \$1059 \$63 VDD pfet_03v3 L=0.28U W=0.36U AS=0.1584P AD=0.1152P
+ PS=1.6U PD=1U
M$553 \$64 \$1060 \$938 VDD pfet_03v3 L=0.28U W=0.36U AS=0.1152P AD=0.1584P
+ PS=1U PD=1.6U
M$554 VDD RB13 \$1060 VDD pfet_03v3 L=0.28U W=0.72U AS=0.3708P AD=0.3168P
+ PS=2.47U PD=2.32U
M$555 \$964 \$127 VDD VDD pfet_03v3 L=0.28U W=0.72U AS=0.3168P AD=0.2097P
+ PS=2.32U PD=1.38U
M$556 \$965 \$1142 \$964 VDD pfet_03v3 L=0.28U W=0.36U AS=0.2097P AD=0.1278P
+ PS=1.38U PD=1.07U
M$557 \$1209 \$1061 \$965 VDD pfet_03v3 L=0.28U W=0.36U AS=0.1278P AD=0.0567P
+ PS=1.07U PD=0.675U
M$558 VDD \$949 \$1209 VDD pfet_03v3 L=0.28U W=0.36U AS=0.0567P AD=0.1584P
+ PS=0.675U PD=1.6U
M$559 \$1061 \$965 VDD VDD pfet_03v3 L=0.28U W=0.36U AS=0.1764P AD=0.1584P
+ PS=1.26U PD=1.6U
M$560 \$939 \$965 VDD VDD pfet_03v3 L=0.28U W=0.72U AS=0.1764P AD=0.36P
+ PS=1.26U PD=2.44U
M$561 \$1062 RA13 VDD VDD pfet_03v3 L=0.28U W=0.72U AS=0.3312P AD=0.3888P
+ PS=2.36U PD=2.52U
M$562 \$939 \$1062 \$65 VDD pfet_03v3 L=0.28U W=0.36U AS=0.1584P AD=0.1152P
+ PS=1.6U PD=1U
M$563 \$66 \$1063 \$939 VDD pfet_03v3 L=0.28U W=0.36U AS=0.1152P AD=0.1584P
+ PS=1U PD=1.6U
M$564 VDD RB13 \$1063 VDD pfet_03v3 L=0.28U W=0.72U AS=0.3708P AD=0.3168P
+ PS=2.47U PD=2.32U
M$565 \$966 \$130 VDD VDD pfet_03v3 L=0.28U W=0.72U AS=0.3168P AD=0.2097P
+ PS=2.32U PD=1.38U
M$566 \$967 \$1142 \$966 VDD pfet_03v3 L=0.28U W=0.36U AS=0.2097P AD=0.1278P
+ PS=1.38U PD=1.07U
M$567 \$1218 \$1064 \$967 VDD pfet_03v3 L=0.28U W=0.36U AS=0.1278P AD=0.0567P
+ PS=1.07U PD=0.675U
M$568 VDD \$949 \$1218 VDD pfet_03v3 L=0.28U W=0.36U AS=0.0567P AD=0.1584P
+ PS=0.675U PD=1.6U
M$569 \$1064 \$967 VDD VDD pfet_03v3 L=0.28U W=0.36U AS=0.1764P AD=0.1584P
+ PS=1.26U PD=1.6U
M$570 \$940 \$967 VDD VDD pfet_03v3 L=0.28U W=0.72U AS=0.1764P AD=0.36P
+ PS=1.26U PD=2.44U
M$571 \$1065 RA13 VDD VDD pfet_03v3 L=0.28U W=0.72U AS=0.3312P AD=0.3888P
+ PS=2.36U PD=2.52U
M$572 \$940 \$1065 \$67 VDD pfet_03v3 L=0.28U W=0.36U AS=0.1584P AD=0.1152P
+ PS=1.6U PD=1U
M$573 \$68 \$1066 \$940 VDD pfet_03v3 L=0.28U W=0.36U AS=0.1152P AD=0.1584P
+ PS=1U PD=1.6U
M$574 VDD RB13 \$1066 VDD pfet_03v3 L=0.28U W=0.72U AS=0.3708P AD=0.3168P
+ PS=2.47U PD=2.32U
M$575 \$968 \$133 VDD VDD pfet_03v3 L=0.28U W=0.72U AS=0.3168P AD=0.2097P
+ PS=2.32U PD=1.38U
M$576 \$969 \$1142 \$968 VDD pfet_03v3 L=0.28U W=0.36U AS=0.2097P AD=0.1278P
+ PS=1.38U PD=1.07U
M$577 \$1227 \$1067 \$969 VDD pfet_03v3 L=0.28U W=0.36U AS=0.1278P AD=0.0567P
+ PS=1.07U PD=0.675U
M$578 VDD \$949 \$1227 VDD pfet_03v3 L=0.28U W=0.36U AS=0.0567P AD=0.1584P
+ PS=0.675U PD=1.6U
M$579 \$1067 \$969 VDD VDD pfet_03v3 L=0.28U W=0.36U AS=0.1764P AD=0.1584P
+ PS=1.26U PD=1.6U
M$580 \$941 \$969 VDD VDD pfet_03v3 L=0.28U W=0.72U AS=0.1764P AD=0.36P
+ PS=1.26U PD=2.44U
M$581 \$1068 RA13 VDD VDD pfet_03v3 L=0.28U W=0.72U AS=0.3312P AD=0.3888P
+ PS=2.36U PD=2.52U
M$582 \$941 \$1068 \$69 VDD pfet_03v3 L=0.28U W=0.36U AS=0.1584P AD=0.1152P
+ PS=1.6U PD=1U
M$583 \$70 \$1069 \$941 VDD pfet_03v3 L=0.28U W=0.36U AS=0.1152P AD=0.1584P
+ PS=1U PD=1.6U
M$584 VDD RB13 \$1069 VDD pfet_03v3 L=0.28U W=0.72U AS=0.3708P AD=0.3168P
+ PS=2.47U PD=2.32U
M$585 \$970 \$136 VDD VDD pfet_03v3 L=0.28U W=0.72U AS=0.3168P AD=0.2097P
+ PS=2.32U PD=1.38U
M$586 \$971 \$1142 \$970 VDD pfet_03v3 L=0.28U W=0.36U AS=0.2097P AD=0.1278P
+ PS=1.38U PD=1.07U
M$587 \$1236 \$1070 \$971 VDD pfet_03v3 L=0.28U W=0.36U AS=0.1278P AD=0.0567P
+ PS=1.07U PD=0.675U
M$588 VDD \$949 \$1236 VDD pfet_03v3 L=0.28U W=0.36U AS=0.0567P AD=0.1584P
+ PS=0.675U PD=1.6U
M$589 \$1070 \$971 VDD VDD pfet_03v3 L=0.28U W=0.36U AS=0.1764P AD=0.1584P
+ PS=1.26U PD=1.6U
M$590 \$942 \$971 VDD VDD pfet_03v3 L=0.28U W=0.72U AS=0.1764P AD=0.36P
+ PS=1.26U PD=2.44U
M$591 \$1071 RA13 VDD VDD pfet_03v3 L=0.28U W=0.72U AS=0.3312P AD=0.3888P
+ PS=2.36U PD=2.52U
M$592 \$942 \$1071 \$71 VDD pfet_03v3 L=0.28U W=0.36U AS=0.1584P AD=0.1152P
+ PS=1.6U PD=1U
M$593 \$72 \$1072 \$942 VDD pfet_03v3 L=0.28U W=0.36U AS=0.1152P AD=0.1584P
+ PS=1U PD=1.6U
M$594 VDD RB13 \$1072 VDD pfet_03v3 L=0.28U W=0.72U AS=0.3708P AD=0.3168P
+ PS=2.47U PD=2.32U
M$595 \$972 \$139 VDD VDD pfet_03v3 L=0.28U W=0.72U AS=0.3168P AD=0.2097P
+ PS=2.32U PD=1.38U
M$596 \$973 \$1142 \$972 VDD pfet_03v3 L=0.28U W=0.36U AS=0.2097P AD=0.1278P
+ PS=1.38U PD=1.07U
M$597 \$1244 \$1073 \$973 VDD pfet_03v3 L=0.28U W=0.36U AS=0.1278P AD=0.0567P
+ PS=1.07U PD=0.675U
M$598 VDD \$949 \$1244 VDD pfet_03v3 L=0.28U W=0.36U AS=0.0567P AD=0.1584P
+ PS=0.675U PD=1.6U
M$599 \$1073 \$973 VDD VDD pfet_03v3 L=0.28U W=0.36U AS=0.1764P AD=0.1584P
+ PS=1.26U PD=1.6U
M$600 \$943 \$973 VDD VDD pfet_03v3 L=0.28U W=0.72U AS=0.1764P AD=0.36P
+ PS=1.26U PD=2.44U
M$601 \$1074 RA13 VDD VDD pfet_03v3 L=0.28U W=0.72U AS=0.3312P AD=0.3888P
+ PS=2.36U PD=2.52U
M$602 \$943 \$1074 \$73 VDD pfet_03v3 L=0.28U W=0.36U AS=0.1584P AD=0.1152P
+ PS=1.6U PD=1U
M$603 \$74 \$1075 \$943 VDD pfet_03v3 L=0.28U W=0.36U AS=0.1152P AD=0.1584P
+ PS=1U PD=1.6U
M$604 VDD RB13 \$1075 VDD pfet_03v3 L=0.28U W=0.72U AS=0.3708P AD=0.3168P
+ PS=2.47U PD=2.32U
M$605 \$974 \$142 VDD VDD pfet_03v3 L=0.28U W=0.72U AS=0.3168P AD=0.2097P
+ PS=2.32U PD=1.38U
M$606 \$975 \$1142 \$974 VDD pfet_03v3 L=0.28U W=0.36U AS=0.2097P AD=0.1278P
+ PS=1.38U PD=1.07U
M$607 \$1230 \$1076 \$975 VDD pfet_03v3 L=0.28U W=0.36U AS=0.1278P AD=0.0567P
+ PS=1.07U PD=0.675U
M$608 VDD \$949 \$1230 VDD pfet_03v3 L=0.28U W=0.36U AS=0.0567P AD=0.1584P
+ PS=0.675U PD=1.6U
M$609 \$1076 \$975 VDD VDD pfet_03v3 L=0.28U W=0.36U AS=0.1764P AD=0.1584P
+ PS=1.26U PD=1.6U
M$610 \$944 \$975 VDD VDD pfet_03v3 L=0.28U W=0.72U AS=0.1764P AD=0.36P
+ PS=1.26U PD=2.44U
M$611 \$1077 RA13 VDD VDD pfet_03v3 L=0.28U W=0.72U AS=0.3312P AD=0.3888P
+ PS=2.36U PD=2.52U
M$612 \$944 \$1077 \$75 VDD pfet_03v3 L=0.28U W=0.36U AS=0.1584P AD=0.1152P
+ PS=1.6U PD=1U
M$613 \$76 \$1078 \$944 VDD pfet_03v3 L=0.28U W=0.36U AS=0.1152P AD=0.1584P
+ PS=1U PD=1.6U
M$614 VDD RB13 \$1078 VDD pfet_03v3 L=0.28U W=0.72U AS=0.3708P AD=0.3168P
+ PS=2.47U PD=2.32U
M$615 \$976 \$145 VDD VDD pfet_03v3 L=0.28U W=0.72U AS=0.3168P AD=0.2097P
+ PS=2.32U PD=1.38U
M$616 \$977 \$1142 \$976 VDD pfet_03v3 L=0.28U W=0.36U AS=0.2097P AD=0.1278P
+ PS=1.38U PD=1.07U
M$617 \$1202 \$1079 \$977 VDD pfet_03v3 L=0.28U W=0.36U AS=0.1278P AD=0.0567P
+ PS=1.07U PD=0.675U
M$618 VDD \$949 \$1202 VDD pfet_03v3 L=0.28U W=0.36U AS=0.0567P AD=0.1584P
+ PS=0.675U PD=1.6U
M$619 \$1079 \$977 VDD VDD pfet_03v3 L=0.28U W=0.36U AS=0.1764P AD=0.1584P
+ PS=1.26U PD=1.6U
M$620 \$945 \$977 VDD VDD pfet_03v3 L=0.28U W=0.72U AS=0.1764P AD=0.36P
+ PS=1.26U PD=2.44U
M$621 \$1080 RA13 VDD VDD pfet_03v3 L=0.28U W=0.72U AS=0.3312P AD=0.3888P
+ PS=2.36U PD=2.52U
M$622 \$945 \$1080 \$77 VDD pfet_03v3 L=0.28U W=0.36U AS=0.1584P AD=0.1152P
+ PS=1.6U PD=1U
M$623 \$78 \$1081 \$945 VDD pfet_03v3 L=0.28U W=0.36U AS=0.1152P AD=0.1584P
+ PS=1U PD=1.6U
M$624 VDD RB13 \$1081 VDD pfet_03v3 L=0.28U W=0.72U AS=0.3708P AD=0.3168P
+ PS=2.47U PD=2.32U
M$625 \$978 \$148 VDD VDD pfet_03v3 L=0.28U W=0.72U AS=0.3168P AD=0.2097P
+ PS=2.32U PD=1.38U
M$626 \$979 \$1142 \$978 VDD pfet_03v3 L=0.28U W=0.36U AS=0.2097P AD=0.1278P
+ PS=1.38U PD=1.07U
M$627 \$1184 \$1082 \$979 VDD pfet_03v3 L=0.28U W=0.36U AS=0.1278P AD=0.0567P
+ PS=1.07U PD=0.675U
M$628 VDD \$949 \$1184 VDD pfet_03v3 L=0.28U W=0.36U AS=0.0567P AD=0.1584P
+ PS=0.675U PD=1.6U
M$629 \$1082 \$979 VDD VDD pfet_03v3 L=0.28U W=0.36U AS=0.1764P AD=0.1584P
+ PS=1.26U PD=1.6U
M$630 \$946 \$979 VDD VDD pfet_03v3 L=0.28U W=0.72U AS=0.1764P AD=0.36P
+ PS=1.26U PD=2.44U
M$631 \$1083 RA13 VDD VDD pfet_03v3 L=0.28U W=0.72U AS=0.3312P AD=0.3888P
+ PS=2.36U PD=2.52U
M$632 \$946 \$1083 \$79 VDD pfet_03v3 L=0.28U W=0.36U AS=0.1584P AD=0.1152P
+ PS=1.6U PD=1U
M$633 \$80 \$1084 \$946 VDD pfet_03v3 L=0.28U W=0.36U AS=0.1152P AD=0.1584P
+ PS=1U PD=1.6U
M$634 VDD RB13 \$1084 VDD pfet_03v3 L=0.28U W=0.72U AS=0.3708P AD=0.3168P
+ PS=2.47U PD=2.32U
M$635 \$980 \$151 VDD VDD pfet_03v3 L=0.28U W=0.72U AS=0.3168P AD=0.2097P
+ PS=2.32U PD=1.38U
M$636 \$981 \$1142 \$980 VDD pfet_03v3 L=0.28U W=0.36U AS=0.2097P AD=0.1278P
+ PS=1.38U PD=1.07U
M$637 \$1156 \$1085 \$981 VDD pfet_03v3 L=0.28U W=0.36U AS=0.1278P AD=0.0567P
+ PS=1.07U PD=0.675U
M$638 VDD \$949 \$1156 VDD pfet_03v3 L=0.28U W=0.36U AS=0.0567P AD=0.1584P
+ PS=0.675U PD=1.6U
M$639 \$1085 \$981 VDD VDD pfet_03v3 L=0.28U W=0.36U AS=0.1764P AD=0.1584P
+ PS=1.26U PD=1.6U
M$640 \$947 \$981 VDD VDD pfet_03v3 L=0.28U W=0.72U AS=0.1764P AD=0.36P
+ PS=1.26U PD=2.44U
M$641 \$1086 RA13 VDD VDD pfet_03v3 L=0.28U W=0.72U AS=0.3312P AD=0.3888P
+ PS=2.36U PD=2.52U
M$642 \$947 \$1086 \$81 VDD pfet_03v3 L=0.28U W=0.36U AS=0.1584P AD=0.1152P
+ PS=1.6U PD=1U
M$643 \$82 \$1087 \$947 VDD pfet_03v3 L=0.28U W=0.36U AS=0.1152P AD=0.1584P
+ PS=1U PD=1.6U
M$644 VDD RB13 \$1087 VDD pfet_03v3 L=0.28U W=0.72U AS=0.3708P AD=0.3168P
+ PS=2.47U PD=2.32U
M$645 \$1248 WE12 VDD VDD pfet_03v3 L=0.28U W=0.72U AS=0.3168P AD=0.1872P
+ PS=2.32U PD=1.24U
M$646 VDD CLK \$1248 VDD pfet_03v3 L=0.28U W=0.72U AS=0.1872P AD=0.3168P
+ PS=1.24U PD=2.32U
M$647 \$1250 \$1248 VDD VDD pfet_03v3 L=0.28U W=1.27U AS=0.5588P AD=0.3302P
+ PS=3.42U PD=1.79U
M$648 VDD \$1248 \$1250 VDD pfet_03v3 L=0.28U W=1.27U AS=0.3302P AD=0.3386P
+ PS=1.79U PD=1.86U
M$649 \$1251 \$1250 VDD VDD pfet_03v3 L=0.28U W=1.34U AS=0.3386P AD=0.3886P
+ PS=1.86U PD=1.92U
M$650 VDD \$1250 \$1251 VDD pfet_03v3 L=0.28U W=1.34U AS=0.3886P AD=0.5896P
+ PS=1.92U PD=3.56U
M$651 \$1255 \$1251 \$1254 VDD pfet_03v3 L=0.28U W=0.36U AS=0.2097P AD=0.1278P
+ PS=1.38U PD=1.07U
M$652 \$1355 \$1256 \$1255 VDD pfet_03v3 L=0.28U W=0.36U AS=0.1278P AD=0.0567P
+ PS=1.07U PD=0.675U
M$653 VDD \$1250 \$1355 VDD pfet_03v3 L=0.28U W=0.36U AS=0.0567P AD=0.1584P
+ PS=0.675U PD=1.6U
M$654 \$1254 \$106 VDD VDD pfet_03v3 L=0.28U W=0.72U AS=0.3168P AD=0.2097P
+ PS=2.32U PD=1.38U
M$655 VDD \$1255 \$1256 VDD pfet_03v3 L=0.28U W=0.36U AS=0.1584P AD=0.1764P
+ PS=1.6U PD=1.26U
M$656 \$1257 \$1255 VDD VDD pfet_03v3 L=0.28U W=0.72U AS=0.1764P AD=0.36P
+ PS=1.26U PD=2.44U
M$657 \$1258 RB12 VDD VDD pfet_03v3 L=0.28U W=0.72U AS=0.3312P AD=0.3888P
+ PS=2.36U PD=2.52U
M$658 \$1257 \$1258 \$51 VDD pfet_03v3 L=0.28U W=0.36U AS=0.1584P AD=0.1152P
+ PS=1.6U PD=1U
M$659 \$52 \$1259 \$1257 VDD pfet_03v3 L=0.28U W=0.36U AS=0.1152P AD=0.1584P
+ PS=1U PD=1.6U
M$660 VDD RA12 \$1259 VDD pfet_03v3 L=0.28U W=0.72U AS=0.3708P AD=0.3168P
+ PS=2.47U PD=2.32U
M$661 \$1261 \$1251 \$1260 VDD pfet_03v3 L=0.28U W=0.36U AS=0.2097P AD=0.1278P
+ PS=1.38U PD=1.07U
M$662 \$1363 \$1262 \$1261 VDD pfet_03v3 L=0.28U W=0.36U AS=0.1278P AD=0.0567P
+ PS=1.07U PD=0.675U
M$663 VDD \$1250 \$1363 VDD pfet_03v3 L=0.28U W=0.36U AS=0.0567P AD=0.1584P
+ PS=0.675U PD=1.6U
M$664 \$1260 \$109 VDD VDD pfet_03v3 L=0.28U W=0.72U AS=0.3168P AD=0.2097P
+ PS=2.32U PD=1.38U
M$665 VDD \$1261 \$1262 VDD pfet_03v3 L=0.28U W=0.36U AS=0.1584P AD=0.1764P
+ PS=1.6U PD=1.26U
M$666 \$1263 \$1261 VDD VDD pfet_03v3 L=0.28U W=0.72U AS=0.1764P AD=0.36P
+ PS=1.26U PD=2.44U
M$667 \$1264 RB12 VDD VDD pfet_03v3 L=0.28U W=0.72U AS=0.3312P AD=0.3888P
+ PS=2.36U PD=2.52U
M$668 \$1263 \$1264 \$53 VDD pfet_03v3 L=0.28U W=0.36U AS=0.1584P AD=0.1152P
+ PS=1.6U PD=1U
M$669 \$54 \$1265 \$1263 VDD pfet_03v3 L=0.28U W=0.36U AS=0.1152P AD=0.1584P
+ PS=1U PD=1.6U
M$670 VDD RA12 \$1265 VDD pfet_03v3 L=0.28U W=0.72U AS=0.3708P AD=0.3168P
+ PS=2.47U PD=2.32U
M$671 \$1267 \$1251 \$1266 VDD pfet_03v3 L=0.28U W=0.36U AS=0.2097P AD=0.1278P
+ PS=1.38U PD=1.07U
M$672 \$1370 \$1268 \$1267 VDD pfet_03v3 L=0.28U W=0.36U AS=0.1278P AD=0.0567P
+ PS=1.07U PD=0.675U
M$673 VDD \$1250 \$1370 VDD pfet_03v3 L=0.28U W=0.36U AS=0.0567P AD=0.1584P
+ PS=0.675U PD=1.6U
M$674 \$1266 \$112 VDD VDD pfet_03v3 L=0.28U W=0.72U AS=0.3168P AD=0.2097P
+ PS=2.32U PD=1.38U
M$675 VDD \$1267 \$1268 VDD pfet_03v3 L=0.28U W=0.36U AS=0.1584P AD=0.1764P
+ PS=1.6U PD=1.26U
M$676 \$1269 \$1267 VDD VDD pfet_03v3 L=0.28U W=0.72U AS=0.1764P AD=0.36P
+ PS=1.26U PD=2.44U
M$677 \$1270 RB12 VDD VDD pfet_03v3 L=0.28U W=0.72U AS=0.3312P AD=0.3888P
+ PS=2.36U PD=2.52U
M$678 \$1269 \$1270 \$55 VDD pfet_03v3 L=0.28U W=0.36U AS=0.1584P AD=0.1152P
+ PS=1.6U PD=1U
M$679 \$56 \$1271 \$1269 VDD pfet_03v3 L=0.28U W=0.36U AS=0.1152P AD=0.1584P
+ PS=1U PD=1.6U
M$680 VDD RA12 \$1271 VDD pfet_03v3 L=0.28U W=0.72U AS=0.3708P AD=0.3168P
+ PS=2.47U PD=2.32U
M$681 \$1273 \$1251 \$1272 VDD pfet_03v3 L=0.28U W=0.36U AS=0.2097P AD=0.1278P
+ PS=1.38U PD=1.07U
M$682 \$1378 \$1274 \$1273 VDD pfet_03v3 L=0.28U W=0.36U AS=0.1278P AD=0.0567P
+ PS=1.07U PD=0.675U
M$683 VDD \$1250 \$1378 VDD pfet_03v3 L=0.28U W=0.36U AS=0.0567P AD=0.1584P
+ PS=0.675U PD=1.6U
M$684 \$1272 \$115 VDD VDD pfet_03v3 L=0.28U W=0.72U AS=0.3168P AD=0.2097P
+ PS=2.32U PD=1.38U
M$685 VDD \$1273 \$1274 VDD pfet_03v3 L=0.28U W=0.36U AS=0.1584P AD=0.1764P
+ PS=1.6U PD=1.26U
M$686 \$1275 \$1273 VDD VDD pfet_03v3 L=0.28U W=0.72U AS=0.1764P AD=0.36P
+ PS=1.26U PD=2.44U
M$687 \$1276 RB12 VDD VDD pfet_03v3 L=0.28U W=0.72U AS=0.3312P AD=0.3888P
+ PS=2.36U PD=2.52U
M$688 \$1275 \$1276 \$57 VDD pfet_03v3 L=0.28U W=0.36U AS=0.1584P AD=0.1152P
+ PS=1.6U PD=1U
M$689 \$58 \$1277 \$1275 VDD pfet_03v3 L=0.28U W=0.36U AS=0.1152P AD=0.1584P
+ PS=1U PD=1.6U
M$690 VDD RA12 \$1277 VDD pfet_03v3 L=0.28U W=0.72U AS=0.3708P AD=0.3168P
+ PS=2.47U PD=2.32U
M$691 \$1279 \$1251 \$1278 VDD pfet_03v3 L=0.28U W=0.36U AS=0.2097P AD=0.1278P
+ PS=1.38U PD=1.07U
M$692 \$1387 \$1280 \$1279 VDD pfet_03v3 L=0.28U W=0.36U AS=0.1278P AD=0.0567P
+ PS=1.07U PD=0.675U
M$693 VDD \$1250 \$1387 VDD pfet_03v3 L=0.28U W=0.36U AS=0.0567P AD=0.1584P
+ PS=0.675U PD=1.6U
M$694 \$1278 \$118 VDD VDD pfet_03v3 L=0.28U W=0.72U AS=0.3168P AD=0.2097P
+ PS=2.32U PD=1.38U
M$695 VDD \$1279 \$1280 VDD pfet_03v3 L=0.28U W=0.36U AS=0.1584P AD=0.1764P
+ PS=1.6U PD=1.26U
M$696 \$1281 \$1279 VDD VDD pfet_03v3 L=0.28U W=0.72U AS=0.1764P AD=0.36P
+ PS=1.26U PD=2.44U
M$697 \$1282 RB12 VDD VDD pfet_03v3 L=0.28U W=0.72U AS=0.3312P AD=0.3888P
+ PS=2.36U PD=2.52U
M$698 \$1281 \$1282 \$59 VDD pfet_03v3 L=0.28U W=0.36U AS=0.1584P AD=0.1152P
+ PS=1.6U PD=1U
M$699 \$60 \$1283 \$1281 VDD pfet_03v3 L=0.28U W=0.36U AS=0.1152P AD=0.1584P
+ PS=1U PD=1.6U
M$700 VDD RA12 \$1283 VDD pfet_03v3 L=0.28U W=0.72U AS=0.3708P AD=0.3168P
+ PS=2.47U PD=2.32U
M$701 \$1285 \$1251 \$1284 VDD pfet_03v3 L=0.28U W=0.36U AS=0.2097P AD=0.1278P
+ PS=1.38U PD=1.07U
M$702 \$1393 \$1286 \$1285 VDD pfet_03v3 L=0.28U W=0.36U AS=0.1278P AD=0.0567P
+ PS=1.07U PD=0.675U
M$703 VDD \$1250 \$1393 VDD pfet_03v3 L=0.28U W=0.36U AS=0.0567P AD=0.1584P
+ PS=0.675U PD=1.6U
M$704 \$1284 \$121 VDD VDD pfet_03v3 L=0.28U W=0.72U AS=0.3168P AD=0.2097P
+ PS=2.32U PD=1.38U
M$705 VDD \$1285 \$1286 VDD pfet_03v3 L=0.28U W=0.36U AS=0.1584P AD=0.1764P
+ PS=1.6U PD=1.26U
M$706 \$1287 \$1285 VDD VDD pfet_03v3 L=0.28U W=0.72U AS=0.1764P AD=0.36P
+ PS=1.26U PD=2.44U
M$707 \$1288 RB12 VDD VDD pfet_03v3 L=0.28U W=0.72U AS=0.3312P AD=0.3888P
+ PS=2.36U PD=2.52U
M$708 \$1287 \$1288 \$61 VDD pfet_03v3 L=0.28U W=0.36U AS=0.1584P AD=0.1152P
+ PS=1.6U PD=1U
M$709 \$62 \$1289 \$1287 VDD pfet_03v3 L=0.28U W=0.36U AS=0.1152P AD=0.1584P
+ PS=1U PD=1.6U
M$710 VDD RA12 \$1289 VDD pfet_03v3 L=0.28U W=0.72U AS=0.3708P AD=0.3168P
+ PS=2.47U PD=2.32U
M$711 \$1291 \$1251 \$1290 VDD pfet_03v3 L=0.28U W=0.36U AS=0.2097P AD=0.1278P
+ PS=1.38U PD=1.07U
M$712 \$1400 \$1292 \$1291 VDD pfet_03v3 L=0.28U W=0.36U AS=0.1278P AD=0.0567P
+ PS=1.07U PD=0.675U
M$713 VDD \$1250 \$1400 VDD pfet_03v3 L=0.28U W=0.36U AS=0.0567P AD=0.1584P
+ PS=0.675U PD=1.6U
M$714 \$1290 \$124 VDD VDD pfet_03v3 L=0.28U W=0.72U AS=0.3168P AD=0.2097P
+ PS=2.32U PD=1.38U
M$715 VDD \$1291 \$1292 VDD pfet_03v3 L=0.28U W=0.36U AS=0.1584P AD=0.1764P
+ PS=1.6U PD=1.26U
M$716 \$1293 \$1291 VDD VDD pfet_03v3 L=0.28U W=0.72U AS=0.1764P AD=0.36P
+ PS=1.26U PD=2.44U
M$717 \$1294 RB12 VDD VDD pfet_03v3 L=0.28U W=0.72U AS=0.3312P AD=0.3888P
+ PS=2.36U PD=2.52U
M$718 \$1293 \$1294 \$63 VDD pfet_03v3 L=0.28U W=0.36U AS=0.1584P AD=0.1152P
+ PS=1.6U PD=1U
M$719 \$64 \$1295 \$1293 VDD pfet_03v3 L=0.28U W=0.36U AS=0.1152P AD=0.1584P
+ PS=1U PD=1.6U
M$720 VDD RA12 \$1295 VDD pfet_03v3 L=0.28U W=0.72U AS=0.3708P AD=0.3168P
+ PS=2.47U PD=2.32U
M$721 \$1297 \$1251 \$1296 VDD pfet_03v3 L=0.28U W=0.36U AS=0.2097P AD=0.1278P
+ PS=1.38U PD=1.07U
M$722 \$1409 \$1298 \$1297 VDD pfet_03v3 L=0.28U W=0.36U AS=0.1278P AD=0.0567P
+ PS=1.07U PD=0.675U
M$723 VDD \$1250 \$1409 VDD pfet_03v3 L=0.28U W=0.36U AS=0.0567P AD=0.1584P
+ PS=0.675U PD=1.6U
M$724 \$1296 \$127 VDD VDD pfet_03v3 L=0.28U W=0.72U AS=0.3168P AD=0.2097P
+ PS=2.32U PD=1.38U
M$725 VDD \$1297 \$1298 VDD pfet_03v3 L=0.28U W=0.36U AS=0.1584P AD=0.1764P
+ PS=1.6U PD=1.26U
M$726 \$1299 \$1297 VDD VDD pfet_03v3 L=0.28U W=0.72U AS=0.1764P AD=0.36P
+ PS=1.26U PD=2.44U
M$727 \$1300 RB12 VDD VDD pfet_03v3 L=0.28U W=0.72U AS=0.3312P AD=0.3888P
+ PS=2.36U PD=2.52U
M$728 \$1299 \$1300 \$65 VDD pfet_03v3 L=0.28U W=0.36U AS=0.1584P AD=0.1152P
+ PS=1.6U PD=1U
M$729 \$66 \$1301 \$1299 VDD pfet_03v3 L=0.28U W=0.36U AS=0.1152P AD=0.1584P
+ PS=1U PD=1.6U
M$730 VDD RA12 \$1301 VDD pfet_03v3 L=0.28U W=0.72U AS=0.3708P AD=0.3168P
+ PS=2.47U PD=2.32U
M$731 \$1303 \$1251 \$1302 VDD pfet_03v3 L=0.28U W=0.36U AS=0.2097P AD=0.1278P
+ PS=1.38U PD=1.07U
M$732 \$1415 \$1304 \$1303 VDD pfet_03v3 L=0.28U W=0.36U AS=0.1278P AD=0.0567P
+ PS=1.07U PD=0.675U
M$733 VDD \$1250 \$1415 VDD pfet_03v3 L=0.28U W=0.36U AS=0.0567P AD=0.1584P
+ PS=0.675U PD=1.6U
M$734 \$1302 \$130 VDD VDD pfet_03v3 L=0.28U W=0.72U AS=0.3168P AD=0.2097P
+ PS=2.32U PD=1.38U
M$735 VDD \$1303 \$1304 VDD pfet_03v3 L=0.28U W=0.36U AS=0.1584P AD=0.1764P
+ PS=1.6U PD=1.26U
M$736 \$1305 \$1303 VDD VDD pfet_03v3 L=0.28U W=0.72U AS=0.1764P AD=0.36P
+ PS=1.26U PD=2.44U
M$737 \$1306 RB12 VDD VDD pfet_03v3 L=0.28U W=0.72U AS=0.3312P AD=0.3888P
+ PS=2.36U PD=2.52U
M$738 \$1305 \$1306 \$67 VDD pfet_03v3 L=0.28U W=0.36U AS=0.1584P AD=0.1152P
+ PS=1.6U PD=1U
M$739 \$68 \$1307 \$1305 VDD pfet_03v3 L=0.28U W=0.36U AS=0.1152P AD=0.1584P
+ PS=1U PD=1.6U
M$740 VDD RA12 \$1307 VDD pfet_03v3 L=0.28U W=0.72U AS=0.3708P AD=0.3168P
+ PS=2.47U PD=2.32U
M$741 \$1309 \$1251 \$1308 VDD pfet_03v3 L=0.28U W=0.36U AS=0.2097P AD=0.1278P
+ PS=1.38U PD=1.07U
M$742 \$1422 \$1310 \$1309 VDD pfet_03v3 L=0.28U W=0.36U AS=0.1278P AD=0.0567P
+ PS=1.07U PD=0.675U
M$743 VDD \$1250 \$1422 VDD pfet_03v3 L=0.28U W=0.36U AS=0.0567P AD=0.1584P
+ PS=0.675U PD=1.6U
M$744 \$1308 \$133 VDD VDD pfet_03v3 L=0.28U W=0.72U AS=0.3168P AD=0.2097P
+ PS=2.32U PD=1.38U
M$745 VDD \$1309 \$1310 VDD pfet_03v3 L=0.28U W=0.36U AS=0.1584P AD=0.1764P
+ PS=1.6U PD=1.26U
M$746 \$1311 \$1309 VDD VDD pfet_03v3 L=0.28U W=0.72U AS=0.1764P AD=0.36P
+ PS=1.26U PD=2.44U
M$747 \$1312 RB12 VDD VDD pfet_03v3 L=0.28U W=0.72U AS=0.3312P AD=0.3888P
+ PS=2.36U PD=2.52U
M$748 \$1311 \$1312 \$69 VDD pfet_03v3 L=0.28U W=0.36U AS=0.1584P AD=0.1152P
+ PS=1.6U PD=1U
M$749 \$70 \$1313 \$1311 VDD pfet_03v3 L=0.28U W=0.36U AS=0.1152P AD=0.1584P
+ PS=1U PD=1.6U
M$750 VDD RA12 \$1313 VDD pfet_03v3 L=0.28U W=0.72U AS=0.3708P AD=0.3168P
+ PS=2.47U PD=2.32U
M$751 \$1315 \$1251 \$1314 VDD pfet_03v3 L=0.28U W=0.36U AS=0.2097P AD=0.1278P
+ PS=1.38U PD=1.07U
M$752 \$1430 \$1316 \$1315 VDD pfet_03v3 L=0.28U W=0.36U AS=0.1278P AD=0.0567P
+ PS=1.07U PD=0.675U
M$753 VDD \$1250 \$1430 VDD pfet_03v3 L=0.28U W=0.36U AS=0.0567P AD=0.1584P
+ PS=0.675U PD=1.6U
M$754 \$1314 \$136 VDD VDD pfet_03v3 L=0.28U W=0.72U AS=0.3168P AD=0.2097P
+ PS=2.32U PD=1.38U
M$755 VDD \$1315 \$1316 VDD pfet_03v3 L=0.28U W=0.36U AS=0.1584P AD=0.1764P
+ PS=1.6U PD=1.26U
M$756 \$1317 \$1315 VDD VDD pfet_03v3 L=0.28U W=0.72U AS=0.1764P AD=0.36P
+ PS=1.26U PD=2.44U
M$757 \$1318 RB12 VDD VDD pfet_03v3 L=0.28U W=0.72U AS=0.3312P AD=0.3888P
+ PS=2.36U PD=2.52U
M$758 \$1317 \$1318 \$71 VDD pfet_03v3 L=0.28U W=0.36U AS=0.1584P AD=0.1152P
+ PS=1.6U PD=1U
M$759 \$72 \$1319 \$1317 VDD pfet_03v3 L=0.28U W=0.36U AS=0.1152P AD=0.1584P
+ PS=1U PD=1.6U
M$760 VDD RA12 \$1319 VDD pfet_03v3 L=0.28U W=0.72U AS=0.3708P AD=0.3168P
+ PS=2.47U PD=2.32U
M$761 \$1321 \$1251 \$1320 VDD pfet_03v3 L=0.28U W=0.36U AS=0.2097P AD=0.1278P
+ PS=1.38U PD=1.07U
M$762 \$1438 \$1322 \$1321 VDD pfet_03v3 L=0.28U W=0.36U AS=0.1278P AD=0.0567P
+ PS=1.07U PD=0.675U
M$763 VDD \$1250 \$1438 VDD pfet_03v3 L=0.28U W=0.36U AS=0.0567P AD=0.1584P
+ PS=0.675U PD=1.6U
M$764 \$1320 \$139 VDD VDD pfet_03v3 L=0.28U W=0.72U AS=0.3168P AD=0.2097P
+ PS=2.32U PD=1.38U
M$765 VDD \$1321 \$1322 VDD pfet_03v3 L=0.28U W=0.36U AS=0.1584P AD=0.1764P
+ PS=1.6U PD=1.26U
M$766 \$1323 \$1321 VDD VDD pfet_03v3 L=0.28U W=0.72U AS=0.1764P AD=0.36P
+ PS=1.26U PD=2.44U
M$767 \$1324 RB12 VDD VDD pfet_03v3 L=0.28U W=0.72U AS=0.3312P AD=0.3888P
+ PS=2.36U PD=2.52U
M$768 \$1323 \$1324 \$73 VDD pfet_03v3 L=0.28U W=0.36U AS=0.1584P AD=0.1152P
+ PS=1.6U PD=1U
M$769 \$74 \$1325 \$1323 VDD pfet_03v3 L=0.28U W=0.36U AS=0.1152P AD=0.1584P
+ PS=1U PD=1.6U
M$770 VDD RA12 \$1325 VDD pfet_03v3 L=0.28U W=0.72U AS=0.3708P AD=0.3168P
+ PS=2.47U PD=2.32U
M$771 \$1327 \$1251 \$1326 VDD pfet_03v3 L=0.28U W=0.36U AS=0.2097P AD=0.1278P
+ PS=1.38U PD=1.07U
M$772 \$1445 \$1328 \$1327 VDD pfet_03v3 L=0.28U W=0.36U AS=0.1278P AD=0.0567P
+ PS=1.07U PD=0.675U
M$773 VDD \$1250 \$1445 VDD pfet_03v3 L=0.28U W=0.36U AS=0.0567P AD=0.1584P
+ PS=0.675U PD=1.6U
M$774 \$1326 \$142 VDD VDD pfet_03v3 L=0.28U W=0.72U AS=0.3168P AD=0.2097P
+ PS=2.32U PD=1.38U
M$775 VDD \$1327 \$1328 VDD pfet_03v3 L=0.28U W=0.36U AS=0.1584P AD=0.1764P
+ PS=1.6U PD=1.26U
M$776 \$1329 \$1327 VDD VDD pfet_03v3 L=0.28U W=0.72U AS=0.1764P AD=0.36P
+ PS=1.26U PD=2.44U
M$777 \$1330 RB12 VDD VDD pfet_03v3 L=0.28U W=0.72U AS=0.3312P AD=0.3888P
+ PS=2.36U PD=2.52U
M$778 \$1329 \$1330 \$75 VDD pfet_03v3 L=0.28U W=0.36U AS=0.1584P AD=0.1152P
+ PS=1.6U PD=1U
M$779 \$76 \$1331 \$1329 VDD pfet_03v3 L=0.28U W=0.36U AS=0.1152P AD=0.1584P
+ PS=1U PD=1.6U
M$780 VDD RA12 \$1331 VDD pfet_03v3 L=0.28U W=0.72U AS=0.3708P AD=0.3168P
+ PS=2.47U PD=2.32U
M$781 \$1333 \$1251 \$1332 VDD pfet_03v3 L=0.28U W=0.36U AS=0.2097P AD=0.1278P
+ PS=1.38U PD=1.07U
M$782 \$1444 \$1334 \$1333 VDD pfet_03v3 L=0.28U W=0.36U AS=0.1278P AD=0.0567P
+ PS=1.07U PD=0.675U
M$783 VDD \$1250 \$1444 VDD pfet_03v3 L=0.28U W=0.36U AS=0.0567P AD=0.1584P
+ PS=0.675U PD=1.6U
M$784 \$1332 \$145 VDD VDD pfet_03v3 L=0.28U W=0.72U AS=0.3168P AD=0.2097P
+ PS=2.32U PD=1.38U
M$785 VDD \$1333 \$1334 VDD pfet_03v3 L=0.28U W=0.36U AS=0.1584P AD=0.1764P
+ PS=1.6U PD=1.26U
M$786 \$1335 \$1333 VDD VDD pfet_03v3 L=0.28U W=0.72U AS=0.1764P AD=0.36P
+ PS=1.26U PD=2.44U
M$787 \$1336 RB12 VDD VDD pfet_03v3 L=0.28U W=0.72U AS=0.3312P AD=0.3888P
+ PS=2.36U PD=2.52U
M$788 \$1335 \$1336 \$77 VDD pfet_03v3 L=0.28U W=0.36U AS=0.1584P AD=0.1152P
+ PS=1.6U PD=1U
M$789 \$78 \$1337 \$1335 VDD pfet_03v3 L=0.28U W=0.36U AS=0.1152P AD=0.1584P
+ PS=1U PD=1.6U
M$790 VDD RA12 \$1337 VDD pfet_03v3 L=0.28U W=0.72U AS=0.3708P AD=0.3168P
+ PS=2.47U PD=2.32U
M$791 \$1339 \$1251 \$1338 VDD pfet_03v3 L=0.28U W=0.36U AS=0.2097P AD=0.1278P
+ PS=1.38U PD=1.07U
M$792 \$1412 \$1340 \$1339 VDD pfet_03v3 L=0.28U W=0.36U AS=0.1278P AD=0.0567P
+ PS=1.07U PD=0.675U
M$793 VDD \$1250 \$1412 VDD pfet_03v3 L=0.28U W=0.36U AS=0.0567P AD=0.1584P
+ PS=0.675U PD=1.6U
M$794 \$1338 \$148 VDD VDD pfet_03v3 L=0.28U W=0.72U AS=0.3168P AD=0.2097P
+ PS=2.32U PD=1.38U
M$795 VDD \$1339 \$1340 VDD pfet_03v3 L=0.28U W=0.36U AS=0.1584P AD=0.1764P
+ PS=1.6U PD=1.26U
M$796 \$1341 \$1339 VDD VDD pfet_03v3 L=0.28U W=0.72U AS=0.1764P AD=0.36P
+ PS=1.26U PD=2.44U
M$797 \$1342 RB12 VDD VDD pfet_03v3 L=0.28U W=0.72U AS=0.3312P AD=0.3888P
+ PS=2.36U PD=2.52U
M$798 \$1341 \$1342 \$79 VDD pfet_03v3 L=0.28U W=0.36U AS=0.1584P AD=0.1152P
+ PS=1.6U PD=1U
M$799 \$80 \$1343 \$1341 VDD pfet_03v3 L=0.28U W=0.36U AS=0.1152P AD=0.1584P
+ PS=1U PD=1.6U
M$800 VDD RA12 \$1343 VDD pfet_03v3 L=0.28U W=0.72U AS=0.3708P AD=0.3168P
+ PS=2.47U PD=2.32U
M$801 \$1345 \$1251 \$1344 VDD pfet_03v3 L=0.28U W=0.36U AS=0.2097P AD=0.1278P
+ PS=1.38U PD=1.07U
M$802 \$1379 \$1346 \$1345 VDD pfet_03v3 L=0.28U W=0.36U AS=0.1278P AD=0.0567P
+ PS=1.07U PD=0.675U
M$803 VDD \$1250 \$1379 VDD pfet_03v3 L=0.28U W=0.36U AS=0.0567P AD=0.1584P
+ PS=0.675U PD=1.6U
M$804 \$1344 \$151 VDD VDD pfet_03v3 L=0.28U W=0.72U AS=0.3168P AD=0.2097P
+ PS=2.32U PD=1.38U
M$805 VDD \$1345 \$1346 VDD pfet_03v3 L=0.28U W=0.36U AS=0.1584P AD=0.1764P
+ PS=1.6U PD=1.26U
M$806 \$1347 \$1345 VDD VDD pfet_03v3 L=0.28U W=0.72U AS=0.1764P AD=0.36P
+ PS=1.26U PD=2.44U
M$807 \$1348 RB12 VDD VDD pfet_03v3 L=0.28U W=0.72U AS=0.3312P AD=0.3888P
+ PS=2.36U PD=2.52U
M$808 \$1347 \$1348 \$81 VDD pfet_03v3 L=0.28U W=0.36U AS=0.1584P AD=0.1152P
+ PS=1.6U PD=1U
M$809 \$82 \$1349 \$1347 VDD pfet_03v3 L=0.28U W=0.36U AS=0.1152P AD=0.1584P
+ PS=1U PD=1.6U
M$810 VDD RA12 \$1349 VDD pfet_03v3 L=0.28U W=0.72U AS=0.3708P AD=0.3168P
+ PS=2.47U PD=2.32U
M$811 \$1551 WE11 VDD VDD pfet_03v3 L=0.28U W=0.72U AS=0.3168P AD=0.1872P
+ PS=2.32U PD=1.24U
M$812 VDD CLK \$1551 VDD pfet_03v3 L=0.28U W=0.72U AS=0.1872P AD=0.3168P
+ PS=1.24U PD=2.32U
M$813 \$1552 \$1551 VDD VDD pfet_03v3 L=0.28U W=1.27U AS=0.5588P AD=0.3302P
+ PS=3.42U PD=1.79U
M$814 \$1552 \$1551 VDD VDD pfet_03v3 L=0.28U W=1.27U AS=0.3386P AD=0.3302P
+ PS=1.86U PD=1.79U
M$815 \$1553 \$1552 VDD VDD pfet_03v3 L=0.28U W=1.34U AS=0.3386P AD=0.3886P
+ PS=1.86U PD=1.92U
M$816 VDD \$1552 \$1553 VDD pfet_03v3 L=0.28U W=1.34U AS=0.3886P AD=0.5896P
+ PS=1.92U PD=3.56U
M$817 \$1554 \$106 VDD VDD pfet_03v3 L=0.28U W=0.72U AS=0.3168P AD=0.2097P
+ PS=2.32U PD=1.38U
M$818 \$1555 \$1553 \$1554 VDD pfet_03v3 L=0.28U W=0.36U AS=0.2097P AD=0.1278P
+ PS=1.38U PD=1.07U
M$819 \$1761 \$1556 \$1555 VDD pfet_03v3 L=0.28U W=0.36U AS=0.1278P AD=0.0567P
+ PS=1.07U PD=0.675U
M$820 VDD \$1552 \$1761 VDD pfet_03v3 L=0.28U W=0.36U AS=0.0567P AD=0.1584P
+ PS=0.675U PD=1.6U
M$821 \$1556 \$1555 VDD VDD pfet_03v3 L=0.28U W=0.36U AS=0.1764P AD=0.1584P
+ PS=1.26U PD=1.6U
M$822 \$1557 \$1555 VDD VDD pfet_03v3 L=0.28U W=0.72U AS=0.1764P AD=0.36P
+ PS=1.26U PD=2.44U
M$823 \$1668 RA11 VDD VDD pfet_03v3 L=0.28U W=0.72U AS=0.3312P AD=0.3888P
+ PS=2.36U PD=2.52U
M$824 \$1557 \$1668 \$51 VDD pfet_03v3 L=0.28U W=0.36U AS=0.1584P AD=0.1152P
+ PS=1.6U PD=1U
M$825 \$52 \$1669 \$1557 VDD pfet_03v3 L=0.28U W=0.36U AS=0.1152P AD=0.1584P
+ PS=1U PD=1.6U
M$826 VDD RB11 \$1669 VDD pfet_03v3 L=0.28U W=0.72U AS=0.3708P AD=0.3168P
+ PS=2.47U PD=2.32U
M$827 \$1558 \$109 VDD VDD pfet_03v3 L=0.28U W=0.72U AS=0.3168P AD=0.2097P
+ PS=2.32U PD=1.38U
M$828 \$1559 \$1553 \$1558 VDD pfet_03v3 L=0.28U W=0.36U AS=0.2097P AD=0.1278P
+ PS=1.38U PD=1.07U
M$829 \$1771 \$1560 \$1559 VDD pfet_03v3 L=0.28U W=0.36U AS=0.1278P AD=0.0567P
+ PS=1.07U PD=0.675U
M$830 VDD \$1552 \$1771 VDD pfet_03v3 L=0.28U W=0.36U AS=0.0567P AD=0.1584P
+ PS=0.675U PD=1.6U
M$831 \$1560 \$1559 VDD VDD pfet_03v3 L=0.28U W=0.36U AS=0.1764P AD=0.1584P
+ PS=1.26U PD=1.6U
M$832 \$1561 \$1559 VDD VDD pfet_03v3 L=0.28U W=0.72U AS=0.1764P AD=0.36P
+ PS=1.26U PD=2.44U
M$833 \$1670 RA11 VDD VDD pfet_03v3 L=0.28U W=0.72U AS=0.3312P AD=0.3888P
+ PS=2.36U PD=2.52U
M$834 \$1561 \$1670 \$53 VDD pfet_03v3 L=0.28U W=0.36U AS=0.1584P AD=0.1152P
+ PS=1.6U PD=1U
M$835 \$54 \$1671 \$1561 VDD pfet_03v3 L=0.28U W=0.36U AS=0.1152P AD=0.1584P
+ PS=1U PD=1.6U
M$836 VDD RB11 \$1671 VDD pfet_03v3 L=0.28U W=0.72U AS=0.3708P AD=0.3168P
+ PS=2.47U PD=2.32U
M$837 \$1562 \$112 VDD VDD pfet_03v3 L=0.28U W=0.72U AS=0.3168P AD=0.2097P
+ PS=2.32U PD=1.38U
M$838 \$1563 \$1553 \$1562 VDD pfet_03v3 L=0.28U W=0.36U AS=0.2097P AD=0.1278P
+ PS=1.38U PD=1.07U
M$839 \$1777 \$1564 \$1563 VDD pfet_03v3 L=0.28U W=0.36U AS=0.1278P AD=0.0567P
+ PS=1.07U PD=0.675U
M$840 VDD \$1552 \$1777 VDD pfet_03v3 L=0.28U W=0.36U AS=0.0567P AD=0.1584P
+ PS=0.675U PD=1.6U
M$841 \$1564 \$1563 VDD VDD pfet_03v3 L=0.28U W=0.36U AS=0.1764P AD=0.1584P
+ PS=1.26U PD=1.6U
M$842 \$1565 \$1563 VDD VDD pfet_03v3 L=0.28U W=0.72U AS=0.1764P AD=0.36P
+ PS=1.26U PD=2.44U
M$843 \$1672 RA11 VDD VDD pfet_03v3 L=0.28U W=0.72U AS=0.3312P AD=0.3888P
+ PS=2.36U PD=2.52U
M$844 \$1565 \$1672 \$55 VDD pfet_03v3 L=0.28U W=0.36U AS=0.1584P AD=0.1152P
+ PS=1.6U PD=1U
M$845 \$56 \$1673 \$1565 VDD pfet_03v3 L=0.28U W=0.36U AS=0.1152P AD=0.1584P
+ PS=1U PD=1.6U
M$846 VDD RB11 \$1673 VDD pfet_03v3 L=0.28U W=0.72U AS=0.3708P AD=0.3168P
+ PS=2.47U PD=2.32U
M$847 \$1566 \$115 VDD VDD pfet_03v3 L=0.28U W=0.72U AS=0.3168P AD=0.2097P
+ PS=2.32U PD=1.38U
M$848 \$1567 \$1553 \$1566 VDD pfet_03v3 L=0.28U W=0.36U AS=0.2097P AD=0.1278P
+ PS=1.38U PD=1.07U
M$849 \$1787 \$1568 \$1567 VDD pfet_03v3 L=0.28U W=0.36U AS=0.1278P AD=0.0567P
+ PS=1.07U PD=0.675U
M$850 VDD \$1552 \$1787 VDD pfet_03v3 L=0.28U W=0.36U AS=0.0567P AD=0.1584P
+ PS=0.675U PD=1.6U
M$851 \$1568 \$1567 VDD VDD pfet_03v3 L=0.28U W=0.36U AS=0.1764P AD=0.1584P
+ PS=1.26U PD=1.6U
M$852 \$1569 \$1567 VDD VDD pfet_03v3 L=0.28U W=0.72U AS=0.1764P AD=0.36P
+ PS=1.26U PD=2.44U
M$853 \$1674 RA11 VDD VDD pfet_03v3 L=0.28U W=0.72U AS=0.3312P AD=0.3888P
+ PS=2.36U PD=2.52U
M$854 \$1569 \$1674 \$57 VDD pfet_03v3 L=0.28U W=0.36U AS=0.1584P AD=0.1152P
+ PS=1.6U PD=1U
M$855 \$58 \$1675 \$1569 VDD pfet_03v3 L=0.28U W=0.36U AS=0.1152P AD=0.1584P
+ PS=1U PD=1.6U
M$856 VDD RB11 \$1675 VDD pfet_03v3 L=0.28U W=0.72U AS=0.3708P AD=0.3168P
+ PS=2.47U PD=2.32U
M$857 \$1570 \$118 VDD VDD pfet_03v3 L=0.28U W=0.72U AS=0.3168P AD=0.2097P
+ PS=2.32U PD=1.38U
M$858 \$1571 \$1553 \$1570 VDD pfet_03v3 L=0.28U W=0.36U AS=0.2097P AD=0.1278P
+ PS=1.38U PD=1.07U
M$859 \$1796 \$1572 \$1571 VDD pfet_03v3 L=0.28U W=0.36U AS=0.1278P AD=0.0567P
+ PS=1.07U PD=0.675U
M$860 VDD \$1552 \$1796 VDD pfet_03v3 L=0.28U W=0.36U AS=0.0567P AD=0.1584P
+ PS=0.675U PD=1.6U
M$861 \$1572 \$1571 VDD VDD pfet_03v3 L=0.28U W=0.36U AS=0.1764P AD=0.1584P
+ PS=1.26U PD=1.6U
M$862 \$1573 \$1571 VDD VDD pfet_03v3 L=0.28U W=0.72U AS=0.1764P AD=0.36P
+ PS=1.26U PD=2.44U
M$863 \$1676 RA11 VDD VDD pfet_03v3 L=0.28U W=0.72U AS=0.3312P AD=0.3888P
+ PS=2.36U PD=2.52U
M$864 \$1573 \$1676 \$59 VDD pfet_03v3 L=0.28U W=0.36U AS=0.1584P AD=0.1152P
+ PS=1.6U PD=1U
M$865 \$60 \$1677 \$1573 VDD pfet_03v3 L=0.28U W=0.36U AS=0.1152P AD=0.1584P
+ PS=1U PD=1.6U
M$866 VDD RB11 \$1677 VDD pfet_03v3 L=0.28U W=0.72U AS=0.3708P AD=0.3168P
+ PS=2.47U PD=2.32U
M$867 \$1574 \$121 VDD VDD pfet_03v3 L=0.28U W=0.72U AS=0.3168P AD=0.2097P
+ PS=2.32U PD=1.38U
M$868 \$1575 \$1553 \$1574 VDD pfet_03v3 L=0.28U W=0.36U AS=0.2097P AD=0.1278P
+ PS=1.38U PD=1.07U
M$869 \$1805 \$1576 \$1575 VDD pfet_03v3 L=0.28U W=0.36U AS=0.1278P AD=0.0567P
+ PS=1.07U PD=0.675U
M$870 VDD \$1552 \$1805 VDD pfet_03v3 L=0.28U W=0.36U AS=0.0567P AD=0.1584P
+ PS=0.675U PD=1.6U
M$871 \$1576 \$1575 VDD VDD pfet_03v3 L=0.28U W=0.36U AS=0.1764P AD=0.1584P
+ PS=1.26U PD=1.6U
M$872 \$1577 \$1575 VDD VDD pfet_03v3 L=0.28U W=0.72U AS=0.1764P AD=0.36P
+ PS=1.26U PD=2.44U
M$873 \$1678 RA11 VDD VDD pfet_03v3 L=0.28U W=0.72U AS=0.3312P AD=0.3888P
+ PS=2.36U PD=2.52U
M$874 \$1577 \$1678 \$61 VDD pfet_03v3 L=0.28U W=0.36U AS=0.1584P AD=0.1152P
+ PS=1.6U PD=1U
M$875 \$62 \$1679 \$1577 VDD pfet_03v3 L=0.28U W=0.36U AS=0.1152P AD=0.1584P
+ PS=1U PD=1.6U
M$876 VDD RB11 \$1679 VDD pfet_03v3 L=0.28U W=0.72U AS=0.3708P AD=0.3168P
+ PS=2.47U PD=2.32U
M$877 \$1578 \$124 VDD VDD pfet_03v3 L=0.28U W=0.72U AS=0.3168P AD=0.2097P
+ PS=2.32U PD=1.38U
M$878 \$1579 \$1553 \$1578 VDD pfet_03v3 L=0.28U W=0.36U AS=0.2097P AD=0.1278P
+ PS=1.38U PD=1.07U
M$879 \$1813 \$1580 \$1579 VDD pfet_03v3 L=0.28U W=0.36U AS=0.1278P AD=0.0567P
+ PS=1.07U PD=0.675U
M$880 VDD \$1552 \$1813 VDD pfet_03v3 L=0.28U W=0.36U AS=0.0567P AD=0.1584P
+ PS=0.675U PD=1.6U
M$881 \$1580 \$1579 VDD VDD pfet_03v3 L=0.28U W=0.36U AS=0.1764P AD=0.1584P
+ PS=1.26U PD=1.6U
M$882 \$1581 \$1579 VDD VDD pfet_03v3 L=0.28U W=0.72U AS=0.1764P AD=0.36P
+ PS=1.26U PD=2.44U
M$883 \$1680 RA11 VDD VDD pfet_03v3 L=0.28U W=0.72U AS=0.3312P AD=0.3888P
+ PS=2.36U PD=2.52U
M$884 \$1581 \$1680 \$63 VDD pfet_03v3 L=0.28U W=0.36U AS=0.1584P AD=0.1152P
+ PS=1.6U PD=1U
M$885 \$64 \$1681 \$1581 VDD pfet_03v3 L=0.28U W=0.36U AS=0.1152P AD=0.1584P
+ PS=1U PD=1.6U
M$886 VDD RB11 \$1681 VDD pfet_03v3 L=0.28U W=0.72U AS=0.3708P AD=0.3168P
+ PS=2.47U PD=2.32U
M$887 \$1582 \$127 VDD VDD pfet_03v3 L=0.28U W=0.72U AS=0.3168P AD=0.2097P
+ PS=2.32U PD=1.38U
M$888 \$1583 \$1553 \$1582 VDD pfet_03v3 L=0.28U W=0.36U AS=0.2097P AD=0.1278P
+ PS=1.38U PD=1.07U
M$889 \$1822 \$1584 \$1583 VDD pfet_03v3 L=0.28U W=0.36U AS=0.1278P AD=0.0567P
+ PS=1.07U PD=0.675U
M$890 VDD \$1552 \$1822 VDD pfet_03v3 L=0.28U W=0.36U AS=0.0567P AD=0.1584P
+ PS=0.675U PD=1.6U
M$891 \$1584 \$1583 VDD VDD pfet_03v3 L=0.28U W=0.36U AS=0.1764P AD=0.1584P
+ PS=1.26U PD=1.6U
M$892 \$1585 \$1583 VDD VDD pfet_03v3 L=0.28U W=0.72U AS=0.1764P AD=0.36P
+ PS=1.26U PD=2.44U
M$893 \$1682 RA11 VDD VDD pfet_03v3 L=0.28U W=0.72U AS=0.3312P AD=0.3888P
+ PS=2.36U PD=2.52U
M$894 \$1585 \$1682 \$65 VDD pfet_03v3 L=0.28U W=0.36U AS=0.1584P AD=0.1152P
+ PS=1.6U PD=1U
M$895 \$66 \$1683 \$1585 VDD pfet_03v3 L=0.28U W=0.36U AS=0.1152P AD=0.1584P
+ PS=1U PD=1.6U
M$896 VDD RB11 \$1683 VDD pfet_03v3 L=0.28U W=0.72U AS=0.3708P AD=0.3168P
+ PS=2.47U PD=2.32U
M$897 \$1586 \$130 VDD VDD pfet_03v3 L=0.28U W=0.72U AS=0.3168P AD=0.2097P
+ PS=2.32U PD=1.38U
M$898 \$1587 \$1553 \$1586 VDD pfet_03v3 L=0.28U W=0.36U AS=0.2097P AD=0.1278P
+ PS=1.38U PD=1.07U
M$899 \$1831 \$1588 \$1587 VDD pfet_03v3 L=0.28U W=0.36U AS=0.1278P AD=0.0567P
+ PS=1.07U PD=0.675U
M$900 VDD \$1552 \$1831 VDD pfet_03v3 L=0.28U W=0.36U AS=0.0567P AD=0.1584P
+ PS=0.675U PD=1.6U
M$901 \$1588 \$1587 VDD VDD pfet_03v3 L=0.28U W=0.36U AS=0.1764P AD=0.1584P
+ PS=1.26U PD=1.6U
M$902 \$1589 \$1587 VDD VDD pfet_03v3 L=0.28U W=0.72U AS=0.1764P AD=0.36P
+ PS=1.26U PD=2.44U
M$903 \$1684 RA11 VDD VDD pfet_03v3 L=0.28U W=0.72U AS=0.3312P AD=0.3888P
+ PS=2.36U PD=2.52U
M$904 \$1589 \$1684 \$67 VDD pfet_03v3 L=0.28U W=0.36U AS=0.1584P AD=0.1152P
+ PS=1.6U PD=1U
M$905 \$68 \$1685 \$1589 VDD pfet_03v3 L=0.28U W=0.36U AS=0.1152P AD=0.1584P
+ PS=1U PD=1.6U
M$906 VDD RB11 \$1685 VDD pfet_03v3 L=0.28U W=0.72U AS=0.3708P AD=0.3168P
+ PS=2.47U PD=2.32U
M$907 \$1590 \$133 VDD VDD pfet_03v3 L=0.28U W=0.72U AS=0.3168P AD=0.2097P
+ PS=2.32U PD=1.38U
M$908 \$1591 \$1553 \$1590 VDD pfet_03v3 L=0.28U W=0.36U AS=0.2097P AD=0.1278P
+ PS=1.38U PD=1.07U
M$909 \$1840 \$1592 \$1591 VDD pfet_03v3 L=0.28U W=0.36U AS=0.1278P AD=0.0567P
+ PS=1.07U PD=0.675U
M$910 VDD \$1552 \$1840 VDD pfet_03v3 L=0.28U W=0.36U AS=0.0567P AD=0.1584P
+ PS=0.675U PD=1.6U
M$911 \$1592 \$1591 VDD VDD pfet_03v3 L=0.28U W=0.36U AS=0.1764P AD=0.1584P
+ PS=1.26U PD=1.6U
M$912 \$1593 \$1591 VDD VDD pfet_03v3 L=0.28U W=0.72U AS=0.1764P AD=0.36P
+ PS=1.26U PD=2.44U
M$913 \$1686 RA11 VDD VDD pfet_03v3 L=0.28U W=0.72U AS=0.3312P AD=0.3888P
+ PS=2.36U PD=2.52U
M$914 \$1593 \$1686 \$69 VDD pfet_03v3 L=0.28U W=0.36U AS=0.1584P AD=0.1152P
+ PS=1.6U PD=1U
M$915 \$70 \$1687 \$1593 VDD pfet_03v3 L=0.28U W=0.36U AS=0.1152P AD=0.1584P
+ PS=1U PD=1.6U
M$916 VDD RB11 \$1687 VDD pfet_03v3 L=0.28U W=0.72U AS=0.3708P AD=0.3168P
+ PS=2.47U PD=2.32U
M$917 \$1594 \$136 VDD VDD pfet_03v3 L=0.28U W=0.72U AS=0.3168P AD=0.2097P
+ PS=2.32U PD=1.38U
M$918 \$1595 \$1553 \$1594 VDD pfet_03v3 L=0.28U W=0.36U AS=0.2097P AD=0.1278P
+ PS=1.38U PD=1.07U
M$919 \$1849 \$1596 \$1595 VDD pfet_03v3 L=0.28U W=0.36U AS=0.1278P AD=0.0567P
+ PS=1.07U PD=0.675U
M$920 VDD \$1552 \$1849 VDD pfet_03v3 L=0.28U W=0.36U AS=0.0567P AD=0.1584P
+ PS=0.675U PD=1.6U
M$921 \$1596 \$1595 VDD VDD pfet_03v3 L=0.28U W=0.36U AS=0.1764P AD=0.1584P
+ PS=1.26U PD=1.6U
M$922 \$1597 \$1595 VDD VDD pfet_03v3 L=0.28U W=0.72U AS=0.1764P AD=0.36P
+ PS=1.26U PD=2.44U
M$923 \$1688 RA11 VDD VDD pfet_03v3 L=0.28U W=0.72U AS=0.3312P AD=0.3888P
+ PS=2.36U PD=2.52U
M$924 \$1597 \$1688 \$71 VDD pfet_03v3 L=0.28U W=0.36U AS=0.1584P AD=0.1152P
+ PS=1.6U PD=1U
M$925 \$72 \$1689 \$1597 VDD pfet_03v3 L=0.28U W=0.36U AS=0.1152P AD=0.1584P
+ PS=1U PD=1.6U
M$926 VDD RB11 \$1689 VDD pfet_03v3 L=0.28U W=0.72U AS=0.3708P AD=0.3168P
+ PS=2.47U PD=2.32U
M$927 \$1598 \$139 VDD VDD pfet_03v3 L=0.28U W=0.72U AS=0.3168P AD=0.2097P
+ PS=2.32U PD=1.38U
M$928 \$1599 \$1553 \$1598 VDD pfet_03v3 L=0.28U W=0.36U AS=0.2097P AD=0.1278P
+ PS=1.38U PD=1.07U
M$929 \$1857 \$1600 \$1599 VDD pfet_03v3 L=0.28U W=0.36U AS=0.1278P AD=0.0567P
+ PS=1.07U PD=0.675U
M$930 VDD \$1552 \$1857 VDD pfet_03v3 L=0.28U W=0.36U AS=0.0567P AD=0.1584P
+ PS=0.675U PD=1.6U
M$931 \$1600 \$1599 VDD VDD pfet_03v3 L=0.28U W=0.36U AS=0.1764P AD=0.1584P
+ PS=1.26U PD=1.6U
M$932 \$1601 \$1599 VDD VDD pfet_03v3 L=0.28U W=0.72U AS=0.1764P AD=0.36P
+ PS=1.26U PD=2.44U
M$933 \$1690 RA11 VDD VDD pfet_03v3 L=0.28U W=0.72U AS=0.3312P AD=0.3888P
+ PS=2.36U PD=2.52U
M$934 \$1601 \$1690 \$73 VDD pfet_03v3 L=0.28U W=0.36U AS=0.1584P AD=0.1152P
+ PS=1.6U PD=1U
M$935 \$74 \$1691 \$1601 VDD pfet_03v3 L=0.28U W=0.36U AS=0.1152P AD=0.1584P
+ PS=1U PD=1.6U
M$936 VDD RB11 \$1691 VDD pfet_03v3 L=0.28U W=0.72U AS=0.3708P AD=0.3168P
+ PS=2.47U PD=2.32U
M$937 \$1602 \$142 VDD VDD pfet_03v3 L=0.28U W=0.72U AS=0.3168P AD=0.2097P
+ PS=2.32U PD=1.38U
M$938 \$1603 \$1553 \$1602 VDD pfet_03v3 L=0.28U W=0.36U AS=0.2097P AD=0.1278P
+ PS=1.38U PD=1.07U
M$939 \$1843 \$1604 \$1603 VDD pfet_03v3 L=0.28U W=0.36U AS=0.1278P AD=0.0567P
+ PS=1.07U PD=0.675U
M$940 VDD \$1552 \$1843 VDD pfet_03v3 L=0.28U W=0.36U AS=0.0567P AD=0.1584P
+ PS=0.675U PD=1.6U
M$941 \$1604 \$1603 VDD VDD pfet_03v3 L=0.28U W=0.36U AS=0.1764P AD=0.1584P
+ PS=1.26U PD=1.6U
M$942 \$1605 \$1603 VDD VDD pfet_03v3 L=0.28U W=0.72U AS=0.1764P AD=0.36P
+ PS=1.26U PD=2.44U
M$943 \$1692 RA11 VDD VDD pfet_03v3 L=0.28U W=0.72U AS=0.3312P AD=0.3888P
+ PS=2.36U PD=2.52U
M$944 \$1605 \$1692 \$75 VDD pfet_03v3 L=0.28U W=0.36U AS=0.1584P AD=0.1152P
+ PS=1.6U PD=1U
M$945 \$76 \$1693 \$1605 VDD pfet_03v3 L=0.28U W=0.36U AS=0.1152P AD=0.1584P
+ PS=1U PD=1.6U
M$946 VDD RB11 \$1693 VDD pfet_03v3 L=0.28U W=0.72U AS=0.3708P AD=0.3168P
+ PS=2.47U PD=2.32U
M$947 \$1606 \$145 VDD VDD pfet_03v3 L=0.28U W=0.72U AS=0.3168P AD=0.2097P
+ PS=2.32U PD=1.38U
M$948 \$1607 \$1553 \$1606 VDD pfet_03v3 L=0.28U W=0.36U AS=0.2097P AD=0.1278P
+ PS=1.38U PD=1.07U
M$949 \$1815 \$1608 \$1607 VDD pfet_03v3 L=0.28U W=0.36U AS=0.1278P AD=0.0567P
+ PS=1.07U PD=0.675U
M$950 VDD \$1552 \$1815 VDD pfet_03v3 L=0.28U W=0.36U AS=0.0567P AD=0.1584P
+ PS=0.675U PD=1.6U
M$951 \$1608 \$1607 VDD VDD pfet_03v3 L=0.28U W=0.36U AS=0.1764P AD=0.1584P
+ PS=1.26U PD=1.6U
M$952 \$1609 \$1607 VDD VDD pfet_03v3 L=0.28U W=0.72U AS=0.1764P AD=0.36P
+ PS=1.26U PD=2.44U
M$953 \$1694 RA11 VDD VDD pfet_03v3 L=0.28U W=0.72U AS=0.3312P AD=0.3888P
+ PS=2.36U PD=2.52U
M$954 \$1609 \$1694 \$77 VDD pfet_03v3 L=0.28U W=0.36U AS=0.1584P AD=0.1152P
+ PS=1.6U PD=1U
M$955 \$78 \$1695 \$1609 VDD pfet_03v3 L=0.28U W=0.36U AS=0.1152P AD=0.1584P
+ PS=1U PD=1.6U
M$956 VDD RB11 \$1695 VDD pfet_03v3 L=0.28U W=0.72U AS=0.3708P AD=0.3168P
+ PS=2.47U PD=2.32U
M$957 \$1610 \$148 VDD VDD pfet_03v3 L=0.28U W=0.72U AS=0.3168P AD=0.2097P
+ PS=2.32U PD=1.38U
M$958 \$1611 \$1553 \$1610 VDD pfet_03v3 L=0.28U W=0.36U AS=0.2097P AD=0.1278P
+ PS=1.38U PD=1.07U
M$959 \$1797 \$1612 \$1611 VDD pfet_03v3 L=0.28U W=0.36U AS=0.1278P AD=0.0567P
+ PS=1.07U PD=0.675U
M$960 VDD \$1552 \$1797 VDD pfet_03v3 L=0.28U W=0.36U AS=0.0567P AD=0.1584P
+ PS=0.675U PD=1.6U
M$961 \$1612 \$1611 VDD VDD pfet_03v3 L=0.28U W=0.36U AS=0.1764P AD=0.1584P
+ PS=1.26U PD=1.6U
M$962 \$1613 \$1611 VDD VDD pfet_03v3 L=0.28U W=0.72U AS=0.1764P AD=0.36P
+ PS=1.26U PD=2.44U
M$963 \$1696 RA11 VDD VDD pfet_03v3 L=0.28U W=0.72U AS=0.3312P AD=0.3888P
+ PS=2.36U PD=2.52U
M$964 \$1613 \$1696 \$79 VDD pfet_03v3 L=0.28U W=0.36U AS=0.1584P AD=0.1152P
+ PS=1.6U PD=1U
M$965 \$80 \$1697 \$1613 VDD pfet_03v3 L=0.28U W=0.36U AS=0.1152P AD=0.1584P
+ PS=1U PD=1.6U
M$966 VDD RB11 \$1697 VDD pfet_03v3 L=0.28U W=0.72U AS=0.3708P AD=0.3168P
+ PS=2.47U PD=2.32U
M$967 \$1614 \$151 VDD VDD pfet_03v3 L=0.28U W=0.72U AS=0.3168P AD=0.2097P
+ PS=2.32U PD=1.38U
M$968 \$1615 \$1553 \$1614 VDD pfet_03v3 L=0.28U W=0.36U AS=0.2097P AD=0.1278P
+ PS=1.38U PD=1.07U
M$969 \$1769 \$1616 \$1615 VDD pfet_03v3 L=0.28U W=0.36U AS=0.1278P AD=0.0567P
+ PS=1.07U PD=0.675U
M$970 VDD \$1552 \$1769 VDD pfet_03v3 L=0.28U W=0.36U AS=0.0567P AD=0.1584P
+ PS=0.675U PD=1.6U
M$971 \$1616 \$1615 VDD VDD pfet_03v3 L=0.28U W=0.36U AS=0.1764P AD=0.1584P
+ PS=1.26U PD=1.6U
M$972 \$1617 \$1615 VDD VDD pfet_03v3 L=0.28U W=0.72U AS=0.1764P AD=0.36P
+ PS=1.26U PD=2.44U
M$973 \$1698 RA11 VDD VDD pfet_03v3 L=0.28U W=0.72U AS=0.3312P AD=0.3888P
+ PS=2.36U PD=2.52U
M$974 \$1617 \$1698 \$81 VDD pfet_03v3 L=0.28U W=0.36U AS=0.1584P AD=0.1152P
+ PS=1.6U PD=1U
M$975 \$82 \$1699 \$1617 VDD pfet_03v3 L=0.28U W=0.36U AS=0.1152P AD=0.1584P
+ PS=1U PD=1.6U
M$976 VDD RB11 \$1699 VDD pfet_03v3 L=0.28U W=0.72U AS=0.3708P AD=0.3168P
+ PS=2.47U PD=2.32U
M$977 \$1861 WE10 VDD VDD pfet_03v3 L=0.28U W=0.72U AS=0.3168P AD=0.1872P
+ PS=2.32U PD=1.24U
M$978 VDD CLK \$1861 VDD pfet_03v3 L=0.28U W=0.72U AS=0.1872P AD=0.3168P
+ PS=1.24U PD=2.32U
M$979 \$1863 \$1861 VDD VDD pfet_03v3 L=0.28U W=1.27U AS=0.5588P AD=0.3302P
+ PS=3.42U PD=1.79U
M$980 VDD \$1861 \$1863 VDD pfet_03v3 L=0.28U W=1.27U AS=0.3302P AD=0.3386P
+ PS=1.79U PD=1.86U
M$981 \$1864 \$1863 VDD VDD pfet_03v3 L=0.28U W=1.34U AS=0.3386P AD=0.3886P
+ PS=1.86U PD=1.92U
M$982 VDD \$1863 \$1864 VDD pfet_03v3 L=0.28U W=1.34U AS=0.3886P AD=0.5896P
+ PS=1.92U PD=3.56U
M$983 \$1868 \$1864 \$1867 VDD pfet_03v3 L=0.28U W=0.36U AS=0.2097P AD=0.1278P
+ PS=1.38U PD=1.07U
M$984 \$1968 \$1869 \$1868 VDD pfet_03v3 L=0.28U W=0.36U AS=0.1278P AD=0.0567P
+ PS=1.07U PD=0.675U
M$985 VDD \$1863 \$1968 VDD pfet_03v3 L=0.28U W=0.36U AS=0.0567P AD=0.1584P
+ PS=0.675U PD=1.6U
M$986 \$1867 \$106 VDD VDD pfet_03v3 L=0.28U W=0.72U AS=0.3168P AD=0.2097P
+ PS=2.32U PD=1.38U
M$987 VDD \$1868 \$1869 VDD pfet_03v3 L=0.28U W=0.36U AS=0.1584P AD=0.1764P
+ PS=1.6U PD=1.26U
M$988 \$1870 \$1868 VDD VDD pfet_03v3 L=0.28U W=0.72U AS=0.1764P AD=0.36P
+ PS=1.26U PD=2.44U
M$989 \$1871 RB10 VDD VDD pfet_03v3 L=0.28U W=0.72U AS=0.3312P AD=0.3888P
+ PS=2.36U PD=2.52U
M$990 \$1870 \$1871 \$51 VDD pfet_03v3 L=0.28U W=0.36U AS=0.1584P AD=0.1152P
+ PS=1.6U PD=1U
M$991 \$52 \$1872 \$1870 VDD pfet_03v3 L=0.28U W=0.36U AS=0.1152P AD=0.1584P
+ PS=1U PD=1.6U
M$992 VDD RA10 \$1872 VDD pfet_03v3 L=0.28U W=0.72U AS=0.3708P AD=0.3168P
+ PS=2.47U PD=2.32U
M$993 \$1874 \$1864 \$1873 VDD pfet_03v3 L=0.28U W=0.36U AS=0.2097P AD=0.1278P
+ PS=1.38U PD=1.07U
M$994 \$1976 \$1875 \$1874 VDD pfet_03v3 L=0.28U W=0.36U AS=0.1278P AD=0.0567P
+ PS=1.07U PD=0.675U
M$995 VDD \$1863 \$1976 VDD pfet_03v3 L=0.28U W=0.36U AS=0.0567P AD=0.1584P
+ PS=0.675U PD=1.6U
M$996 \$1873 \$109 VDD VDD pfet_03v3 L=0.28U W=0.72U AS=0.3168P AD=0.2097P
+ PS=2.32U PD=1.38U
M$997 VDD \$1874 \$1875 VDD pfet_03v3 L=0.28U W=0.36U AS=0.1584P AD=0.1764P
+ PS=1.6U PD=1.26U
M$998 \$1876 \$1874 VDD VDD pfet_03v3 L=0.28U W=0.72U AS=0.1764P AD=0.36P
+ PS=1.26U PD=2.44U
M$999 \$1877 RB10 VDD VDD pfet_03v3 L=0.28U W=0.72U AS=0.3312P AD=0.3888P
+ PS=2.36U PD=2.52U
M$1000 \$1876 \$1877 \$53 VDD pfet_03v3 L=0.28U W=0.36U AS=0.1584P AD=0.1152P
+ PS=1.6U PD=1U
M$1001 \$54 \$1878 \$1876 VDD pfet_03v3 L=0.28U W=0.36U AS=0.1152P AD=0.1584P
+ PS=1U PD=1.6U
M$1002 VDD RA10 \$1878 VDD pfet_03v3 L=0.28U W=0.72U AS=0.3708P AD=0.3168P
+ PS=2.47U PD=2.32U
M$1003 \$1880 \$1864 \$1879 VDD pfet_03v3 L=0.28U W=0.36U AS=0.2097P AD=0.1278P
+ PS=1.38U PD=1.07U
M$1004 \$1983 \$1881 \$1880 VDD pfet_03v3 L=0.28U W=0.36U AS=0.1278P AD=0.0567P
+ PS=1.07U PD=0.675U
M$1005 VDD \$1863 \$1983 VDD pfet_03v3 L=0.28U W=0.36U AS=0.0567P AD=0.1584P
+ PS=0.675U PD=1.6U
M$1006 \$1879 \$112 VDD VDD pfet_03v3 L=0.28U W=0.72U AS=0.3168P AD=0.2097P
+ PS=2.32U PD=1.38U
M$1007 VDD \$1880 \$1881 VDD pfet_03v3 L=0.28U W=0.36U AS=0.1584P AD=0.1764P
+ PS=1.6U PD=1.26U
M$1008 \$1882 \$1880 VDD VDD pfet_03v3 L=0.28U W=0.72U AS=0.1764P AD=0.36P
+ PS=1.26U PD=2.44U
M$1009 \$1883 RB10 VDD VDD pfet_03v3 L=0.28U W=0.72U AS=0.3312P AD=0.3888P
+ PS=2.36U PD=2.52U
M$1010 \$1882 \$1883 \$55 VDD pfet_03v3 L=0.28U W=0.36U AS=0.1584P AD=0.1152P
+ PS=1.6U PD=1U
M$1011 \$56 \$1884 \$1882 VDD pfet_03v3 L=0.28U W=0.36U AS=0.1152P AD=0.1584P
+ PS=1U PD=1.6U
M$1012 VDD RA10 \$1884 VDD pfet_03v3 L=0.28U W=0.72U AS=0.3708P AD=0.3168P
+ PS=2.47U PD=2.32U
M$1013 \$1886 \$1864 \$1885 VDD pfet_03v3 L=0.28U W=0.36U AS=0.2097P AD=0.1278P
+ PS=1.38U PD=1.07U
M$1014 \$1991 \$1887 \$1886 VDD pfet_03v3 L=0.28U W=0.36U AS=0.1278P AD=0.0567P
+ PS=1.07U PD=0.675U
M$1015 VDD \$1863 \$1991 VDD pfet_03v3 L=0.28U W=0.36U AS=0.0567P AD=0.1584P
+ PS=0.675U PD=1.6U
M$1016 \$1885 \$115 VDD VDD pfet_03v3 L=0.28U W=0.72U AS=0.3168P AD=0.2097P
+ PS=2.32U PD=1.38U
M$1017 VDD \$1886 \$1887 VDD pfet_03v3 L=0.28U W=0.36U AS=0.1584P AD=0.1764P
+ PS=1.6U PD=1.26U
M$1018 \$1888 \$1886 VDD VDD pfet_03v3 L=0.28U W=0.72U AS=0.1764P AD=0.36P
+ PS=1.26U PD=2.44U
M$1019 \$1889 RB10 VDD VDD pfet_03v3 L=0.28U W=0.72U AS=0.3312P AD=0.3888P
+ PS=2.36U PD=2.52U
M$1020 \$1888 \$1889 \$57 VDD pfet_03v3 L=0.28U W=0.36U AS=0.1584P AD=0.1152P
+ PS=1.6U PD=1U
M$1021 \$58 \$1890 \$1888 VDD pfet_03v3 L=0.28U W=0.36U AS=0.1152P AD=0.1584P
+ PS=1U PD=1.6U
M$1022 VDD RA10 \$1890 VDD pfet_03v3 L=0.28U W=0.72U AS=0.3708P AD=0.3168P
+ PS=2.47U PD=2.32U
M$1023 \$1892 \$1864 \$1891 VDD pfet_03v3 L=0.28U W=0.36U AS=0.2097P AD=0.1278P
+ PS=1.38U PD=1.07U
M$1024 \$2000 \$1893 \$1892 VDD pfet_03v3 L=0.28U W=0.36U AS=0.1278P AD=0.0567P
+ PS=1.07U PD=0.675U
M$1025 VDD \$1863 \$2000 VDD pfet_03v3 L=0.28U W=0.36U AS=0.0567P AD=0.1584P
+ PS=0.675U PD=1.6U
M$1026 \$1891 \$118 VDD VDD pfet_03v3 L=0.28U W=0.72U AS=0.3168P AD=0.2097P
+ PS=2.32U PD=1.38U
M$1027 VDD \$1892 \$1893 VDD pfet_03v3 L=0.28U W=0.36U AS=0.1584P AD=0.1764P
+ PS=1.6U PD=1.26U
M$1028 \$1894 \$1892 VDD VDD pfet_03v3 L=0.28U W=0.72U AS=0.1764P AD=0.36P
+ PS=1.26U PD=2.44U
M$1029 \$1895 RB10 VDD VDD pfet_03v3 L=0.28U W=0.72U AS=0.3312P AD=0.3888P
+ PS=2.36U PD=2.52U
M$1030 \$1894 \$1895 \$59 VDD pfet_03v3 L=0.28U W=0.36U AS=0.1584P AD=0.1152P
+ PS=1.6U PD=1U
M$1031 \$60 \$1896 \$1894 VDD pfet_03v3 L=0.28U W=0.36U AS=0.1152P AD=0.1584P
+ PS=1U PD=1.6U
M$1032 VDD RA10 \$1896 VDD pfet_03v3 L=0.28U W=0.72U AS=0.3708P AD=0.3168P
+ PS=2.47U PD=2.32U
M$1033 \$1898 \$1864 \$1897 VDD pfet_03v3 L=0.28U W=0.36U AS=0.2097P AD=0.1278P
+ PS=1.38U PD=1.07U
M$1034 \$2006 \$1899 \$1898 VDD pfet_03v3 L=0.28U W=0.36U AS=0.1278P AD=0.0567P
+ PS=1.07U PD=0.675U
M$1035 VDD \$1863 \$2006 VDD pfet_03v3 L=0.28U W=0.36U AS=0.0567P AD=0.1584P
+ PS=0.675U PD=1.6U
M$1036 \$1897 \$121 VDD VDD pfet_03v3 L=0.28U W=0.72U AS=0.3168P AD=0.2097P
+ PS=2.32U PD=1.38U
M$1037 VDD \$1898 \$1899 VDD pfet_03v3 L=0.28U W=0.36U AS=0.1584P AD=0.1764P
+ PS=1.6U PD=1.26U
M$1038 \$1900 \$1898 VDD VDD pfet_03v3 L=0.28U W=0.72U AS=0.1764P AD=0.36P
+ PS=1.26U PD=2.44U
M$1039 \$1901 RB10 VDD VDD pfet_03v3 L=0.28U W=0.72U AS=0.3312P AD=0.3888P
+ PS=2.36U PD=2.52U
M$1040 \$1900 \$1901 \$61 VDD pfet_03v3 L=0.28U W=0.36U AS=0.1584P AD=0.1152P
+ PS=1.6U PD=1U
M$1041 \$62 \$1902 \$1900 VDD pfet_03v3 L=0.28U W=0.36U AS=0.1152P AD=0.1584P
+ PS=1U PD=1.6U
M$1042 VDD RA10 \$1902 VDD pfet_03v3 L=0.28U W=0.72U AS=0.3708P AD=0.3168P
+ PS=2.47U PD=2.32U
M$1043 \$1904 \$1864 \$1903 VDD pfet_03v3 L=0.28U W=0.36U AS=0.2097P AD=0.1278P
+ PS=1.38U PD=1.07U
M$1044 \$2013 \$1905 \$1904 VDD pfet_03v3 L=0.28U W=0.36U AS=0.1278P AD=0.0567P
+ PS=1.07U PD=0.675U
M$1045 VDD \$1863 \$2013 VDD pfet_03v3 L=0.28U W=0.36U AS=0.0567P AD=0.1584P
+ PS=0.675U PD=1.6U
M$1046 \$1903 \$124 VDD VDD pfet_03v3 L=0.28U W=0.72U AS=0.3168P AD=0.2097P
+ PS=2.32U PD=1.38U
M$1047 VDD \$1904 \$1905 VDD pfet_03v3 L=0.28U W=0.36U AS=0.1584P AD=0.1764P
+ PS=1.6U PD=1.26U
M$1048 \$1906 \$1904 VDD VDD pfet_03v3 L=0.28U W=0.72U AS=0.1764P AD=0.36P
+ PS=1.26U PD=2.44U
M$1049 \$1907 RB10 VDD VDD pfet_03v3 L=0.28U W=0.72U AS=0.3312P AD=0.3888P
+ PS=2.36U PD=2.52U
M$1050 \$1906 \$1907 \$63 VDD pfet_03v3 L=0.28U W=0.36U AS=0.1584P AD=0.1152P
+ PS=1.6U PD=1U
M$1051 \$64 \$1908 \$1906 VDD pfet_03v3 L=0.28U W=0.36U AS=0.1152P AD=0.1584P
+ PS=1U PD=1.6U
M$1052 VDD RA10 \$1908 VDD pfet_03v3 L=0.28U W=0.72U AS=0.3708P AD=0.3168P
+ PS=2.47U PD=2.32U
M$1053 \$1910 \$1864 \$1909 VDD pfet_03v3 L=0.28U W=0.36U AS=0.2097P AD=0.1278P
+ PS=1.38U PD=1.07U
M$1054 \$2022 \$1911 \$1910 VDD pfet_03v3 L=0.28U W=0.36U AS=0.1278P AD=0.0567P
+ PS=1.07U PD=0.675U
M$1055 VDD \$1863 \$2022 VDD pfet_03v3 L=0.28U W=0.36U AS=0.0567P AD=0.1584P
+ PS=0.675U PD=1.6U
M$1056 \$1909 \$127 VDD VDD pfet_03v3 L=0.28U W=0.72U AS=0.3168P AD=0.2097P
+ PS=2.32U PD=1.38U
M$1057 VDD \$1910 \$1911 VDD pfet_03v3 L=0.28U W=0.36U AS=0.1584P AD=0.1764P
+ PS=1.6U PD=1.26U
M$1058 \$1912 \$1910 VDD VDD pfet_03v3 L=0.28U W=0.72U AS=0.1764P AD=0.36P
+ PS=1.26U PD=2.44U
M$1059 \$1913 RB10 VDD VDD pfet_03v3 L=0.28U W=0.72U AS=0.3312P AD=0.3888P
+ PS=2.36U PD=2.52U
M$1060 \$1912 \$1913 \$65 VDD pfet_03v3 L=0.28U W=0.36U AS=0.1584P AD=0.1152P
+ PS=1.6U PD=1U
M$1061 \$66 \$1914 \$1912 VDD pfet_03v3 L=0.28U W=0.36U AS=0.1152P AD=0.1584P
+ PS=1U PD=1.6U
M$1062 VDD RA10 \$1914 VDD pfet_03v3 L=0.28U W=0.72U AS=0.3708P AD=0.3168P
+ PS=2.47U PD=2.32U
M$1063 \$1916 \$1864 \$1915 VDD pfet_03v3 L=0.28U W=0.36U AS=0.2097P AD=0.1278P
+ PS=1.38U PD=1.07U
M$1064 \$2028 \$1917 \$1916 VDD pfet_03v3 L=0.28U W=0.36U AS=0.1278P AD=0.0567P
+ PS=1.07U PD=0.675U
M$1065 VDD \$1863 \$2028 VDD pfet_03v3 L=0.28U W=0.36U AS=0.0567P AD=0.1584P
+ PS=0.675U PD=1.6U
M$1066 \$1915 \$130 VDD VDD pfet_03v3 L=0.28U W=0.72U AS=0.3168P AD=0.2097P
+ PS=2.32U PD=1.38U
M$1067 VDD \$1916 \$1917 VDD pfet_03v3 L=0.28U W=0.36U AS=0.1584P AD=0.1764P
+ PS=1.6U PD=1.26U
M$1068 \$1918 \$1916 VDD VDD pfet_03v3 L=0.28U W=0.72U AS=0.1764P AD=0.36P
+ PS=1.26U PD=2.44U
M$1069 \$1919 RB10 VDD VDD pfet_03v3 L=0.28U W=0.72U AS=0.3312P AD=0.3888P
+ PS=2.36U PD=2.52U
M$1070 \$1918 \$1919 \$67 VDD pfet_03v3 L=0.28U W=0.36U AS=0.1584P AD=0.1152P
+ PS=1.6U PD=1U
M$1071 \$68 \$1920 \$1918 VDD pfet_03v3 L=0.28U W=0.36U AS=0.1152P AD=0.1584P
+ PS=1U PD=1.6U
M$1072 VDD RA10 \$1920 VDD pfet_03v3 L=0.28U W=0.72U AS=0.3708P AD=0.3168P
+ PS=2.47U PD=2.32U
M$1073 \$1922 \$1864 \$1921 VDD pfet_03v3 L=0.28U W=0.36U AS=0.2097P AD=0.1278P
+ PS=1.38U PD=1.07U
M$1074 \$2035 \$1923 \$1922 VDD pfet_03v3 L=0.28U W=0.36U AS=0.1278P AD=0.0567P
+ PS=1.07U PD=0.675U
M$1075 VDD \$1863 \$2035 VDD pfet_03v3 L=0.28U W=0.36U AS=0.0567P AD=0.1584P
+ PS=0.675U PD=1.6U
M$1076 \$1921 \$133 VDD VDD pfet_03v3 L=0.28U W=0.72U AS=0.3168P AD=0.2097P
+ PS=2.32U PD=1.38U
M$1077 VDD \$1922 \$1923 VDD pfet_03v3 L=0.28U W=0.36U AS=0.1584P AD=0.1764P
+ PS=1.6U PD=1.26U
M$1078 \$1924 \$1922 VDD VDD pfet_03v3 L=0.28U W=0.72U AS=0.1764P AD=0.36P
+ PS=1.26U PD=2.44U
M$1079 \$1925 RB10 VDD VDD pfet_03v3 L=0.28U W=0.72U AS=0.3312P AD=0.3888P
+ PS=2.36U PD=2.52U
M$1080 \$1924 \$1925 \$69 VDD pfet_03v3 L=0.28U W=0.36U AS=0.1584P AD=0.1152P
+ PS=1.6U PD=1U
M$1081 \$70 \$1926 \$1924 VDD pfet_03v3 L=0.28U W=0.36U AS=0.1152P AD=0.1584P
+ PS=1U PD=1.6U
M$1082 VDD RA10 \$1926 VDD pfet_03v3 L=0.28U W=0.72U AS=0.3708P AD=0.3168P
+ PS=2.47U PD=2.32U
M$1083 \$1928 \$1864 \$1927 VDD pfet_03v3 L=0.28U W=0.36U AS=0.2097P AD=0.1278P
+ PS=1.38U PD=1.07U
M$1084 \$2043 \$1929 \$1928 VDD pfet_03v3 L=0.28U W=0.36U AS=0.1278P AD=0.0567P
+ PS=1.07U PD=0.675U
M$1085 VDD \$1863 \$2043 VDD pfet_03v3 L=0.28U W=0.36U AS=0.0567P AD=0.1584P
+ PS=0.675U PD=1.6U
M$1086 \$1927 \$136 VDD VDD pfet_03v3 L=0.28U W=0.72U AS=0.3168P AD=0.2097P
+ PS=2.32U PD=1.38U
M$1087 VDD \$1928 \$1929 VDD pfet_03v3 L=0.28U W=0.36U AS=0.1584P AD=0.1764P
+ PS=1.6U PD=1.26U
M$1088 \$1930 \$1928 VDD VDD pfet_03v3 L=0.28U W=0.72U AS=0.1764P AD=0.36P
+ PS=1.26U PD=2.44U
M$1089 \$1931 RB10 VDD VDD pfet_03v3 L=0.28U W=0.72U AS=0.3312P AD=0.3888P
+ PS=2.36U PD=2.52U
M$1090 \$1930 \$1931 \$71 VDD pfet_03v3 L=0.28U W=0.36U AS=0.1584P AD=0.1152P
+ PS=1.6U PD=1U
M$1091 \$72 \$1932 \$1930 VDD pfet_03v3 L=0.28U W=0.36U AS=0.1152P AD=0.1584P
+ PS=1U PD=1.6U
M$1092 VDD RA10 \$1932 VDD pfet_03v3 L=0.28U W=0.72U AS=0.3708P AD=0.3168P
+ PS=2.47U PD=2.32U
M$1093 \$1934 \$1864 \$1933 VDD pfet_03v3 L=0.28U W=0.36U AS=0.2097P AD=0.1278P
+ PS=1.38U PD=1.07U
M$1094 \$2051 \$1935 \$1934 VDD pfet_03v3 L=0.28U W=0.36U AS=0.1278P AD=0.0567P
+ PS=1.07U PD=0.675U
M$1095 VDD \$1863 \$2051 VDD pfet_03v3 L=0.28U W=0.36U AS=0.0567P AD=0.1584P
+ PS=0.675U PD=1.6U
M$1096 \$1933 \$139 VDD VDD pfet_03v3 L=0.28U W=0.72U AS=0.3168P AD=0.2097P
+ PS=2.32U PD=1.38U
M$1097 VDD \$1934 \$1935 VDD pfet_03v3 L=0.28U W=0.36U AS=0.1584P AD=0.1764P
+ PS=1.6U PD=1.26U
M$1098 \$1936 \$1934 VDD VDD pfet_03v3 L=0.28U W=0.72U AS=0.1764P AD=0.36P
+ PS=1.26U PD=2.44U
M$1099 \$1937 RB10 VDD VDD pfet_03v3 L=0.28U W=0.72U AS=0.3312P AD=0.3888P
+ PS=2.36U PD=2.52U
M$1100 \$1936 \$1937 \$73 VDD pfet_03v3 L=0.28U W=0.36U AS=0.1584P AD=0.1152P
+ PS=1.6U PD=1U
M$1101 \$74 \$1938 \$1936 VDD pfet_03v3 L=0.28U W=0.36U AS=0.1152P AD=0.1584P
+ PS=1U PD=1.6U
M$1102 VDD RA10 \$1938 VDD pfet_03v3 L=0.28U W=0.72U AS=0.3708P AD=0.3168P
+ PS=2.47U PD=2.32U
M$1103 \$1940 \$1864 \$1939 VDD pfet_03v3 L=0.28U W=0.36U AS=0.2097P AD=0.1278P
+ PS=1.38U PD=1.07U
M$1104 \$2058 \$1941 \$1940 VDD pfet_03v3 L=0.28U W=0.36U AS=0.1278P AD=0.0567P
+ PS=1.07U PD=0.675U
M$1105 VDD \$1863 \$2058 VDD pfet_03v3 L=0.28U W=0.36U AS=0.0567P AD=0.1584P
+ PS=0.675U PD=1.6U
M$1106 \$1939 \$142 VDD VDD pfet_03v3 L=0.28U W=0.72U AS=0.3168P AD=0.2097P
+ PS=2.32U PD=1.38U
M$1107 VDD \$1940 \$1941 VDD pfet_03v3 L=0.28U W=0.36U AS=0.1584P AD=0.1764P
+ PS=1.6U PD=1.26U
M$1108 \$1942 \$1940 VDD VDD pfet_03v3 L=0.28U W=0.72U AS=0.1764P AD=0.36P
+ PS=1.26U PD=2.44U
M$1109 \$1943 RB10 VDD VDD pfet_03v3 L=0.28U W=0.72U AS=0.3312P AD=0.3888P
+ PS=2.36U PD=2.52U
M$1110 \$1942 \$1943 \$75 VDD pfet_03v3 L=0.28U W=0.36U AS=0.1584P AD=0.1152P
+ PS=1.6U PD=1U
M$1111 \$76 \$1944 \$1942 VDD pfet_03v3 L=0.28U W=0.36U AS=0.1152P AD=0.1584P
+ PS=1U PD=1.6U
M$1112 VDD RA10 \$1944 VDD pfet_03v3 L=0.28U W=0.72U AS=0.3708P AD=0.3168P
+ PS=2.47U PD=2.32U
M$1113 \$1946 \$1864 \$1945 VDD pfet_03v3 L=0.28U W=0.36U AS=0.2097P AD=0.1278P
+ PS=1.38U PD=1.07U
M$1114 \$2057 \$1947 \$1946 VDD pfet_03v3 L=0.28U W=0.36U AS=0.1278P AD=0.0567P
+ PS=1.07U PD=0.675U
M$1115 VDD \$1863 \$2057 VDD pfet_03v3 L=0.28U W=0.36U AS=0.0567P AD=0.1584P
+ PS=0.675U PD=1.6U
M$1116 \$1945 \$145 VDD VDD pfet_03v3 L=0.28U W=0.72U AS=0.3168P AD=0.2097P
+ PS=2.32U PD=1.38U
M$1117 VDD \$1946 \$1947 VDD pfet_03v3 L=0.28U W=0.36U AS=0.1584P AD=0.1764P
+ PS=1.6U PD=1.26U
M$1118 \$1948 \$1946 VDD VDD pfet_03v3 L=0.28U W=0.72U AS=0.1764P AD=0.36P
+ PS=1.26U PD=2.44U
M$1119 \$1949 RB10 VDD VDD pfet_03v3 L=0.28U W=0.72U AS=0.3312P AD=0.3888P
+ PS=2.36U PD=2.52U
M$1120 \$1948 \$1949 \$77 VDD pfet_03v3 L=0.28U W=0.36U AS=0.1584P AD=0.1152P
+ PS=1.6U PD=1U
M$1121 \$78 \$1950 \$1948 VDD pfet_03v3 L=0.28U W=0.36U AS=0.1152P AD=0.1584P
+ PS=1U PD=1.6U
M$1122 VDD RA10 \$1950 VDD pfet_03v3 L=0.28U W=0.72U AS=0.3708P AD=0.3168P
+ PS=2.47U PD=2.32U
M$1123 \$1952 \$1864 \$1951 VDD pfet_03v3 L=0.28U W=0.36U AS=0.2097P AD=0.1278P
+ PS=1.38U PD=1.07U
M$1124 \$2025 \$1953 \$1952 VDD pfet_03v3 L=0.28U W=0.36U AS=0.1278P AD=0.0567P
+ PS=1.07U PD=0.675U
M$1125 VDD \$1863 \$2025 VDD pfet_03v3 L=0.28U W=0.36U AS=0.0567P AD=0.1584P
+ PS=0.675U PD=1.6U
M$1126 \$1951 \$148 VDD VDD pfet_03v3 L=0.28U W=0.72U AS=0.3168P AD=0.2097P
+ PS=2.32U PD=1.38U
M$1127 VDD \$1952 \$1953 VDD pfet_03v3 L=0.28U W=0.36U AS=0.1584P AD=0.1764P
+ PS=1.6U PD=1.26U
M$1128 \$1954 \$1952 VDD VDD pfet_03v3 L=0.28U W=0.72U AS=0.1764P AD=0.36P
+ PS=1.26U PD=2.44U
M$1129 \$1955 RB10 VDD VDD pfet_03v3 L=0.28U W=0.72U AS=0.3312P AD=0.3888P
+ PS=2.36U PD=2.52U
M$1130 \$1954 \$1955 \$79 VDD pfet_03v3 L=0.28U W=0.36U AS=0.1584P AD=0.1152P
+ PS=1.6U PD=1U
M$1131 \$80 \$1956 \$1954 VDD pfet_03v3 L=0.28U W=0.36U AS=0.1152P AD=0.1584P
+ PS=1U PD=1.6U
M$1132 VDD RA10 \$1956 VDD pfet_03v3 L=0.28U W=0.72U AS=0.3708P AD=0.3168P
+ PS=2.47U PD=2.32U
M$1133 \$1958 \$1864 \$1957 VDD pfet_03v3 L=0.28U W=0.36U AS=0.2097P AD=0.1278P
+ PS=1.38U PD=1.07U
M$1134 \$1992 \$1959 \$1958 VDD pfet_03v3 L=0.28U W=0.36U AS=0.1278P AD=0.0567P
+ PS=1.07U PD=0.675U
M$1135 VDD \$1863 \$1992 VDD pfet_03v3 L=0.28U W=0.36U AS=0.0567P AD=0.1584P
+ PS=0.675U PD=1.6U
M$1136 \$1957 \$151 VDD VDD pfet_03v3 L=0.28U W=0.72U AS=0.3168P AD=0.2097P
+ PS=2.32U PD=1.38U
M$1137 VDD \$1958 \$1959 VDD pfet_03v3 L=0.28U W=0.36U AS=0.1584P AD=0.1764P
+ PS=1.6U PD=1.26U
M$1138 \$1960 \$1958 VDD VDD pfet_03v3 L=0.28U W=0.72U AS=0.1764P AD=0.36P
+ PS=1.26U PD=2.44U
M$1139 \$1961 RB10 VDD VDD pfet_03v3 L=0.28U W=0.72U AS=0.3312P AD=0.3888P
+ PS=2.36U PD=2.52U
M$1140 \$1960 \$1961 \$81 VDD pfet_03v3 L=0.28U W=0.36U AS=0.1584P AD=0.1152P
+ PS=1.6U PD=1U
M$1141 \$82 \$1962 \$1960 VDD pfet_03v3 L=0.28U W=0.36U AS=0.1152P AD=0.1584P
+ PS=1U PD=1.6U
M$1142 VDD RA10 \$1962 VDD pfet_03v3 L=0.28U W=0.72U AS=0.3708P AD=0.3168P
+ PS=2.47U PD=2.32U
M$1143 \$2164 WE9 VDD VDD pfet_03v3 L=0.28U W=0.72U AS=0.3168P AD=0.1872P
+ PS=2.32U PD=1.24U
M$1144 VDD CLK \$2164 VDD pfet_03v3 L=0.28U W=0.72U AS=0.1872P AD=0.3168P
+ PS=1.24U PD=2.32U
M$1145 \$2165 \$2164 VDD VDD pfet_03v3 L=0.28U W=1.27U AS=0.5588P AD=0.3302P
+ PS=3.42U PD=1.79U
M$1146 \$2165 \$2164 VDD VDD pfet_03v3 L=0.28U W=1.27U AS=0.3386P AD=0.3302P
+ PS=1.86U PD=1.79U
M$1147 \$2166 \$2165 VDD VDD pfet_03v3 L=0.28U W=1.34U AS=0.3386P AD=0.3886P
+ PS=1.86U PD=1.92U
M$1148 VDD \$2165 \$2166 VDD pfet_03v3 L=0.28U W=1.34U AS=0.3886P AD=0.5896P
+ PS=1.92U PD=3.56U
M$1149 \$2167 \$106 VDD VDD pfet_03v3 L=0.28U W=0.72U AS=0.3168P AD=0.2097P
+ PS=2.32U PD=1.38U
M$1150 \$2168 \$2166 \$2167 VDD pfet_03v3 L=0.28U W=0.36U AS=0.2097P AD=0.1278P
+ PS=1.38U PD=1.07U
M$1151 \$2374 \$2169 \$2168 VDD pfet_03v3 L=0.28U W=0.36U AS=0.1278P AD=0.0567P
+ PS=1.07U PD=0.675U
M$1152 VDD \$2165 \$2374 VDD pfet_03v3 L=0.28U W=0.36U AS=0.0567P AD=0.1584P
+ PS=0.675U PD=1.6U
M$1153 \$2169 \$2168 VDD VDD pfet_03v3 L=0.28U W=0.36U AS=0.1764P AD=0.1584P
+ PS=1.26U PD=1.6U
M$1154 \$2170 \$2168 VDD VDD pfet_03v3 L=0.28U W=0.72U AS=0.1764P AD=0.36P
+ PS=1.26U PD=2.44U
M$1155 \$2281 RA9 VDD VDD pfet_03v3 L=0.28U W=0.72U AS=0.3312P AD=0.3888P
+ PS=2.36U PD=2.52U
M$1156 \$2170 \$2281 \$51 VDD pfet_03v3 L=0.28U W=0.36U AS=0.1584P AD=0.1152P
+ PS=1.6U PD=1U
M$1157 \$52 \$2282 \$2170 VDD pfet_03v3 L=0.28U W=0.36U AS=0.1152P AD=0.1584P
+ PS=1U PD=1.6U
M$1158 VDD RB9 \$2282 VDD pfet_03v3 L=0.28U W=0.72U AS=0.3708P AD=0.3168P
+ PS=2.47U PD=2.32U
M$1159 \$2171 \$109 VDD VDD pfet_03v3 L=0.28U W=0.72U AS=0.3168P AD=0.2097P
+ PS=2.32U PD=1.38U
M$1160 \$2172 \$2166 \$2171 VDD pfet_03v3 L=0.28U W=0.36U AS=0.2097P AD=0.1278P
+ PS=1.38U PD=1.07U
M$1161 \$2384 \$2173 \$2172 VDD pfet_03v3 L=0.28U W=0.36U AS=0.1278P AD=0.0567P
+ PS=1.07U PD=0.675U
M$1162 VDD \$2165 \$2384 VDD pfet_03v3 L=0.28U W=0.36U AS=0.0567P AD=0.1584P
+ PS=0.675U PD=1.6U
M$1163 \$2173 \$2172 VDD VDD pfet_03v3 L=0.28U W=0.36U AS=0.1764P AD=0.1584P
+ PS=1.26U PD=1.6U
M$1164 \$2174 \$2172 VDD VDD pfet_03v3 L=0.28U W=0.72U AS=0.1764P AD=0.36P
+ PS=1.26U PD=2.44U
M$1165 \$2283 RA9 VDD VDD pfet_03v3 L=0.28U W=0.72U AS=0.3312P AD=0.3888P
+ PS=2.36U PD=2.52U
M$1166 \$2174 \$2283 \$53 VDD pfet_03v3 L=0.28U W=0.36U AS=0.1584P AD=0.1152P
+ PS=1.6U PD=1U
M$1167 \$54 \$2284 \$2174 VDD pfet_03v3 L=0.28U W=0.36U AS=0.1152P AD=0.1584P
+ PS=1U PD=1.6U
M$1168 VDD RB9 \$2284 VDD pfet_03v3 L=0.28U W=0.72U AS=0.3708P AD=0.3168P
+ PS=2.47U PD=2.32U
M$1169 \$2175 \$112 VDD VDD pfet_03v3 L=0.28U W=0.72U AS=0.3168P AD=0.2097P
+ PS=2.32U PD=1.38U
M$1170 \$2176 \$2166 \$2175 VDD pfet_03v3 L=0.28U W=0.36U AS=0.2097P AD=0.1278P
+ PS=1.38U PD=1.07U
M$1171 \$2390 \$2177 \$2176 VDD pfet_03v3 L=0.28U W=0.36U AS=0.1278P AD=0.0567P
+ PS=1.07U PD=0.675U
M$1172 VDD \$2165 \$2390 VDD pfet_03v3 L=0.28U W=0.36U AS=0.0567P AD=0.1584P
+ PS=0.675U PD=1.6U
M$1173 \$2177 \$2176 VDD VDD pfet_03v3 L=0.28U W=0.36U AS=0.1764P AD=0.1584P
+ PS=1.26U PD=1.6U
M$1174 \$2178 \$2176 VDD VDD pfet_03v3 L=0.28U W=0.72U AS=0.1764P AD=0.36P
+ PS=1.26U PD=2.44U
M$1175 \$2285 RA9 VDD VDD pfet_03v3 L=0.28U W=0.72U AS=0.3312P AD=0.3888P
+ PS=2.36U PD=2.52U
M$1176 \$2178 \$2285 \$55 VDD pfet_03v3 L=0.28U W=0.36U AS=0.1584P AD=0.1152P
+ PS=1.6U PD=1U
M$1177 \$56 \$2286 \$2178 VDD pfet_03v3 L=0.28U W=0.36U AS=0.1152P AD=0.1584P
+ PS=1U PD=1.6U
M$1178 VDD RB9 \$2286 VDD pfet_03v3 L=0.28U W=0.72U AS=0.3708P AD=0.3168P
+ PS=2.47U PD=2.32U
M$1179 \$2179 \$115 VDD VDD pfet_03v3 L=0.28U W=0.72U AS=0.3168P AD=0.2097P
+ PS=2.32U PD=1.38U
M$1180 \$2180 \$2166 \$2179 VDD pfet_03v3 L=0.28U W=0.36U AS=0.2097P AD=0.1278P
+ PS=1.38U PD=1.07U
M$1181 \$2400 \$2181 \$2180 VDD pfet_03v3 L=0.28U W=0.36U AS=0.1278P AD=0.0567P
+ PS=1.07U PD=0.675U
M$1182 VDD \$2165 \$2400 VDD pfet_03v3 L=0.28U W=0.36U AS=0.0567P AD=0.1584P
+ PS=0.675U PD=1.6U
M$1183 \$2181 \$2180 VDD VDD pfet_03v3 L=0.28U W=0.36U AS=0.1764P AD=0.1584P
+ PS=1.26U PD=1.6U
M$1184 \$2182 \$2180 VDD VDD pfet_03v3 L=0.28U W=0.72U AS=0.1764P AD=0.36P
+ PS=1.26U PD=2.44U
M$1185 \$2287 RA9 VDD VDD pfet_03v3 L=0.28U W=0.72U AS=0.3312P AD=0.3888P
+ PS=2.36U PD=2.52U
M$1186 \$2182 \$2287 \$57 VDD pfet_03v3 L=0.28U W=0.36U AS=0.1584P AD=0.1152P
+ PS=1.6U PD=1U
M$1187 \$58 \$2288 \$2182 VDD pfet_03v3 L=0.28U W=0.36U AS=0.1152P AD=0.1584P
+ PS=1U PD=1.6U
M$1188 VDD RB9 \$2288 VDD pfet_03v3 L=0.28U W=0.72U AS=0.3708P AD=0.3168P
+ PS=2.47U PD=2.32U
M$1189 \$2183 \$118 VDD VDD pfet_03v3 L=0.28U W=0.72U AS=0.3168P AD=0.2097P
+ PS=2.32U PD=1.38U
M$1190 \$2184 \$2166 \$2183 VDD pfet_03v3 L=0.28U W=0.36U AS=0.2097P AD=0.1278P
+ PS=1.38U PD=1.07U
M$1191 \$2409 \$2185 \$2184 VDD pfet_03v3 L=0.28U W=0.36U AS=0.1278P AD=0.0567P
+ PS=1.07U PD=0.675U
M$1192 VDD \$2165 \$2409 VDD pfet_03v3 L=0.28U W=0.36U AS=0.0567P AD=0.1584P
+ PS=0.675U PD=1.6U
M$1193 \$2185 \$2184 VDD VDD pfet_03v3 L=0.28U W=0.36U AS=0.1764P AD=0.1584P
+ PS=1.26U PD=1.6U
M$1194 \$2186 \$2184 VDD VDD pfet_03v3 L=0.28U W=0.72U AS=0.1764P AD=0.36P
+ PS=1.26U PD=2.44U
M$1195 \$2289 RA9 VDD VDD pfet_03v3 L=0.28U W=0.72U AS=0.3312P AD=0.3888P
+ PS=2.36U PD=2.52U
M$1196 \$2186 \$2289 \$59 VDD pfet_03v3 L=0.28U W=0.36U AS=0.1584P AD=0.1152P
+ PS=1.6U PD=1U
M$1197 \$60 \$2290 \$2186 VDD pfet_03v3 L=0.28U W=0.36U AS=0.1152P AD=0.1584P
+ PS=1U PD=1.6U
M$1198 VDD RB9 \$2290 VDD pfet_03v3 L=0.28U W=0.72U AS=0.3708P AD=0.3168P
+ PS=2.47U PD=2.32U
M$1199 \$2187 \$121 VDD VDD pfet_03v3 L=0.28U W=0.72U AS=0.3168P AD=0.2097P
+ PS=2.32U PD=1.38U
M$1200 \$2188 \$2166 \$2187 VDD pfet_03v3 L=0.28U W=0.36U AS=0.2097P AD=0.1278P
+ PS=1.38U PD=1.07U
M$1201 \$2418 \$2189 \$2188 VDD pfet_03v3 L=0.28U W=0.36U AS=0.1278P AD=0.0567P
+ PS=1.07U PD=0.675U
M$1202 VDD \$2165 \$2418 VDD pfet_03v3 L=0.28U W=0.36U AS=0.0567P AD=0.1584P
+ PS=0.675U PD=1.6U
M$1203 \$2189 \$2188 VDD VDD pfet_03v3 L=0.28U W=0.36U AS=0.1764P AD=0.1584P
+ PS=1.26U PD=1.6U
M$1204 \$2190 \$2188 VDD VDD pfet_03v3 L=0.28U W=0.72U AS=0.1764P AD=0.36P
+ PS=1.26U PD=2.44U
M$1205 \$2291 RA9 VDD VDD pfet_03v3 L=0.28U W=0.72U AS=0.3312P AD=0.3888P
+ PS=2.36U PD=2.52U
M$1206 \$2190 \$2291 \$61 VDD pfet_03v3 L=0.28U W=0.36U AS=0.1584P AD=0.1152P
+ PS=1.6U PD=1U
M$1207 \$62 \$2292 \$2190 VDD pfet_03v3 L=0.28U W=0.36U AS=0.1152P AD=0.1584P
+ PS=1U PD=1.6U
M$1208 VDD RB9 \$2292 VDD pfet_03v3 L=0.28U W=0.72U AS=0.3708P AD=0.3168P
+ PS=2.47U PD=2.32U
M$1209 \$2191 \$124 VDD VDD pfet_03v3 L=0.28U W=0.72U AS=0.3168P AD=0.2097P
+ PS=2.32U PD=1.38U
M$1210 \$2192 \$2166 \$2191 VDD pfet_03v3 L=0.28U W=0.36U AS=0.2097P AD=0.1278P
+ PS=1.38U PD=1.07U
M$1211 \$2426 \$2193 \$2192 VDD pfet_03v3 L=0.28U W=0.36U AS=0.1278P AD=0.0567P
+ PS=1.07U PD=0.675U
M$1212 VDD \$2165 \$2426 VDD pfet_03v3 L=0.28U W=0.36U AS=0.0567P AD=0.1584P
+ PS=0.675U PD=1.6U
M$1213 \$2193 \$2192 VDD VDD pfet_03v3 L=0.28U W=0.36U AS=0.1764P AD=0.1584P
+ PS=1.26U PD=1.6U
M$1214 \$2194 \$2192 VDD VDD pfet_03v3 L=0.28U W=0.72U AS=0.1764P AD=0.36P
+ PS=1.26U PD=2.44U
M$1215 \$2293 RA9 VDD VDD pfet_03v3 L=0.28U W=0.72U AS=0.3312P AD=0.3888P
+ PS=2.36U PD=2.52U
M$1216 \$2194 \$2293 \$63 VDD pfet_03v3 L=0.28U W=0.36U AS=0.1584P AD=0.1152P
+ PS=1.6U PD=1U
M$1217 \$64 \$2294 \$2194 VDD pfet_03v3 L=0.28U W=0.36U AS=0.1152P AD=0.1584P
+ PS=1U PD=1.6U
M$1218 VDD RB9 \$2294 VDD pfet_03v3 L=0.28U W=0.72U AS=0.3708P AD=0.3168P
+ PS=2.47U PD=2.32U
M$1219 \$2195 \$127 VDD VDD pfet_03v3 L=0.28U W=0.72U AS=0.3168P AD=0.2097P
+ PS=2.32U PD=1.38U
M$1220 \$2196 \$2166 \$2195 VDD pfet_03v3 L=0.28U W=0.36U AS=0.2097P AD=0.1278P
+ PS=1.38U PD=1.07U
M$1221 \$2435 \$2197 \$2196 VDD pfet_03v3 L=0.28U W=0.36U AS=0.1278P AD=0.0567P
+ PS=1.07U PD=0.675U
M$1222 VDD \$2165 \$2435 VDD pfet_03v3 L=0.28U W=0.36U AS=0.0567P AD=0.1584P
+ PS=0.675U PD=1.6U
M$1223 \$2197 \$2196 VDD VDD pfet_03v3 L=0.28U W=0.36U AS=0.1764P AD=0.1584P
+ PS=1.26U PD=1.6U
M$1224 \$2198 \$2196 VDD VDD pfet_03v3 L=0.28U W=0.72U AS=0.1764P AD=0.36P
+ PS=1.26U PD=2.44U
M$1225 \$2295 RA9 VDD VDD pfet_03v3 L=0.28U W=0.72U AS=0.3312P AD=0.3888P
+ PS=2.36U PD=2.52U
M$1226 \$2198 \$2295 \$65 VDD pfet_03v3 L=0.28U W=0.36U AS=0.1584P AD=0.1152P
+ PS=1.6U PD=1U
M$1227 \$66 \$2296 \$2198 VDD pfet_03v3 L=0.28U W=0.36U AS=0.1152P AD=0.1584P
+ PS=1U PD=1.6U
M$1228 VDD RB9 \$2296 VDD pfet_03v3 L=0.28U W=0.72U AS=0.3708P AD=0.3168P
+ PS=2.47U PD=2.32U
M$1229 \$2199 \$130 VDD VDD pfet_03v3 L=0.28U W=0.72U AS=0.3168P AD=0.2097P
+ PS=2.32U PD=1.38U
M$1230 \$2200 \$2166 \$2199 VDD pfet_03v3 L=0.28U W=0.36U AS=0.2097P AD=0.1278P
+ PS=1.38U PD=1.07U
M$1231 \$2444 \$2201 \$2200 VDD pfet_03v3 L=0.28U W=0.36U AS=0.1278P AD=0.0567P
+ PS=1.07U PD=0.675U
M$1232 VDD \$2165 \$2444 VDD pfet_03v3 L=0.28U W=0.36U AS=0.0567P AD=0.1584P
+ PS=0.675U PD=1.6U
M$1233 \$2201 \$2200 VDD VDD pfet_03v3 L=0.28U W=0.36U AS=0.1764P AD=0.1584P
+ PS=1.26U PD=1.6U
M$1234 \$2202 \$2200 VDD VDD pfet_03v3 L=0.28U W=0.72U AS=0.1764P AD=0.36P
+ PS=1.26U PD=2.44U
M$1235 \$2297 RA9 VDD VDD pfet_03v3 L=0.28U W=0.72U AS=0.3312P AD=0.3888P
+ PS=2.36U PD=2.52U
M$1236 \$2202 \$2297 \$67 VDD pfet_03v3 L=0.28U W=0.36U AS=0.1584P AD=0.1152P
+ PS=1.6U PD=1U
M$1237 \$68 \$2298 \$2202 VDD pfet_03v3 L=0.28U W=0.36U AS=0.1152P AD=0.1584P
+ PS=1U PD=1.6U
M$1238 VDD RB9 \$2298 VDD pfet_03v3 L=0.28U W=0.72U AS=0.3708P AD=0.3168P
+ PS=2.47U PD=2.32U
M$1239 \$2203 \$133 VDD VDD pfet_03v3 L=0.28U W=0.72U AS=0.3168P AD=0.2097P
+ PS=2.32U PD=1.38U
M$1240 \$2204 \$2166 \$2203 VDD pfet_03v3 L=0.28U W=0.36U AS=0.2097P AD=0.1278P
+ PS=1.38U PD=1.07U
M$1241 \$2453 \$2205 \$2204 VDD pfet_03v3 L=0.28U W=0.36U AS=0.1278P AD=0.0567P
+ PS=1.07U PD=0.675U
M$1242 VDD \$2165 \$2453 VDD pfet_03v3 L=0.28U W=0.36U AS=0.0567P AD=0.1584P
+ PS=0.675U PD=1.6U
M$1243 \$2205 \$2204 VDD VDD pfet_03v3 L=0.28U W=0.36U AS=0.1764P AD=0.1584P
+ PS=1.26U PD=1.6U
M$1244 \$2206 \$2204 VDD VDD pfet_03v3 L=0.28U W=0.72U AS=0.1764P AD=0.36P
+ PS=1.26U PD=2.44U
M$1245 \$2299 RA9 VDD VDD pfet_03v3 L=0.28U W=0.72U AS=0.3312P AD=0.3888P
+ PS=2.36U PD=2.52U
M$1246 \$2206 \$2299 \$69 VDD pfet_03v3 L=0.28U W=0.36U AS=0.1584P AD=0.1152P
+ PS=1.6U PD=1U
M$1247 \$70 \$2300 \$2206 VDD pfet_03v3 L=0.28U W=0.36U AS=0.1152P AD=0.1584P
+ PS=1U PD=1.6U
M$1248 VDD RB9 \$2300 VDD pfet_03v3 L=0.28U W=0.72U AS=0.3708P AD=0.3168P
+ PS=2.47U PD=2.32U
M$1249 \$2207 \$136 VDD VDD pfet_03v3 L=0.28U W=0.72U AS=0.3168P AD=0.2097P
+ PS=2.32U PD=1.38U
M$1250 \$2208 \$2166 \$2207 VDD pfet_03v3 L=0.28U W=0.36U AS=0.2097P AD=0.1278P
+ PS=1.38U PD=1.07U
M$1251 \$2462 \$2209 \$2208 VDD pfet_03v3 L=0.28U W=0.36U AS=0.1278P AD=0.0567P
+ PS=1.07U PD=0.675U
M$1252 VDD \$2165 \$2462 VDD pfet_03v3 L=0.28U W=0.36U AS=0.0567P AD=0.1584P
+ PS=0.675U PD=1.6U
M$1253 \$2209 \$2208 VDD VDD pfet_03v3 L=0.28U W=0.36U AS=0.1764P AD=0.1584P
+ PS=1.26U PD=1.6U
M$1254 \$2210 \$2208 VDD VDD pfet_03v3 L=0.28U W=0.72U AS=0.1764P AD=0.36P
+ PS=1.26U PD=2.44U
M$1255 \$2301 RA9 VDD VDD pfet_03v3 L=0.28U W=0.72U AS=0.3312P AD=0.3888P
+ PS=2.36U PD=2.52U
M$1256 \$2210 \$2301 \$71 VDD pfet_03v3 L=0.28U W=0.36U AS=0.1584P AD=0.1152P
+ PS=1.6U PD=1U
M$1257 \$72 \$2302 \$2210 VDD pfet_03v3 L=0.28U W=0.36U AS=0.1152P AD=0.1584P
+ PS=1U PD=1.6U
M$1258 VDD RB9 \$2302 VDD pfet_03v3 L=0.28U W=0.72U AS=0.3708P AD=0.3168P
+ PS=2.47U PD=2.32U
M$1259 \$2211 \$139 VDD VDD pfet_03v3 L=0.28U W=0.72U AS=0.3168P AD=0.2097P
+ PS=2.32U PD=1.38U
M$1260 \$2212 \$2166 \$2211 VDD pfet_03v3 L=0.28U W=0.36U AS=0.2097P AD=0.1278P
+ PS=1.38U PD=1.07U
M$1261 \$2470 \$2213 \$2212 VDD pfet_03v3 L=0.28U W=0.36U AS=0.1278P AD=0.0567P
+ PS=1.07U PD=0.675U
M$1262 VDD \$2165 \$2470 VDD pfet_03v3 L=0.28U W=0.36U AS=0.0567P AD=0.1584P
+ PS=0.675U PD=1.6U
M$1263 \$2213 \$2212 VDD VDD pfet_03v3 L=0.28U W=0.36U AS=0.1764P AD=0.1584P
+ PS=1.26U PD=1.6U
M$1264 \$2214 \$2212 VDD VDD pfet_03v3 L=0.28U W=0.72U AS=0.1764P AD=0.36P
+ PS=1.26U PD=2.44U
M$1265 \$2303 RA9 VDD VDD pfet_03v3 L=0.28U W=0.72U AS=0.3312P AD=0.3888P
+ PS=2.36U PD=2.52U
M$1266 \$2214 \$2303 \$73 VDD pfet_03v3 L=0.28U W=0.36U AS=0.1584P AD=0.1152P
+ PS=1.6U PD=1U
M$1267 \$74 \$2304 \$2214 VDD pfet_03v3 L=0.28U W=0.36U AS=0.1152P AD=0.1584P
+ PS=1U PD=1.6U
M$1268 VDD RB9 \$2304 VDD pfet_03v3 L=0.28U W=0.72U AS=0.3708P AD=0.3168P
+ PS=2.47U PD=2.32U
M$1269 \$2215 \$142 VDD VDD pfet_03v3 L=0.28U W=0.72U AS=0.3168P AD=0.2097P
+ PS=2.32U PD=1.38U
M$1270 \$2216 \$2166 \$2215 VDD pfet_03v3 L=0.28U W=0.36U AS=0.2097P AD=0.1278P
+ PS=1.38U PD=1.07U
M$1271 \$2456 \$2217 \$2216 VDD pfet_03v3 L=0.28U W=0.36U AS=0.1278P AD=0.0567P
+ PS=1.07U PD=0.675U
M$1272 VDD \$2165 \$2456 VDD pfet_03v3 L=0.28U W=0.36U AS=0.0567P AD=0.1584P
+ PS=0.675U PD=1.6U
M$1273 \$2217 \$2216 VDD VDD pfet_03v3 L=0.28U W=0.36U AS=0.1764P AD=0.1584P
+ PS=1.26U PD=1.6U
M$1274 \$2218 \$2216 VDD VDD pfet_03v3 L=0.28U W=0.72U AS=0.1764P AD=0.36P
+ PS=1.26U PD=2.44U
M$1275 \$2305 RA9 VDD VDD pfet_03v3 L=0.28U W=0.72U AS=0.3312P AD=0.3888P
+ PS=2.36U PD=2.52U
M$1276 \$2218 \$2305 \$75 VDD pfet_03v3 L=0.28U W=0.36U AS=0.1584P AD=0.1152P
+ PS=1.6U PD=1U
M$1277 \$76 \$2306 \$2218 VDD pfet_03v3 L=0.28U W=0.36U AS=0.1152P AD=0.1584P
+ PS=1U PD=1.6U
M$1278 VDD RB9 \$2306 VDD pfet_03v3 L=0.28U W=0.72U AS=0.3708P AD=0.3168P
+ PS=2.47U PD=2.32U
M$1279 \$2219 \$145 VDD VDD pfet_03v3 L=0.28U W=0.72U AS=0.3168P AD=0.2097P
+ PS=2.32U PD=1.38U
M$1280 \$2220 \$2166 \$2219 VDD pfet_03v3 L=0.28U W=0.36U AS=0.2097P AD=0.1278P
+ PS=1.38U PD=1.07U
M$1281 \$2428 \$2221 \$2220 VDD pfet_03v3 L=0.28U W=0.36U AS=0.1278P AD=0.0567P
+ PS=1.07U PD=0.675U
M$1282 VDD \$2165 \$2428 VDD pfet_03v3 L=0.28U W=0.36U AS=0.0567P AD=0.1584P
+ PS=0.675U PD=1.6U
M$1283 \$2221 \$2220 VDD VDD pfet_03v3 L=0.28U W=0.36U AS=0.1764P AD=0.1584P
+ PS=1.26U PD=1.6U
M$1284 \$2222 \$2220 VDD VDD pfet_03v3 L=0.28U W=0.72U AS=0.1764P AD=0.36P
+ PS=1.26U PD=2.44U
M$1285 \$2307 RA9 VDD VDD pfet_03v3 L=0.28U W=0.72U AS=0.3312P AD=0.3888P
+ PS=2.36U PD=2.52U
M$1286 \$2222 \$2307 \$77 VDD pfet_03v3 L=0.28U W=0.36U AS=0.1584P AD=0.1152P
+ PS=1.6U PD=1U
M$1287 \$78 \$2308 \$2222 VDD pfet_03v3 L=0.28U W=0.36U AS=0.1152P AD=0.1584P
+ PS=1U PD=1.6U
M$1288 VDD RB9 \$2308 VDD pfet_03v3 L=0.28U W=0.72U AS=0.3708P AD=0.3168P
+ PS=2.47U PD=2.32U
M$1289 \$2223 \$148 VDD VDD pfet_03v3 L=0.28U W=0.72U AS=0.3168P AD=0.2097P
+ PS=2.32U PD=1.38U
M$1290 \$2224 \$2166 \$2223 VDD pfet_03v3 L=0.28U W=0.36U AS=0.2097P AD=0.1278P
+ PS=1.38U PD=1.07U
M$1291 \$2410 \$2225 \$2224 VDD pfet_03v3 L=0.28U W=0.36U AS=0.1278P AD=0.0567P
+ PS=1.07U PD=0.675U
M$1292 VDD \$2165 \$2410 VDD pfet_03v3 L=0.28U W=0.36U AS=0.0567P AD=0.1584P
+ PS=0.675U PD=1.6U
M$1293 \$2225 \$2224 VDD VDD pfet_03v3 L=0.28U W=0.36U AS=0.1764P AD=0.1584P
+ PS=1.26U PD=1.6U
M$1294 \$2226 \$2224 VDD VDD pfet_03v3 L=0.28U W=0.72U AS=0.1764P AD=0.36P
+ PS=1.26U PD=2.44U
M$1295 \$2309 RA9 VDD VDD pfet_03v3 L=0.28U W=0.72U AS=0.3312P AD=0.3888P
+ PS=2.36U PD=2.52U
M$1296 \$2226 \$2309 \$79 VDD pfet_03v3 L=0.28U W=0.36U AS=0.1584P AD=0.1152P
+ PS=1.6U PD=1U
M$1297 \$80 \$2310 \$2226 VDD pfet_03v3 L=0.28U W=0.36U AS=0.1152P AD=0.1584P
+ PS=1U PD=1.6U
M$1298 VDD RB9 \$2310 VDD pfet_03v3 L=0.28U W=0.72U AS=0.3708P AD=0.3168P
+ PS=2.47U PD=2.32U
M$1299 \$2227 \$151 VDD VDD pfet_03v3 L=0.28U W=0.72U AS=0.3168P AD=0.2097P
+ PS=2.32U PD=1.38U
M$1300 \$2228 \$2166 \$2227 VDD pfet_03v3 L=0.28U W=0.36U AS=0.2097P AD=0.1278P
+ PS=1.38U PD=1.07U
M$1301 \$2382 \$2229 \$2228 VDD pfet_03v3 L=0.28U W=0.36U AS=0.1278P AD=0.0567P
+ PS=1.07U PD=0.675U
M$1302 VDD \$2165 \$2382 VDD pfet_03v3 L=0.28U W=0.36U AS=0.0567P AD=0.1584P
+ PS=0.675U PD=1.6U
M$1303 \$2229 \$2228 VDD VDD pfet_03v3 L=0.28U W=0.36U AS=0.1764P AD=0.1584P
+ PS=1.26U PD=1.6U
M$1304 \$2230 \$2228 VDD VDD pfet_03v3 L=0.28U W=0.72U AS=0.1764P AD=0.36P
+ PS=1.26U PD=2.44U
M$1305 \$2311 RA9 VDD VDD pfet_03v3 L=0.28U W=0.72U AS=0.3312P AD=0.3888P
+ PS=2.36U PD=2.52U
M$1306 \$2230 \$2311 \$81 VDD pfet_03v3 L=0.28U W=0.36U AS=0.1584P AD=0.1152P
+ PS=1.6U PD=1U
M$1307 \$82 \$2312 \$2230 VDD pfet_03v3 L=0.28U W=0.36U AS=0.1152P AD=0.1584P
+ PS=1U PD=1.6U
M$1308 VDD RB9 \$2312 VDD pfet_03v3 L=0.28U W=0.72U AS=0.3708P AD=0.3168P
+ PS=2.47U PD=2.32U
M$1309 \$2474 WE8 VDD VDD pfet_03v3 L=0.28U W=0.72U AS=0.3168P AD=0.1872P
+ PS=2.32U PD=1.24U
M$1310 VDD CLK \$2474 VDD pfet_03v3 L=0.28U W=0.72U AS=0.1872P AD=0.3168P
+ PS=1.24U PD=2.32U
M$1311 \$2476 \$2474 VDD VDD pfet_03v3 L=0.28U W=1.27U AS=0.5588P AD=0.3302P
+ PS=3.42U PD=1.79U
M$1312 VDD \$2474 \$2476 VDD pfet_03v3 L=0.28U W=1.27U AS=0.3302P AD=0.3386P
+ PS=1.79U PD=1.86U
M$1313 \$2477 \$2476 VDD VDD pfet_03v3 L=0.28U W=1.34U AS=0.3386P AD=0.3886P
+ PS=1.86U PD=1.92U
M$1314 VDD \$2476 \$2477 VDD pfet_03v3 L=0.28U W=1.34U AS=0.3886P AD=0.5896P
+ PS=1.92U PD=3.56U
M$1315 \$2481 \$2477 \$2480 VDD pfet_03v3 L=0.28U W=0.36U AS=0.2097P AD=0.1278P
+ PS=1.38U PD=1.07U
M$1316 \$2581 \$2482 \$2481 VDD pfet_03v3 L=0.28U W=0.36U AS=0.1278P AD=0.0567P
+ PS=1.07U PD=0.675U
M$1317 VDD \$2476 \$2581 VDD pfet_03v3 L=0.28U W=0.36U AS=0.0567P AD=0.1584P
+ PS=0.675U PD=1.6U
M$1318 \$2480 \$106 VDD VDD pfet_03v3 L=0.28U W=0.72U AS=0.3168P AD=0.2097P
+ PS=2.32U PD=1.38U
M$1319 VDD \$2481 \$2482 VDD pfet_03v3 L=0.28U W=0.36U AS=0.1584P AD=0.1764P
+ PS=1.6U PD=1.26U
M$1320 \$2483 \$2481 VDD VDD pfet_03v3 L=0.28U W=0.72U AS=0.1764P AD=0.36P
+ PS=1.26U PD=2.44U
M$1321 \$2484 RB8 VDD VDD pfet_03v3 L=0.28U W=0.72U AS=0.3312P AD=0.3888P
+ PS=2.36U PD=2.52U
M$1322 \$2483 \$2484 \$51 VDD pfet_03v3 L=0.28U W=0.36U AS=0.1584P AD=0.1152P
+ PS=1.6U PD=1U
M$1323 \$52 \$2485 \$2483 VDD pfet_03v3 L=0.28U W=0.36U AS=0.1152P AD=0.1584P
+ PS=1U PD=1.6U
M$1324 VDD RA8 \$2485 VDD pfet_03v3 L=0.28U W=0.72U AS=0.3708P AD=0.3168P
+ PS=2.47U PD=2.32U
M$1325 \$2487 \$2477 \$2486 VDD pfet_03v3 L=0.28U W=0.36U AS=0.2097P AD=0.1278P
+ PS=1.38U PD=1.07U
M$1326 \$2589 \$2488 \$2487 VDD pfet_03v3 L=0.28U W=0.36U AS=0.1278P AD=0.0567P
+ PS=1.07U PD=0.675U
M$1327 VDD \$2476 \$2589 VDD pfet_03v3 L=0.28U W=0.36U AS=0.0567P AD=0.1584P
+ PS=0.675U PD=1.6U
M$1328 \$2486 \$109 VDD VDD pfet_03v3 L=0.28U W=0.72U AS=0.3168P AD=0.2097P
+ PS=2.32U PD=1.38U
M$1329 VDD \$2487 \$2488 VDD pfet_03v3 L=0.28U W=0.36U AS=0.1584P AD=0.1764P
+ PS=1.6U PD=1.26U
M$1330 \$2489 \$2487 VDD VDD pfet_03v3 L=0.28U W=0.72U AS=0.1764P AD=0.36P
+ PS=1.26U PD=2.44U
M$1331 \$2490 RB8 VDD VDD pfet_03v3 L=0.28U W=0.72U AS=0.3312P AD=0.3888P
+ PS=2.36U PD=2.52U
M$1332 \$2489 \$2490 \$53 VDD pfet_03v3 L=0.28U W=0.36U AS=0.1584P AD=0.1152P
+ PS=1.6U PD=1U
M$1333 \$54 \$2491 \$2489 VDD pfet_03v3 L=0.28U W=0.36U AS=0.1152P AD=0.1584P
+ PS=1U PD=1.6U
M$1334 VDD RA8 \$2491 VDD pfet_03v3 L=0.28U W=0.72U AS=0.3708P AD=0.3168P
+ PS=2.47U PD=2.32U
M$1335 \$2493 \$2477 \$2492 VDD pfet_03v3 L=0.28U W=0.36U AS=0.2097P AD=0.1278P
+ PS=1.38U PD=1.07U
M$1336 \$2596 \$2494 \$2493 VDD pfet_03v3 L=0.28U W=0.36U AS=0.1278P AD=0.0567P
+ PS=1.07U PD=0.675U
M$1337 VDD \$2476 \$2596 VDD pfet_03v3 L=0.28U W=0.36U AS=0.0567P AD=0.1584P
+ PS=0.675U PD=1.6U
M$1338 \$2492 \$112 VDD VDD pfet_03v3 L=0.28U W=0.72U AS=0.3168P AD=0.2097P
+ PS=2.32U PD=1.38U
M$1339 VDD \$2493 \$2494 VDD pfet_03v3 L=0.28U W=0.36U AS=0.1584P AD=0.1764P
+ PS=1.6U PD=1.26U
M$1340 \$2495 \$2493 VDD VDD pfet_03v3 L=0.28U W=0.72U AS=0.1764P AD=0.36P
+ PS=1.26U PD=2.44U
M$1341 \$2496 RB8 VDD VDD pfet_03v3 L=0.28U W=0.72U AS=0.3312P AD=0.3888P
+ PS=2.36U PD=2.52U
M$1342 \$2495 \$2496 \$55 VDD pfet_03v3 L=0.28U W=0.36U AS=0.1584P AD=0.1152P
+ PS=1.6U PD=1U
M$1343 \$56 \$2497 \$2495 VDD pfet_03v3 L=0.28U W=0.36U AS=0.1152P AD=0.1584P
+ PS=1U PD=1.6U
M$1344 VDD RA8 \$2497 VDD pfet_03v3 L=0.28U W=0.72U AS=0.3708P AD=0.3168P
+ PS=2.47U PD=2.32U
M$1345 \$2499 \$2477 \$2498 VDD pfet_03v3 L=0.28U W=0.36U AS=0.2097P AD=0.1278P
+ PS=1.38U PD=1.07U
M$1346 \$2604 \$2500 \$2499 VDD pfet_03v3 L=0.28U W=0.36U AS=0.1278P AD=0.0567P
+ PS=1.07U PD=0.675U
M$1347 VDD \$2476 \$2604 VDD pfet_03v3 L=0.28U W=0.36U AS=0.0567P AD=0.1584P
+ PS=0.675U PD=1.6U
M$1348 \$2498 \$115 VDD VDD pfet_03v3 L=0.28U W=0.72U AS=0.3168P AD=0.2097P
+ PS=2.32U PD=1.38U
M$1349 VDD \$2499 \$2500 VDD pfet_03v3 L=0.28U W=0.36U AS=0.1584P AD=0.1764P
+ PS=1.6U PD=1.26U
M$1350 \$2501 \$2499 VDD VDD pfet_03v3 L=0.28U W=0.72U AS=0.1764P AD=0.36P
+ PS=1.26U PD=2.44U
M$1351 \$2502 RB8 VDD VDD pfet_03v3 L=0.28U W=0.72U AS=0.3312P AD=0.3888P
+ PS=2.36U PD=2.52U
M$1352 \$2501 \$2502 \$57 VDD pfet_03v3 L=0.28U W=0.36U AS=0.1584P AD=0.1152P
+ PS=1.6U PD=1U
M$1353 \$58 \$2503 \$2501 VDD pfet_03v3 L=0.28U W=0.36U AS=0.1152P AD=0.1584P
+ PS=1U PD=1.6U
M$1354 VDD RA8 \$2503 VDD pfet_03v3 L=0.28U W=0.72U AS=0.3708P AD=0.3168P
+ PS=2.47U PD=2.32U
M$1355 \$2505 \$2477 \$2504 VDD pfet_03v3 L=0.28U W=0.36U AS=0.2097P AD=0.1278P
+ PS=1.38U PD=1.07U
M$1356 \$2613 \$2506 \$2505 VDD pfet_03v3 L=0.28U W=0.36U AS=0.1278P AD=0.0567P
+ PS=1.07U PD=0.675U
M$1357 VDD \$2476 \$2613 VDD pfet_03v3 L=0.28U W=0.36U AS=0.0567P AD=0.1584P
+ PS=0.675U PD=1.6U
M$1358 \$2504 \$118 VDD VDD pfet_03v3 L=0.28U W=0.72U AS=0.3168P AD=0.2097P
+ PS=2.32U PD=1.38U
M$1359 VDD \$2505 \$2506 VDD pfet_03v3 L=0.28U W=0.36U AS=0.1584P AD=0.1764P
+ PS=1.6U PD=1.26U
M$1360 \$2507 \$2505 VDD VDD pfet_03v3 L=0.28U W=0.72U AS=0.1764P AD=0.36P
+ PS=1.26U PD=2.44U
M$1361 \$2508 RB8 VDD VDD pfet_03v3 L=0.28U W=0.72U AS=0.3312P AD=0.3888P
+ PS=2.36U PD=2.52U
M$1362 \$2507 \$2508 \$59 VDD pfet_03v3 L=0.28U W=0.36U AS=0.1584P AD=0.1152P
+ PS=1.6U PD=1U
M$1363 \$60 \$2509 \$2507 VDD pfet_03v3 L=0.28U W=0.36U AS=0.1152P AD=0.1584P
+ PS=1U PD=1.6U
M$1364 VDD RA8 \$2509 VDD pfet_03v3 L=0.28U W=0.72U AS=0.3708P AD=0.3168P
+ PS=2.47U PD=2.32U
M$1365 \$2511 \$2477 \$2510 VDD pfet_03v3 L=0.28U W=0.36U AS=0.2097P AD=0.1278P
+ PS=1.38U PD=1.07U
M$1366 \$2619 \$2512 \$2511 VDD pfet_03v3 L=0.28U W=0.36U AS=0.1278P AD=0.0567P
+ PS=1.07U PD=0.675U
M$1367 VDD \$2476 \$2619 VDD pfet_03v3 L=0.28U W=0.36U AS=0.0567P AD=0.1584P
+ PS=0.675U PD=1.6U
M$1368 \$2510 \$121 VDD VDD pfet_03v3 L=0.28U W=0.72U AS=0.3168P AD=0.2097P
+ PS=2.32U PD=1.38U
M$1369 VDD \$2511 \$2512 VDD pfet_03v3 L=0.28U W=0.36U AS=0.1584P AD=0.1764P
+ PS=1.6U PD=1.26U
M$1370 \$2513 \$2511 VDD VDD pfet_03v3 L=0.28U W=0.72U AS=0.1764P AD=0.36P
+ PS=1.26U PD=2.44U
M$1371 \$2514 RB8 VDD VDD pfet_03v3 L=0.28U W=0.72U AS=0.3312P AD=0.3888P
+ PS=2.36U PD=2.52U
M$1372 \$2513 \$2514 \$61 VDD pfet_03v3 L=0.28U W=0.36U AS=0.1584P AD=0.1152P
+ PS=1.6U PD=1U
M$1373 \$62 \$2515 \$2513 VDD pfet_03v3 L=0.28U W=0.36U AS=0.1152P AD=0.1584P
+ PS=1U PD=1.6U
M$1374 VDD RA8 \$2515 VDD pfet_03v3 L=0.28U W=0.72U AS=0.3708P AD=0.3168P
+ PS=2.47U PD=2.32U
M$1375 \$2517 \$2477 \$2516 VDD pfet_03v3 L=0.28U W=0.36U AS=0.2097P AD=0.1278P
+ PS=1.38U PD=1.07U
M$1376 \$2626 \$2518 \$2517 VDD pfet_03v3 L=0.28U W=0.36U AS=0.1278P AD=0.0567P
+ PS=1.07U PD=0.675U
M$1377 VDD \$2476 \$2626 VDD pfet_03v3 L=0.28U W=0.36U AS=0.0567P AD=0.1584P
+ PS=0.675U PD=1.6U
M$1378 \$2516 \$124 VDD VDD pfet_03v3 L=0.28U W=0.72U AS=0.3168P AD=0.2097P
+ PS=2.32U PD=1.38U
M$1379 VDD \$2517 \$2518 VDD pfet_03v3 L=0.28U W=0.36U AS=0.1584P AD=0.1764P
+ PS=1.6U PD=1.26U
M$1380 \$2519 \$2517 VDD VDD pfet_03v3 L=0.28U W=0.72U AS=0.1764P AD=0.36P
+ PS=1.26U PD=2.44U
M$1381 \$2520 RB8 VDD VDD pfet_03v3 L=0.28U W=0.72U AS=0.3312P AD=0.3888P
+ PS=2.36U PD=2.52U
M$1382 \$2519 \$2520 \$63 VDD pfet_03v3 L=0.28U W=0.36U AS=0.1584P AD=0.1152P
+ PS=1.6U PD=1U
M$1383 \$64 \$2521 \$2519 VDD pfet_03v3 L=0.28U W=0.36U AS=0.1152P AD=0.1584P
+ PS=1U PD=1.6U
M$1384 VDD RA8 \$2521 VDD pfet_03v3 L=0.28U W=0.72U AS=0.3708P AD=0.3168P
+ PS=2.47U PD=2.32U
M$1385 \$2523 \$2477 \$2522 VDD pfet_03v3 L=0.28U W=0.36U AS=0.2097P AD=0.1278P
+ PS=1.38U PD=1.07U
M$1386 \$2635 \$2524 \$2523 VDD pfet_03v3 L=0.28U W=0.36U AS=0.1278P AD=0.0567P
+ PS=1.07U PD=0.675U
M$1387 VDD \$2476 \$2635 VDD pfet_03v3 L=0.28U W=0.36U AS=0.0567P AD=0.1584P
+ PS=0.675U PD=1.6U
M$1388 \$2522 \$127 VDD VDD pfet_03v3 L=0.28U W=0.72U AS=0.3168P AD=0.2097P
+ PS=2.32U PD=1.38U
M$1389 VDD \$2523 \$2524 VDD pfet_03v3 L=0.28U W=0.36U AS=0.1584P AD=0.1764P
+ PS=1.6U PD=1.26U
M$1390 \$2525 \$2523 VDD VDD pfet_03v3 L=0.28U W=0.72U AS=0.1764P AD=0.36P
+ PS=1.26U PD=2.44U
M$1391 \$2526 RB8 VDD VDD pfet_03v3 L=0.28U W=0.72U AS=0.3312P AD=0.3888P
+ PS=2.36U PD=2.52U
M$1392 \$2525 \$2526 \$65 VDD pfet_03v3 L=0.28U W=0.36U AS=0.1584P AD=0.1152P
+ PS=1.6U PD=1U
M$1393 \$66 \$2527 \$2525 VDD pfet_03v3 L=0.28U W=0.36U AS=0.1152P AD=0.1584P
+ PS=1U PD=1.6U
M$1394 VDD RA8 \$2527 VDD pfet_03v3 L=0.28U W=0.72U AS=0.3708P AD=0.3168P
+ PS=2.47U PD=2.32U
M$1395 \$2529 \$2477 \$2528 VDD pfet_03v3 L=0.28U W=0.36U AS=0.2097P AD=0.1278P
+ PS=1.38U PD=1.07U
M$1396 \$2641 \$2530 \$2529 VDD pfet_03v3 L=0.28U W=0.36U AS=0.1278P AD=0.0567P
+ PS=1.07U PD=0.675U
M$1397 VDD \$2476 \$2641 VDD pfet_03v3 L=0.28U W=0.36U AS=0.0567P AD=0.1584P
+ PS=0.675U PD=1.6U
M$1398 \$2528 \$130 VDD VDD pfet_03v3 L=0.28U W=0.72U AS=0.3168P AD=0.2097P
+ PS=2.32U PD=1.38U
M$1399 VDD \$2529 \$2530 VDD pfet_03v3 L=0.28U W=0.36U AS=0.1584P AD=0.1764P
+ PS=1.6U PD=1.26U
M$1400 \$2531 \$2529 VDD VDD pfet_03v3 L=0.28U W=0.72U AS=0.1764P AD=0.36P
+ PS=1.26U PD=2.44U
M$1401 \$2532 RB8 VDD VDD pfet_03v3 L=0.28U W=0.72U AS=0.3312P AD=0.3888P
+ PS=2.36U PD=2.52U
M$1402 \$2531 \$2532 \$67 VDD pfet_03v3 L=0.28U W=0.36U AS=0.1584P AD=0.1152P
+ PS=1.6U PD=1U
M$1403 \$68 \$2533 \$2531 VDD pfet_03v3 L=0.28U W=0.36U AS=0.1152P AD=0.1584P
+ PS=1U PD=1.6U
M$1404 VDD RA8 \$2533 VDD pfet_03v3 L=0.28U W=0.72U AS=0.3708P AD=0.3168P
+ PS=2.47U PD=2.32U
M$1405 \$2535 \$2477 \$2534 VDD pfet_03v3 L=0.28U W=0.36U AS=0.2097P AD=0.1278P
+ PS=1.38U PD=1.07U
M$1406 \$2648 \$2536 \$2535 VDD pfet_03v3 L=0.28U W=0.36U AS=0.1278P AD=0.0567P
+ PS=1.07U PD=0.675U
M$1407 VDD \$2476 \$2648 VDD pfet_03v3 L=0.28U W=0.36U AS=0.0567P AD=0.1584P
+ PS=0.675U PD=1.6U
M$1408 \$2534 \$133 VDD VDD pfet_03v3 L=0.28U W=0.72U AS=0.3168P AD=0.2097P
+ PS=2.32U PD=1.38U
M$1409 VDD \$2535 \$2536 VDD pfet_03v3 L=0.28U W=0.36U AS=0.1584P AD=0.1764P
+ PS=1.6U PD=1.26U
M$1410 \$2537 \$2535 VDD VDD pfet_03v3 L=0.28U W=0.72U AS=0.1764P AD=0.36P
+ PS=1.26U PD=2.44U
M$1411 \$2538 RB8 VDD VDD pfet_03v3 L=0.28U W=0.72U AS=0.3312P AD=0.3888P
+ PS=2.36U PD=2.52U
M$1412 \$2537 \$2538 \$69 VDD pfet_03v3 L=0.28U W=0.36U AS=0.1584P AD=0.1152P
+ PS=1.6U PD=1U
M$1413 \$70 \$2539 \$2537 VDD pfet_03v3 L=0.28U W=0.36U AS=0.1152P AD=0.1584P
+ PS=1U PD=1.6U
M$1414 VDD RA8 \$2539 VDD pfet_03v3 L=0.28U W=0.72U AS=0.3708P AD=0.3168P
+ PS=2.47U PD=2.32U
M$1415 \$2541 \$2477 \$2540 VDD pfet_03v3 L=0.28U W=0.36U AS=0.2097P AD=0.1278P
+ PS=1.38U PD=1.07U
M$1416 \$2656 \$2542 \$2541 VDD pfet_03v3 L=0.28U W=0.36U AS=0.1278P AD=0.0567P
+ PS=1.07U PD=0.675U
M$1417 VDD \$2476 \$2656 VDD pfet_03v3 L=0.28U W=0.36U AS=0.0567P AD=0.1584P
+ PS=0.675U PD=1.6U
M$1418 \$2540 \$136 VDD VDD pfet_03v3 L=0.28U W=0.72U AS=0.3168P AD=0.2097P
+ PS=2.32U PD=1.38U
M$1419 VDD \$2541 \$2542 VDD pfet_03v3 L=0.28U W=0.36U AS=0.1584P AD=0.1764P
+ PS=1.6U PD=1.26U
M$1420 \$2543 \$2541 VDD VDD pfet_03v3 L=0.28U W=0.72U AS=0.1764P AD=0.36P
+ PS=1.26U PD=2.44U
M$1421 \$2544 RB8 VDD VDD pfet_03v3 L=0.28U W=0.72U AS=0.3312P AD=0.3888P
+ PS=2.36U PD=2.52U
M$1422 \$2543 \$2544 \$71 VDD pfet_03v3 L=0.28U W=0.36U AS=0.1584P AD=0.1152P
+ PS=1.6U PD=1U
M$1423 \$72 \$2545 \$2543 VDD pfet_03v3 L=0.28U W=0.36U AS=0.1152P AD=0.1584P
+ PS=1U PD=1.6U
M$1424 VDD RA8 \$2545 VDD pfet_03v3 L=0.28U W=0.72U AS=0.3708P AD=0.3168P
+ PS=2.47U PD=2.32U
M$1425 \$2547 \$2477 \$2546 VDD pfet_03v3 L=0.28U W=0.36U AS=0.2097P AD=0.1278P
+ PS=1.38U PD=1.07U
M$1426 \$2664 \$2548 \$2547 VDD pfet_03v3 L=0.28U W=0.36U AS=0.1278P AD=0.0567P
+ PS=1.07U PD=0.675U
M$1427 VDD \$2476 \$2664 VDD pfet_03v3 L=0.28U W=0.36U AS=0.0567P AD=0.1584P
+ PS=0.675U PD=1.6U
M$1428 \$2546 \$139 VDD VDD pfet_03v3 L=0.28U W=0.72U AS=0.3168P AD=0.2097P
+ PS=2.32U PD=1.38U
M$1429 VDD \$2547 \$2548 VDD pfet_03v3 L=0.28U W=0.36U AS=0.1584P AD=0.1764P
+ PS=1.6U PD=1.26U
M$1430 \$2549 \$2547 VDD VDD pfet_03v3 L=0.28U W=0.72U AS=0.1764P AD=0.36P
+ PS=1.26U PD=2.44U
M$1431 \$2550 RB8 VDD VDD pfet_03v3 L=0.28U W=0.72U AS=0.3312P AD=0.3888P
+ PS=2.36U PD=2.52U
M$1432 \$2549 \$2550 \$73 VDD pfet_03v3 L=0.28U W=0.36U AS=0.1584P AD=0.1152P
+ PS=1.6U PD=1U
M$1433 \$74 \$2551 \$2549 VDD pfet_03v3 L=0.28U W=0.36U AS=0.1152P AD=0.1584P
+ PS=1U PD=1.6U
M$1434 VDD RA8 \$2551 VDD pfet_03v3 L=0.28U W=0.72U AS=0.3708P AD=0.3168P
+ PS=2.47U PD=2.32U
M$1435 \$2553 \$2477 \$2552 VDD pfet_03v3 L=0.28U W=0.36U AS=0.2097P AD=0.1278P
+ PS=1.38U PD=1.07U
M$1436 \$2671 \$2554 \$2553 VDD pfet_03v3 L=0.28U W=0.36U AS=0.1278P AD=0.0567P
+ PS=1.07U PD=0.675U
M$1437 VDD \$2476 \$2671 VDD pfet_03v3 L=0.28U W=0.36U AS=0.0567P AD=0.1584P
+ PS=0.675U PD=1.6U
M$1438 \$2552 \$142 VDD VDD pfet_03v3 L=0.28U W=0.72U AS=0.3168P AD=0.2097P
+ PS=2.32U PD=1.38U
M$1439 VDD \$2553 \$2554 VDD pfet_03v3 L=0.28U W=0.36U AS=0.1584P AD=0.1764P
+ PS=1.6U PD=1.26U
M$1440 \$2555 \$2553 VDD VDD pfet_03v3 L=0.28U W=0.72U AS=0.1764P AD=0.36P
+ PS=1.26U PD=2.44U
M$1441 \$2556 RB8 VDD VDD pfet_03v3 L=0.28U W=0.72U AS=0.3312P AD=0.3888P
+ PS=2.36U PD=2.52U
M$1442 \$2555 \$2556 \$75 VDD pfet_03v3 L=0.28U W=0.36U AS=0.1584P AD=0.1152P
+ PS=1.6U PD=1U
M$1443 \$76 \$2557 \$2555 VDD pfet_03v3 L=0.28U W=0.36U AS=0.1152P AD=0.1584P
+ PS=1U PD=1.6U
M$1444 VDD RA8 \$2557 VDD pfet_03v3 L=0.28U W=0.72U AS=0.3708P AD=0.3168P
+ PS=2.47U PD=2.32U
M$1445 \$2559 \$2477 \$2558 VDD pfet_03v3 L=0.28U W=0.36U AS=0.2097P AD=0.1278P
+ PS=1.38U PD=1.07U
M$1446 \$2670 \$2560 \$2559 VDD pfet_03v3 L=0.28U W=0.36U AS=0.1278P AD=0.0567P
+ PS=1.07U PD=0.675U
M$1447 VDD \$2476 \$2670 VDD pfet_03v3 L=0.28U W=0.36U AS=0.0567P AD=0.1584P
+ PS=0.675U PD=1.6U
M$1448 \$2558 \$145 VDD VDD pfet_03v3 L=0.28U W=0.72U AS=0.3168P AD=0.2097P
+ PS=2.32U PD=1.38U
M$1449 VDD \$2559 \$2560 VDD pfet_03v3 L=0.28U W=0.36U AS=0.1584P AD=0.1764P
+ PS=1.6U PD=1.26U
M$1450 \$2561 \$2559 VDD VDD pfet_03v3 L=0.28U W=0.72U AS=0.1764P AD=0.36P
+ PS=1.26U PD=2.44U
M$1451 \$2562 RB8 VDD VDD pfet_03v3 L=0.28U W=0.72U AS=0.3312P AD=0.3888P
+ PS=2.36U PD=2.52U
M$1452 \$2561 \$2562 \$77 VDD pfet_03v3 L=0.28U W=0.36U AS=0.1584P AD=0.1152P
+ PS=1.6U PD=1U
M$1453 \$78 \$2563 \$2561 VDD pfet_03v3 L=0.28U W=0.36U AS=0.1152P AD=0.1584P
+ PS=1U PD=1.6U
M$1454 VDD RA8 \$2563 VDD pfet_03v3 L=0.28U W=0.72U AS=0.3708P AD=0.3168P
+ PS=2.47U PD=2.32U
M$1455 \$2565 \$2477 \$2564 VDD pfet_03v3 L=0.28U W=0.36U AS=0.2097P AD=0.1278P
+ PS=1.38U PD=1.07U
M$1456 \$2638 \$2566 \$2565 VDD pfet_03v3 L=0.28U W=0.36U AS=0.1278P AD=0.0567P
+ PS=1.07U PD=0.675U
M$1457 VDD \$2476 \$2638 VDD pfet_03v3 L=0.28U W=0.36U AS=0.0567P AD=0.1584P
+ PS=0.675U PD=1.6U
M$1458 \$2564 \$148 VDD VDD pfet_03v3 L=0.28U W=0.72U AS=0.3168P AD=0.2097P
+ PS=2.32U PD=1.38U
M$1459 VDD \$2565 \$2566 VDD pfet_03v3 L=0.28U W=0.36U AS=0.1584P AD=0.1764P
+ PS=1.6U PD=1.26U
M$1460 \$2567 \$2565 VDD VDD pfet_03v3 L=0.28U W=0.72U AS=0.1764P AD=0.36P
+ PS=1.26U PD=2.44U
M$1461 \$2568 RB8 VDD VDD pfet_03v3 L=0.28U W=0.72U AS=0.3312P AD=0.3888P
+ PS=2.36U PD=2.52U
M$1462 \$2567 \$2568 \$79 VDD pfet_03v3 L=0.28U W=0.36U AS=0.1584P AD=0.1152P
+ PS=1.6U PD=1U
M$1463 \$80 \$2569 \$2567 VDD pfet_03v3 L=0.28U W=0.36U AS=0.1152P AD=0.1584P
+ PS=1U PD=1.6U
M$1464 VDD RA8 \$2569 VDD pfet_03v3 L=0.28U W=0.72U AS=0.3708P AD=0.3168P
+ PS=2.47U PD=2.32U
M$1465 \$2571 \$2477 \$2570 VDD pfet_03v3 L=0.28U W=0.36U AS=0.2097P AD=0.1278P
+ PS=1.38U PD=1.07U
M$1466 \$2605 \$2572 \$2571 VDD pfet_03v3 L=0.28U W=0.36U AS=0.1278P AD=0.0567P
+ PS=1.07U PD=0.675U
M$1467 VDD \$2476 \$2605 VDD pfet_03v3 L=0.28U W=0.36U AS=0.0567P AD=0.1584P
+ PS=0.675U PD=1.6U
M$1468 \$2570 \$151 VDD VDD pfet_03v3 L=0.28U W=0.72U AS=0.3168P AD=0.2097P
+ PS=2.32U PD=1.38U
M$1469 VDD \$2571 \$2572 VDD pfet_03v3 L=0.28U W=0.36U AS=0.1584P AD=0.1764P
+ PS=1.6U PD=1.26U
M$1470 \$2573 \$2571 VDD VDD pfet_03v3 L=0.28U W=0.72U AS=0.1764P AD=0.36P
+ PS=1.26U PD=2.44U
M$1471 \$2574 RB8 VDD VDD pfet_03v3 L=0.28U W=0.72U AS=0.3312P AD=0.3888P
+ PS=2.36U PD=2.52U
M$1472 \$2573 \$2574 \$81 VDD pfet_03v3 L=0.28U W=0.36U AS=0.1584P AD=0.1152P
+ PS=1.6U PD=1U
M$1473 \$82 \$2575 \$2573 VDD pfet_03v3 L=0.28U W=0.36U AS=0.1152P AD=0.1584P
+ PS=1U PD=1.6U
M$1474 VDD RA8 \$2575 VDD pfet_03v3 L=0.28U W=0.72U AS=0.3708P AD=0.3168P
+ PS=2.47U PD=2.32U
M$1475 \$2777 WE7 VDD VDD pfet_03v3 L=0.28U W=0.72U AS=0.3168P AD=0.1872P
+ PS=2.32U PD=1.24U
M$1476 VDD CLK \$2777 VDD pfet_03v3 L=0.28U W=0.72U AS=0.1872P AD=0.3168P
+ PS=1.24U PD=2.32U
M$1477 \$2778 \$2777 VDD VDD pfet_03v3 L=0.28U W=1.27U AS=0.5588P AD=0.3302P
+ PS=3.42U PD=1.79U
M$1478 \$2778 \$2777 VDD VDD pfet_03v3 L=0.28U W=1.27U AS=0.3386P AD=0.3302P
+ PS=1.86U PD=1.79U
M$1479 \$2779 \$2778 VDD VDD pfet_03v3 L=0.28U W=1.34U AS=0.3386P AD=0.3886P
+ PS=1.86U PD=1.92U
M$1480 VDD \$2778 \$2779 VDD pfet_03v3 L=0.28U W=1.34U AS=0.3886P AD=0.5896P
+ PS=1.92U PD=3.56U
M$1481 \$2780 \$106 VDD VDD pfet_03v3 L=0.28U W=0.72U AS=0.3168P AD=0.2097P
+ PS=2.32U PD=1.38U
M$1482 \$2781 \$2779 \$2780 VDD pfet_03v3 L=0.28U W=0.36U AS=0.2097P AD=0.1278P
+ PS=1.38U PD=1.07U
M$1483 \$2993 \$2782 \$2781 VDD pfet_03v3 L=0.28U W=0.36U AS=0.1278P AD=0.0567P
+ PS=1.07U PD=0.675U
M$1484 VDD \$2778 \$2993 VDD pfet_03v3 L=0.28U W=0.36U AS=0.0567P AD=0.1584P
+ PS=0.675U PD=1.6U
M$1485 \$2782 \$2781 VDD VDD pfet_03v3 L=0.28U W=0.36U AS=0.1764P AD=0.1584P
+ PS=1.26U PD=1.6U
M$1486 \$2783 \$2781 VDD VDD pfet_03v3 L=0.28U W=0.72U AS=0.1764P AD=0.36P
+ PS=1.26U PD=2.44U
M$1487 \$2900 RA7 VDD VDD pfet_03v3 L=0.28U W=0.72U AS=0.3312P AD=0.3888P
+ PS=2.36U PD=2.52U
M$1488 \$2783 \$2900 \$51 VDD pfet_03v3 L=0.28U W=0.36U AS=0.1584P AD=0.1152P
+ PS=1.6U PD=1U
M$1489 \$52 \$2901 \$2783 VDD pfet_03v3 L=0.28U W=0.36U AS=0.1152P AD=0.1584P
+ PS=1U PD=1.6U
M$1490 VDD RB7 \$2901 VDD pfet_03v3 L=0.28U W=0.72U AS=0.3708P AD=0.3168P
+ PS=2.47U PD=2.32U
M$1491 \$2784 \$109 VDD VDD pfet_03v3 L=0.28U W=0.72U AS=0.3168P AD=0.2097P
+ PS=2.32U PD=1.38U
M$1492 \$2785 \$2779 \$2784 VDD pfet_03v3 L=0.28U W=0.36U AS=0.2097P AD=0.1278P
+ PS=1.38U PD=1.07U
M$1493 \$3003 \$2786 \$2785 VDD pfet_03v3 L=0.28U W=0.36U AS=0.1278P AD=0.0567P
+ PS=1.07U PD=0.675U
M$1494 VDD \$2778 \$3003 VDD pfet_03v3 L=0.28U W=0.36U AS=0.0567P AD=0.1584P
+ PS=0.675U PD=1.6U
M$1495 \$2786 \$2785 VDD VDD pfet_03v3 L=0.28U W=0.36U AS=0.1764P AD=0.1584P
+ PS=1.26U PD=1.6U
M$1496 \$2787 \$2785 VDD VDD pfet_03v3 L=0.28U W=0.72U AS=0.1764P AD=0.36P
+ PS=1.26U PD=2.44U
M$1497 \$2902 RA7 VDD VDD pfet_03v3 L=0.28U W=0.72U AS=0.3312P AD=0.3888P
+ PS=2.36U PD=2.52U
M$1498 \$2787 \$2902 \$53 VDD pfet_03v3 L=0.28U W=0.36U AS=0.1584P AD=0.1152P
+ PS=1.6U PD=1U
M$1499 \$54 \$2903 \$2787 VDD pfet_03v3 L=0.28U W=0.36U AS=0.1152P AD=0.1584P
+ PS=1U PD=1.6U
M$1500 VDD RB7 \$2903 VDD pfet_03v3 L=0.28U W=0.72U AS=0.3708P AD=0.3168P
+ PS=2.47U PD=2.32U
M$1501 \$2788 \$112 VDD VDD pfet_03v3 L=0.28U W=0.72U AS=0.3168P AD=0.2097P
+ PS=2.32U PD=1.38U
M$1502 \$2789 \$2779 \$2788 VDD pfet_03v3 L=0.28U W=0.36U AS=0.2097P AD=0.1278P
+ PS=1.38U PD=1.07U
M$1503 \$3009 \$2790 \$2789 VDD pfet_03v3 L=0.28U W=0.36U AS=0.1278P AD=0.0567P
+ PS=1.07U PD=0.675U
M$1504 VDD \$2778 \$3009 VDD pfet_03v3 L=0.28U W=0.36U AS=0.0567P AD=0.1584P
+ PS=0.675U PD=1.6U
M$1505 \$2790 \$2789 VDD VDD pfet_03v3 L=0.28U W=0.36U AS=0.1764P AD=0.1584P
+ PS=1.26U PD=1.6U
M$1506 \$2791 \$2789 VDD VDD pfet_03v3 L=0.28U W=0.72U AS=0.1764P AD=0.36P
+ PS=1.26U PD=2.44U
M$1507 \$2904 RA7 VDD VDD pfet_03v3 L=0.28U W=0.72U AS=0.3312P AD=0.3888P
+ PS=2.36U PD=2.52U
M$1508 \$2791 \$2904 \$55 VDD pfet_03v3 L=0.28U W=0.36U AS=0.1584P AD=0.1152P
+ PS=1.6U PD=1U
M$1509 \$56 \$2905 \$2791 VDD pfet_03v3 L=0.28U W=0.36U AS=0.1152P AD=0.1584P
+ PS=1U PD=1.6U
M$1510 VDD RB7 \$2905 VDD pfet_03v3 L=0.28U W=0.72U AS=0.3708P AD=0.3168P
+ PS=2.47U PD=2.32U
M$1511 \$2792 \$115 VDD VDD pfet_03v3 L=0.28U W=0.72U AS=0.3168P AD=0.2097P
+ PS=2.32U PD=1.38U
M$1512 \$2793 \$2779 \$2792 VDD pfet_03v3 L=0.28U W=0.36U AS=0.2097P AD=0.1278P
+ PS=1.38U PD=1.07U
M$1513 \$3019 \$2794 \$2793 VDD pfet_03v3 L=0.28U W=0.36U AS=0.1278P AD=0.0567P
+ PS=1.07U PD=0.675U
M$1514 VDD \$2778 \$3019 VDD pfet_03v3 L=0.28U W=0.36U AS=0.0567P AD=0.1584P
+ PS=0.675U PD=1.6U
M$1515 \$2794 \$2793 VDD VDD pfet_03v3 L=0.28U W=0.36U AS=0.1764P AD=0.1584P
+ PS=1.26U PD=1.6U
M$1516 \$2795 \$2793 VDD VDD pfet_03v3 L=0.28U W=0.72U AS=0.1764P AD=0.36P
+ PS=1.26U PD=2.44U
M$1517 \$2906 RA7 VDD VDD pfet_03v3 L=0.28U W=0.72U AS=0.3312P AD=0.3888P
+ PS=2.36U PD=2.52U
M$1518 \$2795 \$2906 \$57 VDD pfet_03v3 L=0.28U W=0.36U AS=0.1584P AD=0.1152P
+ PS=1.6U PD=1U
M$1519 \$58 \$2907 \$2795 VDD pfet_03v3 L=0.28U W=0.36U AS=0.1152P AD=0.1584P
+ PS=1U PD=1.6U
M$1520 VDD RB7 \$2907 VDD pfet_03v3 L=0.28U W=0.72U AS=0.3708P AD=0.3168P
+ PS=2.47U PD=2.32U
M$1521 \$2796 \$118 VDD VDD pfet_03v3 L=0.28U W=0.72U AS=0.3168P AD=0.2097P
+ PS=2.32U PD=1.38U
M$1522 \$2797 \$2779 \$2796 VDD pfet_03v3 L=0.28U W=0.36U AS=0.2097P AD=0.1278P
+ PS=1.38U PD=1.07U
M$1523 \$3028 \$2798 \$2797 VDD pfet_03v3 L=0.28U W=0.36U AS=0.1278P AD=0.0567P
+ PS=1.07U PD=0.675U
M$1524 VDD \$2778 \$3028 VDD pfet_03v3 L=0.28U W=0.36U AS=0.0567P AD=0.1584P
+ PS=0.675U PD=1.6U
M$1525 \$2798 \$2797 VDD VDD pfet_03v3 L=0.28U W=0.36U AS=0.1764P AD=0.1584P
+ PS=1.26U PD=1.6U
M$1526 \$2799 \$2797 VDD VDD pfet_03v3 L=0.28U W=0.72U AS=0.1764P AD=0.36P
+ PS=1.26U PD=2.44U
M$1527 \$2908 RA7 VDD VDD pfet_03v3 L=0.28U W=0.72U AS=0.3312P AD=0.3888P
+ PS=2.36U PD=2.52U
M$1528 \$2799 \$2908 \$59 VDD pfet_03v3 L=0.28U W=0.36U AS=0.1584P AD=0.1152P
+ PS=1.6U PD=1U
M$1529 \$60 \$2909 \$2799 VDD pfet_03v3 L=0.28U W=0.36U AS=0.1152P AD=0.1584P
+ PS=1U PD=1.6U
M$1530 VDD RB7 \$2909 VDD pfet_03v3 L=0.28U W=0.72U AS=0.3708P AD=0.3168P
+ PS=2.47U PD=2.32U
M$1531 \$2800 \$121 VDD VDD pfet_03v3 L=0.28U W=0.72U AS=0.3168P AD=0.2097P
+ PS=2.32U PD=1.38U
M$1532 \$2801 \$2779 \$2800 VDD pfet_03v3 L=0.28U W=0.36U AS=0.2097P AD=0.1278P
+ PS=1.38U PD=1.07U
M$1533 \$3037 \$2802 \$2801 VDD pfet_03v3 L=0.28U W=0.36U AS=0.1278P AD=0.0567P
+ PS=1.07U PD=0.675U
M$1534 VDD \$2778 \$3037 VDD pfet_03v3 L=0.28U W=0.36U AS=0.0567P AD=0.1584P
+ PS=0.675U PD=1.6U
M$1535 \$2802 \$2801 VDD VDD pfet_03v3 L=0.28U W=0.36U AS=0.1764P AD=0.1584P
+ PS=1.26U PD=1.6U
M$1536 \$2803 \$2801 VDD VDD pfet_03v3 L=0.28U W=0.72U AS=0.1764P AD=0.36P
+ PS=1.26U PD=2.44U
M$1537 \$2910 RA7 VDD VDD pfet_03v3 L=0.28U W=0.72U AS=0.3312P AD=0.3888P
+ PS=2.36U PD=2.52U
M$1538 \$2803 \$2910 \$61 VDD pfet_03v3 L=0.28U W=0.36U AS=0.1584P AD=0.1152P
+ PS=1.6U PD=1U
M$1539 \$62 \$2911 \$2803 VDD pfet_03v3 L=0.28U W=0.36U AS=0.1152P AD=0.1584P
+ PS=1U PD=1.6U
M$1540 VDD RB7 \$2911 VDD pfet_03v3 L=0.28U W=0.72U AS=0.3708P AD=0.3168P
+ PS=2.47U PD=2.32U
M$1541 \$2804 \$124 VDD VDD pfet_03v3 L=0.28U W=0.72U AS=0.3168P AD=0.2097P
+ PS=2.32U PD=1.38U
M$1542 \$2805 \$2779 \$2804 VDD pfet_03v3 L=0.28U W=0.36U AS=0.2097P AD=0.1278P
+ PS=1.38U PD=1.07U
M$1543 \$3045 \$2806 \$2805 VDD pfet_03v3 L=0.28U W=0.36U AS=0.1278P AD=0.0567P
+ PS=1.07U PD=0.675U
M$1544 VDD \$2778 \$3045 VDD pfet_03v3 L=0.28U W=0.36U AS=0.0567P AD=0.1584P
+ PS=0.675U PD=1.6U
M$1545 \$2806 \$2805 VDD VDD pfet_03v3 L=0.28U W=0.36U AS=0.1764P AD=0.1584P
+ PS=1.26U PD=1.6U
M$1546 \$2807 \$2805 VDD VDD pfet_03v3 L=0.28U W=0.72U AS=0.1764P AD=0.36P
+ PS=1.26U PD=2.44U
M$1547 \$2912 RA7 VDD VDD pfet_03v3 L=0.28U W=0.72U AS=0.3312P AD=0.3888P
+ PS=2.36U PD=2.52U
M$1548 \$2807 \$2912 \$63 VDD pfet_03v3 L=0.28U W=0.36U AS=0.1584P AD=0.1152P
+ PS=1.6U PD=1U
M$1549 \$64 \$2913 \$2807 VDD pfet_03v3 L=0.28U W=0.36U AS=0.1152P AD=0.1584P
+ PS=1U PD=1.6U
M$1550 VDD RB7 \$2913 VDD pfet_03v3 L=0.28U W=0.72U AS=0.3708P AD=0.3168P
+ PS=2.47U PD=2.32U
M$1551 \$2808 \$127 VDD VDD pfet_03v3 L=0.28U W=0.72U AS=0.3168P AD=0.2097P
+ PS=2.32U PD=1.38U
M$1552 \$2809 \$2779 \$2808 VDD pfet_03v3 L=0.28U W=0.36U AS=0.2097P AD=0.1278P
+ PS=1.38U PD=1.07U
M$1553 \$3054 \$2810 \$2809 VDD pfet_03v3 L=0.28U W=0.36U AS=0.1278P AD=0.0567P
+ PS=1.07U PD=0.675U
M$1554 VDD \$2778 \$3054 VDD pfet_03v3 L=0.28U W=0.36U AS=0.0567P AD=0.1584P
+ PS=0.675U PD=1.6U
M$1555 \$2810 \$2809 VDD VDD pfet_03v3 L=0.28U W=0.36U AS=0.1764P AD=0.1584P
+ PS=1.26U PD=1.6U
M$1556 \$2811 \$2809 VDD VDD pfet_03v3 L=0.28U W=0.72U AS=0.1764P AD=0.36P
+ PS=1.26U PD=2.44U
M$1557 \$2914 RA7 VDD VDD pfet_03v3 L=0.28U W=0.72U AS=0.3312P AD=0.3888P
+ PS=2.36U PD=2.52U
M$1558 \$2811 \$2914 \$65 VDD pfet_03v3 L=0.28U W=0.36U AS=0.1584P AD=0.1152P
+ PS=1.6U PD=1U
M$1559 \$66 \$2915 \$2811 VDD pfet_03v3 L=0.28U W=0.36U AS=0.1152P AD=0.1584P
+ PS=1U PD=1.6U
M$1560 VDD RB7 \$2915 VDD pfet_03v3 L=0.28U W=0.72U AS=0.3708P AD=0.3168P
+ PS=2.47U PD=2.32U
M$1561 \$2812 \$130 VDD VDD pfet_03v3 L=0.28U W=0.72U AS=0.3168P AD=0.2097P
+ PS=2.32U PD=1.38U
M$1562 \$2813 \$2779 \$2812 VDD pfet_03v3 L=0.28U W=0.36U AS=0.2097P AD=0.1278P
+ PS=1.38U PD=1.07U
M$1563 \$3063 \$2814 \$2813 VDD pfet_03v3 L=0.28U W=0.36U AS=0.1278P AD=0.0567P
+ PS=1.07U PD=0.675U
M$1564 VDD \$2778 \$3063 VDD pfet_03v3 L=0.28U W=0.36U AS=0.0567P AD=0.1584P
+ PS=0.675U PD=1.6U
M$1565 \$2814 \$2813 VDD VDD pfet_03v3 L=0.28U W=0.36U AS=0.1764P AD=0.1584P
+ PS=1.26U PD=1.6U
M$1566 \$2815 \$2813 VDD VDD pfet_03v3 L=0.28U W=0.72U AS=0.1764P AD=0.36P
+ PS=1.26U PD=2.44U
M$1567 \$2916 RA7 VDD VDD pfet_03v3 L=0.28U W=0.72U AS=0.3312P AD=0.3888P
+ PS=2.36U PD=2.52U
M$1568 \$2815 \$2916 \$67 VDD pfet_03v3 L=0.28U W=0.36U AS=0.1584P AD=0.1152P
+ PS=1.6U PD=1U
M$1569 \$68 \$2917 \$2815 VDD pfet_03v3 L=0.28U W=0.36U AS=0.1152P AD=0.1584P
+ PS=1U PD=1.6U
M$1570 VDD RB7 \$2917 VDD pfet_03v3 L=0.28U W=0.72U AS=0.3708P AD=0.3168P
+ PS=2.47U PD=2.32U
M$1571 \$2816 \$133 VDD VDD pfet_03v3 L=0.28U W=0.72U AS=0.3168P AD=0.2097P
+ PS=2.32U PD=1.38U
M$1572 \$2817 \$2779 \$2816 VDD pfet_03v3 L=0.28U W=0.36U AS=0.2097P AD=0.1278P
+ PS=1.38U PD=1.07U
M$1573 \$3072 \$2818 \$2817 VDD pfet_03v3 L=0.28U W=0.36U AS=0.1278P AD=0.0567P
+ PS=1.07U PD=0.675U
M$1574 VDD \$2778 \$3072 VDD pfet_03v3 L=0.28U W=0.36U AS=0.0567P AD=0.1584P
+ PS=0.675U PD=1.6U
M$1575 \$2818 \$2817 VDD VDD pfet_03v3 L=0.28U W=0.36U AS=0.1764P AD=0.1584P
+ PS=1.26U PD=1.6U
M$1576 \$2819 \$2817 VDD VDD pfet_03v3 L=0.28U W=0.72U AS=0.1764P AD=0.36P
+ PS=1.26U PD=2.44U
M$1577 \$2918 RA7 VDD VDD pfet_03v3 L=0.28U W=0.72U AS=0.3312P AD=0.3888P
+ PS=2.36U PD=2.52U
M$1578 \$2819 \$2918 \$69 VDD pfet_03v3 L=0.28U W=0.36U AS=0.1584P AD=0.1152P
+ PS=1.6U PD=1U
M$1579 \$70 \$2919 \$2819 VDD pfet_03v3 L=0.28U W=0.36U AS=0.1152P AD=0.1584P
+ PS=1U PD=1.6U
M$1580 VDD RB7 \$2919 VDD pfet_03v3 L=0.28U W=0.72U AS=0.3708P AD=0.3168P
+ PS=2.47U PD=2.32U
M$1581 \$2820 \$136 VDD VDD pfet_03v3 L=0.28U W=0.72U AS=0.3168P AD=0.2097P
+ PS=2.32U PD=1.38U
M$1582 \$2821 \$2779 \$2820 VDD pfet_03v3 L=0.28U W=0.36U AS=0.2097P AD=0.1278P
+ PS=1.38U PD=1.07U
M$1583 \$3081 \$2822 \$2821 VDD pfet_03v3 L=0.28U W=0.36U AS=0.1278P AD=0.0567P
+ PS=1.07U PD=0.675U
M$1584 VDD \$2778 \$3081 VDD pfet_03v3 L=0.28U W=0.36U AS=0.0567P AD=0.1584P
+ PS=0.675U PD=1.6U
M$1585 \$2822 \$2821 VDD VDD pfet_03v3 L=0.28U W=0.36U AS=0.1764P AD=0.1584P
+ PS=1.26U PD=1.6U
M$1586 \$2823 \$2821 VDD VDD pfet_03v3 L=0.28U W=0.72U AS=0.1764P AD=0.36P
+ PS=1.26U PD=2.44U
M$1587 \$2920 RA7 VDD VDD pfet_03v3 L=0.28U W=0.72U AS=0.3312P AD=0.3888P
+ PS=2.36U PD=2.52U
M$1588 \$2823 \$2920 \$71 VDD pfet_03v3 L=0.28U W=0.36U AS=0.1584P AD=0.1152P
+ PS=1.6U PD=1U
M$1589 \$72 \$2921 \$2823 VDD pfet_03v3 L=0.28U W=0.36U AS=0.1152P AD=0.1584P
+ PS=1U PD=1.6U
M$1590 VDD RB7 \$2921 VDD pfet_03v3 L=0.28U W=0.72U AS=0.3708P AD=0.3168P
+ PS=2.47U PD=2.32U
M$1591 \$2824 \$139 VDD VDD pfet_03v3 L=0.28U W=0.72U AS=0.3168P AD=0.2097P
+ PS=2.32U PD=1.38U
M$1592 \$2825 \$2779 \$2824 VDD pfet_03v3 L=0.28U W=0.36U AS=0.2097P AD=0.1278P
+ PS=1.38U PD=1.07U
M$1593 \$3089 \$2826 \$2825 VDD pfet_03v3 L=0.28U W=0.36U AS=0.1278P AD=0.0567P
+ PS=1.07U PD=0.675U
M$1594 VDD \$2778 \$3089 VDD pfet_03v3 L=0.28U W=0.36U AS=0.0567P AD=0.1584P
+ PS=0.675U PD=1.6U
M$1595 \$2826 \$2825 VDD VDD pfet_03v3 L=0.28U W=0.36U AS=0.1764P AD=0.1584P
+ PS=1.26U PD=1.6U
M$1596 \$2827 \$2825 VDD VDD pfet_03v3 L=0.28U W=0.72U AS=0.1764P AD=0.36P
+ PS=1.26U PD=2.44U
M$1597 \$2922 RA7 VDD VDD pfet_03v3 L=0.28U W=0.72U AS=0.3312P AD=0.3888P
+ PS=2.36U PD=2.52U
M$1598 \$2827 \$2922 \$73 VDD pfet_03v3 L=0.28U W=0.36U AS=0.1584P AD=0.1152P
+ PS=1.6U PD=1U
M$1599 \$74 \$2923 \$2827 VDD pfet_03v3 L=0.28U W=0.36U AS=0.1152P AD=0.1584P
+ PS=1U PD=1.6U
M$1600 VDD RB7 \$2923 VDD pfet_03v3 L=0.28U W=0.72U AS=0.3708P AD=0.3168P
+ PS=2.47U PD=2.32U
M$1601 \$2828 \$142 VDD VDD pfet_03v3 L=0.28U W=0.72U AS=0.3168P AD=0.2097P
+ PS=2.32U PD=1.38U
M$1602 \$2829 \$2779 \$2828 VDD pfet_03v3 L=0.28U W=0.36U AS=0.2097P AD=0.1278P
+ PS=1.38U PD=1.07U
M$1603 \$3075 \$2830 \$2829 VDD pfet_03v3 L=0.28U W=0.36U AS=0.1278P AD=0.0567P
+ PS=1.07U PD=0.675U
M$1604 VDD \$2778 \$3075 VDD pfet_03v3 L=0.28U W=0.36U AS=0.0567P AD=0.1584P
+ PS=0.675U PD=1.6U
M$1605 \$2830 \$2829 VDD VDD pfet_03v3 L=0.28U W=0.36U AS=0.1764P AD=0.1584P
+ PS=1.26U PD=1.6U
M$1606 \$2831 \$2829 VDD VDD pfet_03v3 L=0.28U W=0.72U AS=0.1764P AD=0.36P
+ PS=1.26U PD=2.44U
M$1607 \$2924 RA7 VDD VDD pfet_03v3 L=0.28U W=0.72U AS=0.3312P AD=0.3888P
+ PS=2.36U PD=2.52U
M$1608 \$2831 \$2924 \$75 VDD pfet_03v3 L=0.28U W=0.36U AS=0.1584P AD=0.1152P
+ PS=1.6U PD=1U
M$1609 \$76 \$2925 \$2831 VDD pfet_03v3 L=0.28U W=0.36U AS=0.1152P AD=0.1584P
+ PS=1U PD=1.6U
M$1610 VDD RB7 \$2925 VDD pfet_03v3 L=0.28U W=0.72U AS=0.3708P AD=0.3168P
+ PS=2.47U PD=2.32U
M$1611 \$2832 \$145 VDD VDD pfet_03v3 L=0.28U W=0.72U AS=0.3168P AD=0.2097P
+ PS=2.32U PD=1.38U
M$1612 \$2833 \$2779 \$2832 VDD pfet_03v3 L=0.28U W=0.36U AS=0.2097P AD=0.1278P
+ PS=1.38U PD=1.07U
M$1613 \$3047 \$2834 \$2833 VDD pfet_03v3 L=0.28U W=0.36U AS=0.1278P AD=0.0567P
+ PS=1.07U PD=0.675U
M$1614 VDD \$2778 \$3047 VDD pfet_03v3 L=0.28U W=0.36U AS=0.0567P AD=0.1584P
+ PS=0.675U PD=1.6U
M$1615 \$2834 \$2833 VDD VDD pfet_03v3 L=0.28U W=0.36U AS=0.1764P AD=0.1584P
+ PS=1.26U PD=1.6U
M$1616 \$2835 \$2833 VDD VDD pfet_03v3 L=0.28U W=0.72U AS=0.1764P AD=0.36P
+ PS=1.26U PD=2.44U
M$1617 \$2926 RA7 VDD VDD pfet_03v3 L=0.28U W=0.72U AS=0.3312P AD=0.3888P
+ PS=2.36U PD=2.52U
M$1618 \$2835 \$2926 \$77 VDD pfet_03v3 L=0.28U W=0.36U AS=0.1584P AD=0.1152P
+ PS=1.6U PD=1U
M$1619 \$78 \$2927 \$2835 VDD pfet_03v3 L=0.28U W=0.36U AS=0.1152P AD=0.1584P
+ PS=1U PD=1.6U
M$1620 VDD RB7 \$2927 VDD pfet_03v3 L=0.28U W=0.72U AS=0.3708P AD=0.3168P
+ PS=2.47U PD=2.32U
M$1621 \$2836 \$148 VDD VDD pfet_03v3 L=0.28U W=0.72U AS=0.3168P AD=0.2097P
+ PS=2.32U PD=1.38U
M$1622 \$2837 \$2779 \$2836 VDD pfet_03v3 L=0.28U W=0.36U AS=0.2097P AD=0.1278P
+ PS=1.38U PD=1.07U
M$1623 \$3029 \$2838 \$2837 VDD pfet_03v3 L=0.28U W=0.36U AS=0.1278P AD=0.0567P
+ PS=1.07U PD=0.675U
M$1624 VDD \$2778 \$3029 VDD pfet_03v3 L=0.28U W=0.36U AS=0.0567P AD=0.1584P
+ PS=0.675U PD=1.6U
M$1625 \$2838 \$2837 VDD VDD pfet_03v3 L=0.28U W=0.36U AS=0.1764P AD=0.1584P
+ PS=1.26U PD=1.6U
M$1626 \$2839 \$2837 VDD VDD pfet_03v3 L=0.28U W=0.72U AS=0.1764P AD=0.36P
+ PS=1.26U PD=2.44U
M$1627 \$2928 RA7 VDD VDD pfet_03v3 L=0.28U W=0.72U AS=0.3312P AD=0.3888P
+ PS=2.36U PD=2.52U
M$1628 \$2839 \$2928 \$79 VDD pfet_03v3 L=0.28U W=0.36U AS=0.1584P AD=0.1152P
+ PS=1.6U PD=1U
M$1629 \$80 \$2929 \$2839 VDD pfet_03v3 L=0.28U W=0.36U AS=0.1152P AD=0.1584P
+ PS=1U PD=1.6U
M$1630 VDD RB7 \$2929 VDD pfet_03v3 L=0.28U W=0.72U AS=0.3708P AD=0.3168P
+ PS=2.47U PD=2.32U
M$1631 \$2840 \$151 VDD VDD pfet_03v3 L=0.28U W=0.72U AS=0.3168P AD=0.2097P
+ PS=2.32U PD=1.38U
M$1632 \$2841 \$2779 \$2840 VDD pfet_03v3 L=0.28U W=0.36U AS=0.2097P AD=0.1278P
+ PS=1.38U PD=1.07U
M$1633 \$3001 \$2842 \$2841 VDD pfet_03v3 L=0.28U W=0.36U AS=0.1278P AD=0.0567P
+ PS=1.07U PD=0.675U
M$1634 VDD \$2778 \$3001 VDD pfet_03v3 L=0.28U W=0.36U AS=0.0567P AD=0.1584P
+ PS=0.675U PD=1.6U
M$1635 \$2842 \$2841 VDD VDD pfet_03v3 L=0.28U W=0.36U AS=0.1764P AD=0.1584P
+ PS=1.26U PD=1.6U
M$1636 \$2843 \$2841 VDD VDD pfet_03v3 L=0.28U W=0.72U AS=0.1764P AD=0.36P
+ PS=1.26U PD=2.44U
M$1637 \$2930 RA7 VDD VDD pfet_03v3 L=0.28U W=0.72U AS=0.3312P AD=0.3888P
+ PS=2.36U PD=2.52U
M$1638 \$2843 \$2930 \$81 VDD pfet_03v3 L=0.28U W=0.36U AS=0.1584P AD=0.1152P
+ PS=1.6U PD=1U
M$1639 \$82 \$2931 \$2843 VDD pfet_03v3 L=0.28U W=0.36U AS=0.1152P AD=0.1584P
+ PS=1U PD=1.6U
M$1640 VDD RB7 \$2931 VDD pfet_03v3 L=0.28U W=0.72U AS=0.3708P AD=0.3168P
+ PS=2.47U PD=2.32U
M$1641 \$3093 WE6 VDD VDD pfet_03v3 L=0.28U W=0.72U AS=0.3168P AD=0.1872P
+ PS=2.32U PD=1.24U
M$1642 VDD CLK \$3093 VDD pfet_03v3 L=0.28U W=0.72U AS=0.1872P AD=0.3168P
+ PS=1.24U PD=2.32U
M$1643 \$3095 \$3093 VDD VDD pfet_03v3 L=0.28U W=1.27U AS=0.5588P AD=0.3302P
+ PS=3.42U PD=1.79U
M$1644 VDD \$3093 \$3095 VDD pfet_03v3 L=0.28U W=1.27U AS=0.3302P AD=0.3386P
+ PS=1.79U PD=1.86U
M$1645 \$3096 \$3095 VDD VDD pfet_03v3 L=0.28U W=1.34U AS=0.3386P AD=0.3886P
+ PS=1.86U PD=1.92U
M$1646 VDD \$3095 \$3096 VDD pfet_03v3 L=0.28U W=1.34U AS=0.3886P AD=0.5896P
+ PS=1.92U PD=3.56U
M$1647 \$3100 \$3096 \$3099 VDD pfet_03v3 L=0.28U W=0.36U AS=0.2097P AD=0.1278P
+ PS=1.38U PD=1.07U
M$1648 \$3200 \$3101 \$3100 VDD pfet_03v3 L=0.28U W=0.36U AS=0.1278P AD=0.0567P
+ PS=1.07U PD=0.675U
M$1649 VDD \$3095 \$3200 VDD pfet_03v3 L=0.28U W=0.36U AS=0.0567P AD=0.1584P
+ PS=0.675U PD=1.6U
M$1650 \$3099 \$106 VDD VDD pfet_03v3 L=0.28U W=0.72U AS=0.3168P AD=0.2097P
+ PS=2.32U PD=1.38U
M$1651 VDD \$3100 \$3101 VDD pfet_03v3 L=0.28U W=0.36U AS=0.1584P AD=0.1764P
+ PS=1.6U PD=1.26U
M$1652 \$3102 \$3100 VDD VDD pfet_03v3 L=0.28U W=0.72U AS=0.1764P AD=0.36P
+ PS=1.26U PD=2.44U
M$1653 \$3103 RB6 VDD VDD pfet_03v3 L=0.28U W=0.72U AS=0.3312P AD=0.3888P
+ PS=2.36U PD=2.52U
M$1654 \$3102 \$3103 \$51 VDD pfet_03v3 L=0.28U W=0.36U AS=0.1584P AD=0.1152P
+ PS=1.6U PD=1U
M$1655 \$52 \$3104 \$3102 VDD pfet_03v3 L=0.28U W=0.36U AS=0.1152P AD=0.1584P
+ PS=1U PD=1.6U
M$1656 VDD RA6 \$3104 VDD pfet_03v3 L=0.28U W=0.72U AS=0.3708P AD=0.3168P
+ PS=2.47U PD=2.32U
M$1657 \$3106 \$3096 \$3105 VDD pfet_03v3 L=0.28U W=0.36U AS=0.2097P AD=0.1278P
+ PS=1.38U PD=1.07U
M$1658 \$3208 \$3107 \$3106 VDD pfet_03v3 L=0.28U W=0.36U AS=0.1278P AD=0.0567P
+ PS=1.07U PD=0.675U
M$1659 VDD \$3095 \$3208 VDD pfet_03v3 L=0.28U W=0.36U AS=0.0567P AD=0.1584P
+ PS=0.675U PD=1.6U
M$1660 \$3105 \$109 VDD VDD pfet_03v3 L=0.28U W=0.72U AS=0.3168P AD=0.2097P
+ PS=2.32U PD=1.38U
M$1661 VDD \$3106 \$3107 VDD pfet_03v3 L=0.28U W=0.36U AS=0.1584P AD=0.1764P
+ PS=1.6U PD=1.26U
M$1662 \$3108 \$3106 VDD VDD pfet_03v3 L=0.28U W=0.72U AS=0.1764P AD=0.36P
+ PS=1.26U PD=2.44U
M$1663 \$3109 RB6 VDD VDD pfet_03v3 L=0.28U W=0.72U AS=0.3312P AD=0.3888P
+ PS=2.36U PD=2.52U
M$1664 \$3108 \$3109 \$53 VDD pfet_03v3 L=0.28U W=0.36U AS=0.1584P AD=0.1152P
+ PS=1.6U PD=1U
M$1665 \$54 \$3110 \$3108 VDD pfet_03v3 L=0.28U W=0.36U AS=0.1152P AD=0.1584P
+ PS=1U PD=1.6U
M$1666 VDD RA6 \$3110 VDD pfet_03v3 L=0.28U W=0.72U AS=0.3708P AD=0.3168P
+ PS=2.47U PD=2.32U
M$1667 \$3112 \$3096 \$3111 VDD pfet_03v3 L=0.28U W=0.36U AS=0.2097P AD=0.1278P
+ PS=1.38U PD=1.07U
M$1668 \$3215 \$3113 \$3112 VDD pfet_03v3 L=0.28U W=0.36U AS=0.1278P AD=0.0567P
+ PS=1.07U PD=0.675U
M$1669 VDD \$3095 \$3215 VDD pfet_03v3 L=0.28U W=0.36U AS=0.0567P AD=0.1584P
+ PS=0.675U PD=1.6U
M$1670 \$3111 \$112 VDD VDD pfet_03v3 L=0.28U W=0.72U AS=0.3168P AD=0.2097P
+ PS=2.32U PD=1.38U
M$1671 VDD \$3112 \$3113 VDD pfet_03v3 L=0.28U W=0.36U AS=0.1584P AD=0.1764P
+ PS=1.6U PD=1.26U
M$1672 \$3114 \$3112 VDD VDD pfet_03v3 L=0.28U W=0.72U AS=0.1764P AD=0.36P
+ PS=1.26U PD=2.44U
M$1673 \$3115 RB6 VDD VDD pfet_03v3 L=0.28U W=0.72U AS=0.3312P AD=0.3888P
+ PS=2.36U PD=2.52U
M$1674 \$3114 \$3115 \$55 VDD pfet_03v3 L=0.28U W=0.36U AS=0.1584P AD=0.1152P
+ PS=1.6U PD=1U
M$1675 \$56 \$3116 \$3114 VDD pfet_03v3 L=0.28U W=0.36U AS=0.1152P AD=0.1584P
+ PS=1U PD=1.6U
M$1676 VDD RA6 \$3116 VDD pfet_03v3 L=0.28U W=0.72U AS=0.3708P AD=0.3168P
+ PS=2.47U PD=2.32U
M$1677 \$3118 \$3096 \$3117 VDD pfet_03v3 L=0.28U W=0.36U AS=0.2097P AD=0.1278P
+ PS=1.38U PD=1.07U
M$1678 \$3223 \$3119 \$3118 VDD pfet_03v3 L=0.28U W=0.36U AS=0.1278P AD=0.0567P
+ PS=1.07U PD=0.675U
M$1679 VDD \$3095 \$3223 VDD pfet_03v3 L=0.28U W=0.36U AS=0.0567P AD=0.1584P
+ PS=0.675U PD=1.6U
M$1680 \$3117 \$115 VDD VDD pfet_03v3 L=0.28U W=0.72U AS=0.3168P AD=0.2097P
+ PS=2.32U PD=1.38U
M$1681 VDD \$3118 \$3119 VDD pfet_03v3 L=0.28U W=0.36U AS=0.1584P AD=0.1764P
+ PS=1.6U PD=1.26U
M$1682 \$3120 \$3118 VDD VDD pfet_03v3 L=0.28U W=0.72U AS=0.1764P AD=0.36P
+ PS=1.26U PD=2.44U
M$1683 \$3121 RB6 VDD VDD pfet_03v3 L=0.28U W=0.72U AS=0.3312P AD=0.3888P
+ PS=2.36U PD=2.52U
M$1684 \$3120 \$3121 \$57 VDD pfet_03v3 L=0.28U W=0.36U AS=0.1584P AD=0.1152P
+ PS=1.6U PD=1U
M$1685 \$58 \$3122 \$3120 VDD pfet_03v3 L=0.28U W=0.36U AS=0.1152P AD=0.1584P
+ PS=1U PD=1.6U
M$1686 VDD RA6 \$3122 VDD pfet_03v3 L=0.28U W=0.72U AS=0.3708P AD=0.3168P
+ PS=2.47U PD=2.32U
M$1687 \$3124 \$3096 \$3123 VDD pfet_03v3 L=0.28U W=0.36U AS=0.2097P AD=0.1278P
+ PS=1.38U PD=1.07U
M$1688 \$3232 \$3125 \$3124 VDD pfet_03v3 L=0.28U W=0.36U AS=0.1278P AD=0.0567P
+ PS=1.07U PD=0.675U
M$1689 VDD \$3095 \$3232 VDD pfet_03v3 L=0.28U W=0.36U AS=0.0567P AD=0.1584P
+ PS=0.675U PD=1.6U
M$1690 \$3123 \$118 VDD VDD pfet_03v3 L=0.28U W=0.72U AS=0.3168P AD=0.2097P
+ PS=2.32U PD=1.38U
M$1691 VDD \$3124 \$3125 VDD pfet_03v3 L=0.28U W=0.36U AS=0.1584P AD=0.1764P
+ PS=1.6U PD=1.26U
M$1692 \$3126 \$3124 VDD VDD pfet_03v3 L=0.28U W=0.72U AS=0.1764P AD=0.36P
+ PS=1.26U PD=2.44U
M$1693 \$3127 RB6 VDD VDD pfet_03v3 L=0.28U W=0.72U AS=0.3312P AD=0.3888P
+ PS=2.36U PD=2.52U
M$1694 \$3126 \$3127 \$59 VDD pfet_03v3 L=0.28U W=0.36U AS=0.1584P AD=0.1152P
+ PS=1.6U PD=1U
M$1695 \$60 \$3128 \$3126 VDD pfet_03v3 L=0.28U W=0.36U AS=0.1152P AD=0.1584P
+ PS=1U PD=1.6U
M$1696 VDD RA6 \$3128 VDD pfet_03v3 L=0.28U W=0.72U AS=0.3708P AD=0.3168P
+ PS=2.47U PD=2.32U
M$1697 \$3130 \$3096 \$3129 VDD pfet_03v3 L=0.28U W=0.36U AS=0.2097P AD=0.1278P
+ PS=1.38U PD=1.07U
M$1698 \$3238 \$3131 \$3130 VDD pfet_03v3 L=0.28U W=0.36U AS=0.1278P AD=0.0567P
+ PS=1.07U PD=0.675U
M$1699 VDD \$3095 \$3238 VDD pfet_03v3 L=0.28U W=0.36U AS=0.0567P AD=0.1584P
+ PS=0.675U PD=1.6U
M$1700 \$3129 \$121 VDD VDD pfet_03v3 L=0.28U W=0.72U AS=0.3168P AD=0.2097P
+ PS=2.32U PD=1.38U
M$1701 VDD \$3130 \$3131 VDD pfet_03v3 L=0.28U W=0.36U AS=0.1584P AD=0.1764P
+ PS=1.6U PD=1.26U
M$1702 \$3132 \$3130 VDD VDD pfet_03v3 L=0.28U W=0.72U AS=0.1764P AD=0.36P
+ PS=1.26U PD=2.44U
M$1703 \$3133 RB6 VDD VDD pfet_03v3 L=0.28U W=0.72U AS=0.3312P AD=0.3888P
+ PS=2.36U PD=2.52U
M$1704 \$3132 \$3133 \$61 VDD pfet_03v3 L=0.28U W=0.36U AS=0.1584P AD=0.1152P
+ PS=1.6U PD=1U
M$1705 \$62 \$3134 \$3132 VDD pfet_03v3 L=0.28U W=0.36U AS=0.1152P AD=0.1584P
+ PS=1U PD=1.6U
M$1706 VDD RA6 \$3134 VDD pfet_03v3 L=0.28U W=0.72U AS=0.3708P AD=0.3168P
+ PS=2.47U PD=2.32U
M$1707 \$3136 \$3096 \$3135 VDD pfet_03v3 L=0.28U W=0.36U AS=0.2097P AD=0.1278P
+ PS=1.38U PD=1.07U
M$1708 \$3245 \$3137 \$3136 VDD pfet_03v3 L=0.28U W=0.36U AS=0.1278P AD=0.0567P
+ PS=1.07U PD=0.675U
M$1709 VDD \$3095 \$3245 VDD pfet_03v3 L=0.28U W=0.36U AS=0.0567P AD=0.1584P
+ PS=0.675U PD=1.6U
M$1710 \$3135 \$124 VDD VDD pfet_03v3 L=0.28U W=0.72U AS=0.3168P AD=0.2097P
+ PS=2.32U PD=1.38U
M$1711 VDD \$3136 \$3137 VDD pfet_03v3 L=0.28U W=0.36U AS=0.1584P AD=0.1764P
+ PS=1.6U PD=1.26U
M$1712 \$3138 \$3136 VDD VDD pfet_03v3 L=0.28U W=0.72U AS=0.1764P AD=0.36P
+ PS=1.26U PD=2.44U
M$1713 \$3139 RB6 VDD VDD pfet_03v3 L=0.28U W=0.72U AS=0.3312P AD=0.3888P
+ PS=2.36U PD=2.52U
M$1714 \$3138 \$3139 \$63 VDD pfet_03v3 L=0.28U W=0.36U AS=0.1584P AD=0.1152P
+ PS=1.6U PD=1U
M$1715 \$64 \$3140 \$3138 VDD pfet_03v3 L=0.28U W=0.36U AS=0.1152P AD=0.1584P
+ PS=1U PD=1.6U
M$1716 VDD RA6 \$3140 VDD pfet_03v3 L=0.28U W=0.72U AS=0.3708P AD=0.3168P
+ PS=2.47U PD=2.32U
M$1717 \$3142 \$3096 \$3141 VDD pfet_03v3 L=0.28U W=0.36U AS=0.2097P AD=0.1278P
+ PS=1.38U PD=1.07U
M$1718 \$3254 \$3143 \$3142 VDD pfet_03v3 L=0.28U W=0.36U AS=0.1278P AD=0.0567P
+ PS=1.07U PD=0.675U
M$1719 VDD \$3095 \$3254 VDD pfet_03v3 L=0.28U W=0.36U AS=0.0567P AD=0.1584P
+ PS=0.675U PD=1.6U
M$1720 \$3141 \$127 VDD VDD pfet_03v3 L=0.28U W=0.72U AS=0.3168P AD=0.2097P
+ PS=2.32U PD=1.38U
M$1721 VDD \$3142 \$3143 VDD pfet_03v3 L=0.28U W=0.36U AS=0.1584P AD=0.1764P
+ PS=1.6U PD=1.26U
M$1722 \$3144 \$3142 VDD VDD pfet_03v3 L=0.28U W=0.72U AS=0.1764P AD=0.36P
+ PS=1.26U PD=2.44U
M$1723 \$3145 RB6 VDD VDD pfet_03v3 L=0.28U W=0.72U AS=0.3312P AD=0.3888P
+ PS=2.36U PD=2.52U
M$1724 \$3144 \$3145 \$65 VDD pfet_03v3 L=0.28U W=0.36U AS=0.1584P AD=0.1152P
+ PS=1.6U PD=1U
M$1725 \$66 \$3146 \$3144 VDD pfet_03v3 L=0.28U W=0.36U AS=0.1152P AD=0.1584P
+ PS=1U PD=1.6U
M$1726 VDD RA6 \$3146 VDD pfet_03v3 L=0.28U W=0.72U AS=0.3708P AD=0.3168P
+ PS=2.47U PD=2.32U
M$1727 \$3148 \$3096 \$3147 VDD pfet_03v3 L=0.28U W=0.36U AS=0.2097P AD=0.1278P
+ PS=1.38U PD=1.07U
M$1728 \$3260 \$3149 \$3148 VDD pfet_03v3 L=0.28U W=0.36U AS=0.1278P AD=0.0567P
+ PS=1.07U PD=0.675U
M$1729 VDD \$3095 \$3260 VDD pfet_03v3 L=0.28U W=0.36U AS=0.0567P AD=0.1584P
+ PS=0.675U PD=1.6U
M$1730 \$3147 \$130 VDD VDD pfet_03v3 L=0.28U W=0.72U AS=0.3168P AD=0.2097P
+ PS=2.32U PD=1.38U
M$1731 VDD \$3148 \$3149 VDD pfet_03v3 L=0.28U W=0.36U AS=0.1584P AD=0.1764P
+ PS=1.6U PD=1.26U
M$1732 \$3150 \$3148 VDD VDD pfet_03v3 L=0.28U W=0.72U AS=0.1764P AD=0.36P
+ PS=1.26U PD=2.44U
M$1733 \$3151 RB6 VDD VDD pfet_03v3 L=0.28U W=0.72U AS=0.3312P AD=0.3888P
+ PS=2.36U PD=2.52U
M$1734 \$3150 \$3151 \$67 VDD pfet_03v3 L=0.28U W=0.36U AS=0.1584P AD=0.1152P
+ PS=1.6U PD=1U
M$1735 \$68 \$3152 \$3150 VDD pfet_03v3 L=0.28U W=0.36U AS=0.1152P AD=0.1584P
+ PS=1U PD=1.6U
M$1736 VDD RA6 \$3152 VDD pfet_03v3 L=0.28U W=0.72U AS=0.3708P AD=0.3168P
+ PS=2.47U PD=2.32U
M$1737 \$3154 \$3096 \$3153 VDD pfet_03v3 L=0.28U W=0.36U AS=0.2097P AD=0.1278P
+ PS=1.38U PD=1.07U
M$1738 \$3267 \$3155 \$3154 VDD pfet_03v3 L=0.28U W=0.36U AS=0.1278P AD=0.0567P
+ PS=1.07U PD=0.675U
M$1739 VDD \$3095 \$3267 VDD pfet_03v3 L=0.28U W=0.36U AS=0.0567P AD=0.1584P
+ PS=0.675U PD=1.6U
M$1740 \$3153 \$133 VDD VDD pfet_03v3 L=0.28U W=0.72U AS=0.3168P AD=0.2097P
+ PS=2.32U PD=1.38U
M$1741 VDD \$3154 \$3155 VDD pfet_03v3 L=0.28U W=0.36U AS=0.1584P AD=0.1764P
+ PS=1.6U PD=1.26U
M$1742 \$3156 \$3154 VDD VDD pfet_03v3 L=0.28U W=0.72U AS=0.1764P AD=0.36P
+ PS=1.26U PD=2.44U
M$1743 \$3157 RB6 VDD VDD pfet_03v3 L=0.28U W=0.72U AS=0.3312P AD=0.3888P
+ PS=2.36U PD=2.52U
M$1744 \$3156 \$3157 \$69 VDD pfet_03v3 L=0.28U W=0.36U AS=0.1584P AD=0.1152P
+ PS=1.6U PD=1U
M$1745 \$70 \$3158 \$3156 VDD pfet_03v3 L=0.28U W=0.36U AS=0.1152P AD=0.1584P
+ PS=1U PD=1.6U
M$1746 VDD RA6 \$3158 VDD pfet_03v3 L=0.28U W=0.72U AS=0.3708P AD=0.3168P
+ PS=2.47U PD=2.32U
M$1747 \$3160 \$3096 \$3159 VDD pfet_03v3 L=0.28U W=0.36U AS=0.2097P AD=0.1278P
+ PS=1.38U PD=1.07U
M$1748 \$3275 \$3161 \$3160 VDD pfet_03v3 L=0.28U W=0.36U AS=0.1278P AD=0.0567P
+ PS=1.07U PD=0.675U
M$1749 VDD \$3095 \$3275 VDD pfet_03v3 L=0.28U W=0.36U AS=0.0567P AD=0.1584P
+ PS=0.675U PD=1.6U
M$1750 \$3159 \$136 VDD VDD pfet_03v3 L=0.28U W=0.72U AS=0.3168P AD=0.2097P
+ PS=2.32U PD=1.38U
M$1751 VDD \$3160 \$3161 VDD pfet_03v3 L=0.28U W=0.36U AS=0.1584P AD=0.1764P
+ PS=1.6U PD=1.26U
M$1752 \$3162 \$3160 VDD VDD pfet_03v3 L=0.28U W=0.72U AS=0.1764P AD=0.36P
+ PS=1.26U PD=2.44U
M$1753 \$3163 RB6 VDD VDD pfet_03v3 L=0.28U W=0.72U AS=0.3312P AD=0.3888P
+ PS=2.36U PD=2.52U
M$1754 \$3162 \$3163 \$71 VDD pfet_03v3 L=0.28U W=0.36U AS=0.1584P AD=0.1152P
+ PS=1.6U PD=1U
M$1755 \$72 \$3164 \$3162 VDD pfet_03v3 L=0.28U W=0.36U AS=0.1152P AD=0.1584P
+ PS=1U PD=1.6U
M$1756 VDD RA6 \$3164 VDD pfet_03v3 L=0.28U W=0.72U AS=0.3708P AD=0.3168P
+ PS=2.47U PD=2.32U
M$1757 \$3166 \$3096 \$3165 VDD pfet_03v3 L=0.28U W=0.36U AS=0.2097P AD=0.1278P
+ PS=1.38U PD=1.07U
M$1758 \$3283 \$3167 \$3166 VDD pfet_03v3 L=0.28U W=0.36U AS=0.1278P AD=0.0567P
+ PS=1.07U PD=0.675U
M$1759 VDD \$3095 \$3283 VDD pfet_03v3 L=0.28U W=0.36U AS=0.0567P AD=0.1584P
+ PS=0.675U PD=1.6U
M$1760 \$3165 \$139 VDD VDD pfet_03v3 L=0.28U W=0.72U AS=0.3168P AD=0.2097P
+ PS=2.32U PD=1.38U
M$1761 VDD \$3166 \$3167 VDD pfet_03v3 L=0.28U W=0.36U AS=0.1584P AD=0.1764P
+ PS=1.6U PD=1.26U
M$1762 \$3168 \$3166 VDD VDD pfet_03v3 L=0.28U W=0.72U AS=0.1764P AD=0.36P
+ PS=1.26U PD=2.44U
M$1763 \$3169 RB6 VDD VDD pfet_03v3 L=0.28U W=0.72U AS=0.3312P AD=0.3888P
+ PS=2.36U PD=2.52U
M$1764 \$3168 \$3169 \$73 VDD pfet_03v3 L=0.28U W=0.36U AS=0.1584P AD=0.1152P
+ PS=1.6U PD=1U
M$1765 \$74 \$3170 \$3168 VDD pfet_03v3 L=0.28U W=0.36U AS=0.1152P AD=0.1584P
+ PS=1U PD=1.6U
M$1766 VDD RA6 \$3170 VDD pfet_03v3 L=0.28U W=0.72U AS=0.3708P AD=0.3168P
+ PS=2.47U PD=2.32U
M$1767 \$3172 \$3096 \$3171 VDD pfet_03v3 L=0.28U W=0.36U AS=0.2097P AD=0.1278P
+ PS=1.38U PD=1.07U
M$1768 \$3290 \$3173 \$3172 VDD pfet_03v3 L=0.28U W=0.36U AS=0.1278P AD=0.0567P
+ PS=1.07U PD=0.675U
M$1769 VDD \$3095 \$3290 VDD pfet_03v3 L=0.28U W=0.36U AS=0.0567P AD=0.1584P
+ PS=0.675U PD=1.6U
M$1770 \$3171 \$142 VDD VDD pfet_03v3 L=0.28U W=0.72U AS=0.3168P AD=0.2097P
+ PS=2.32U PD=1.38U
M$1771 VDD \$3172 \$3173 VDD pfet_03v3 L=0.28U W=0.36U AS=0.1584P AD=0.1764P
+ PS=1.6U PD=1.26U
M$1772 \$3174 \$3172 VDD VDD pfet_03v3 L=0.28U W=0.72U AS=0.1764P AD=0.36P
+ PS=1.26U PD=2.44U
M$1773 \$3175 RB6 VDD VDD pfet_03v3 L=0.28U W=0.72U AS=0.3312P AD=0.3888P
+ PS=2.36U PD=2.52U
M$1774 \$3174 \$3175 \$75 VDD pfet_03v3 L=0.28U W=0.36U AS=0.1584P AD=0.1152P
+ PS=1.6U PD=1U
M$1775 \$76 \$3176 \$3174 VDD pfet_03v3 L=0.28U W=0.36U AS=0.1152P AD=0.1584P
+ PS=1U PD=1.6U
M$1776 VDD RA6 \$3176 VDD pfet_03v3 L=0.28U W=0.72U AS=0.3708P AD=0.3168P
+ PS=2.47U PD=2.32U
M$1777 \$3178 \$3096 \$3177 VDD pfet_03v3 L=0.28U W=0.36U AS=0.2097P AD=0.1278P
+ PS=1.38U PD=1.07U
M$1778 \$3289 \$3179 \$3178 VDD pfet_03v3 L=0.28U W=0.36U AS=0.1278P AD=0.0567P
+ PS=1.07U PD=0.675U
M$1779 VDD \$3095 \$3289 VDD pfet_03v3 L=0.28U W=0.36U AS=0.0567P AD=0.1584P
+ PS=0.675U PD=1.6U
M$1780 \$3177 \$145 VDD VDD pfet_03v3 L=0.28U W=0.72U AS=0.3168P AD=0.2097P
+ PS=2.32U PD=1.38U
M$1781 VDD \$3178 \$3179 VDD pfet_03v3 L=0.28U W=0.36U AS=0.1584P AD=0.1764P
+ PS=1.6U PD=1.26U
M$1782 \$3180 \$3178 VDD VDD pfet_03v3 L=0.28U W=0.72U AS=0.1764P AD=0.36P
+ PS=1.26U PD=2.44U
M$1783 \$3181 RB6 VDD VDD pfet_03v3 L=0.28U W=0.72U AS=0.3312P AD=0.3888P
+ PS=2.36U PD=2.52U
M$1784 \$3180 \$3181 \$77 VDD pfet_03v3 L=0.28U W=0.36U AS=0.1584P AD=0.1152P
+ PS=1.6U PD=1U
M$1785 \$78 \$3182 \$3180 VDD pfet_03v3 L=0.28U W=0.36U AS=0.1152P AD=0.1584P
+ PS=1U PD=1.6U
M$1786 VDD RA6 \$3182 VDD pfet_03v3 L=0.28U W=0.72U AS=0.3708P AD=0.3168P
+ PS=2.47U PD=2.32U
M$1787 \$3184 \$3096 \$3183 VDD pfet_03v3 L=0.28U W=0.36U AS=0.2097P AD=0.1278P
+ PS=1.38U PD=1.07U
M$1788 \$3257 \$3185 \$3184 VDD pfet_03v3 L=0.28U W=0.36U AS=0.1278P AD=0.0567P
+ PS=1.07U PD=0.675U
M$1789 VDD \$3095 \$3257 VDD pfet_03v3 L=0.28U W=0.36U AS=0.0567P AD=0.1584P
+ PS=0.675U PD=1.6U
M$1790 \$3183 \$148 VDD VDD pfet_03v3 L=0.28U W=0.72U AS=0.3168P AD=0.2097P
+ PS=2.32U PD=1.38U
M$1791 VDD \$3184 \$3185 VDD pfet_03v3 L=0.28U W=0.36U AS=0.1584P AD=0.1764P
+ PS=1.6U PD=1.26U
M$1792 \$3186 \$3184 VDD VDD pfet_03v3 L=0.28U W=0.72U AS=0.1764P AD=0.36P
+ PS=1.26U PD=2.44U
M$1793 \$3187 RB6 VDD VDD pfet_03v3 L=0.28U W=0.72U AS=0.3312P AD=0.3888P
+ PS=2.36U PD=2.52U
M$1794 \$3186 \$3187 \$79 VDD pfet_03v3 L=0.28U W=0.36U AS=0.1584P AD=0.1152P
+ PS=1.6U PD=1U
M$1795 \$80 \$3188 \$3186 VDD pfet_03v3 L=0.28U W=0.36U AS=0.1152P AD=0.1584P
+ PS=1U PD=1.6U
M$1796 VDD RA6 \$3188 VDD pfet_03v3 L=0.28U W=0.72U AS=0.3708P AD=0.3168P
+ PS=2.47U PD=2.32U
M$1797 \$3190 \$3096 \$3189 VDD pfet_03v3 L=0.28U W=0.36U AS=0.2097P AD=0.1278P
+ PS=1.38U PD=1.07U
M$1798 \$3224 \$3191 \$3190 VDD pfet_03v3 L=0.28U W=0.36U AS=0.1278P AD=0.0567P
+ PS=1.07U PD=0.675U
M$1799 VDD \$3095 \$3224 VDD pfet_03v3 L=0.28U W=0.36U AS=0.0567P AD=0.1584P
+ PS=0.675U PD=1.6U
M$1800 \$3189 \$151 VDD VDD pfet_03v3 L=0.28U W=0.72U AS=0.3168P AD=0.2097P
+ PS=2.32U PD=1.38U
M$1801 VDD \$3190 \$3191 VDD pfet_03v3 L=0.28U W=0.36U AS=0.1584P AD=0.1764P
+ PS=1.6U PD=1.26U
M$1802 \$3192 \$3190 VDD VDD pfet_03v3 L=0.28U W=0.72U AS=0.1764P AD=0.36P
+ PS=1.26U PD=2.44U
M$1803 \$3193 RB6 VDD VDD pfet_03v3 L=0.28U W=0.72U AS=0.3312P AD=0.3888P
+ PS=2.36U PD=2.52U
M$1804 \$3192 \$3193 \$81 VDD pfet_03v3 L=0.28U W=0.36U AS=0.1584P AD=0.1152P
+ PS=1.6U PD=1U
M$1805 \$82 \$3194 \$3192 VDD pfet_03v3 L=0.28U W=0.36U AS=0.1152P AD=0.1584P
+ PS=1U PD=1.6U
M$1806 VDD RA6 \$3194 VDD pfet_03v3 L=0.28U W=0.72U AS=0.3708P AD=0.3168P
+ PS=2.47U PD=2.32U
M$1807 \$3396 WE5 VDD VDD pfet_03v3 L=0.28U W=0.72U AS=0.3168P AD=0.1872P
+ PS=2.32U PD=1.24U
M$1808 VDD CLK \$3396 VDD pfet_03v3 L=0.28U W=0.72U AS=0.1872P AD=0.3168P
+ PS=1.24U PD=2.32U
M$1809 \$3397 \$3396 VDD VDD pfet_03v3 L=0.28U W=1.27U AS=0.5588P AD=0.3302P
+ PS=3.42U PD=1.79U
M$1810 \$3397 \$3396 VDD VDD pfet_03v3 L=0.28U W=1.27U AS=0.3386P AD=0.3302P
+ PS=1.86U PD=1.79U
M$1811 \$3398 \$3397 VDD VDD pfet_03v3 L=0.28U W=1.34U AS=0.3386P AD=0.3886P
+ PS=1.86U PD=1.92U
M$1812 VDD \$3397 \$3398 VDD pfet_03v3 L=0.28U W=1.34U AS=0.3886P AD=0.5896P
+ PS=1.92U PD=3.56U
M$1813 \$3399 \$106 VDD VDD pfet_03v3 L=0.28U W=0.72U AS=0.3168P AD=0.2097P
+ PS=2.32U PD=1.38U
M$1814 \$3400 \$3398 \$3399 VDD pfet_03v3 L=0.28U W=0.36U AS=0.2097P AD=0.1278P
+ PS=1.38U PD=1.07U
M$1815 \$3606 \$3401 \$3400 VDD pfet_03v3 L=0.28U W=0.36U AS=0.1278P AD=0.0567P
+ PS=1.07U PD=0.675U
M$1816 VDD \$3397 \$3606 VDD pfet_03v3 L=0.28U W=0.36U AS=0.0567P AD=0.1584P
+ PS=0.675U PD=1.6U
M$1817 \$3401 \$3400 VDD VDD pfet_03v3 L=0.28U W=0.36U AS=0.1764P AD=0.1584P
+ PS=1.26U PD=1.6U
M$1818 \$3402 \$3400 VDD VDD pfet_03v3 L=0.28U W=0.72U AS=0.1764P AD=0.36P
+ PS=1.26U PD=2.44U
M$1819 \$3513 RA5 VDD VDD pfet_03v3 L=0.28U W=0.72U AS=0.3312P AD=0.3888P
+ PS=2.36U PD=2.52U
M$1820 \$3402 \$3513 \$51 VDD pfet_03v3 L=0.28U W=0.36U AS=0.1584P AD=0.1152P
+ PS=1.6U PD=1U
M$1821 \$52 \$3514 \$3402 VDD pfet_03v3 L=0.28U W=0.36U AS=0.1152P AD=0.1584P
+ PS=1U PD=1.6U
M$1822 VDD RB5 \$3514 VDD pfet_03v3 L=0.28U W=0.72U AS=0.3708P AD=0.3168P
+ PS=2.47U PD=2.32U
M$1823 \$3403 \$109 VDD VDD pfet_03v3 L=0.28U W=0.72U AS=0.3168P AD=0.2097P
+ PS=2.32U PD=1.38U
M$1824 \$3404 \$3398 \$3403 VDD pfet_03v3 L=0.28U W=0.36U AS=0.2097P AD=0.1278P
+ PS=1.38U PD=1.07U
M$1825 \$3616 \$3405 \$3404 VDD pfet_03v3 L=0.28U W=0.36U AS=0.1278P AD=0.0567P
+ PS=1.07U PD=0.675U
M$1826 VDD \$3397 \$3616 VDD pfet_03v3 L=0.28U W=0.36U AS=0.0567P AD=0.1584P
+ PS=0.675U PD=1.6U
M$1827 \$3405 \$3404 VDD VDD pfet_03v3 L=0.28U W=0.36U AS=0.1764P AD=0.1584P
+ PS=1.26U PD=1.6U
M$1828 \$3406 \$3404 VDD VDD pfet_03v3 L=0.28U W=0.72U AS=0.1764P AD=0.36P
+ PS=1.26U PD=2.44U
M$1829 \$3515 RA5 VDD VDD pfet_03v3 L=0.28U W=0.72U AS=0.3312P AD=0.3888P
+ PS=2.36U PD=2.52U
M$1830 \$3406 \$3515 \$53 VDD pfet_03v3 L=0.28U W=0.36U AS=0.1584P AD=0.1152P
+ PS=1.6U PD=1U
M$1831 \$54 \$3516 \$3406 VDD pfet_03v3 L=0.28U W=0.36U AS=0.1152P AD=0.1584P
+ PS=1U PD=1.6U
M$1832 VDD RB5 \$3516 VDD pfet_03v3 L=0.28U W=0.72U AS=0.3708P AD=0.3168P
+ PS=2.47U PD=2.32U
M$1833 \$3407 \$112 VDD VDD pfet_03v3 L=0.28U W=0.72U AS=0.3168P AD=0.2097P
+ PS=2.32U PD=1.38U
M$1834 \$3408 \$3398 \$3407 VDD pfet_03v3 L=0.28U W=0.36U AS=0.2097P AD=0.1278P
+ PS=1.38U PD=1.07U
M$1835 \$3622 \$3409 \$3408 VDD pfet_03v3 L=0.28U W=0.36U AS=0.1278P AD=0.0567P
+ PS=1.07U PD=0.675U
M$1836 VDD \$3397 \$3622 VDD pfet_03v3 L=0.28U W=0.36U AS=0.0567P AD=0.1584P
+ PS=0.675U PD=1.6U
M$1837 \$3409 \$3408 VDD VDD pfet_03v3 L=0.28U W=0.36U AS=0.1764P AD=0.1584P
+ PS=1.26U PD=1.6U
M$1838 \$3410 \$3408 VDD VDD pfet_03v3 L=0.28U W=0.72U AS=0.1764P AD=0.36P
+ PS=1.26U PD=2.44U
M$1839 \$3517 RA5 VDD VDD pfet_03v3 L=0.28U W=0.72U AS=0.3312P AD=0.3888P
+ PS=2.36U PD=2.52U
M$1840 \$3410 \$3517 \$55 VDD pfet_03v3 L=0.28U W=0.36U AS=0.1584P AD=0.1152P
+ PS=1.6U PD=1U
M$1841 \$56 \$3518 \$3410 VDD pfet_03v3 L=0.28U W=0.36U AS=0.1152P AD=0.1584P
+ PS=1U PD=1.6U
M$1842 VDD RB5 \$3518 VDD pfet_03v3 L=0.28U W=0.72U AS=0.3708P AD=0.3168P
+ PS=2.47U PD=2.32U
M$1843 \$3411 \$115 VDD VDD pfet_03v3 L=0.28U W=0.72U AS=0.3168P AD=0.2097P
+ PS=2.32U PD=1.38U
M$1844 \$3412 \$3398 \$3411 VDD pfet_03v3 L=0.28U W=0.36U AS=0.2097P AD=0.1278P
+ PS=1.38U PD=1.07U
M$1845 \$3631 \$3413 \$3412 VDD pfet_03v3 L=0.28U W=0.36U AS=0.1278P AD=0.0567P
+ PS=1.07U PD=0.675U
M$1846 VDD \$3397 \$3631 VDD pfet_03v3 L=0.28U W=0.36U AS=0.0567P AD=0.1584P
+ PS=0.675U PD=1.6U
M$1847 \$3413 \$3412 VDD VDD pfet_03v3 L=0.28U W=0.36U AS=0.1764P AD=0.1584P
+ PS=1.26U PD=1.6U
M$1848 \$3414 \$3412 VDD VDD pfet_03v3 L=0.28U W=0.72U AS=0.1764P AD=0.36P
+ PS=1.26U PD=2.44U
M$1849 \$3519 RA5 VDD VDD pfet_03v3 L=0.28U W=0.72U AS=0.3312P AD=0.3888P
+ PS=2.36U PD=2.52U
M$1850 \$3414 \$3519 \$57 VDD pfet_03v3 L=0.28U W=0.36U AS=0.1584P AD=0.1152P
+ PS=1.6U PD=1U
M$1851 \$58 \$3520 \$3414 VDD pfet_03v3 L=0.28U W=0.36U AS=0.1152P AD=0.1584P
+ PS=1U PD=1.6U
M$1852 VDD RB5 \$3520 VDD pfet_03v3 L=0.28U W=0.72U AS=0.3708P AD=0.3168P
+ PS=2.47U PD=2.32U
M$1853 \$3415 \$118 VDD VDD pfet_03v3 L=0.28U W=0.72U AS=0.3168P AD=0.2097P
+ PS=2.32U PD=1.38U
M$1854 \$3416 \$3398 \$3415 VDD pfet_03v3 L=0.28U W=0.36U AS=0.2097P AD=0.1278P
+ PS=1.38U PD=1.07U
M$1855 \$3641 \$3417 \$3416 VDD pfet_03v3 L=0.28U W=0.36U AS=0.1278P AD=0.0567P
+ PS=1.07U PD=0.675U
M$1856 VDD \$3397 \$3641 VDD pfet_03v3 L=0.28U W=0.36U AS=0.0567P AD=0.1584P
+ PS=0.675U PD=1.6U
M$1857 \$3417 \$3416 VDD VDD pfet_03v3 L=0.28U W=0.36U AS=0.1764P AD=0.1584P
+ PS=1.26U PD=1.6U
M$1858 \$3418 \$3416 VDD VDD pfet_03v3 L=0.28U W=0.72U AS=0.1764P AD=0.36P
+ PS=1.26U PD=2.44U
M$1859 \$3521 RA5 VDD VDD pfet_03v3 L=0.28U W=0.72U AS=0.3312P AD=0.3888P
+ PS=2.36U PD=2.52U
M$1860 \$3418 \$3521 \$59 VDD pfet_03v3 L=0.28U W=0.36U AS=0.1584P AD=0.1152P
+ PS=1.6U PD=1U
M$1861 \$60 \$3522 \$3418 VDD pfet_03v3 L=0.28U W=0.36U AS=0.1152P AD=0.1584P
+ PS=1U PD=1.6U
M$1862 VDD RB5 \$3522 VDD pfet_03v3 L=0.28U W=0.72U AS=0.3708P AD=0.3168P
+ PS=2.47U PD=2.32U
M$1863 \$3419 \$121 VDD VDD pfet_03v3 L=0.28U W=0.72U AS=0.3168P AD=0.2097P
+ PS=2.32U PD=1.38U
M$1864 \$3420 \$3398 \$3419 VDD pfet_03v3 L=0.28U W=0.36U AS=0.2097P AD=0.1278P
+ PS=1.38U PD=1.07U
M$1865 \$3650 \$3421 \$3420 VDD pfet_03v3 L=0.28U W=0.36U AS=0.1278P AD=0.0567P
+ PS=1.07U PD=0.675U
M$1866 VDD \$3397 \$3650 VDD pfet_03v3 L=0.28U W=0.36U AS=0.0567P AD=0.1584P
+ PS=0.675U PD=1.6U
M$1867 \$3421 \$3420 VDD VDD pfet_03v3 L=0.28U W=0.36U AS=0.1764P AD=0.1584P
+ PS=1.26U PD=1.6U
M$1868 \$3422 \$3420 VDD VDD pfet_03v3 L=0.28U W=0.72U AS=0.1764P AD=0.36P
+ PS=1.26U PD=2.44U
M$1869 \$3523 RA5 VDD VDD pfet_03v3 L=0.28U W=0.72U AS=0.3312P AD=0.3888P
+ PS=2.36U PD=2.52U
M$1870 \$3422 \$3523 \$61 VDD pfet_03v3 L=0.28U W=0.36U AS=0.1584P AD=0.1152P
+ PS=1.6U PD=1U
M$1871 \$62 \$3524 \$3422 VDD pfet_03v3 L=0.28U W=0.36U AS=0.1152P AD=0.1584P
+ PS=1U PD=1.6U
M$1872 VDD RB5 \$3524 VDD pfet_03v3 L=0.28U W=0.72U AS=0.3708P AD=0.3168P
+ PS=2.47U PD=2.32U
M$1873 \$3423 \$124 VDD VDD pfet_03v3 L=0.28U W=0.72U AS=0.3168P AD=0.2097P
+ PS=2.32U PD=1.38U
M$1874 \$3424 \$3398 \$3423 VDD pfet_03v3 L=0.28U W=0.36U AS=0.2097P AD=0.1278P
+ PS=1.38U PD=1.07U
M$1875 \$3658 \$3425 \$3424 VDD pfet_03v3 L=0.28U W=0.36U AS=0.1278P AD=0.0567P
+ PS=1.07U PD=0.675U
M$1876 VDD \$3397 \$3658 VDD pfet_03v3 L=0.28U W=0.36U AS=0.0567P AD=0.1584P
+ PS=0.675U PD=1.6U
M$1877 \$3425 \$3424 VDD VDD pfet_03v3 L=0.28U W=0.36U AS=0.1764P AD=0.1584P
+ PS=1.26U PD=1.6U
M$1878 \$3426 \$3424 VDD VDD pfet_03v3 L=0.28U W=0.72U AS=0.1764P AD=0.36P
+ PS=1.26U PD=2.44U
M$1879 \$3525 RA5 VDD VDD pfet_03v3 L=0.28U W=0.72U AS=0.3312P AD=0.3888P
+ PS=2.36U PD=2.52U
M$1880 \$3426 \$3525 \$63 VDD pfet_03v3 L=0.28U W=0.36U AS=0.1584P AD=0.1152P
+ PS=1.6U PD=1U
M$1881 \$64 \$3526 \$3426 VDD pfet_03v3 L=0.28U W=0.36U AS=0.1152P AD=0.1584P
+ PS=1U PD=1.6U
M$1882 VDD RB5 \$3526 VDD pfet_03v3 L=0.28U W=0.72U AS=0.3708P AD=0.3168P
+ PS=2.47U PD=2.32U
M$1883 \$3427 \$127 VDD VDD pfet_03v3 L=0.28U W=0.72U AS=0.3168P AD=0.2097P
+ PS=2.32U PD=1.38U
M$1884 \$3428 \$3398 \$3427 VDD pfet_03v3 L=0.28U W=0.36U AS=0.2097P AD=0.1278P
+ PS=1.38U PD=1.07U
M$1885 \$3667 \$3429 \$3428 VDD pfet_03v3 L=0.28U W=0.36U AS=0.1278P AD=0.0567P
+ PS=1.07U PD=0.675U
M$1886 VDD \$3397 \$3667 VDD pfet_03v3 L=0.28U W=0.36U AS=0.0567P AD=0.1584P
+ PS=0.675U PD=1.6U
M$1887 \$3429 \$3428 VDD VDD pfet_03v3 L=0.28U W=0.36U AS=0.1764P AD=0.1584P
+ PS=1.26U PD=1.6U
M$1888 \$3430 \$3428 VDD VDD pfet_03v3 L=0.28U W=0.72U AS=0.1764P AD=0.36P
+ PS=1.26U PD=2.44U
M$1889 \$3527 RA5 VDD VDD pfet_03v3 L=0.28U W=0.72U AS=0.3312P AD=0.3888P
+ PS=2.36U PD=2.52U
M$1890 \$3430 \$3527 \$65 VDD pfet_03v3 L=0.28U W=0.36U AS=0.1584P AD=0.1152P
+ PS=1.6U PD=1U
M$1891 \$66 \$3528 \$3430 VDD pfet_03v3 L=0.28U W=0.36U AS=0.1152P AD=0.1584P
+ PS=1U PD=1.6U
M$1892 VDD RB5 \$3528 VDD pfet_03v3 L=0.28U W=0.72U AS=0.3708P AD=0.3168P
+ PS=2.47U PD=2.32U
M$1893 \$3431 \$130 VDD VDD pfet_03v3 L=0.28U W=0.72U AS=0.3168P AD=0.2097P
+ PS=2.32U PD=1.38U
M$1894 \$3432 \$3398 \$3431 VDD pfet_03v3 L=0.28U W=0.36U AS=0.2097P AD=0.1278P
+ PS=1.38U PD=1.07U
M$1895 \$3676 \$3433 \$3432 VDD pfet_03v3 L=0.28U W=0.36U AS=0.1278P AD=0.0567P
+ PS=1.07U PD=0.675U
M$1896 VDD \$3397 \$3676 VDD pfet_03v3 L=0.28U W=0.36U AS=0.0567P AD=0.1584P
+ PS=0.675U PD=1.6U
M$1897 \$3433 \$3432 VDD VDD pfet_03v3 L=0.28U W=0.36U AS=0.1764P AD=0.1584P
+ PS=1.26U PD=1.6U
M$1898 \$3434 \$3432 VDD VDD pfet_03v3 L=0.28U W=0.72U AS=0.1764P AD=0.36P
+ PS=1.26U PD=2.44U
M$1899 \$3529 RA5 VDD VDD pfet_03v3 L=0.28U W=0.72U AS=0.3312P AD=0.3888P
+ PS=2.36U PD=2.52U
M$1900 \$3434 \$3529 \$67 VDD pfet_03v3 L=0.28U W=0.36U AS=0.1584P AD=0.1152P
+ PS=1.6U PD=1U
M$1901 \$68 \$3530 \$3434 VDD pfet_03v3 L=0.28U W=0.36U AS=0.1152P AD=0.1584P
+ PS=1U PD=1.6U
M$1902 VDD RB5 \$3530 VDD pfet_03v3 L=0.28U W=0.72U AS=0.3708P AD=0.3168P
+ PS=2.47U PD=2.32U
M$1903 \$3435 \$133 VDD VDD pfet_03v3 L=0.28U W=0.72U AS=0.3168P AD=0.2097P
+ PS=2.32U PD=1.38U
M$1904 \$3436 \$3398 \$3435 VDD pfet_03v3 L=0.28U W=0.36U AS=0.2097P AD=0.1278P
+ PS=1.38U PD=1.07U
M$1905 \$3685 \$3437 \$3436 VDD pfet_03v3 L=0.28U W=0.36U AS=0.1278P AD=0.0567P
+ PS=1.07U PD=0.675U
M$1906 VDD \$3397 \$3685 VDD pfet_03v3 L=0.28U W=0.36U AS=0.0567P AD=0.1584P
+ PS=0.675U PD=1.6U
M$1907 \$3437 \$3436 VDD VDD pfet_03v3 L=0.28U W=0.36U AS=0.1764P AD=0.1584P
+ PS=1.26U PD=1.6U
M$1908 \$3438 \$3436 VDD VDD pfet_03v3 L=0.28U W=0.72U AS=0.1764P AD=0.36P
+ PS=1.26U PD=2.44U
M$1909 \$3531 RA5 VDD VDD pfet_03v3 L=0.28U W=0.72U AS=0.3312P AD=0.3888P
+ PS=2.36U PD=2.52U
M$1910 \$3438 \$3531 \$69 VDD pfet_03v3 L=0.28U W=0.36U AS=0.1584P AD=0.1152P
+ PS=1.6U PD=1U
M$1911 \$70 \$3532 \$3438 VDD pfet_03v3 L=0.28U W=0.36U AS=0.1152P AD=0.1584P
+ PS=1U PD=1.6U
M$1912 VDD RB5 \$3532 VDD pfet_03v3 L=0.28U W=0.72U AS=0.3708P AD=0.3168P
+ PS=2.47U PD=2.32U
M$1913 \$3439 \$136 VDD VDD pfet_03v3 L=0.28U W=0.72U AS=0.3168P AD=0.2097P
+ PS=2.32U PD=1.38U
M$1914 \$3440 \$3398 \$3439 VDD pfet_03v3 L=0.28U W=0.36U AS=0.2097P AD=0.1278P
+ PS=1.38U PD=1.07U
M$1915 \$3694 \$3441 \$3440 VDD pfet_03v3 L=0.28U W=0.36U AS=0.1278P AD=0.0567P
+ PS=1.07U PD=0.675U
M$1916 VDD \$3397 \$3694 VDD pfet_03v3 L=0.28U W=0.36U AS=0.0567P AD=0.1584P
+ PS=0.675U PD=1.6U
M$1917 \$3441 \$3440 VDD VDD pfet_03v3 L=0.28U W=0.36U AS=0.1764P AD=0.1584P
+ PS=1.26U PD=1.6U
M$1918 \$3442 \$3440 VDD VDD pfet_03v3 L=0.28U W=0.72U AS=0.1764P AD=0.36P
+ PS=1.26U PD=2.44U
M$1919 \$3533 RA5 VDD VDD pfet_03v3 L=0.28U W=0.72U AS=0.3312P AD=0.3888P
+ PS=2.36U PD=2.52U
M$1920 \$3442 \$3533 \$71 VDD pfet_03v3 L=0.28U W=0.36U AS=0.1584P AD=0.1152P
+ PS=1.6U PD=1U
M$1921 \$72 \$3534 \$3442 VDD pfet_03v3 L=0.28U W=0.36U AS=0.1152P AD=0.1584P
+ PS=1U PD=1.6U
M$1922 VDD RB5 \$3534 VDD pfet_03v3 L=0.28U W=0.72U AS=0.3708P AD=0.3168P
+ PS=2.47U PD=2.32U
M$1923 \$3443 \$139 VDD VDD pfet_03v3 L=0.28U W=0.72U AS=0.3168P AD=0.2097P
+ PS=2.32U PD=1.38U
M$1924 \$3444 \$3398 \$3443 VDD pfet_03v3 L=0.28U W=0.36U AS=0.2097P AD=0.1278P
+ PS=1.38U PD=1.07U
M$1925 \$3702 \$3445 \$3444 VDD pfet_03v3 L=0.28U W=0.36U AS=0.1278P AD=0.0567P
+ PS=1.07U PD=0.675U
M$1926 VDD \$3397 \$3702 VDD pfet_03v3 L=0.28U W=0.36U AS=0.0567P AD=0.1584P
+ PS=0.675U PD=1.6U
M$1927 \$3445 \$3444 VDD VDD pfet_03v3 L=0.28U W=0.36U AS=0.1764P AD=0.1584P
+ PS=1.26U PD=1.6U
M$1928 \$3446 \$3444 VDD VDD pfet_03v3 L=0.28U W=0.72U AS=0.1764P AD=0.36P
+ PS=1.26U PD=2.44U
M$1929 \$3535 RA5 VDD VDD pfet_03v3 L=0.28U W=0.72U AS=0.3312P AD=0.3888P
+ PS=2.36U PD=2.52U
M$1930 \$3446 \$3535 \$73 VDD pfet_03v3 L=0.28U W=0.36U AS=0.1584P AD=0.1152P
+ PS=1.6U PD=1U
M$1931 \$74 \$3536 \$3446 VDD pfet_03v3 L=0.28U W=0.36U AS=0.1152P AD=0.1584P
+ PS=1U PD=1.6U
M$1932 VDD RB5 \$3536 VDD pfet_03v3 L=0.28U W=0.72U AS=0.3708P AD=0.3168P
+ PS=2.47U PD=2.32U
M$1933 \$3447 \$142 VDD VDD pfet_03v3 L=0.28U W=0.72U AS=0.3168P AD=0.2097P
+ PS=2.32U PD=1.38U
M$1934 \$3448 \$3398 \$3447 VDD pfet_03v3 L=0.28U W=0.36U AS=0.2097P AD=0.1278P
+ PS=1.38U PD=1.07U
M$1935 \$3688 \$3449 \$3448 VDD pfet_03v3 L=0.28U W=0.36U AS=0.1278P AD=0.0567P
+ PS=1.07U PD=0.675U
M$1936 VDD \$3397 \$3688 VDD pfet_03v3 L=0.28U W=0.36U AS=0.0567P AD=0.1584P
+ PS=0.675U PD=1.6U
M$1937 \$3449 \$3448 VDD VDD pfet_03v3 L=0.28U W=0.36U AS=0.1764P AD=0.1584P
+ PS=1.26U PD=1.6U
M$1938 \$3450 \$3448 VDD VDD pfet_03v3 L=0.28U W=0.72U AS=0.1764P AD=0.36P
+ PS=1.26U PD=2.44U
M$1939 \$3537 RA5 VDD VDD pfet_03v3 L=0.28U W=0.72U AS=0.3312P AD=0.3888P
+ PS=2.36U PD=2.52U
M$1940 \$3450 \$3537 \$75 VDD pfet_03v3 L=0.28U W=0.36U AS=0.1584P AD=0.1152P
+ PS=1.6U PD=1U
M$1941 \$76 \$3538 \$3450 VDD pfet_03v3 L=0.28U W=0.36U AS=0.1152P AD=0.1584P
+ PS=1U PD=1.6U
M$1942 VDD RB5 \$3538 VDD pfet_03v3 L=0.28U W=0.72U AS=0.3708P AD=0.3168P
+ PS=2.47U PD=2.32U
M$1943 \$3451 \$145 VDD VDD pfet_03v3 L=0.28U W=0.72U AS=0.3168P AD=0.2097P
+ PS=2.32U PD=1.38U
M$1944 \$3452 \$3398 \$3451 VDD pfet_03v3 L=0.28U W=0.36U AS=0.2097P AD=0.1278P
+ PS=1.38U PD=1.07U
M$1945 \$3660 \$3453 \$3452 VDD pfet_03v3 L=0.28U W=0.36U AS=0.1278P AD=0.0567P
+ PS=1.07U PD=0.675U
M$1946 VDD \$3397 \$3660 VDD pfet_03v3 L=0.28U W=0.36U AS=0.0567P AD=0.1584P
+ PS=0.675U PD=1.6U
M$1947 \$3453 \$3452 VDD VDD pfet_03v3 L=0.28U W=0.36U AS=0.1764P AD=0.1584P
+ PS=1.26U PD=1.6U
M$1948 \$3454 \$3452 VDD VDD pfet_03v3 L=0.28U W=0.72U AS=0.1764P AD=0.36P
+ PS=1.26U PD=2.44U
M$1949 \$3539 RA5 VDD VDD pfet_03v3 L=0.28U W=0.72U AS=0.3312P AD=0.3888P
+ PS=2.36U PD=2.52U
M$1950 \$3454 \$3539 \$77 VDD pfet_03v3 L=0.28U W=0.36U AS=0.1584P AD=0.1152P
+ PS=1.6U PD=1U
M$1951 \$78 \$3540 \$3454 VDD pfet_03v3 L=0.28U W=0.36U AS=0.1152P AD=0.1584P
+ PS=1U PD=1.6U
M$1952 VDD RB5 \$3540 VDD pfet_03v3 L=0.28U W=0.72U AS=0.3708P AD=0.3168P
+ PS=2.47U PD=2.32U
M$1953 \$3455 \$148 VDD VDD pfet_03v3 L=0.28U W=0.72U AS=0.3168P AD=0.2097P
+ PS=2.32U PD=1.38U
M$1954 \$3456 \$3398 \$3455 VDD pfet_03v3 L=0.28U W=0.36U AS=0.2097P AD=0.1278P
+ PS=1.38U PD=1.07U
M$1955 \$3642 \$3457 \$3456 VDD pfet_03v3 L=0.28U W=0.36U AS=0.1278P AD=0.0567P
+ PS=1.07U PD=0.675U
M$1956 VDD \$3397 \$3642 VDD pfet_03v3 L=0.28U W=0.36U AS=0.0567P AD=0.1584P
+ PS=0.675U PD=1.6U
M$1957 \$3457 \$3456 VDD VDD pfet_03v3 L=0.28U W=0.36U AS=0.1764P AD=0.1584P
+ PS=1.26U PD=1.6U
M$1958 \$3458 \$3456 VDD VDD pfet_03v3 L=0.28U W=0.72U AS=0.1764P AD=0.36P
+ PS=1.26U PD=2.44U
M$1959 \$3541 RA5 VDD VDD pfet_03v3 L=0.28U W=0.72U AS=0.3312P AD=0.3888P
+ PS=2.36U PD=2.52U
M$1960 \$3458 \$3541 \$79 VDD pfet_03v3 L=0.28U W=0.36U AS=0.1584P AD=0.1152P
+ PS=1.6U PD=1U
M$1961 \$80 \$3542 \$3458 VDD pfet_03v3 L=0.28U W=0.36U AS=0.1152P AD=0.1584P
+ PS=1U PD=1.6U
M$1962 VDD RB5 \$3542 VDD pfet_03v3 L=0.28U W=0.72U AS=0.3708P AD=0.3168P
+ PS=2.47U PD=2.32U
M$1963 \$3459 \$151 VDD VDD pfet_03v3 L=0.28U W=0.72U AS=0.3168P AD=0.2097P
+ PS=2.32U PD=1.38U
M$1964 \$3460 \$3398 \$3459 VDD pfet_03v3 L=0.28U W=0.36U AS=0.2097P AD=0.1278P
+ PS=1.38U PD=1.07U
M$1965 \$3614 \$3461 \$3460 VDD pfet_03v3 L=0.28U W=0.36U AS=0.1278P AD=0.0567P
+ PS=1.07U PD=0.675U
M$1966 VDD \$3397 \$3614 VDD pfet_03v3 L=0.28U W=0.36U AS=0.0567P AD=0.1584P
+ PS=0.675U PD=1.6U
M$1967 \$3461 \$3460 VDD VDD pfet_03v3 L=0.28U W=0.36U AS=0.1764P AD=0.1584P
+ PS=1.26U PD=1.6U
M$1968 \$3462 \$3460 VDD VDD pfet_03v3 L=0.28U W=0.72U AS=0.1764P AD=0.36P
+ PS=1.26U PD=2.44U
M$1969 \$3543 RA5 VDD VDD pfet_03v3 L=0.28U W=0.72U AS=0.3312P AD=0.3888P
+ PS=2.36U PD=2.52U
M$1970 \$3462 \$3543 \$81 VDD pfet_03v3 L=0.28U W=0.36U AS=0.1584P AD=0.1152P
+ PS=1.6U PD=1U
M$1971 \$82 \$3544 \$3462 VDD pfet_03v3 L=0.28U W=0.36U AS=0.1152P AD=0.1584P
+ PS=1U PD=1.6U
M$1972 VDD RB5 \$3544 VDD pfet_03v3 L=0.28U W=0.72U AS=0.3708P AD=0.3168P
+ PS=2.47U PD=2.32U
M$1973 \$3706 WE4 VDD VDD pfet_03v3 L=0.28U W=0.72U AS=0.3168P AD=0.1872P
+ PS=2.32U PD=1.24U
M$1974 VDD CLK \$3706 VDD pfet_03v3 L=0.28U W=0.72U AS=0.1872P AD=0.3168P
+ PS=1.24U PD=2.32U
M$1975 \$3708 \$3706 VDD VDD pfet_03v3 L=0.28U W=1.27U AS=0.5588P AD=0.3302P
+ PS=3.42U PD=1.79U
M$1976 VDD \$3706 \$3708 VDD pfet_03v3 L=0.28U W=1.27U AS=0.3302P AD=0.3386P
+ PS=1.79U PD=1.86U
M$1977 \$3709 \$3708 VDD VDD pfet_03v3 L=0.28U W=1.34U AS=0.3386P AD=0.3886P
+ PS=1.86U PD=1.92U
M$1978 VDD \$3708 \$3709 VDD pfet_03v3 L=0.28U W=1.34U AS=0.3886P AD=0.5896P
+ PS=1.92U PD=3.56U
M$1979 \$3713 \$3709 \$3712 VDD pfet_03v3 L=0.28U W=0.36U AS=0.2097P AD=0.1278P
+ PS=1.38U PD=1.07U
M$1980 \$3813 \$3714 \$3713 VDD pfet_03v3 L=0.28U W=0.36U AS=0.1278P AD=0.0567P
+ PS=1.07U PD=0.675U
M$1981 VDD \$3708 \$3813 VDD pfet_03v3 L=0.28U W=0.36U AS=0.0567P AD=0.1584P
+ PS=0.675U PD=1.6U
M$1982 \$3712 \$106 VDD VDD pfet_03v3 L=0.28U W=0.72U AS=0.3168P AD=0.2097P
+ PS=2.32U PD=1.38U
M$1983 VDD \$3713 \$3714 VDD pfet_03v3 L=0.28U W=0.36U AS=0.1584P AD=0.1764P
+ PS=1.6U PD=1.26U
M$1984 \$3715 \$3713 VDD VDD pfet_03v3 L=0.28U W=0.72U AS=0.1764P AD=0.36P
+ PS=1.26U PD=2.44U
M$1985 \$3716 RB4 VDD VDD pfet_03v3 L=0.28U W=0.72U AS=0.3312P AD=0.3888P
+ PS=2.36U PD=2.52U
M$1986 \$3715 \$3716 \$51 VDD pfet_03v3 L=0.28U W=0.36U AS=0.1584P AD=0.1152P
+ PS=1.6U PD=1U
M$1987 \$52 \$3717 \$3715 VDD pfet_03v3 L=0.28U W=0.36U AS=0.1152P AD=0.1584P
+ PS=1U PD=1.6U
M$1988 VDD RA4 \$3717 VDD pfet_03v3 L=0.28U W=0.72U AS=0.3708P AD=0.3168P
+ PS=2.47U PD=2.32U
M$1989 \$3719 \$3709 \$3718 VDD pfet_03v3 L=0.28U W=0.36U AS=0.2097P AD=0.1278P
+ PS=1.38U PD=1.07U
M$1990 \$3821 \$3720 \$3719 VDD pfet_03v3 L=0.28U W=0.36U AS=0.1278P AD=0.0567P
+ PS=1.07U PD=0.675U
M$1991 VDD \$3708 \$3821 VDD pfet_03v3 L=0.28U W=0.36U AS=0.0567P AD=0.1584P
+ PS=0.675U PD=1.6U
M$1992 \$3718 \$109 VDD VDD pfet_03v3 L=0.28U W=0.72U AS=0.3168P AD=0.2097P
+ PS=2.32U PD=1.38U
M$1993 VDD \$3719 \$3720 VDD pfet_03v3 L=0.28U W=0.36U AS=0.1584P AD=0.1764P
+ PS=1.6U PD=1.26U
M$1994 \$3721 \$3719 VDD VDD pfet_03v3 L=0.28U W=0.72U AS=0.1764P AD=0.36P
+ PS=1.26U PD=2.44U
M$1995 \$3722 RB4 VDD VDD pfet_03v3 L=0.28U W=0.72U AS=0.3312P AD=0.3888P
+ PS=2.36U PD=2.52U
M$1996 \$3721 \$3722 \$53 VDD pfet_03v3 L=0.28U W=0.36U AS=0.1584P AD=0.1152P
+ PS=1.6U PD=1U
M$1997 \$54 \$3723 \$3721 VDD pfet_03v3 L=0.28U W=0.36U AS=0.1152P AD=0.1584P
+ PS=1U PD=1.6U
M$1998 VDD RA4 \$3723 VDD pfet_03v3 L=0.28U W=0.72U AS=0.3708P AD=0.3168P
+ PS=2.47U PD=2.32U
M$1999 \$3725 \$3709 \$3724 VDD pfet_03v3 L=0.28U W=0.36U AS=0.2097P AD=0.1278P
+ PS=1.38U PD=1.07U
M$2000 \$3828 \$3726 \$3725 VDD pfet_03v3 L=0.28U W=0.36U AS=0.1278P AD=0.0567P
+ PS=1.07U PD=0.675U
M$2001 VDD \$3708 \$3828 VDD pfet_03v3 L=0.28U W=0.36U AS=0.0567P AD=0.1584P
+ PS=0.675U PD=1.6U
M$2002 \$3724 \$112 VDD VDD pfet_03v3 L=0.28U W=0.72U AS=0.3168P AD=0.2097P
+ PS=2.32U PD=1.38U
M$2003 VDD \$3725 \$3726 VDD pfet_03v3 L=0.28U W=0.36U AS=0.1584P AD=0.1764P
+ PS=1.6U PD=1.26U
M$2004 \$3727 \$3725 VDD VDD pfet_03v3 L=0.28U W=0.72U AS=0.1764P AD=0.36P
+ PS=1.26U PD=2.44U
M$2005 \$3728 RB4 VDD VDD pfet_03v3 L=0.28U W=0.72U AS=0.3312P AD=0.3888P
+ PS=2.36U PD=2.52U
M$2006 \$3727 \$3728 \$55 VDD pfet_03v3 L=0.28U W=0.36U AS=0.1584P AD=0.1152P
+ PS=1.6U PD=1U
M$2007 \$56 \$3729 \$3727 VDD pfet_03v3 L=0.28U W=0.36U AS=0.1152P AD=0.1584P
+ PS=1U PD=1.6U
M$2008 VDD RA4 \$3729 VDD pfet_03v3 L=0.28U W=0.72U AS=0.3708P AD=0.3168P
+ PS=2.47U PD=2.32U
M$2009 \$3731 \$3709 \$3730 VDD pfet_03v3 L=0.28U W=0.36U AS=0.2097P AD=0.1278P
+ PS=1.38U PD=1.07U
M$2010 \$3836 \$3732 \$3731 VDD pfet_03v3 L=0.28U W=0.36U AS=0.1278P AD=0.0567P
+ PS=1.07U PD=0.675U
M$2011 VDD \$3708 \$3836 VDD pfet_03v3 L=0.28U W=0.36U AS=0.0567P AD=0.1584P
+ PS=0.675U PD=1.6U
M$2012 \$3730 \$115 VDD VDD pfet_03v3 L=0.28U W=0.72U AS=0.3168P AD=0.2097P
+ PS=2.32U PD=1.38U
M$2013 VDD \$3731 \$3732 VDD pfet_03v3 L=0.28U W=0.36U AS=0.1584P AD=0.1764P
+ PS=1.6U PD=1.26U
M$2014 \$3733 \$3731 VDD VDD pfet_03v3 L=0.28U W=0.72U AS=0.1764P AD=0.36P
+ PS=1.26U PD=2.44U
M$2015 \$3734 RB4 VDD VDD pfet_03v3 L=0.28U W=0.72U AS=0.3312P AD=0.3888P
+ PS=2.36U PD=2.52U
M$2016 \$3733 \$3734 \$57 VDD pfet_03v3 L=0.28U W=0.36U AS=0.1584P AD=0.1152P
+ PS=1.6U PD=1U
M$2017 \$58 \$3735 \$3733 VDD pfet_03v3 L=0.28U W=0.36U AS=0.1152P AD=0.1584P
+ PS=1U PD=1.6U
M$2018 VDD RA4 \$3735 VDD pfet_03v3 L=0.28U W=0.72U AS=0.3708P AD=0.3168P
+ PS=2.47U PD=2.32U
M$2019 \$3737 \$3709 \$3736 VDD pfet_03v3 L=0.28U W=0.36U AS=0.2097P AD=0.1278P
+ PS=1.38U PD=1.07U
M$2020 \$3845 \$3738 \$3737 VDD pfet_03v3 L=0.28U W=0.36U AS=0.1278P AD=0.0567P
+ PS=1.07U PD=0.675U
M$2021 VDD \$3708 \$3845 VDD pfet_03v3 L=0.28U W=0.36U AS=0.0567P AD=0.1584P
+ PS=0.675U PD=1.6U
M$2022 \$3736 \$118 VDD VDD pfet_03v3 L=0.28U W=0.72U AS=0.3168P AD=0.2097P
+ PS=2.32U PD=1.38U
M$2023 VDD \$3737 \$3738 VDD pfet_03v3 L=0.28U W=0.36U AS=0.1584P AD=0.1764P
+ PS=1.6U PD=1.26U
M$2024 \$3739 \$3737 VDD VDD pfet_03v3 L=0.28U W=0.72U AS=0.1764P AD=0.36P
+ PS=1.26U PD=2.44U
M$2025 \$3740 RB4 VDD VDD pfet_03v3 L=0.28U W=0.72U AS=0.3312P AD=0.3888P
+ PS=2.36U PD=2.52U
M$2026 \$3739 \$3740 \$59 VDD pfet_03v3 L=0.28U W=0.36U AS=0.1584P AD=0.1152P
+ PS=1.6U PD=1U
M$2027 \$60 \$3741 \$3739 VDD pfet_03v3 L=0.28U W=0.36U AS=0.1152P AD=0.1584P
+ PS=1U PD=1.6U
M$2028 VDD RA4 \$3741 VDD pfet_03v3 L=0.28U W=0.72U AS=0.3708P AD=0.3168P
+ PS=2.47U PD=2.32U
M$2029 \$3743 \$3709 \$3742 VDD pfet_03v3 L=0.28U W=0.36U AS=0.2097P AD=0.1278P
+ PS=1.38U PD=1.07U
M$2030 \$3851 \$3744 \$3743 VDD pfet_03v3 L=0.28U W=0.36U AS=0.1278P AD=0.0567P
+ PS=1.07U PD=0.675U
M$2031 VDD \$3708 \$3851 VDD pfet_03v3 L=0.28U W=0.36U AS=0.0567P AD=0.1584P
+ PS=0.675U PD=1.6U
M$2032 \$3742 \$121 VDD VDD pfet_03v3 L=0.28U W=0.72U AS=0.3168P AD=0.2097P
+ PS=2.32U PD=1.38U
M$2033 VDD \$3743 \$3744 VDD pfet_03v3 L=0.28U W=0.36U AS=0.1584P AD=0.1764P
+ PS=1.6U PD=1.26U
M$2034 \$3745 \$3743 VDD VDD pfet_03v3 L=0.28U W=0.72U AS=0.1764P AD=0.36P
+ PS=1.26U PD=2.44U
M$2035 \$3746 RB4 VDD VDD pfet_03v3 L=0.28U W=0.72U AS=0.3312P AD=0.3888P
+ PS=2.36U PD=2.52U
M$2036 \$3745 \$3746 \$61 VDD pfet_03v3 L=0.28U W=0.36U AS=0.1584P AD=0.1152P
+ PS=1.6U PD=1U
M$2037 \$62 \$3747 \$3745 VDD pfet_03v3 L=0.28U W=0.36U AS=0.1152P AD=0.1584P
+ PS=1U PD=1.6U
M$2038 VDD RA4 \$3747 VDD pfet_03v3 L=0.28U W=0.72U AS=0.3708P AD=0.3168P
+ PS=2.47U PD=2.32U
M$2039 \$3749 \$3709 \$3748 VDD pfet_03v3 L=0.28U W=0.36U AS=0.2097P AD=0.1278P
+ PS=1.38U PD=1.07U
M$2040 \$3858 \$3750 \$3749 VDD pfet_03v3 L=0.28U W=0.36U AS=0.1278P AD=0.0567P
+ PS=1.07U PD=0.675U
M$2041 VDD \$3708 \$3858 VDD pfet_03v3 L=0.28U W=0.36U AS=0.0567P AD=0.1584P
+ PS=0.675U PD=1.6U
M$2042 \$3748 \$124 VDD VDD pfet_03v3 L=0.28U W=0.72U AS=0.3168P AD=0.2097P
+ PS=2.32U PD=1.38U
M$2043 VDD \$3749 \$3750 VDD pfet_03v3 L=0.28U W=0.36U AS=0.1584P AD=0.1764P
+ PS=1.6U PD=1.26U
M$2044 \$3751 \$3749 VDD VDD pfet_03v3 L=0.28U W=0.72U AS=0.1764P AD=0.36P
+ PS=1.26U PD=2.44U
M$2045 \$3752 RB4 VDD VDD pfet_03v3 L=0.28U W=0.72U AS=0.3312P AD=0.3888P
+ PS=2.36U PD=2.52U
M$2046 \$3751 \$3752 \$63 VDD pfet_03v3 L=0.28U W=0.36U AS=0.1584P AD=0.1152P
+ PS=1.6U PD=1U
M$2047 \$64 \$3753 \$3751 VDD pfet_03v3 L=0.28U W=0.36U AS=0.1152P AD=0.1584P
+ PS=1U PD=1.6U
M$2048 VDD RA4 \$3753 VDD pfet_03v3 L=0.28U W=0.72U AS=0.3708P AD=0.3168P
+ PS=2.47U PD=2.32U
M$2049 \$3755 \$3709 \$3754 VDD pfet_03v3 L=0.28U W=0.36U AS=0.2097P AD=0.1278P
+ PS=1.38U PD=1.07U
M$2050 \$3867 \$3756 \$3755 VDD pfet_03v3 L=0.28U W=0.36U AS=0.1278P AD=0.0567P
+ PS=1.07U PD=0.675U
M$2051 VDD \$3708 \$3867 VDD pfet_03v3 L=0.28U W=0.36U AS=0.0567P AD=0.1584P
+ PS=0.675U PD=1.6U
M$2052 \$3754 \$127 VDD VDD pfet_03v3 L=0.28U W=0.72U AS=0.3168P AD=0.2097P
+ PS=2.32U PD=1.38U
M$2053 VDD \$3755 \$3756 VDD pfet_03v3 L=0.28U W=0.36U AS=0.1584P AD=0.1764P
+ PS=1.6U PD=1.26U
M$2054 \$3757 \$3755 VDD VDD pfet_03v3 L=0.28U W=0.72U AS=0.1764P AD=0.36P
+ PS=1.26U PD=2.44U
M$2055 \$3758 RB4 VDD VDD pfet_03v3 L=0.28U W=0.72U AS=0.3312P AD=0.3888P
+ PS=2.36U PD=2.52U
M$2056 \$3757 \$3758 \$65 VDD pfet_03v3 L=0.28U W=0.36U AS=0.1584P AD=0.1152P
+ PS=1.6U PD=1U
M$2057 \$66 \$3759 \$3757 VDD pfet_03v3 L=0.28U W=0.36U AS=0.1152P AD=0.1584P
+ PS=1U PD=1.6U
M$2058 VDD RA4 \$3759 VDD pfet_03v3 L=0.28U W=0.72U AS=0.3708P AD=0.3168P
+ PS=2.47U PD=2.32U
M$2059 \$3761 \$3709 \$3760 VDD pfet_03v3 L=0.28U W=0.36U AS=0.2097P AD=0.1278P
+ PS=1.38U PD=1.07U
M$2060 \$3873 \$3762 \$3761 VDD pfet_03v3 L=0.28U W=0.36U AS=0.1278P AD=0.0567P
+ PS=1.07U PD=0.675U
M$2061 VDD \$3708 \$3873 VDD pfet_03v3 L=0.28U W=0.36U AS=0.0567P AD=0.1584P
+ PS=0.675U PD=1.6U
M$2062 \$3760 \$130 VDD VDD pfet_03v3 L=0.28U W=0.72U AS=0.3168P AD=0.2097P
+ PS=2.32U PD=1.38U
M$2063 VDD \$3761 \$3762 VDD pfet_03v3 L=0.28U W=0.36U AS=0.1584P AD=0.1764P
+ PS=1.6U PD=1.26U
M$2064 \$3763 \$3761 VDD VDD pfet_03v3 L=0.28U W=0.72U AS=0.1764P AD=0.36P
+ PS=1.26U PD=2.44U
M$2065 \$3764 RB4 VDD VDD pfet_03v3 L=0.28U W=0.72U AS=0.3312P AD=0.3888P
+ PS=2.36U PD=2.52U
M$2066 \$3763 \$3764 \$67 VDD pfet_03v3 L=0.28U W=0.36U AS=0.1584P AD=0.1152P
+ PS=1.6U PD=1U
M$2067 \$68 \$3765 \$3763 VDD pfet_03v3 L=0.28U W=0.36U AS=0.1152P AD=0.1584P
+ PS=1U PD=1.6U
M$2068 VDD RA4 \$3765 VDD pfet_03v3 L=0.28U W=0.72U AS=0.3708P AD=0.3168P
+ PS=2.47U PD=2.32U
M$2069 \$3767 \$3709 \$3766 VDD pfet_03v3 L=0.28U W=0.36U AS=0.2097P AD=0.1278P
+ PS=1.38U PD=1.07U
M$2070 \$3880 \$3768 \$3767 VDD pfet_03v3 L=0.28U W=0.36U AS=0.1278P AD=0.0567P
+ PS=1.07U PD=0.675U
M$2071 VDD \$3708 \$3880 VDD pfet_03v3 L=0.28U W=0.36U AS=0.0567P AD=0.1584P
+ PS=0.675U PD=1.6U
M$2072 \$3766 \$133 VDD VDD pfet_03v3 L=0.28U W=0.72U AS=0.3168P AD=0.2097P
+ PS=2.32U PD=1.38U
M$2073 VDD \$3767 \$3768 VDD pfet_03v3 L=0.28U W=0.36U AS=0.1584P AD=0.1764P
+ PS=1.6U PD=1.26U
M$2074 \$3769 \$3767 VDD VDD pfet_03v3 L=0.28U W=0.72U AS=0.1764P AD=0.36P
+ PS=1.26U PD=2.44U
M$2075 \$3770 RB4 VDD VDD pfet_03v3 L=0.28U W=0.72U AS=0.3312P AD=0.3888P
+ PS=2.36U PD=2.52U
M$2076 \$3769 \$3770 \$69 VDD pfet_03v3 L=0.28U W=0.36U AS=0.1584P AD=0.1152P
+ PS=1.6U PD=1U
M$2077 \$70 \$3771 \$3769 VDD pfet_03v3 L=0.28U W=0.36U AS=0.1152P AD=0.1584P
+ PS=1U PD=1.6U
M$2078 VDD RA4 \$3771 VDD pfet_03v3 L=0.28U W=0.72U AS=0.3708P AD=0.3168P
+ PS=2.47U PD=2.32U
M$2079 \$3773 \$3709 \$3772 VDD pfet_03v3 L=0.28U W=0.36U AS=0.2097P AD=0.1278P
+ PS=1.38U PD=1.07U
M$2080 \$3888 \$3774 \$3773 VDD pfet_03v3 L=0.28U W=0.36U AS=0.1278P AD=0.0567P
+ PS=1.07U PD=0.675U
M$2081 VDD \$3708 \$3888 VDD pfet_03v3 L=0.28U W=0.36U AS=0.0567P AD=0.1584P
+ PS=0.675U PD=1.6U
M$2082 \$3772 \$136 VDD VDD pfet_03v3 L=0.28U W=0.72U AS=0.3168P AD=0.2097P
+ PS=2.32U PD=1.38U
M$2083 VDD \$3773 \$3774 VDD pfet_03v3 L=0.28U W=0.36U AS=0.1584P AD=0.1764P
+ PS=1.6U PD=1.26U
M$2084 \$3775 \$3773 VDD VDD pfet_03v3 L=0.28U W=0.72U AS=0.1764P AD=0.36P
+ PS=1.26U PD=2.44U
M$2085 \$3776 RB4 VDD VDD pfet_03v3 L=0.28U W=0.72U AS=0.3312P AD=0.3888P
+ PS=2.36U PD=2.52U
M$2086 \$3775 \$3776 \$71 VDD pfet_03v3 L=0.28U W=0.36U AS=0.1584P AD=0.1152P
+ PS=1.6U PD=1U
M$2087 \$72 \$3777 \$3775 VDD pfet_03v3 L=0.28U W=0.36U AS=0.1152P AD=0.1584P
+ PS=1U PD=1.6U
M$2088 VDD RA4 \$3777 VDD pfet_03v3 L=0.28U W=0.72U AS=0.3708P AD=0.3168P
+ PS=2.47U PD=2.32U
M$2089 \$3779 \$3709 \$3778 VDD pfet_03v3 L=0.28U W=0.36U AS=0.2097P AD=0.1278P
+ PS=1.38U PD=1.07U
M$2090 \$3896 \$3780 \$3779 VDD pfet_03v3 L=0.28U W=0.36U AS=0.1278P AD=0.0567P
+ PS=1.07U PD=0.675U
M$2091 VDD \$3708 \$3896 VDD pfet_03v3 L=0.28U W=0.36U AS=0.0567P AD=0.1584P
+ PS=0.675U PD=1.6U
M$2092 \$3778 \$139 VDD VDD pfet_03v3 L=0.28U W=0.72U AS=0.3168P AD=0.2097P
+ PS=2.32U PD=1.38U
M$2093 VDD \$3779 \$3780 VDD pfet_03v3 L=0.28U W=0.36U AS=0.1584P AD=0.1764P
+ PS=1.6U PD=1.26U
M$2094 \$3781 \$3779 VDD VDD pfet_03v3 L=0.28U W=0.72U AS=0.1764P AD=0.36P
+ PS=1.26U PD=2.44U
M$2095 \$3782 RB4 VDD VDD pfet_03v3 L=0.28U W=0.72U AS=0.3312P AD=0.3888P
+ PS=2.36U PD=2.52U
M$2096 \$3781 \$3782 \$73 VDD pfet_03v3 L=0.28U W=0.36U AS=0.1584P AD=0.1152P
+ PS=1.6U PD=1U
M$2097 \$74 \$3783 \$3781 VDD pfet_03v3 L=0.28U W=0.36U AS=0.1152P AD=0.1584P
+ PS=1U PD=1.6U
M$2098 VDD RA4 \$3783 VDD pfet_03v3 L=0.28U W=0.72U AS=0.3708P AD=0.3168P
+ PS=2.47U PD=2.32U
M$2099 \$3785 \$3709 \$3784 VDD pfet_03v3 L=0.28U W=0.36U AS=0.2097P AD=0.1278P
+ PS=1.38U PD=1.07U
M$2100 \$3903 \$3786 \$3785 VDD pfet_03v3 L=0.28U W=0.36U AS=0.1278P AD=0.0567P
+ PS=1.07U PD=0.675U
M$2101 VDD \$3708 \$3903 VDD pfet_03v3 L=0.28U W=0.36U AS=0.0567P AD=0.1584P
+ PS=0.675U PD=1.6U
M$2102 \$3784 \$142 VDD VDD pfet_03v3 L=0.28U W=0.72U AS=0.3168P AD=0.2097P
+ PS=2.32U PD=1.38U
M$2103 VDD \$3785 \$3786 VDD pfet_03v3 L=0.28U W=0.36U AS=0.1584P AD=0.1764P
+ PS=1.6U PD=1.26U
M$2104 \$3787 \$3785 VDD VDD pfet_03v3 L=0.28U W=0.72U AS=0.1764P AD=0.36P
+ PS=1.26U PD=2.44U
M$2105 \$3788 RB4 VDD VDD pfet_03v3 L=0.28U W=0.72U AS=0.3312P AD=0.3888P
+ PS=2.36U PD=2.52U
M$2106 \$3787 \$3788 \$75 VDD pfet_03v3 L=0.28U W=0.36U AS=0.1584P AD=0.1152P
+ PS=1.6U PD=1U
M$2107 \$76 \$3789 \$3787 VDD pfet_03v3 L=0.28U W=0.36U AS=0.1152P AD=0.1584P
+ PS=1U PD=1.6U
M$2108 VDD RA4 \$3789 VDD pfet_03v3 L=0.28U W=0.72U AS=0.3708P AD=0.3168P
+ PS=2.47U PD=2.32U
M$2109 \$3791 \$3709 \$3790 VDD pfet_03v3 L=0.28U W=0.36U AS=0.2097P AD=0.1278P
+ PS=1.38U PD=1.07U
M$2110 \$3902 \$3792 \$3791 VDD pfet_03v3 L=0.28U W=0.36U AS=0.1278P AD=0.0567P
+ PS=1.07U PD=0.675U
M$2111 VDD \$3708 \$3902 VDD pfet_03v3 L=0.28U W=0.36U AS=0.0567P AD=0.1584P
+ PS=0.675U PD=1.6U
M$2112 \$3790 \$145 VDD VDD pfet_03v3 L=0.28U W=0.72U AS=0.3168P AD=0.2097P
+ PS=2.32U PD=1.38U
M$2113 VDD \$3791 \$3792 VDD pfet_03v3 L=0.28U W=0.36U AS=0.1584P AD=0.1764P
+ PS=1.6U PD=1.26U
M$2114 \$3793 \$3791 VDD VDD pfet_03v3 L=0.28U W=0.72U AS=0.1764P AD=0.36P
+ PS=1.26U PD=2.44U
M$2115 \$3794 RB4 VDD VDD pfet_03v3 L=0.28U W=0.72U AS=0.3312P AD=0.3888P
+ PS=2.36U PD=2.52U
M$2116 \$3793 \$3794 \$77 VDD pfet_03v3 L=0.28U W=0.36U AS=0.1584P AD=0.1152P
+ PS=1.6U PD=1U
M$2117 \$78 \$3795 \$3793 VDD pfet_03v3 L=0.28U W=0.36U AS=0.1152P AD=0.1584P
+ PS=1U PD=1.6U
M$2118 VDD RA4 \$3795 VDD pfet_03v3 L=0.28U W=0.72U AS=0.3708P AD=0.3168P
+ PS=2.47U PD=2.32U
M$2119 \$3797 \$3709 \$3796 VDD pfet_03v3 L=0.28U W=0.36U AS=0.2097P AD=0.1278P
+ PS=1.38U PD=1.07U
M$2120 \$3869 \$3798 \$3797 VDD pfet_03v3 L=0.28U W=0.36U AS=0.1278P AD=0.0567P
+ PS=1.07U PD=0.675U
M$2121 VDD \$3708 \$3869 VDD pfet_03v3 L=0.28U W=0.36U AS=0.0567P AD=0.1584P
+ PS=0.675U PD=1.6U
M$2122 \$3796 \$148 VDD VDD pfet_03v3 L=0.28U W=0.72U AS=0.3168P AD=0.2097P
+ PS=2.32U PD=1.38U
M$2123 VDD \$3797 \$3798 VDD pfet_03v3 L=0.28U W=0.36U AS=0.1584P AD=0.1764P
+ PS=1.6U PD=1.26U
M$2124 \$3799 \$3797 VDD VDD pfet_03v3 L=0.28U W=0.72U AS=0.1764P AD=0.36P
+ PS=1.26U PD=2.44U
M$2125 \$3800 RB4 VDD VDD pfet_03v3 L=0.28U W=0.72U AS=0.3312P AD=0.3888P
+ PS=2.36U PD=2.52U
M$2126 \$3799 \$3800 \$79 VDD pfet_03v3 L=0.28U W=0.36U AS=0.1584P AD=0.1152P
+ PS=1.6U PD=1U
M$2127 \$80 \$3801 \$3799 VDD pfet_03v3 L=0.28U W=0.36U AS=0.1152P AD=0.1584P
+ PS=1U PD=1.6U
M$2128 VDD RA4 \$3801 VDD pfet_03v3 L=0.28U W=0.72U AS=0.3708P AD=0.3168P
+ PS=2.47U PD=2.32U
M$2129 \$3803 \$3709 \$3802 VDD pfet_03v3 L=0.28U W=0.36U AS=0.2097P AD=0.1278P
+ PS=1.38U PD=1.07U
M$2130 \$3837 \$3804 \$3803 VDD pfet_03v3 L=0.28U W=0.36U AS=0.1278P AD=0.0567P
+ PS=1.07U PD=0.675U
M$2131 VDD \$3708 \$3837 VDD pfet_03v3 L=0.28U W=0.36U AS=0.0567P AD=0.1584P
+ PS=0.675U PD=1.6U
M$2132 \$3802 \$151 VDD VDD pfet_03v3 L=0.28U W=0.72U AS=0.3168P AD=0.2097P
+ PS=2.32U PD=1.38U
M$2133 VDD \$3803 \$3804 VDD pfet_03v3 L=0.28U W=0.36U AS=0.1584P AD=0.1764P
+ PS=1.6U PD=1.26U
M$2134 \$3805 \$3803 VDD VDD pfet_03v3 L=0.28U W=0.72U AS=0.1764P AD=0.36P
+ PS=1.26U PD=2.44U
M$2135 \$3806 RB4 VDD VDD pfet_03v3 L=0.28U W=0.72U AS=0.3312P AD=0.3888P
+ PS=2.36U PD=2.52U
M$2136 \$3805 \$3806 \$81 VDD pfet_03v3 L=0.28U W=0.36U AS=0.1584P AD=0.1152P
+ PS=1.6U PD=1U
M$2137 \$82 \$3807 \$3805 VDD pfet_03v3 L=0.28U W=0.36U AS=0.1152P AD=0.1584P
+ PS=1U PD=1.6U
M$2138 VDD RA4 \$3807 VDD pfet_03v3 L=0.28U W=0.72U AS=0.3708P AD=0.3168P
+ PS=2.47U PD=2.32U
M$2139 \$4009 WE3 VDD VDD pfet_03v3 L=0.28U W=0.72U AS=0.3168P AD=0.1872P
+ PS=2.32U PD=1.24U
M$2140 VDD CLK \$4009 VDD pfet_03v3 L=0.28U W=0.72U AS=0.1872P AD=0.3168P
+ PS=1.24U PD=2.32U
M$2141 \$4010 \$4009 VDD VDD pfet_03v3 L=0.28U W=1.27U AS=0.5588P AD=0.3302P
+ PS=3.42U PD=1.79U
M$2142 \$4010 \$4009 VDD VDD pfet_03v3 L=0.28U W=1.27U AS=0.3386P AD=0.3302P
+ PS=1.86U PD=1.79U
M$2143 \$4011 \$4010 VDD VDD pfet_03v3 L=0.28U W=1.34U AS=0.3386P AD=0.3886P
+ PS=1.86U PD=1.92U
M$2144 VDD \$4010 \$4011 VDD pfet_03v3 L=0.28U W=1.34U AS=0.3886P AD=0.5896P
+ PS=1.92U PD=3.56U
M$2145 \$4012 \$106 VDD VDD pfet_03v3 L=0.28U W=0.72U AS=0.3168P AD=0.2097P
+ PS=2.32U PD=1.38U
M$2146 \$4013 \$4011 \$4012 VDD pfet_03v3 L=0.28U W=0.36U AS=0.2097P AD=0.1278P
+ PS=1.38U PD=1.07U
M$2147 \$4219 \$4014 \$4013 VDD pfet_03v3 L=0.28U W=0.36U AS=0.1278P AD=0.0567P
+ PS=1.07U PD=0.675U
M$2148 VDD \$4010 \$4219 VDD pfet_03v3 L=0.28U W=0.36U AS=0.0567P AD=0.1584P
+ PS=0.675U PD=1.6U
M$2149 \$4014 \$4013 VDD VDD pfet_03v3 L=0.28U W=0.36U AS=0.1764P AD=0.1584P
+ PS=1.26U PD=1.6U
M$2150 \$4015 \$4013 VDD VDD pfet_03v3 L=0.28U W=0.72U AS=0.1764P AD=0.36P
+ PS=1.26U PD=2.44U
M$2151 \$4126 RA3 VDD VDD pfet_03v3 L=0.28U W=0.72U AS=0.3312P AD=0.3888P
+ PS=2.36U PD=2.52U
M$2152 \$4015 \$4126 \$51 VDD pfet_03v3 L=0.28U W=0.36U AS=0.1584P AD=0.1152P
+ PS=1.6U PD=1U
M$2153 \$52 \$4127 \$4015 VDD pfet_03v3 L=0.28U W=0.36U AS=0.1152P AD=0.1584P
+ PS=1U PD=1.6U
M$2154 VDD RB3 \$4127 VDD pfet_03v3 L=0.28U W=0.72U AS=0.3708P AD=0.3168P
+ PS=2.47U PD=2.32U
M$2155 \$4016 \$109 VDD VDD pfet_03v3 L=0.28U W=0.72U AS=0.3168P AD=0.2097P
+ PS=2.32U PD=1.38U
M$2156 \$4017 \$4011 \$4016 VDD pfet_03v3 L=0.28U W=0.36U AS=0.2097P AD=0.1278P
+ PS=1.38U PD=1.07U
M$2157 \$4229 \$4018 \$4017 VDD pfet_03v3 L=0.28U W=0.36U AS=0.1278P AD=0.0567P
+ PS=1.07U PD=0.675U
M$2158 VDD \$4010 \$4229 VDD pfet_03v3 L=0.28U W=0.36U AS=0.0567P AD=0.1584P
+ PS=0.675U PD=1.6U
M$2159 \$4018 \$4017 VDD VDD pfet_03v3 L=0.28U W=0.36U AS=0.1764P AD=0.1584P
+ PS=1.26U PD=1.6U
M$2160 \$4019 \$4017 VDD VDD pfet_03v3 L=0.28U W=0.72U AS=0.1764P AD=0.36P
+ PS=1.26U PD=2.44U
M$2161 \$4128 RA3 VDD VDD pfet_03v3 L=0.28U W=0.72U AS=0.3312P AD=0.3888P
+ PS=2.36U PD=2.52U
M$2162 \$4019 \$4128 \$53 VDD pfet_03v3 L=0.28U W=0.36U AS=0.1584P AD=0.1152P
+ PS=1.6U PD=1U
M$2163 \$54 \$4129 \$4019 VDD pfet_03v3 L=0.28U W=0.36U AS=0.1152P AD=0.1584P
+ PS=1U PD=1.6U
M$2164 VDD RB3 \$4129 VDD pfet_03v3 L=0.28U W=0.72U AS=0.3708P AD=0.3168P
+ PS=2.47U PD=2.32U
M$2165 \$4020 \$112 VDD VDD pfet_03v3 L=0.28U W=0.72U AS=0.3168P AD=0.2097P
+ PS=2.32U PD=1.38U
M$2166 \$4021 \$4011 \$4020 VDD pfet_03v3 L=0.28U W=0.36U AS=0.2097P AD=0.1278P
+ PS=1.38U PD=1.07U
M$2167 \$4235 \$4022 \$4021 VDD pfet_03v3 L=0.28U W=0.36U AS=0.1278P AD=0.0567P
+ PS=1.07U PD=0.675U
M$2168 VDD \$4010 \$4235 VDD pfet_03v3 L=0.28U W=0.36U AS=0.0567P AD=0.1584P
+ PS=0.675U PD=1.6U
M$2169 \$4022 \$4021 VDD VDD pfet_03v3 L=0.28U W=0.36U AS=0.1764P AD=0.1584P
+ PS=1.26U PD=1.6U
M$2170 \$4023 \$4021 VDD VDD pfet_03v3 L=0.28U W=0.72U AS=0.1764P AD=0.36P
+ PS=1.26U PD=2.44U
M$2171 \$4130 RA3 VDD VDD pfet_03v3 L=0.28U W=0.72U AS=0.3312P AD=0.3888P
+ PS=2.36U PD=2.52U
M$2172 \$4023 \$4130 \$55 VDD pfet_03v3 L=0.28U W=0.36U AS=0.1584P AD=0.1152P
+ PS=1.6U PD=1U
M$2173 \$56 \$4131 \$4023 VDD pfet_03v3 L=0.28U W=0.36U AS=0.1152P AD=0.1584P
+ PS=1U PD=1.6U
M$2174 VDD RB3 \$4131 VDD pfet_03v3 L=0.28U W=0.72U AS=0.3708P AD=0.3168P
+ PS=2.47U PD=2.32U
M$2175 \$4024 \$115 VDD VDD pfet_03v3 L=0.28U W=0.72U AS=0.3168P AD=0.2097P
+ PS=2.32U PD=1.38U
M$2176 \$4025 \$4011 \$4024 VDD pfet_03v3 L=0.28U W=0.36U AS=0.2097P AD=0.1278P
+ PS=1.38U PD=1.07U
M$2177 \$4244 \$4026 \$4025 VDD pfet_03v3 L=0.28U W=0.36U AS=0.1278P AD=0.0567P
+ PS=1.07U PD=0.675U
M$2178 VDD \$4010 \$4244 VDD pfet_03v3 L=0.28U W=0.36U AS=0.0567P AD=0.1584P
+ PS=0.675U PD=1.6U
M$2179 \$4026 \$4025 VDD VDD pfet_03v3 L=0.28U W=0.36U AS=0.1764P AD=0.1584P
+ PS=1.26U PD=1.6U
M$2180 \$4027 \$4025 VDD VDD pfet_03v3 L=0.28U W=0.72U AS=0.1764P AD=0.36P
+ PS=1.26U PD=2.44U
M$2181 \$4132 RA3 VDD VDD pfet_03v3 L=0.28U W=0.72U AS=0.3312P AD=0.3888P
+ PS=2.36U PD=2.52U
M$2182 \$4027 \$4132 \$57 VDD pfet_03v3 L=0.28U W=0.36U AS=0.1584P AD=0.1152P
+ PS=1.6U PD=1U
M$2183 \$58 \$4133 \$4027 VDD pfet_03v3 L=0.28U W=0.36U AS=0.1152P AD=0.1584P
+ PS=1U PD=1.6U
M$2184 VDD RB3 \$4133 VDD pfet_03v3 L=0.28U W=0.72U AS=0.3708P AD=0.3168P
+ PS=2.47U PD=2.32U
M$2185 \$4028 \$118 VDD VDD pfet_03v3 L=0.28U W=0.72U AS=0.3168P AD=0.2097P
+ PS=2.32U PD=1.38U
M$2186 \$4029 \$4011 \$4028 VDD pfet_03v3 L=0.28U W=0.36U AS=0.2097P AD=0.1278P
+ PS=1.38U PD=1.07U
M$2187 \$4254 \$4030 \$4029 VDD pfet_03v3 L=0.28U W=0.36U AS=0.1278P AD=0.0567P
+ PS=1.07U PD=0.675U
M$2188 VDD \$4010 \$4254 VDD pfet_03v3 L=0.28U W=0.36U AS=0.0567P AD=0.1584P
+ PS=0.675U PD=1.6U
M$2189 \$4030 \$4029 VDD VDD pfet_03v3 L=0.28U W=0.36U AS=0.1764P AD=0.1584P
+ PS=1.26U PD=1.6U
M$2190 \$4031 \$4029 VDD VDD pfet_03v3 L=0.28U W=0.72U AS=0.1764P AD=0.36P
+ PS=1.26U PD=2.44U
M$2191 \$4134 RA3 VDD VDD pfet_03v3 L=0.28U W=0.72U AS=0.3312P AD=0.3888P
+ PS=2.36U PD=2.52U
M$2192 \$4031 \$4134 \$59 VDD pfet_03v3 L=0.28U W=0.36U AS=0.1584P AD=0.1152P
+ PS=1.6U PD=1U
M$2193 \$60 \$4135 \$4031 VDD pfet_03v3 L=0.28U W=0.36U AS=0.1152P AD=0.1584P
+ PS=1U PD=1.6U
M$2194 VDD RB3 \$4135 VDD pfet_03v3 L=0.28U W=0.72U AS=0.3708P AD=0.3168P
+ PS=2.47U PD=2.32U
M$2195 \$4032 \$121 VDD VDD pfet_03v3 L=0.28U W=0.72U AS=0.3168P AD=0.2097P
+ PS=2.32U PD=1.38U
M$2196 \$4033 \$4011 \$4032 VDD pfet_03v3 L=0.28U W=0.36U AS=0.2097P AD=0.1278P
+ PS=1.38U PD=1.07U
M$2197 \$4263 \$4034 \$4033 VDD pfet_03v3 L=0.28U W=0.36U AS=0.1278P AD=0.0567P
+ PS=1.07U PD=0.675U
M$2198 VDD \$4010 \$4263 VDD pfet_03v3 L=0.28U W=0.36U AS=0.0567P AD=0.1584P
+ PS=0.675U PD=1.6U
M$2199 \$4034 \$4033 VDD VDD pfet_03v3 L=0.28U W=0.36U AS=0.1764P AD=0.1584P
+ PS=1.26U PD=1.6U
M$2200 \$4035 \$4033 VDD VDD pfet_03v3 L=0.28U W=0.72U AS=0.1764P AD=0.36P
+ PS=1.26U PD=2.44U
M$2201 \$4136 RA3 VDD VDD pfet_03v3 L=0.28U W=0.72U AS=0.3312P AD=0.3888P
+ PS=2.36U PD=2.52U
M$2202 \$4035 \$4136 \$61 VDD pfet_03v3 L=0.28U W=0.36U AS=0.1584P AD=0.1152P
+ PS=1.6U PD=1U
M$2203 \$62 \$4137 \$4035 VDD pfet_03v3 L=0.28U W=0.36U AS=0.1152P AD=0.1584P
+ PS=1U PD=1.6U
M$2204 VDD RB3 \$4137 VDD pfet_03v3 L=0.28U W=0.72U AS=0.3708P AD=0.3168P
+ PS=2.47U PD=2.32U
M$2205 \$4036 \$124 VDD VDD pfet_03v3 L=0.28U W=0.72U AS=0.3168P AD=0.2097P
+ PS=2.32U PD=1.38U
M$2206 \$4037 \$4011 \$4036 VDD pfet_03v3 L=0.28U W=0.36U AS=0.2097P AD=0.1278P
+ PS=1.38U PD=1.07U
M$2207 \$4271 \$4038 \$4037 VDD pfet_03v3 L=0.28U W=0.36U AS=0.1278P AD=0.0567P
+ PS=1.07U PD=0.675U
M$2208 VDD \$4010 \$4271 VDD pfet_03v3 L=0.28U W=0.36U AS=0.0567P AD=0.1584P
+ PS=0.675U PD=1.6U
M$2209 \$4038 \$4037 VDD VDD pfet_03v3 L=0.28U W=0.36U AS=0.1764P AD=0.1584P
+ PS=1.26U PD=1.6U
M$2210 \$4039 \$4037 VDD VDD pfet_03v3 L=0.28U W=0.72U AS=0.1764P AD=0.36P
+ PS=1.26U PD=2.44U
M$2211 \$4138 RA3 VDD VDD pfet_03v3 L=0.28U W=0.72U AS=0.3312P AD=0.3888P
+ PS=2.36U PD=2.52U
M$2212 \$4039 \$4138 \$63 VDD pfet_03v3 L=0.28U W=0.36U AS=0.1584P AD=0.1152P
+ PS=1.6U PD=1U
M$2213 \$64 \$4139 \$4039 VDD pfet_03v3 L=0.28U W=0.36U AS=0.1152P AD=0.1584P
+ PS=1U PD=1.6U
M$2214 VDD RB3 \$4139 VDD pfet_03v3 L=0.28U W=0.72U AS=0.3708P AD=0.3168P
+ PS=2.47U PD=2.32U
M$2215 \$4040 \$127 VDD VDD pfet_03v3 L=0.28U W=0.72U AS=0.3168P AD=0.2097P
+ PS=2.32U PD=1.38U
M$2216 \$4041 \$4011 \$4040 VDD pfet_03v3 L=0.28U W=0.36U AS=0.2097P AD=0.1278P
+ PS=1.38U PD=1.07U
M$2217 \$4280 \$4042 \$4041 VDD pfet_03v3 L=0.28U W=0.36U AS=0.1278P AD=0.0567P
+ PS=1.07U PD=0.675U
M$2218 VDD \$4010 \$4280 VDD pfet_03v3 L=0.28U W=0.36U AS=0.0567P AD=0.1584P
+ PS=0.675U PD=1.6U
M$2219 \$4042 \$4041 VDD VDD pfet_03v3 L=0.28U W=0.36U AS=0.1764P AD=0.1584P
+ PS=1.26U PD=1.6U
M$2220 \$4043 \$4041 VDD VDD pfet_03v3 L=0.28U W=0.72U AS=0.1764P AD=0.36P
+ PS=1.26U PD=2.44U
M$2221 \$4140 RA3 VDD VDD pfet_03v3 L=0.28U W=0.72U AS=0.3312P AD=0.3888P
+ PS=2.36U PD=2.52U
M$2222 \$4043 \$4140 \$65 VDD pfet_03v3 L=0.28U W=0.36U AS=0.1584P AD=0.1152P
+ PS=1.6U PD=1U
M$2223 \$66 \$4141 \$4043 VDD pfet_03v3 L=0.28U W=0.36U AS=0.1152P AD=0.1584P
+ PS=1U PD=1.6U
M$2224 VDD RB3 \$4141 VDD pfet_03v3 L=0.28U W=0.72U AS=0.3708P AD=0.3168P
+ PS=2.47U PD=2.32U
M$2225 \$4044 \$130 VDD VDD pfet_03v3 L=0.28U W=0.72U AS=0.3168P AD=0.2097P
+ PS=2.32U PD=1.38U
M$2226 \$4045 \$4011 \$4044 VDD pfet_03v3 L=0.28U W=0.36U AS=0.2097P AD=0.1278P
+ PS=1.38U PD=1.07U
M$2227 \$4289 \$4046 \$4045 VDD pfet_03v3 L=0.28U W=0.36U AS=0.1278P AD=0.0567P
+ PS=1.07U PD=0.675U
M$2228 VDD \$4010 \$4289 VDD pfet_03v3 L=0.28U W=0.36U AS=0.0567P AD=0.1584P
+ PS=0.675U PD=1.6U
M$2229 \$4046 \$4045 VDD VDD pfet_03v3 L=0.28U W=0.36U AS=0.1764P AD=0.1584P
+ PS=1.26U PD=1.6U
M$2230 \$4047 \$4045 VDD VDD pfet_03v3 L=0.28U W=0.72U AS=0.1764P AD=0.36P
+ PS=1.26U PD=2.44U
M$2231 \$4142 RA3 VDD VDD pfet_03v3 L=0.28U W=0.72U AS=0.3312P AD=0.3888P
+ PS=2.36U PD=2.52U
M$2232 \$4047 \$4142 \$67 VDD pfet_03v3 L=0.28U W=0.36U AS=0.1584P AD=0.1152P
+ PS=1.6U PD=1U
M$2233 \$68 \$4143 \$4047 VDD pfet_03v3 L=0.28U W=0.36U AS=0.1152P AD=0.1584P
+ PS=1U PD=1.6U
M$2234 VDD RB3 \$4143 VDD pfet_03v3 L=0.28U W=0.72U AS=0.3708P AD=0.3168P
+ PS=2.47U PD=2.32U
M$2235 \$4048 \$133 VDD VDD pfet_03v3 L=0.28U W=0.72U AS=0.3168P AD=0.2097P
+ PS=2.32U PD=1.38U
M$2236 \$4049 \$4011 \$4048 VDD pfet_03v3 L=0.28U W=0.36U AS=0.2097P AD=0.1278P
+ PS=1.38U PD=1.07U
M$2237 \$4298 \$4050 \$4049 VDD pfet_03v3 L=0.28U W=0.36U AS=0.1278P AD=0.0567P
+ PS=1.07U PD=0.675U
M$2238 VDD \$4010 \$4298 VDD pfet_03v3 L=0.28U W=0.36U AS=0.0567P AD=0.1584P
+ PS=0.675U PD=1.6U
M$2239 \$4050 \$4049 VDD VDD pfet_03v3 L=0.28U W=0.36U AS=0.1764P AD=0.1584P
+ PS=1.26U PD=1.6U
M$2240 \$4051 \$4049 VDD VDD pfet_03v3 L=0.28U W=0.72U AS=0.1764P AD=0.36P
+ PS=1.26U PD=2.44U
M$2241 \$4144 RA3 VDD VDD pfet_03v3 L=0.28U W=0.72U AS=0.3312P AD=0.3888P
+ PS=2.36U PD=2.52U
M$2242 \$4051 \$4144 \$69 VDD pfet_03v3 L=0.28U W=0.36U AS=0.1584P AD=0.1152P
+ PS=1.6U PD=1U
M$2243 \$70 \$4145 \$4051 VDD pfet_03v3 L=0.28U W=0.36U AS=0.1152P AD=0.1584P
+ PS=1U PD=1.6U
M$2244 VDD RB3 \$4145 VDD pfet_03v3 L=0.28U W=0.72U AS=0.3708P AD=0.3168P
+ PS=2.47U PD=2.32U
M$2245 \$4052 \$136 VDD VDD pfet_03v3 L=0.28U W=0.72U AS=0.3168P AD=0.2097P
+ PS=2.32U PD=1.38U
M$2246 \$4053 \$4011 \$4052 VDD pfet_03v3 L=0.28U W=0.36U AS=0.2097P AD=0.1278P
+ PS=1.38U PD=1.07U
M$2247 \$4307 \$4054 \$4053 VDD pfet_03v3 L=0.28U W=0.36U AS=0.1278P AD=0.0567P
+ PS=1.07U PD=0.675U
M$2248 VDD \$4010 \$4307 VDD pfet_03v3 L=0.28U W=0.36U AS=0.0567P AD=0.1584P
+ PS=0.675U PD=1.6U
M$2249 \$4054 \$4053 VDD VDD pfet_03v3 L=0.28U W=0.36U AS=0.1764P AD=0.1584P
+ PS=1.26U PD=1.6U
M$2250 \$4055 \$4053 VDD VDD pfet_03v3 L=0.28U W=0.72U AS=0.1764P AD=0.36P
+ PS=1.26U PD=2.44U
M$2251 \$4146 RA3 VDD VDD pfet_03v3 L=0.28U W=0.72U AS=0.3312P AD=0.3888P
+ PS=2.36U PD=2.52U
M$2252 \$4055 \$4146 \$71 VDD pfet_03v3 L=0.28U W=0.36U AS=0.1584P AD=0.1152P
+ PS=1.6U PD=1U
M$2253 \$72 \$4147 \$4055 VDD pfet_03v3 L=0.28U W=0.36U AS=0.1152P AD=0.1584P
+ PS=1U PD=1.6U
M$2254 VDD RB3 \$4147 VDD pfet_03v3 L=0.28U W=0.72U AS=0.3708P AD=0.3168P
+ PS=2.47U PD=2.32U
M$2255 \$4056 \$139 VDD VDD pfet_03v3 L=0.28U W=0.72U AS=0.3168P AD=0.2097P
+ PS=2.32U PD=1.38U
M$2256 \$4057 \$4011 \$4056 VDD pfet_03v3 L=0.28U W=0.36U AS=0.2097P AD=0.1278P
+ PS=1.38U PD=1.07U
M$2257 \$4315 \$4058 \$4057 VDD pfet_03v3 L=0.28U W=0.36U AS=0.1278P AD=0.0567P
+ PS=1.07U PD=0.675U
M$2258 VDD \$4010 \$4315 VDD pfet_03v3 L=0.28U W=0.36U AS=0.0567P AD=0.1584P
+ PS=0.675U PD=1.6U
M$2259 \$4058 \$4057 VDD VDD pfet_03v3 L=0.28U W=0.36U AS=0.1764P AD=0.1584P
+ PS=1.26U PD=1.6U
M$2260 \$4059 \$4057 VDD VDD pfet_03v3 L=0.28U W=0.72U AS=0.1764P AD=0.36P
+ PS=1.26U PD=2.44U
M$2261 \$4148 RA3 VDD VDD pfet_03v3 L=0.28U W=0.72U AS=0.3312P AD=0.3888P
+ PS=2.36U PD=2.52U
M$2262 \$4059 \$4148 \$73 VDD pfet_03v3 L=0.28U W=0.36U AS=0.1584P AD=0.1152P
+ PS=1.6U PD=1U
M$2263 \$74 \$4149 \$4059 VDD pfet_03v3 L=0.28U W=0.36U AS=0.1152P AD=0.1584P
+ PS=1U PD=1.6U
M$2264 VDD RB3 \$4149 VDD pfet_03v3 L=0.28U W=0.72U AS=0.3708P AD=0.3168P
+ PS=2.47U PD=2.32U
M$2265 \$4060 \$142 VDD VDD pfet_03v3 L=0.28U W=0.72U AS=0.3168P AD=0.2097P
+ PS=2.32U PD=1.38U
M$2266 \$4061 \$4011 \$4060 VDD pfet_03v3 L=0.28U W=0.36U AS=0.2097P AD=0.1278P
+ PS=1.38U PD=1.07U
M$2267 \$4301 \$4062 \$4061 VDD pfet_03v3 L=0.28U W=0.36U AS=0.1278P AD=0.0567P
+ PS=1.07U PD=0.675U
M$2268 VDD \$4010 \$4301 VDD pfet_03v3 L=0.28U W=0.36U AS=0.0567P AD=0.1584P
+ PS=0.675U PD=1.6U
M$2269 \$4062 \$4061 VDD VDD pfet_03v3 L=0.28U W=0.36U AS=0.1764P AD=0.1584P
+ PS=1.26U PD=1.6U
M$2270 \$4063 \$4061 VDD VDD pfet_03v3 L=0.28U W=0.72U AS=0.1764P AD=0.36P
+ PS=1.26U PD=2.44U
M$2271 \$4150 RA3 VDD VDD pfet_03v3 L=0.28U W=0.72U AS=0.3312P AD=0.3888P
+ PS=2.36U PD=2.52U
M$2272 \$4063 \$4150 \$75 VDD pfet_03v3 L=0.28U W=0.36U AS=0.1584P AD=0.1152P
+ PS=1.6U PD=1U
M$2273 \$76 \$4151 \$4063 VDD pfet_03v3 L=0.28U W=0.36U AS=0.1152P AD=0.1584P
+ PS=1U PD=1.6U
M$2274 VDD RB3 \$4151 VDD pfet_03v3 L=0.28U W=0.72U AS=0.3708P AD=0.3168P
+ PS=2.47U PD=2.32U
M$2275 \$4064 \$145 VDD VDD pfet_03v3 L=0.28U W=0.72U AS=0.3168P AD=0.2097P
+ PS=2.32U PD=1.38U
M$2276 \$4065 \$4011 \$4064 VDD pfet_03v3 L=0.28U W=0.36U AS=0.2097P AD=0.1278P
+ PS=1.38U PD=1.07U
M$2277 \$4273 \$4066 \$4065 VDD pfet_03v3 L=0.28U W=0.36U AS=0.1278P AD=0.0567P
+ PS=1.07U PD=0.675U
M$2278 VDD \$4010 \$4273 VDD pfet_03v3 L=0.28U W=0.36U AS=0.0567P AD=0.1584P
+ PS=0.675U PD=1.6U
M$2279 \$4066 \$4065 VDD VDD pfet_03v3 L=0.28U W=0.36U AS=0.1764P AD=0.1584P
+ PS=1.26U PD=1.6U
M$2280 \$4067 \$4065 VDD VDD pfet_03v3 L=0.28U W=0.72U AS=0.1764P AD=0.36P
+ PS=1.26U PD=2.44U
M$2281 \$4152 RA3 VDD VDD pfet_03v3 L=0.28U W=0.72U AS=0.3312P AD=0.3888P
+ PS=2.36U PD=2.52U
M$2282 \$4067 \$4152 \$77 VDD pfet_03v3 L=0.28U W=0.36U AS=0.1584P AD=0.1152P
+ PS=1.6U PD=1U
M$2283 \$78 \$4153 \$4067 VDD pfet_03v3 L=0.28U W=0.36U AS=0.1152P AD=0.1584P
+ PS=1U PD=1.6U
M$2284 VDD RB3 \$4153 VDD pfet_03v3 L=0.28U W=0.72U AS=0.3708P AD=0.3168P
+ PS=2.47U PD=2.32U
M$2285 \$4068 \$148 VDD VDD pfet_03v3 L=0.28U W=0.72U AS=0.3168P AD=0.2097P
+ PS=2.32U PD=1.38U
M$2286 \$4069 \$4011 \$4068 VDD pfet_03v3 L=0.28U W=0.36U AS=0.2097P AD=0.1278P
+ PS=1.38U PD=1.07U
M$2287 \$4255 \$4070 \$4069 VDD pfet_03v3 L=0.28U W=0.36U AS=0.1278P AD=0.0567P
+ PS=1.07U PD=0.675U
M$2288 VDD \$4010 \$4255 VDD pfet_03v3 L=0.28U W=0.36U AS=0.0567P AD=0.1584P
+ PS=0.675U PD=1.6U
M$2289 \$4070 \$4069 VDD VDD pfet_03v3 L=0.28U W=0.36U AS=0.1764P AD=0.1584P
+ PS=1.26U PD=1.6U
M$2290 \$4071 \$4069 VDD VDD pfet_03v3 L=0.28U W=0.72U AS=0.1764P AD=0.36P
+ PS=1.26U PD=2.44U
M$2291 \$4154 RA3 VDD VDD pfet_03v3 L=0.28U W=0.72U AS=0.3312P AD=0.3888P
+ PS=2.36U PD=2.52U
M$2292 \$4071 \$4154 \$79 VDD pfet_03v3 L=0.28U W=0.36U AS=0.1584P AD=0.1152P
+ PS=1.6U PD=1U
M$2293 \$80 \$4155 \$4071 VDD pfet_03v3 L=0.28U W=0.36U AS=0.1152P AD=0.1584P
+ PS=1U PD=1.6U
M$2294 VDD RB3 \$4155 VDD pfet_03v3 L=0.28U W=0.72U AS=0.3708P AD=0.3168P
+ PS=2.47U PD=2.32U
M$2295 \$4072 \$151 VDD VDD pfet_03v3 L=0.28U W=0.72U AS=0.3168P AD=0.2097P
+ PS=2.32U PD=1.38U
M$2296 \$4073 \$4011 \$4072 VDD pfet_03v3 L=0.28U W=0.36U AS=0.2097P AD=0.1278P
+ PS=1.38U PD=1.07U
M$2297 \$4227 \$4074 \$4073 VDD pfet_03v3 L=0.28U W=0.36U AS=0.1278P AD=0.0567P
+ PS=1.07U PD=0.675U
M$2298 VDD \$4010 \$4227 VDD pfet_03v3 L=0.28U W=0.36U AS=0.0567P AD=0.1584P
+ PS=0.675U PD=1.6U
M$2299 \$4074 \$4073 VDD VDD pfet_03v3 L=0.28U W=0.36U AS=0.1764P AD=0.1584P
+ PS=1.26U PD=1.6U
M$2300 \$4075 \$4073 VDD VDD pfet_03v3 L=0.28U W=0.72U AS=0.1764P AD=0.36P
+ PS=1.26U PD=2.44U
M$2301 \$4156 RA3 VDD VDD pfet_03v3 L=0.28U W=0.72U AS=0.3312P AD=0.3888P
+ PS=2.36U PD=2.52U
M$2302 \$4075 \$4156 \$81 VDD pfet_03v3 L=0.28U W=0.36U AS=0.1584P AD=0.1152P
+ PS=1.6U PD=1U
M$2303 \$82 \$4157 \$4075 VDD pfet_03v3 L=0.28U W=0.36U AS=0.1152P AD=0.1584P
+ PS=1U PD=1.6U
M$2304 VDD RB3 \$4157 VDD pfet_03v3 L=0.28U W=0.72U AS=0.3708P AD=0.3168P
+ PS=2.47U PD=2.32U
M$2305 \$4319 WE2 VDD VDD pfet_03v3 L=0.28U W=0.72U AS=0.3168P AD=0.1872P
+ PS=2.32U PD=1.24U
M$2306 VDD CLK \$4319 VDD pfet_03v3 L=0.28U W=0.72U AS=0.1872P AD=0.3168P
+ PS=1.24U PD=2.32U
M$2307 \$4321 \$4319 VDD VDD pfet_03v3 L=0.28U W=1.27U AS=0.5588P AD=0.3302P
+ PS=3.42U PD=1.79U
M$2308 VDD \$4319 \$4321 VDD pfet_03v3 L=0.28U W=1.27U AS=0.3302P AD=0.3386P
+ PS=1.79U PD=1.86U
M$2309 \$4322 \$4321 VDD VDD pfet_03v3 L=0.28U W=1.34U AS=0.3386P AD=0.3886P
+ PS=1.86U PD=1.92U
M$2310 VDD \$4321 \$4322 VDD pfet_03v3 L=0.28U W=1.34U AS=0.3886P AD=0.5896P
+ PS=1.92U PD=3.56U
M$2311 \$4326 \$4322 \$4325 VDD pfet_03v3 L=0.28U W=0.36U AS=0.2097P AD=0.1278P
+ PS=1.38U PD=1.07U
M$2312 \$4426 \$4327 \$4326 VDD pfet_03v3 L=0.28U W=0.36U AS=0.1278P AD=0.0567P
+ PS=1.07U PD=0.675U
M$2313 VDD \$4321 \$4426 VDD pfet_03v3 L=0.28U W=0.36U AS=0.0567P AD=0.1584P
+ PS=0.675U PD=1.6U
M$2314 \$4325 \$106 VDD VDD pfet_03v3 L=0.28U W=0.72U AS=0.3168P AD=0.2097P
+ PS=2.32U PD=1.38U
M$2315 VDD \$4326 \$4327 VDD pfet_03v3 L=0.28U W=0.36U AS=0.1584P AD=0.1764P
+ PS=1.6U PD=1.26U
M$2316 \$4328 \$4326 VDD VDD pfet_03v3 L=0.28U W=0.72U AS=0.1764P AD=0.36P
+ PS=1.26U PD=2.44U
M$2317 \$4329 RB2 VDD VDD pfet_03v3 L=0.28U W=0.72U AS=0.3312P AD=0.3888P
+ PS=2.36U PD=2.52U
M$2318 \$4328 \$4329 \$51 VDD pfet_03v3 L=0.28U W=0.36U AS=0.1584P AD=0.1152P
+ PS=1.6U PD=1U
M$2319 \$52 \$4330 \$4328 VDD pfet_03v3 L=0.28U W=0.36U AS=0.1152P AD=0.1584P
+ PS=1U PD=1.6U
M$2320 VDD RA2 \$4330 VDD pfet_03v3 L=0.28U W=0.72U AS=0.3708P AD=0.3168P
+ PS=2.47U PD=2.32U
M$2321 \$4332 \$4322 \$4331 VDD pfet_03v3 L=0.28U W=0.36U AS=0.2097P AD=0.1278P
+ PS=1.38U PD=1.07U
M$2322 \$4434 \$4333 \$4332 VDD pfet_03v3 L=0.28U W=0.36U AS=0.1278P AD=0.0567P
+ PS=1.07U PD=0.675U
M$2323 VDD \$4321 \$4434 VDD pfet_03v3 L=0.28U W=0.36U AS=0.0567P AD=0.1584P
+ PS=0.675U PD=1.6U
M$2324 \$4331 \$109 VDD VDD pfet_03v3 L=0.28U W=0.72U AS=0.3168P AD=0.2097P
+ PS=2.32U PD=1.38U
M$2325 VDD \$4332 \$4333 VDD pfet_03v3 L=0.28U W=0.36U AS=0.1584P AD=0.1764P
+ PS=1.6U PD=1.26U
M$2326 \$4334 \$4332 VDD VDD pfet_03v3 L=0.28U W=0.72U AS=0.1764P AD=0.36P
+ PS=1.26U PD=2.44U
M$2327 \$4335 RB2 VDD VDD pfet_03v3 L=0.28U W=0.72U AS=0.3312P AD=0.3888P
+ PS=2.36U PD=2.52U
M$2328 \$4334 \$4335 \$53 VDD pfet_03v3 L=0.28U W=0.36U AS=0.1584P AD=0.1152P
+ PS=1.6U PD=1U
M$2329 \$54 \$4336 \$4334 VDD pfet_03v3 L=0.28U W=0.36U AS=0.1152P AD=0.1584P
+ PS=1U PD=1.6U
M$2330 VDD RA2 \$4336 VDD pfet_03v3 L=0.28U W=0.72U AS=0.3708P AD=0.3168P
+ PS=2.47U PD=2.32U
M$2331 \$4338 \$4322 \$4337 VDD pfet_03v3 L=0.28U W=0.36U AS=0.2097P AD=0.1278P
+ PS=1.38U PD=1.07U
M$2332 \$4441 \$4339 \$4338 VDD pfet_03v3 L=0.28U W=0.36U AS=0.1278P AD=0.0567P
+ PS=1.07U PD=0.675U
M$2333 VDD \$4321 \$4441 VDD pfet_03v3 L=0.28U W=0.36U AS=0.0567P AD=0.1584P
+ PS=0.675U PD=1.6U
M$2334 \$4337 \$112 VDD VDD pfet_03v3 L=0.28U W=0.72U AS=0.3168P AD=0.2097P
+ PS=2.32U PD=1.38U
M$2335 VDD \$4338 \$4339 VDD pfet_03v3 L=0.28U W=0.36U AS=0.1584P AD=0.1764P
+ PS=1.6U PD=1.26U
M$2336 \$4340 \$4338 VDD VDD pfet_03v3 L=0.28U W=0.72U AS=0.1764P AD=0.36P
+ PS=1.26U PD=2.44U
M$2337 \$4341 RB2 VDD VDD pfet_03v3 L=0.28U W=0.72U AS=0.3312P AD=0.3888P
+ PS=2.36U PD=2.52U
M$2338 \$4340 \$4341 \$55 VDD pfet_03v3 L=0.28U W=0.36U AS=0.1584P AD=0.1152P
+ PS=1.6U PD=1U
M$2339 \$56 \$4342 \$4340 VDD pfet_03v3 L=0.28U W=0.36U AS=0.1152P AD=0.1584P
+ PS=1U PD=1.6U
M$2340 VDD RA2 \$4342 VDD pfet_03v3 L=0.28U W=0.72U AS=0.3708P AD=0.3168P
+ PS=2.47U PD=2.32U
M$2341 \$4344 \$4322 \$4343 VDD pfet_03v3 L=0.28U W=0.36U AS=0.2097P AD=0.1278P
+ PS=1.38U PD=1.07U
M$2342 \$4449 \$4345 \$4344 VDD pfet_03v3 L=0.28U W=0.36U AS=0.1278P AD=0.0567P
+ PS=1.07U PD=0.675U
M$2343 VDD \$4321 \$4449 VDD pfet_03v3 L=0.28U W=0.36U AS=0.0567P AD=0.1584P
+ PS=0.675U PD=1.6U
M$2344 \$4343 \$115 VDD VDD pfet_03v3 L=0.28U W=0.72U AS=0.3168P AD=0.2097P
+ PS=2.32U PD=1.38U
M$2345 VDD \$4344 \$4345 VDD pfet_03v3 L=0.28U W=0.36U AS=0.1584P AD=0.1764P
+ PS=1.6U PD=1.26U
M$2346 \$4346 \$4344 VDD VDD pfet_03v3 L=0.28U W=0.72U AS=0.1764P AD=0.36P
+ PS=1.26U PD=2.44U
M$2347 \$4347 RB2 VDD VDD pfet_03v3 L=0.28U W=0.72U AS=0.3312P AD=0.3888P
+ PS=2.36U PD=2.52U
M$2348 \$4346 \$4347 \$57 VDD pfet_03v3 L=0.28U W=0.36U AS=0.1584P AD=0.1152P
+ PS=1.6U PD=1U
M$2349 \$58 \$4348 \$4346 VDD pfet_03v3 L=0.28U W=0.36U AS=0.1152P AD=0.1584P
+ PS=1U PD=1.6U
M$2350 VDD RA2 \$4348 VDD pfet_03v3 L=0.28U W=0.72U AS=0.3708P AD=0.3168P
+ PS=2.47U PD=2.32U
M$2351 \$4350 \$4322 \$4349 VDD pfet_03v3 L=0.28U W=0.36U AS=0.2097P AD=0.1278P
+ PS=1.38U PD=1.07U
M$2352 \$4458 \$4351 \$4350 VDD pfet_03v3 L=0.28U W=0.36U AS=0.1278P AD=0.0567P
+ PS=1.07U PD=0.675U
M$2353 VDD \$4321 \$4458 VDD pfet_03v3 L=0.28U W=0.36U AS=0.0567P AD=0.1584P
+ PS=0.675U PD=1.6U
M$2354 \$4349 \$118 VDD VDD pfet_03v3 L=0.28U W=0.72U AS=0.3168P AD=0.2097P
+ PS=2.32U PD=1.38U
M$2355 VDD \$4350 \$4351 VDD pfet_03v3 L=0.28U W=0.36U AS=0.1584P AD=0.1764P
+ PS=1.6U PD=1.26U
M$2356 \$4352 \$4350 VDD VDD pfet_03v3 L=0.28U W=0.72U AS=0.1764P AD=0.36P
+ PS=1.26U PD=2.44U
M$2357 \$4353 RB2 VDD VDD pfet_03v3 L=0.28U W=0.72U AS=0.3312P AD=0.3888P
+ PS=2.36U PD=2.52U
M$2358 \$4352 \$4353 \$59 VDD pfet_03v3 L=0.28U W=0.36U AS=0.1584P AD=0.1152P
+ PS=1.6U PD=1U
M$2359 \$60 \$4354 \$4352 VDD pfet_03v3 L=0.28U W=0.36U AS=0.1152P AD=0.1584P
+ PS=1U PD=1.6U
M$2360 VDD RA2 \$4354 VDD pfet_03v3 L=0.28U W=0.72U AS=0.3708P AD=0.3168P
+ PS=2.47U PD=2.32U
M$2361 \$4356 \$4322 \$4355 VDD pfet_03v3 L=0.28U W=0.36U AS=0.2097P AD=0.1278P
+ PS=1.38U PD=1.07U
M$2362 \$4464 \$4357 \$4356 VDD pfet_03v3 L=0.28U W=0.36U AS=0.1278P AD=0.0567P
+ PS=1.07U PD=0.675U
M$2363 VDD \$4321 \$4464 VDD pfet_03v3 L=0.28U W=0.36U AS=0.0567P AD=0.1584P
+ PS=0.675U PD=1.6U
M$2364 \$4355 \$121 VDD VDD pfet_03v3 L=0.28U W=0.72U AS=0.3168P AD=0.2097P
+ PS=2.32U PD=1.38U
M$2365 VDD \$4356 \$4357 VDD pfet_03v3 L=0.28U W=0.36U AS=0.1584P AD=0.1764P
+ PS=1.6U PD=1.26U
M$2366 \$4358 \$4356 VDD VDD pfet_03v3 L=0.28U W=0.72U AS=0.1764P AD=0.36P
+ PS=1.26U PD=2.44U
M$2367 \$4359 RB2 VDD VDD pfet_03v3 L=0.28U W=0.72U AS=0.3312P AD=0.3888P
+ PS=2.36U PD=2.52U
M$2368 \$4358 \$4359 \$61 VDD pfet_03v3 L=0.28U W=0.36U AS=0.1584P AD=0.1152P
+ PS=1.6U PD=1U
M$2369 \$62 \$4360 \$4358 VDD pfet_03v3 L=0.28U W=0.36U AS=0.1152P AD=0.1584P
+ PS=1U PD=1.6U
M$2370 VDD RA2 \$4360 VDD pfet_03v3 L=0.28U W=0.72U AS=0.3708P AD=0.3168P
+ PS=2.47U PD=2.32U
M$2371 \$4362 \$4322 \$4361 VDD pfet_03v3 L=0.28U W=0.36U AS=0.2097P AD=0.1278P
+ PS=1.38U PD=1.07U
M$2372 \$4471 \$4363 \$4362 VDD pfet_03v3 L=0.28U W=0.36U AS=0.1278P AD=0.0567P
+ PS=1.07U PD=0.675U
M$2373 VDD \$4321 \$4471 VDD pfet_03v3 L=0.28U W=0.36U AS=0.0567P AD=0.1584P
+ PS=0.675U PD=1.6U
M$2374 \$4361 \$124 VDD VDD pfet_03v3 L=0.28U W=0.72U AS=0.3168P AD=0.2097P
+ PS=2.32U PD=1.38U
M$2375 VDD \$4362 \$4363 VDD pfet_03v3 L=0.28U W=0.36U AS=0.1584P AD=0.1764P
+ PS=1.6U PD=1.26U
M$2376 \$4364 \$4362 VDD VDD pfet_03v3 L=0.28U W=0.72U AS=0.1764P AD=0.36P
+ PS=1.26U PD=2.44U
M$2377 \$4365 RB2 VDD VDD pfet_03v3 L=0.28U W=0.72U AS=0.3312P AD=0.3888P
+ PS=2.36U PD=2.52U
M$2378 \$4364 \$4365 \$63 VDD pfet_03v3 L=0.28U W=0.36U AS=0.1584P AD=0.1152P
+ PS=1.6U PD=1U
M$2379 \$64 \$4366 \$4364 VDD pfet_03v3 L=0.28U W=0.36U AS=0.1152P AD=0.1584P
+ PS=1U PD=1.6U
M$2380 VDD RA2 \$4366 VDD pfet_03v3 L=0.28U W=0.72U AS=0.3708P AD=0.3168P
+ PS=2.47U PD=2.32U
M$2381 \$4368 \$4322 \$4367 VDD pfet_03v3 L=0.28U W=0.36U AS=0.2097P AD=0.1278P
+ PS=1.38U PD=1.07U
M$2382 \$4480 \$4369 \$4368 VDD pfet_03v3 L=0.28U W=0.36U AS=0.1278P AD=0.0567P
+ PS=1.07U PD=0.675U
M$2383 VDD \$4321 \$4480 VDD pfet_03v3 L=0.28U W=0.36U AS=0.0567P AD=0.1584P
+ PS=0.675U PD=1.6U
M$2384 \$4367 \$127 VDD VDD pfet_03v3 L=0.28U W=0.72U AS=0.3168P AD=0.2097P
+ PS=2.32U PD=1.38U
M$2385 VDD \$4368 \$4369 VDD pfet_03v3 L=0.28U W=0.36U AS=0.1584P AD=0.1764P
+ PS=1.6U PD=1.26U
M$2386 \$4370 \$4368 VDD VDD pfet_03v3 L=0.28U W=0.72U AS=0.1764P AD=0.36P
+ PS=1.26U PD=2.44U
M$2387 \$4371 RB2 VDD VDD pfet_03v3 L=0.28U W=0.72U AS=0.3312P AD=0.3888P
+ PS=2.36U PD=2.52U
M$2388 \$4370 \$4371 \$65 VDD pfet_03v3 L=0.28U W=0.36U AS=0.1584P AD=0.1152P
+ PS=1.6U PD=1U
M$2389 \$66 \$4372 \$4370 VDD pfet_03v3 L=0.28U W=0.36U AS=0.1152P AD=0.1584P
+ PS=1U PD=1.6U
M$2390 VDD RA2 \$4372 VDD pfet_03v3 L=0.28U W=0.72U AS=0.3708P AD=0.3168P
+ PS=2.47U PD=2.32U
M$2391 \$4374 \$4322 \$4373 VDD pfet_03v3 L=0.28U W=0.36U AS=0.2097P AD=0.1278P
+ PS=1.38U PD=1.07U
M$2392 \$4486 \$4375 \$4374 VDD pfet_03v3 L=0.28U W=0.36U AS=0.1278P AD=0.0567P
+ PS=1.07U PD=0.675U
M$2393 VDD \$4321 \$4486 VDD pfet_03v3 L=0.28U W=0.36U AS=0.0567P AD=0.1584P
+ PS=0.675U PD=1.6U
M$2394 \$4373 \$130 VDD VDD pfet_03v3 L=0.28U W=0.72U AS=0.3168P AD=0.2097P
+ PS=2.32U PD=1.38U
M$2395 VDD \$4374 \$4375 VDD pfet_03v3 L=0.28U W=0.36U AS=0.1584P AD=0.1764P
+ PS=1.6U PD=1.26U
M$2396 \$4376 \$4374 VDD VDD pfet_03v3 L=0.28U W=0.72U AS=0.1764P AD=0.36P
+ PS=1.26U PD=2.44U
M$2397 \$4377 RB2 VDD VDD pfet_03v3 L=0.28U W=0.72U AS=0.3312P AD=0.3888P
+ PS=2.36U PD=2.52U
M$2398 \$4376 \$4377 \$67 VDD pfet_03v3 L=0.28U W=0.36U AS=0.1584P AD=0.1152P
+ PS=1.6U PD=1U
M$2399 \$68 \$4378 \$4376 VDD pfet_03v3 L=0.28U W=0.36U AS=0.1152P AD=0.1584P
+ PS=1U PD=1.6U
M$2400 VDD RA2 \$4378 VDD pfet_03v3 L=0.28U W=0.72U AS=0.3708P AD=0.3168P
+ PS=2.47U PD=2.32U
M$2401 \$4380 \$4322 \$4379 VDD pfet_03v3 L=0.28U W=0.36U AS=0.2097P AD=0.1278P
+ PS=1.38U PD=1.07U
M$2402 \$4493 \$4381 \$4380 VDD pfet_03v3 L=0.28U W=0.36U AS=0.1278P AD=0.0567P
+ PS=1.07U PD=0.675U
M$2403 VDD \$4321 \$4493 VDD pfet_03v3 L=0.28U W=0.36U AS=0.0567P AD=0.1584P
+ PS=0.675U PD=1.6U
M$2404 \$4379 \$133 VDD VDD pfet_03v3 L=0.28U W=0.72U AS=0.3168P AD=0.2097P
+ PS=2.32U PD=1.38U
M$2405 VDD \$4380 \$4381 VDD pfet_03v3 L=0.28U W=0.36U AS=0.1584P AD=0.1764P
+ PS=1.6U PD=1.26U
M$2406 \$4382 \$4380 VDD VDD pfet_03v3 L=0.28U W=0.72U AS=0.1764P AD=0.36P
+ PS=1.26U PD=2.44U
M$2407 \$4383 RB2 VDD VDD pfet_03v3 L=0.28U W=0.72U AS=0.3312P AD=0.3888P
+ PS=2.36U PD=2.52U
M$2408 \$4382 \$4383 \$69 VDD pfet_03v3 L=0.28U W=0.36U AS=0.1584P AD=0.1152P
+ PS=1.6U PD=1U
M$2409 \$70 \$4384 \$4382 VDD pfet_03v3 L=0.28U W=0.36U AS=0.1152P AD=0.1584P
+ PS=1U PD=1.6U
M$2410 VDD RA2 \$4384 VDD pfet_03v3 L=0.28U W=0.72U AS=0.3708P AD=0.3168P
+ PS=2.47U PD=2.32U
M$2411 \$4386 \$4322 \$4385 VDD pfet_03v3 L=0.28U W=0.36U AS=0.2097P AD=0.1278P
+ PS=1.38U PD=1.07U
M$2412 \$4501 \$4387 \$4386 VDD pfet_03v3 L=0.28U W=0.36U AS=0.1278P AD=0.0567P
+ PS=1.07U PD=0.675U
M$2413 VDD \$4321 \$4501 VDD pfet_03v3 L=0.28U W=0.36U AS=0.0567P AD=0.1584P
+ PS=0.675U PD=1.6U
M$2414 \$4385 \$136 VDD VDD pfet_03v3 L=0.28U W=0.72U AS=0.3168P AD=0.2097P
+ PS=2.32U PD=1.38U
M$2415 VDD \$4386 \$4387 VDD pfet_03v3 L=0.28U W=0.36U AS=0.1584P AD=0.1764P
+ PS=1.6U PD=1.26U
M$2416 \$4388 \$4386 VDD VDD pfet_03v3 L=0.28U W=0.72U AS=0.1764P AD=0.36P
+ PS=1.26U PD=2.44U
M$2417 \$4389 RB2 VDD VDD pfet_03v3 L=0.28U W=0.72U AS=0.3312P AD=0.3888P
+ PS=2.36U PD=2.52U
M$2418 \$4388 \$4389 \$71 VDD pfet_03v3 L=0.28U W=0.36U AS=0.1584P AD=0.1152P
+ PS=1.6U PD=1U
M$2419 \$72 \$4390 \$4388 VDD pfet_03v3 L=0.28U W=0.36U AS=0.1152P AD=0.1584P
+ PS=1U PD=1.6U
M$2420 VDD RA2 \$4390 VDD pfet_03v3 L=0.28U W=0.72U AS=0.3708P AD=0.3168P
+ PS=2.47U PD=2.32U
M$2421 \$4392 \$4322 \$4391 VDD pfet_03v3 L=0.28U W=0.36U AS=0.2097P AD=0.1278P
+ PS=1.38U PD=1.07U
M$2422 \$4509 \$4393 \$4392 VDD pfet_03v3 L=0.28U W=0.36U AS=0.1278P AD=0.0567P
+ PS=1.07U PD=0.675U
M$2423 VDD \$4321 \$4509 VDD pfet_03v3 L=0.28U W=0.36U AS=0.0567P AD=0.1584P
+ PS=0.675U PD=1.6U
M$2424 \$4391 \$139 VDD VDD pfet_03v3 L=0.28U W=0.72U AS=0.3168P AD=0.2097P
+ PS=2.32U PD=1.38U
M$2425 VDD \$4392 \$4393 VDD pfet_03v3 L=0.28U W=0.36U AS=0.1584P AD=0.1764P
+ PS=1.6U PD=1.26U
M$2426 \$4394 \$4392 VDD VDD pfet_03v3 L=0.28U W=0.72U AS=0.1764P AD=0.36P
+ PS=1.26U PD=2.44U
M$2427 \$4395 RB2 VDD VDD pfet_03v3 L=0.28U W=0.72U AS=0.3312P AD=0.3888P
+ PS=2.36U PD=2.52U
M$2428 \$4394 \$4395 \$73 VDD pfet_03v3 L=0.28U W=0.36U AS=0.1584P AD=0.1152P
+ PS=1.6U PD=1U
M$2429 \$74 \$4396 \$4394 VDD pfet_03v3 L=0.28U W=0.36U AS=0.1152P AD=0.1584P
+ PS=1U PD=1.6U
M$2430 VDD RA2 \$4396 VDD pfet_03v3 L=0.28U W=0.72U AS=0.3708P AD=0.3168P
+ PS=2.47U PD=2.32U
M$2431 \$4398 \$4322 \$4397 VDD pfet_03v3 L=0.28U W=0.36U AS=0.2097P AD=0.1278P
+ PS=1.38U PD=1.07U
M$2432 \$4516 \$4399 \$4398 VDD pfet_03v3 L=0.28U W=0.36U AS=0.1278P AD=0.0567P
+ PS=1.07U PD=0.675U
M$2433 VDD \$4321 \$4516 VDD pfet_03v3 L=0.28U W=0.36U AS=0.0567P AD=0.1584P
+ PS=0.675U PD=1.6U
M$2434 \$4397 \$142 VDD VDD pfet_03v3 L=0.28U W=0.72U AS=0.3168P AD=0.2097P
+ PS=2.32U PD=1.38U
M$2435 VDD \$4398 \$4399 VDD pfet_03v3 L=0.28U W=0.36U AS=0.1584P AD=0.1764P
+ PS=1.6U PD=1.26U
M$2436 \$4400 \$4398 VDD VDD pfet_03v3 L=0.28U W=0.72U AS=0.1764P AD=0.36P
+ PS=1.26U PD=2.44U
M$2437 \$4401 RB2 VDD VDD pfet_03v3 L=0.28U W=0.72U AS=0.3312P AD=0.3888P
+ PS=2.36U PD=2.52U
M$2438 \$4400 \$4401 \$75 VDD pfet_03v3 L=0.28U W=0.36U AS=0.1584P AD=0.1152P
+ PS=1.6U PD=1U
M$2439 \$76 \$4402 \$4400 VDD pfet_03v3 L=0.28U W=0.36U AS=0.1152P AD=0.1584P
+ PS=1U PD=1.6U
M$2440 VDD RA2 \$4402 VDD pfet_03v3 L=0.28U W=0.72U AS=0.3708P AD=0.3168P
+ PS=2.47U PD=2.32U
M$2441 \$4404 \$4322 \$4403 VDD pfet_03v3 L=0.28U W=0.36U AS=0.2097P AD=0.1278P
+ PS=1.38U PD=1.07U
M$2442 \$4515 \$4405 \$4404 VDD pfet_03v3 L=0.28U W=0.36U AS=0.1278P AD=0.0567P
+ PS=1.07U PD=0.675U
M$2443 VDD \$4321 \$4515 VDD pfet_03v3 L=0.28U W=0.36U AS=0.0567P AD=0.1584P
+ PS=0.675U PD=1.6U
M$2444 \$4403 \$145 VDD VDD pfet_03v3 L=0.28U W=0.72U AS=0.3168P AD=0.2097P
+ PS=2.32U PD=1.38U
M$2445 VDD \$4404 \$4405 VDD pfet_03v3 L=0.28U W=0.36U AS=0.1584P AD=0.1764P
+ PS=1.6U PD=1.26U
M$2446 \$4406 \$4404 VDD VDD pfet_03v3 L=0.28U W=0.72U AS=0.1764P AD=0.36P
+ PS=1.26U PD=2.44U
M$2447 \$4407 RB2 VDD VDD pfet_03v3 L=0.28U W=0.72U AS=0.3312P AD=0.3888P
+ PS=2.36U PD=2.52U
M$2448 \$4406 \$4407 \$77 VDD pfet_03v3 L=0.28U W=0.36U AS=0.1584P AD=0.1152P
+ PS=1.6U PD=1U
M$2449 \$78 \$4408 \$4406 VDD pfet_03v3 L=0.28U W=0.36U AS=0.1152P AD=0.1584P
+ PS=1U PD=1.6U
M$2450 VDD RA2 \$4408 VDD pfet_03v3 L=0.28U W=0.72U AS=0.3708P AD=0.3168P
+ PS=2.47U PD=2.32U
M$2451 \$4410 \$4322 \$4409 VDD pfet_03v3 L=0.28U W=0.36U AS=0.2097P AD=0.1278P
+ PS=1.38U PD=1.07U
M$2452 \$4482 \$4411 \$4410 VDD pfet_03v3 L=0.28U W=0.36U AS=0.1278P AD=0.0567P
+ PS=1.07U PD=0.675U
M$2453 VDD \$4321 \$4482 VDD pfet_03v3 L=0.28U W=0.36U AS=0.0567P AD=0.1584P
+ PS=0.675U PD=1.6U
M$2454 \$4409 \$148 VDD VDD pfet_03v3 L=0.28U W=0.72U AS=0.3168P AD=0.2097P
+ PS=2.32U PD=1.38U
M$2455 VDD \$4410 \$4411 VDD pfet_03v3 L=0.28U W=0.36U AS=0.1584P AD=0.1764P
+ PS=1.6U PD=1.26U
M$2456 \$4412 \$4410 VDD VDD pfet_03v3 L=0.28U W=0.72U AS=0.1764P AD=0.36P
+ PS=1.26U PD=2.44U
M$2457 \$4413 RB2 VDD VDD pfet_03v3 L=0.28U W=0.72U AS=0.3312P AD=0.3888P
+ PS=2.36U PD=2.52U
M$2458 \$4412 \$4413 \$79 VDD pfet_03v3 L=0.28U W=0.36U AS=0.1584P AD=0.1152P
+ PS=1.6U PD=1U
M$2459 \$80 \$4414 \$4412 VDD pfet_03v3 L=0.28U W=0.36U AS=0.1152P AD=0.1584P
+ PS=1U PD=1.6U
M$2460 VDD RA2 \$4414 VDD pfet_03v3 L=0.28U W=0.72U AS=0.3708P AD=0.3168P
+ PS=2.47U PD=2.32U
M$2461 \$4416 \$4322 \$4415 VDD pfet_03v3 L=0.28U W=0.36U AS=0.2097P AD=0.1278P
+ PS=1.38U PD=1.07U
M$2462 \$4450 \$4417 \$4416 VDD pfet_03v3 L=0.28U W=0.36U AS=0.1278P AD=0.0567P
+ PS=1.07U PD=0.675U
M$2463 VDD \$4321 \$4450 VDD pfet_03v3 L=0.28U W=0.36U AS=0.0567P AD=0.1584P
+ PS=0.675U PD=1.6U
M$2464 \$4415 \$151 VDD VDD pfet_03v3 L=0.28U W=0.72U AS=0.3168P AD=0.2097P
+ PS=2.32U PD=1.38U
M$2465 VDD \$4416 \$4417 VDD pfet_03v3 L=0.28U W=0.36U AS=0.1584P AD=0.1764P
+ PS=1.6U PD=1.26U
M$2466 \$4418 \$4416 VDD VDD pfet_03v3 L=0.28U W=0.72U AS=0.1764P AD=0.36P
+ PS=1.26U PD=2.44U
M$2467 \$4419 RB2 VDD VDD pfet_03v3 L=0.28U W=0.72U AS=0.3312P AD=0.3888P
+ PS=2.36U PD=2.52U
M$2468 \$4418 \$4419 \$81 VDD pfet_03v3 L=0.28U W=0.36U AS=0.1584P AD=0.1152P
+ PS=1.6U PD=1U
M$2469 \$82 \$4420 \$4418 VDD pfet_03v3 L=0.28U W=0.36U AS=0.1152P AD=0.1584P
+ PS=1U PD=1.6U
M$2470 VDD RA2 \$4420 VDD pfet_03v3 L=0.28U W=0.72U AS=0.3708P AD=0.3168P
+ PS=2.47U PD=2.32U
M$2471 \$4622 WE1 VDD VDD pfet_03v3 L=0.28U W=0.72U AS=0.3168P AD=0.1872P
+ PS=2.32U PD=1.24U
M$2472 VDD CLK \$4622 VDD pfet_03v3 L=0.28U W=0.72U AS=0.1872P AD=0.3168P
+ PS=1.24U PD=2.32U
M$2473 \$4623 \$4622 VDD VDD pfet_03v3 L=0.28U W=1.27U AS=0.5588P AD=0.3302P
+ PS=3.42U PD=1.79U
M$2474 \$4623 \$4622 VDD VDD pfet_03v3 L=0.28U W=1.27U AS=0.3386P AD=0.3302P
+ PS=1.86U PD=1.79U
M$2475 \$4624 \$4623 VDD VDD pfet_03v3 L=0.28U W=1.34U AS=0.3386P AD=0.3886P
+ PS=1.86U PD=1.92U
M$2476 VDD \$4623 \$4624 VDD pfet_03v3 L=0.28U W=1.34U AS=0.3886P AD=0.5896P
+ PS=1.92U PD=3.56U
M$2477 \$4625 \$106 VDD VDD pfet_03v3 L=0.28U W=0.72U AS=0.3168P AD=0.2097P
+ PS=2.32U PD=1.38U
M$2478 \$4626 \$4624 \$4625 VDD pfet_03v3 L=0.28U W=0.36U AS=0.2097P AD=0.1278P
+ PS=1.38U PD=1.07U
M$2479 \$4838 \$4627 \$4626 VDD pfet_03v3 L=0.28U W=0.36U AS=0.1278P AD=0.0567P
+ PS=1.07U PD=0.675U
M$2480 VDD \$4623 \$4838 VDD pfet_03v3 L=0.28U W=0.36U AS=0.0567P AD=0.1584P
+ PS=0.675U PD=1.6U
M$2481 \$4627 \$4626 VDD VDD pfet_03v3 L=0.28U W=0.36U AS=0.1764P AD=0.1584P
+ PS=1.26U PD=1.6U
M$2482 \$4628 \$4626 VDD VDD pfet_03v3 L=0.28U W=0.72U AS=0.1764P AD=0.36P
+ PS=1.26U PD=2.44U
M$2483 \$4745 RA1 VDD VDD pfet_03v3 L=0.28U W=0.72U AS=0.3312P AD=0.3888P
+ PS=2.36U PD=2.52U
M$2484 \$4628 \$4745 \$51 VDD pfet_03v3 L=0.28U W=0.36U AS=0.1584P AD=0.1152P
+ PS=1.6U PD=1U
M$2485 \$52 \$4746 \$4628 VDD pfet_03v3 L=0.28U W=0.36U AS=0.1152P AD=0.1584P
+ PS=1U PD=1.6U
M$2486 VDD RB1 \$4746 VDD pfet_03v3 L=0.28U W=0.72U AS=0.3708P AD=0.3168P
+ PS=2.47U PD=2.32U
M$2487 \$4629 \$109 VDD VDD pfet_03v3 L=0.28U W=0.72U AS=0.3168P AD=0.2097P
+ PS=2.32U PD=1.38U
M$2488 \$4630 \$4624 \$4629 VDD pfet_03v3 L=0.28U W=0.36U AS=0.2097P AD=0.1278P
+ PS=1.38U PD=1.07U
M$2489 \$4848 \$4631 \$4630 VDD pfet_03v3 L=0.28U W=0.36U AS=0.1278P AD=0.0567P
+ PS=1.07U PD=0.675U
M$2490 VDD \$4623 \$4848 VDD pfet_03v3 L=0.28U W=0.36U AS=0.0567P AD=0.1584P
+ PS=0.675U PD=1.6U
M$2491 \$4631 \$4630 VDD VDD pfet_03v3 L=0.28U W=0.36U AS=0.1764P AD=0.1584P
+ PS=1.26U PD=1.6U
M$2492 \$4632 \$4630 VDD VDD pfet_03v3 L=0.28U W=0.72U AS=0.1764P AD=0.36P
+ PS=1.26U PD=2.44U
M$2493 \$4747 RA1 VDD VDD pfet_03v3 L=0.28U W=0.72U AS=0.3312P AD=0.3888P
+ PS=2.36U PD=2.52U
M$2494 \$4632 \$4747 \$53 VDD pfet_03v3 L=0.28U W=0.36U AS=0.1584P AD=0.1152P
+ PS=1.6U PD=1U
M$2495 \$54 \$4748 \$4632 VDD pfet_03v3 L=0.28U W=0.36U AS=0.1152P AD=0.1584P
+ PS=1U PD=1.6U
M$2496 VDD RB1 \$4748 VDD pfet_03v3 L=0.28U W=0.72U AS=0.3708P AD=0.3168P
+ PS=2.47U PD=2.32U
M$2497 \$4633 \$112 VDD VDD pfet_03v3 L=0.28U W=0.72U AS=0.3168P AD=0.2097P
+ PS=2.32U PD=1.38U
M$2498 \$4634 \$4624 \$4633 VDD pfet_03v3 L=0.28U W=0.36U AS=0.2097P AD=0.1278P
+ PS=1.38U PD=1.07U
M$2499 \$4854 \$4635 \$4634 VDD pfet_03v3 L=0.28U W=0.36U AS=0.1278P AD=0.0567P
+ PS=1.07U PD=0.675U
M$2500 VDD \$4623 \$4854 VDD pfet_03v3 L=0.28U W=0.36U AS=0.0567P AD=0.1584P
+ PS=0.675U PD=1.6U
M$2501 \$4635 \$4634 VDD VDD pfet_03v3 L=0.28U W=0.36U AS=0.1764P AD=0.1584P
+ PS=1.26U PD=1.6U
M$2502 \$4636 \$4634 VDD VDD pfet_03v3 L=0.28U W=0.72U AS=0.1764P AD=0.36P
+ PS=1.26U PD=2.44U
M$2503 \$4749 RA1 VDD VDD pfet_03v3 L=0.28U W=0.72U AS=0.3312P AD=0.3888P
+ PS=2.36U PD=2.52U
M$2504 \$4636 \$4749 \$55 VDD pfet_03v3 L=0.28U W=0.36U AS=0.1584P AD=0.1152P
+ PS=1.6U PD=1U
M$2505 \$56 \$4750 \$4636 VDD pfet_03v3 L=0.28U W=0.36U AS=0.1152P AD=0.1584P
+ PS=1U PD=1.6U
M$2506 VDD RB1 \$4750 VDD pfet_03v3 L=0.28U W=0.72U AS=0.3708P AD=0.3168P
+ PS=2.47U PD=2.32U
M$2507 \$4637 \$115 VDD VDD pfet_03v3 L=0.28U W=0.72U AS=0.3168P AD=0.2097P
+ PS=2.32U PD=1.38U
M$2508 \$4638 \$4624 \$4637 VDD pfet_03v3 L=0.28U W=0.36U AS=0.2097P AD=0.1278P
+ PS=1.38U PD=1.07U
M$2509 \$4864 \$4639 \$4638 VDD pfet_03v3 L=0.28U W=0.36U AS=0.1278P AD=0.0567P
+ PS=1.07U PD=0.675U
M$2510 VDD \$4623 \$4864 VDD pfet_03v3 L=0.28U W=0.36U AS=0.0567P AD=0.1584P
+ PS=0.675U PD=1.6U
M$2511 \$4639 \$4638 VDD VDD pfet_03v3 L=0.28U W=0.36U AS=0.1764P AD=0.1584P
+ PS=1.26U PD=1.6U
M$2512 \$4640 \$4638 VDD VDD pfet_03v3 L=0.28U W=0.72U AS=0.1764P AD=0.36P
+ PS=1.26U PD=2.44U
M$2513 \$4751 RA1 VDD VDD pfet_03v3 L=0.28U W=0.72U AS=0.3312P AD=0.3888P
+ PS=2.36U PD=2.52U
M$2514 \$4640 \$4751 \$57 VDD pfet_03v3 L=0.28U W=0.36U AS=0.1584P AD=0.1152P
+ PS=1.6U PD=1U
M$2515 \$58 \$4752 \$4640 VDD pfet_03v3 L=0.28U W=0.36U AS=0.1152P AD=0.1584P
+ PS=1U PD=1.6U
M$2516 VDD RB1 \$4752 VDD pfet_03v3 L=0.28U W=0.72U AS=0.3708P AD=0.3168P
+ PS=2.47U PD=2.32U
M$2517 \$4641 \$118 VDD VDD pfet_03v3 L=0.28U W=0.72U AS=0.3168P AD=0.2097P
+ PS=2.32U PD=1.38U
M$2518 \$4642 \$4624 \$4641 VDD pfet_03v3 L=0.28U W=0.36U AS=0.2097P AD=0.1278P
+ PS=1.38U PD=1.07U
M$2519 \$4873 \$4643 \$4642 VDD pfet_03v3 L=0.28U W=0.36U AS=0.1278P AD=0.0567P
+ PS=1.07U PD=0.675U
M$2520 VDD \$4623 \$4873 VDD pfet_03v3 L=0.28U W=0.36U AS=0.0567P AD=0.1584P
+ PS=0.675U PD=1.6U
M$2521 \$4643 \$4642 VDD VDD pfet_03v3 L=0.28U W=0.36U AS=0.1764P AD=0.1584P
+ PS=1.26U PD=1.6U
M$2522 \$4644 \$4642 VDD VDD pfet_03v3 L=0.28U W=0.72U AS=0.1764P AD=0.36P
+ PS=1.26U PD=2.44U
M$2523 \$4753 RA1 VDD VDD pfet_03v3 L=0.28U W=0.72U AS=0.3312P AD=0.3888P
+ PS=2.36U PD=2.52U
M$2524 \$4644 \$4753 \$59 VDD pfet_03v3 L=0.28U W=0.36U AS=0.1584P AD=0.1152P
+ PS=1.6U PD=1U
M$2525 \$60 \$4754 \$4644 VDD pfet_03v3 L=0.28U W=0.36U AS=0.1152P AD=0.1584P
+ PS=1U PD=1.6U
M$2526 VDD RB1 \$4754 VDD pfet_03v3 L=0.28U W=0.72U AS=0.3708P AD=0.3168P
+ PS=2.47U PD=2.32U
M$2527 \$4645 \$121 VDD VDD pfet_03v3 L=0.28U W=0.72U AS=0.3168P AD=0.2097P
+ PS=2.32U PD=1.38U
M$2528 \$4646 \$4624 \$4645 VDD pfet_03v3 L=0.28U W=0.36U AS=0.2097P AD=0.1278P
+ PS=1.38U PD=1.07U
M$2529 \$4882 \$4647 \$4646 VDD pfet_03v3 L=0.28U W=0.36U AS=0.1278P AD=0.0567P
+ PS=1.07U PD=0.675U
M$2530 VDD \$4623 \$4882 VDD pfet_03v3 L=0.28U W=0.36U AS=0.0567P AD=0.1584P
+ PS=0.675U PD=1.6U
M$2531 \$4647 \$4646 VDD VDD pfet_03v3 L=0.28U W=0.36U AS=0.1764P AD=0.1584P
+ PS=1.26U PD=1.6U
M$2532 \$4648 \$4646 VDD VDD pfet_03v3 L=0.28U W=0.72U AS=0.1764P AD=0.36P
+ PS=1.26U PD=2.44U
M$2533 \$4755 RA1 VDD VDD pfet_03v3 L=0.28U W=0.72U AS=0.3312P AD=0.3888P
+ PS=2.36U PD=2.52U
M$2534 \$4648 \$4755 \$61 VDD pfet_03v3 L=0.28U W=0.36U AS=0.1584P AD=0.1152P
+ PS=1.6U PD=1U
M$2535 \$62 \$4756 \$4648 VDD pfet_03v3 L=0.28U W=0.36U AS=0.1152P AD=0.1584P
+ PS=1U PD=1.6U
M$2536 VDD RB1 \$4756 VDD pfet_03v3 L=0.28U W=0.72U AS=0.3708P AD=0.3168P
+ PS=2.47U PD=2.32U
M$2537 \$4649 \$124 VDD VDD pfet_03v3 L=0.28U W=0.72U AS=0.3168P AD=0.2097P
+ PS=2.32U PD=1.38U
M$2538 \$4650 \$4624 \$4649 VDD pfet_03v3 L=0.28U W=0.36U AS=0.2097P AD=0.1278P
+ PS=1.38U PD=1.07U
M$2539 \$4890 \$4651 \$4650 VDD pfet_03v3 L=0.28U W=0.36U AS=0.1278P AD=0.0567P
+ PS=1.07U PD=0.675U
M$2540 VDD \$4623 \$4890 VDD pfet_03v3 L=0.28U W=0.36U AS=0.0567P AD=0.1584P
+ PS=0.675U PD=1.6U
M$2541 \$4651 \$4650 VDD VDD pfet_03v3 L=0.28U W=0.36U AS=0.1764P AD=0.1584P
+ PS=1.26U PD=1.6U
M$2542 \$4652 \$4650 VDD VDD pfet_03v3 L=0.28U W=0.72U AS=0.1764P AD=0.36P
+ PS=1.26U PD=2.44U
M$2543 \$4757 RA1 VDD VDD pfet_03v3 L=0.28U W=0.72U AS=0.3312P AD=0.3888P
+ PS=2.36U PD=2.52U
M$2544 \$4652 \$4757 \$63 VDD pfet_03v3 L=0.28U W=0.36U AS=0.1584P AD=0.1152P
+ PS=1.6U PD=1U
M$2545 \$64 \$4758 \$4652 VDD pfet_03v3 L=0.28U W=0.36U AS=0.1152P AD=0.1584P
+ PS=1U PD=1.6U
M$2546 VDD RB1 \$4758 VDD pfet_03v3 L=0.28U W=0.72U AS=0.3708P AD=0.3168P
+ PS=2.47U PD=2.32U
M$2547 \$4653 \$127 VDD VDD pfet_03v3 L=0.28U W=0.72U AS=0.3168P AD=0.2097P
+ PS=2.32U PD=1.38U
M$2548 \$4654 \$4624 \$4653 VDD pfet_03v3 L=0.28U W=0.36U AS=0.2097P AD=0.1278P
+ PS=1.38U PD=1.07U
M$2549 \$4899 \$4655 \$4654 VDD pfet_03v3 L=0.28U W=0.36U AS=0.1278P AD=0.0567P
+ PS=1.07U PD=0.675U
M$2550 VDD \$4623 \$4899 VDD pfet_03v3 L=0.28U W=0.36U AS=0.0567P AD=0.1584P
+ PS=0.675U PD=1.6U
M$2551 \$4655 \$4654 VDD VDD pfet_03v3 L=0.28U W=0.36U AS=0.1764P AD=0.1584P
+ PS=1.26U PD=1.6U
M$2552 \$4656 \$4654 VDD VDD pfet_03v3 L=0.28U W=0.72U AS=0.1764P AD=0.36P
+ PS=1.26U PD=2.44U
M$2553 \$4759 RA1 VDD VDD pfet_03v3 L=0.28U W=0.72U AS=0.3312P AD=0.3888P
+ PS=2.36U PD=2.52U
M$2554 \$4656 \$4759 \$65 VDD pfet_03v3 L=0.28U W=0.36U AS=0.1584P AD=0.1152P
+ PS=1.6U PD=1U
M$2555 \$66 \$4760 \$4656 VDD pfet_03v3 L=0.28U W=0.36U AS=0.1152P AD=0.1584P
+ PS=1U PD=1.6U
M$2556 VDD RB1 \$4760 VDD pfet_03v3 L=0.28U W=0.72U AS=0.3708P AD=0.3168P
+ PS=2.47U PD=2.32U
M$2557 \$4657 \$130 VDD VDD pfet_03v3 L=0.28U W=0.72U AS=0.3168P AD=0.2097P
+ PS=2.32U PD=1.38U
M$2558 \$4658 \$4624 \$4657 VDD pfet_03v3 L=0.28U W=0.36U AS=0.2097P AD=0.1278P
+ PS=1.38U PD=1.07U
M$2559 \$4908 \$4659 \$4658 VDD pfet_03v3 L=0.28U W=0.36U AS=0.1278P AD=0.0567P
+ PS=1.07U PD=0.675U
M$2560 VDD \$4623 \$4908 VDD pfet_03v3 L=0.28U W=0.36U AS=0.0567P AD=0.1584P
+ PS=0.675U PD=1.6U
M$2561 \$4659 \$4658 VDD VDD pfet_03v3 L=0.28U W=0.36U AS=0.1764P AD=0.1584P
+ PS=1.26U PD=1.6U
M$2562 \$4660 \$4658 VDD VDD pfet_03v3 L=0.28U W=0.72U AS=0.1764P AD=0.36P
+ PS=1.26U PD=2.44U
M$2563 \$4761 RA1 VDD VDD pfet_03v3 L=0.28U W=0.72U AS=0.3312P AD=0.3888P
+ PS=2.36U PD=2.52U
M$2564 \$4660 \$4761 \$67 VDD pfet_03v3 L=0.28U W=0.36U AS=0.1584P AD=0.1152P
+ PS=1.6U PD=1U
M$2565 \$68 \$4762 \$4660 VDD pfet_03v3 L=0.28U W=0.36U AS=0.1152P AD=0.1584P
+ PS=1U PD=1.6U
M$2566 VDD RB1 \$4762 VDD pfet_03v3 L=0.28U W=0.72U AS=0.3708P AD=0.3168P
+ PS=2.47U PD=2.32U
M$2567 \$4661 \$133 VDD VDD pfet_03v3 L=0.28U W=0.72U AS=0.3168P AD=0.2097P
+ PS=2.32U PD=1.38U
M$2568 \$4662 \$4624 \$4661 VDD pfet_03v3 L=0.28U W=0.36U AS=0.2097P AD=0.1278P
+ PS=1.38U PD=1.07U
M$2569 \$4917 \$4663 \$4662 VDD pfet_03v3 L=0.28U W=0.36U AS=0.1278P AD=0.0567P
+ PS=1.07U PD=0.675U
M$2570 VDD \$4623 \$4917 VDD pfet_03v3 L=0.28U W=0.36U AS=0.0567P AD=0.1584P
+ PS=0.675U PD=1.6U
M$2571 \$4663 \$4662 VDD VDD pfet_03v3 L=0.28U W=0.36U AS=0.1764P AD=0.1584P
+ PS=1.26U PD=1.6U
M$2572 \$4664 \$4662 VDD VDD pfet_03v3 L=0.28U W=0.72U AS=0.1764P AD=0.36P
+ PS=1.26U PD=2.44U
M$2573 \$4763 RA1 VDD VDD pfet_03v3 L=0.28U W=0.72U AS=0.3312P AD=0.3888P
+ PS=2.36U PD=2.52U
M$2574 \$4664 \$4763 \$69 VDD pfet_03v3 L=0.28U W=0.36U AS=0.1584P AD=0.1152P
+ PS=1.6U PD=1U
M$2575 \$70 \$4764 \$4664 VDD pfet_03v3 L=0.28U W=0.36U AS=0.1152P AD=0.1584P
+ PS=1U PD=1.6U
M$2576 VDD RB1 \$4764 VDD pfet_03v3 L=0.28U W=0.72U AS=0.3708P AD=0.3168P
+ PS=2.47U PD=2.32U
M$2577 \$4665 \$136 VDD VDD pfet_03v3 L=0.28U W=0.72U AS=0.3168P AD=0.2097P
+ PS=2.32U PD=1.38U
M$2578 \$4666 \$4624 \$4665 VDD pfet_03v3 L=0.28U W=0.36U AS=0.2097P AD=0.1278P
+ PS=1.38U PD=1.07U
M$2579 \$4926 \$4667 \$4666 VDD pfet_03v3 L=0.28U W=0.36U AS=0.1278P AD=0.0567P
+ PS=1.07U PD=0.675U
M$2580 VDD \$4623 \$4926 VDD pfet_03v3 L=0.28U W=0.36U AS=0.0567P AD=0.1584P
+ PS=0.675U PD=1.6U
M$2581 \$4667 \$4666 VDD VDD pfet_03v3 L=0.28U W=0.36U AS=0.1764P AD=0.1584P
+ PS=1.26U PD=1.6U
M$2582 \$4668 \$4666 VDD VDD pfet_03v3 L=0.28U W=0.72U AS=0.1764P AD=0.36P
+ PS=1.26U PD=2.44U
M$2583 \$4765 RA1 VDD VDD pfet_03v3 L=0.28U W=0.72U AS=0.3312P AD=0.3888P
+ PS=2.36U PD=2.52U
M$2584 \$4668 \$4765 \$71 VDD pfet_03v3 L=0.28U W=0.36U AS=0.1584P AD=0.1152P
+ PS=1.6U PD=1U
M$2585 \$72 \$4766 \$4668 VDD pfet_03v3 L=0.28U W=0.36U AS=0.1152P AD=0.1584P
+ PS=1U PD=1.6U
M$2586 VDD RB1 \$4766 VDD pfet_03v3 L=0.28U W=0.72U AS=0.3708P AD=0.3168P
+ PS=2.47U PD=2.32U
M$2587 \$4669 \$139 VDD VDD pfet_03v3 L=0.28U W=0.72U AS=0.3168P AD=0.2097P
+ PS=2.32U PD=1.38U
M$2588 \$4670 \$4624 \$4669 VDD pfet_03v3 L=0.28U W=0.36U AS=0.2097P AD=0.1278P
+ PS=1.38U PD=1.07U
M$2589 \$4934 \$4671 \$4670 VDD pfet_03v3 L=0.28U W=0.36U AS=0.1278P AD=0.0567P
+ PS=1.07U PD=0.675U
M$2590 VDD \$4623 \$4934 VDD pfet_03v3 L=0.28U W=0.36U AS=0.0567P AD=0.1584P
+ PS=0.675U PD=1.6U
M$2591 \$4671 \$4670 VDD VDD pfet_03v3 L=0.28U W=0.36U AS=0.1764P AD=0.1584P
+ PS=1.26U PD=1.6U
M$2592 \$4672 \$4670 VDD VDD pfet_03v3 L=0.28U W=0.72U AS=0.1764P AD=0.36P
+ PS=1.26U PD=2.44U
M$2593 \$4767 RA1 VDD VDD pfet_03v3 L=0.28U W=0.72U AS=0.3312P AD=0.3888P
+ PS=2.36U PD=2.52U
M$2594 \$4672 \$4767 \$73 VDD pfet_03v3 L=0.28U W=0.36U AS=0.1584P AD=0.1152P
+ PS=1.6U PD=1U
M$2595 \$74 \$4768 \$4672 VDD pfet_03v3 L=0.28U W=0.36U AS=0.1152P AD=0.1584P
+ PS=1U PD=1.6U
M$2596 VDD RB1 \$4768 VDD pfet_03v3 L=0.28U W=0.72U AS=0.3708P AD=0.3168P
+ PS=2.47U PD=2.32U
M$2597 \$4673 \$142 VDD VDD pfet_03v3 L=0.28U W=0.72U AS=0.3168P AD=0.2097P
+ PS=2.32U PD=1.38U
M$2598 \$4674 \$4624 \$4673 VDD pfet_03v3 L=0.28U W=0.36U AS=0.2097P AD=0.1278P
+ PS=1.38U PD=1.07U
M$2599 \$4920 \$4675 \$4674 VDD pfet_03v3 L=0.28U W=0.36U AS=0.1278P AD=0.0567P
+ PS=1.07U PD=0.675U
M$2600 VDD \$4623 \$4920 VDD pfet_03v3 L=0.28U W=0.36U AS=0.0567P AD=0.1584P
+ PS=0.675U PD=1.6U
M$2601 \$4675 \$4674 VDD VDD pfet_03v3 L=0.28U W=0.36U AS=0.1764P AD=0.1584P
+ PS=1.26U PD=1.6U
M$2602 \$4676 \$4674 VDD VDD pfet_03v3 L=0.28U W=0.72U AS=0.1764P AD=0.36P
+ PS=1.26U PD=2.44U
M$2603 \$4769 RA1 VDD VDD pfet_03v3 L=0.28U W=0.72U AS=0.3312P AD=0.3888P
+ PS=2.36U PD=2.52U
M$2604 \$4676 \$4769 \$75 VDD pfet_03v3 L=0.28U W=0.36U AS=0.1584P AD=0.1152P
+ PS=1.6U PD=1U
M$2605 \$76 \$4770 \$4676 VDD pfet_03v3 L=0.28U W=0.36U AS=0.1152P AD=0.1584P
+ PS=1U PD=1.6U
M$2606 VDD RB1 \$4770 VDD pfet_03v3 L=0.28U W=0.72U AS=0.3708P AD=0.3168P
+ PS=2.47U PD=2.32U
M$2607 \$4677 \$145 VDD VDD pfet_03v3 L=0.28U W=0.72U AS=0.3168P AD=0.2097P
+ PS=2.32U PD=1.38U
M$2608 \$4678 \$4624 \$4677 VDD pfet_03v3 L=0.28U W=0.36U AS=0.2097P AD=0.1278P
+ PS=1.38U PD=1.07U
M$2609 \$4892 \$4679 \$4678 VDD pfet_03v3 L=0.28U W=0.36U AS=0.1278P AD=0.0567P
+ PS=1.07U PD=0.675U
M$2610 VDD \$4623 \$4892 VDD pfet_03v3 L=0.28U W=0.36U AS=0.0567P AD=0.1584P
+ PS=0.675U PD=1.6U
M$2611 \$4679 \$4678 VDD VDD pfet_03v3 L=0.28U W=0.36U AS=0.1764P AD=0.1584P
+ PS=1.26U PD=1.6U
M$2612 \$4680 \$4678 VDD VDD pfet_03v3 L=0.28U W=0.72U AS=0.1764P AD=0.36P
+ PS=1.26U PD=2.44U
M$2613 \$4771 RA1 VDD VDD pfet_03v3 L=0.28U W=0.72U AS=0.3312P AD=0.3888P
+ PS=2.36U PD=2.52U
M$2614 \$4680 \$4771 \$77 VDD pfet_03v3 L=0.28U W=0.36U AS=0.1584P AD=0.1152P
+ PS=1.6U PD=1U
M$2615 \$78 \$4772 \$4680 VDD pfet_03v3 L=0.28U W=0.36U AS=0.1152P AD=0.1584P
+ PS=1U PD=1.6U
M$2616 VDD RB1 \$4772 VDD pfet_03v3 L=0.28U W=0.72U AS=0.3708P AD=0.3168P
+ PS=2.47U PD=2.32U
M$2617 \$4681 \$148 VDD VDD pfet_03v3 L=0.28U W=0.72U AS=0.3168P AD=0.2097P
+ PS=2.32U PD=1.38U
M$2618 \$4682 \$4624 \$4681 VDD pfet_03v3 L=0.28U W=0.36U AS=0.2097P AD=0.1278P
+ PS=1.38U PD=1.07U
M$2619 \$4874 \$4683 \$4682 VDD pfet_03v3 L=0.28U W=0.36U AS=0.1278P AD=0.0567P
+ PS=1.07U PD=0.675U
M$2620 VDD \$4623 \$4874 VDD pfet_03v3 L=0.28U W=0.36U AS=0.0567P AD=0.1584P
+ PS=0.675U PD=1.6U
M$2621 \$4683 \$4682 VDD VDD pfet_03v3 L=0.28U W=0.36U AS=0.1764P AD=0.1584P
+ PS=1.26U PD=1.6U
M$2622 \$4684 \$4682 VDD VDD pfet_03v3 L=0.28U W=0.72U AS=0.1764P AD=0.36P
+ PS=1.26U PD=2.44U
M$2623 \$4773 RA1 VDD VDD pfet_03v3 L=0.28U W=0.72U AS=0.3312P AD=0.3888P
+ PS=2.36U PD=2.52U
M$2624 \$4684 \$4773 \$79 VDD pfet_03v3 L=0.28U W=0.36U AS=0.1584P AD=0.1152P
+ PS=1.6U PD=1U
M$2625 \$80 \$4774 \$4684 VDD pfet_03v3 L=0.28U W=0.36U AS=0.1152P AD=0.1584P
+ PS=1U PD=1.6U
M$2626 VDD RB1 \$4774 VDD pfet_03v3 L=0.28U W=0.72U AS=0.3708P AD=0.3168P
+ PS=2.47U PD=2.32U
M$2627 \$4685 \$151 VDD VDD pfet_03v3 L=0.28U W=0.72U AS=0.3168P AD=0.2097P
+ PS=2.32U PD=1.38U
M$2628 \$4686 \$4624 \$4685 VDD pfet_03v3 L=0.28U W=0.36U AS=0.2097P AD=0.1278P
+ PS=1.38U PD=1.07U
M$2629 \$4846 \$4687 \$4686 VDD pfet_03v3 L=0.28U W=0.36U AS=0.1278P AD=0.0567P
+ PS=1.07U PD=0.675U
M$2630 VDD \$4623 \$4846 VDD pfet_03v3 L=0.28U W=0.36U AS=0.0567P AD=0.1584P
+ PS=0.675U PD=1.6U
M$2631 \$4687 \$4686 VDD VDD pfet_03v3 L=0.28U W=0.36U AS=0.1764P AD=0.1584P
+ PS=1.26U PD=1.6U
M$2632 \$4688 \$4686 VDD VDD pfet_03v3 L=0.28U W=0.72U AS=0.1764P AD=0.36P
+ PS=1.26U PD=2.44U
M$2633 \$4775 RA1 VDD VDD pfet_03v3 L=0.28U W=0.72U AS=0.3312P AD=0.3888P
+ PS=2.36U PD=2.52U
M$2634 \$4688 \$4775 \$81 VDD pfet_03v3 L=0.28U W=0.36U AS=0.1584P AD=0.1152P
+ PS=1.6U PD=1U
M$2635 \$82 \$4776 \$4688 VDD pfet_03v3 L=0.28U W=0.36U AS=0.1152P AD=0.1584P
+ PS=1U PD=1.6U
M$2636 VDD RB1 \$4776 VDD pfet_03v3 L=0.28U W=0.72U AS=0.3708P AD=0.3168P
+ PS=2.47U PD=2.32U
M$2637 \$4938 WE0 VDD VDD pfet_03v3 L=0.28U W=0.72U AS=0.3168P AD=0.1872P
+ PS=2.32U PD=1.24U
M$2638 VDD CLK \$4938 VDD pfet_03v3 L=0.28U W=0.72U AS=0.1872P AD=0.3168P
+ PS=1.24U PD=2.32U
M$2639 \$4940 \$4938 VDD VDD pfet_03v3 L=0.28U W=1.27U AS=0.5588P AD=0.3302P
+ PS=3.42U PD=1.79U
M$2640 VDD \$4938 \$4940 VDD pfet_03v3 L=0.28U W=1.27U AS=0.3302P AD=0.3386P
+ PS=1.79U PD=1.86U
M$2641 \$4941 \$4940 VDD VDD pfet_03v3 L=0.28U W=1.34U AS=0.3386P AD=0.3886P
+ PS=1.86U PD=1.92U
M$2642 VDD \$4940 \$4941 VDD pfet_03v3 L=0.28U W=1.34U AS=0.3886P AD=0.5896P
+ PS=1.92U PD=3.56U
M$2643 \$4945 \$4941 \$4944 VDD pfet_03v3 L=0.28U W=0.36U AS=0.2097P AD=0.1278P
+ PS=1.38U PD=1.07U
M$2644 \$5045 \$4946 \$4945 VDD pfet_03v3 L=0.28U W=0.36U AS=0.1278P AD=0.0567P
+ PS=1.07U PD=0.675U
M$2645 VDD \$4940 \$5045 VDD pfet_03v3 L=0.28U W=0.36U AS=0.0567P AD=0.1584P
+ PS=0.675U PD=1.6U
M$2646 \$4944 \$106 VDD VDD pfet_03v3 L=0.28U W=0.72U AS=0.3168P AD=0.2097P
+ PS=2.32U PD=1.38U
M$2647 VDD \$4945 \$4946 VDD pfet_03v3 L=0.28U W=0.36U AS=0.1584P AD=0.1764P
+ PS=1.6U PD=1.26U
M$2648 \$4947 \$4945 VDD VDD pfet_03v3 L=0.28U W=0.72U AS=0.1764P AD=0.36P
+ PS=1.26U PD=2.44U
M$2649 \$4948 RB0 VDD VDD pfet_03v3 L=0.28U W=0.72U AS=0.3312P AD=0.3888P
+ PS=2.36U PD=2.52U
M$2650 \$4947 \$4948 \$51 VDD pfet_03v3 L=0.28U W=0.36U AS=0.1584P AD=0.1152P
+ PS=1.6U PD=1U
M$2651 \$52 \$4949 \$4947 VDD pfet_03v3 L=0.28U W=0.36U AS=0.1152P AD=0.1584P
+ PS=1U PD=1.6U
M$2652 VDD RA0 \$4949 VDD pfet_03v3 L=0.28U W=0.72U AS=0.3708P AD=0.3168P
+ PS=2.47U PD=2.32U
M$2653 \$4951 \$4941 \$4950 VDD pfet_03v3 L=0.28U W=0.36U AS=0.2097P AD=0.1278P
+ PS=1.38U PD=1.07U
M$2654 \$5053 \$4952 \$4951 VDD pfet_03v3 L=0.28U W=0.36U AS=0.1278P AD=0.0567P
+ PS=1.07U PD=0.675U
M$2655 VDD \$4940 \$5053 VDD pfet_03v3 L=0.28U W=0.36U AS=0.0567P AD=0.1584P
+ PS=0.675U PD=1.6U
M$2656 \$4950 \$109 VDD VDD pfet_03v3 L=0.28U W=0.72U AS=0.3168P AD=0.2097P
+ PS=2.32U PD=1.38U
M$2657 VDD \$4951 \$4952 VDD pfet_03v3 L=0.28U W=0.36U AS=0.1584P AD=0.1764P
+ PS=1.6U PD=1.26U
M$2658 \$4953 \$4951 VDD VDD pfet_03v3 L=0.28U W=0.72U AS=0.1764P AD=0.36P
+ PS=1.26U PD=2.44U
M$2659 \$4954 RB0 VDD VDD pfet_03v3 L=0.28U W=0.72U AS=0.3312P AD=0.3888P
+ PS=2.36U PD=2.52U
M$2660 \$4953 \$4954 \$53 VDD pfet_03v3 L=0.28U W=0.36U AS=0.1584P AD=0.1152P
+ PS=1.6U PD=1U
M$2661 \$54 \$4955 \$4953 VDD pfet_03v3 L=0.28U W=0.36U AS=0.1152P AD=0.1584P
+ PS=1U PD=1.6U
M$2662 VDD RA0 \$4955 VDD pfet_03v3 L=0.28U W=0.72U AS=0.3708P AD=0.3168P
+ PS=2.47U PD=2.32U
M$2663 \$4957 \$4941 \$4956 VDD pfet_03v3 L=0.28U W=0.36U AS=0.2097P AD=0.1278P
+ PS=1.38U PD=1.07U
M$2664 \$5060 \$4958 \$4957 VDD pfet_03v3 L=0.28U W=0.36U AS=0.1278P AD=0.0567P
+ PS=1.07U PD=0.675U
M$2665 VDD \$4940 \$5060 VDD pfet_03v3 L=0.28U W=0.36U AS=0.0567P AD=0.1584P
+ PS=0.675U PD=1.6U
M$2666 \$4956 \$112 VDD VDD pfet_03v3 L=0.28U W=0.72U AS=0.3168P AD=0.2097P
+ PS=2.32U PD=1.38U
M$2667 VDD \$4957 \$4958 VDD pfet_03v3 L=0.28U W=0.36U AS=0.1584P AD=0.1764P
+ PS=1.6U PD=1.26U
M$2668 \$4959 \$4957 VDD VDD pfet_03v3 L=0.28U W=0.72U AS=0.1764P AD=0.36P
+ PS=1.26U PD=2.44U
M$2669 \$4960 RB0 VDD VDD pfet_03v3 L=0.28U W=0.72U AS=0.3312P AD=0.3888P
+ PS=2.36U PD=2.52U
M$2670 \$4959 \$4960 \$55 VDD pfet_03v3 L=0.28U W=0.36U AS=0.1584P AD=0.1152P
+ PS=1.6U PD=1U
M$2671 \$56 \$4961 \$4959 VDD pfet_03v3 L=0.28U W=0.36U AS=0.1152P AD=0.1584P
+ PS=1U PD=1.6U
M$2672 VDD RA0 \$4961 VDD pfet_03v3 L=0.28U W=0.72U AS=0.3708P AD=0.3168P
+ PS=2.47U PD=2.32U
M$2673 \$4963 \$4941 \$4962 VDD pfet_03v3 L=0.28U W=0.36U AS=0.2097P AD=0.1278P
+ PS=1.38U PD=1.07U
M$2674 \$5068 \$4964 \$4963 VDD pfet_03v3 L=0.28U W=0.36U AS=0.1278P AD=0.0567P
+ PS=1.07U PD=0.675U
M$2675 VDD \$4940 \$5068 VDD pfet_03v3 L=0.28U W=0.36U AS=0.0567P AD=0.1584P
+ PS=0.675U PD=1.6U
M$2676 \$4962 \$115 VDD VDD pfet_03v3 L=0.28U W=0.72U AS=0.3168P AD=0.2097P
+ PS=2.32U PD=1.38U
M$2677 VDD \$4963 \$4964 VDD pfet_03v3 L=0.28U W=0.36U AS=0.1584P AD=0.1764P
+ PS=1.6U PD=1.26U
M$2678 \$4965 \$4963 VDD VDD pfet_03v3 L=0.28U W=0.72U AS=0.1764P AD=0.36P
+ PS=1.26U PD=2.44U
M$2679 \$4966 RB0 VDD VDD pfet_03v3 L=0.28U W=0.72U AS=0.3312P AD=0.3888P
+ PS=2.36U PD=2.52U
M$2680 \$4965 \$4966 \$57 VDD pfet_03v3 L=0.28U W=0.36U AS=0.1584P AD=0.1152P
+ PS=1.6U PD=1U
M$2681 \$58 \$4967 \$4965 VDD pfet_03v3 L=0.28U W=0.36U AS=0.1152P AD=0.1584P
+ PS=1U PD=1.6U
M$2682 VDD RA0 \$4967 VDD pfet_03v3 L=0.28U W=0.72U AS=0.3708P AD=0.3168P
+ PS=2.47U PD=2.32U
M$2683 \$4969 \$4941 \$4968 VDD pfet_03v3 L=0.28U W=0.36U AS=0.2097P AD=0.1278P
+ PS=1.38U PD=1.07U
M$2684 \$5077 \$4970 \$4969 VDD pfet_03v3 L=0.28U W=0.36U AS=0.1278P AD=0.0567P
+ PS=1.07U PD=0.675U
M$2685 VDD \$4940 \$5077 VDD pfet_03v3 L=0.28U W=0.36U AS=0.0567P AD=0.1584P
+ PS=0.675U PD=1.6U
M$2686 \$4968 \$118 VDD VDD pfet_03v3 L=0.28U W=0.72U AS=0.3168P AD=0.2097P
+ PS=2.32U PD=1.38U
M$2687 VDD \$4969 \$4970 VDD pfet_03v3 L=0.28U W=0.36U AS=0.1584P AD=0.1764P
+ PS=1.6U PD=1.26U
M$2688 \$4971 \$4969 VDD VDD pfet_03v3 L=0.28U W=0.72U AS=0.1764P AD=0.36P
+ PS=1.26U PD=2.44U
M$2689 \$4972 RB0 VDD VDD pfet_03v3 L=0.28U W=0.72U AS=0.3312P AD=0.3888P
+ PS=2.36U PD=2.52U
M$2690 \$4971 \$4972 \$59 VDD pfet_03v3 L=0.28U W=0.36U AS=0.1584P AD=0.1152P
+ PS=1.6U PD=1U
M$2691 \$60 \$4973 \$4971 VDD pfet_03v3 L=0.28U W=0.36U AS=0.1152P AD=0.1584P
+ PS=1U PD=1.6U
M$2692 VDD RA0 \$4973 VDD pfet_03v3 L=0.28U W=0.72U AS=0.3708P AD=0.3168P
+ PS=2.47U PD=2.32U
M$2693 \$4975 \$4941 \$4974 VDD pfet_03v3 L=0.28U W=0.36U AS=0.2097P AD=0.1278P
+ PS=1.38U PD=1.07U
M$2694 \$5083 \$4976 \$4975 VDD pfet_03v3 L=0.28U W=0.36U AS=0.1278P AD=0.0567P
+ PS=1.07U PD=0.675U
M$2695 VDD \$4940 \$5083 VDD pfet_03v3 L=0.28U W=0.36U AS=0.0567P AD=0.1584P
+ PS=0.675U PD=1.6U
M$2696 \$4974 \$121 VDD VDD pfet_03v3 L=0.28U W=0.72U AS=0.3168P AD=0.2097P
+ PS=2.32U PD=1.38U
M$2697 VDD \$4975 \$4976 VDD pfet_03v3 L=0.28U W=0.36U AS=0.1584P AD=0.1764P
+ PS=1.6U PD=1.26U
M$2698 \$4977 \$4975 VDD VDD pfet_03v3 L=0.28U W=0.72U AS=0.1764P AD=0.36P
+ PS=1.26U PD=2.44U
M$2699 \$4978 RB0 VDD VDD pfet_03v3 L=0.28U W=0.72U AS=0.3312P AD=0.3888P
+ PS=2.36U PD=2.52U
M$2700 \$4977 \$4978 \$61 VDD pfet_03v3 L=0.28U W=0.36U AS=0.1584P AD=0.1152P
+ PS=1.6U PD=1U
M$2701 \$62 \$4979 \$4977 VDD pfet_03v3 L=0.28U W=0.36U AS=0.1152P AD=0.1584P
+ PS=1U PD=1.6U
M$2702 VDD RA0 \$4979 VDD pfet_03v3 L=0.28U W=0.72U AS=0.3708P AD=0.3168P
+ PS=2.47U PD=2.32U
M$2703 \$4981 \$4941 \$4980 VDD pfet_03v3 L=0.28U W=0.36U AS=0.2097P AD=0.1278P
+ PS=1.38U PD=1.07U
M$2704 \$5090 \$4982 \$4981 VDD pfet_03v3 L=0.28U W=0.36U AS=0.1278P AD=0.0567P
+ PS=1.07U PD=0.675U
M$2705 VDD \$4940 \$5090 VDD pfet_03v3 L=0.28U W=0.36U AS=0.0567P AD=0.1584P
+ PS=0.675U PD=1.6U
M$2706 \$4980 \$124 VDD VDD pfet_03v3 L=0.28U W=0.72U AS=0.3168P AD=0.2097P
+ PS=2.32U PD=1.38U
M$2707 VDD \$4981 \$4982 VDD pfet_03v3 L=0.28U W=0.36U AS=0.1584P AD=0.1764P
+ PS=1.6U PD=1.26U
M$2708 \$4983 \$4981 VDD VDD pfet_03v3 L=0.28U W=0.72U AS=0.1764P AD=0.36P
+ PS=1.26U PD=2.44U
M$2709 \$4984 RB0 VDD VDD pfet_03v3 L=0.28U W=0.72U AS=0.3312P AD=0.3888P
+ PS=2.36U PD=2.52U
M$2710 \$4983 \$4984 \$63 VDD pfet_03v3 L=0.28U W=0.36U AS=0.1584P AD=0.1152P
+ PS=1.6U PD=1U
M$2711 \$64 \$4985 \$4983 VDD pfet_03v3 L=0.28U W=0.36U AS=0.1152P AD=0.1584P
+ PS=1U PD=1.6U
M$2712 VDD RA0 \$4985 VDD pfet_03v3 L=0.28U W=0.72U AS=0.3708P AD=0.3168P
+ PS=2.47U PD=2.32U
M$2713 \$4987 \$4941 \$4986 VDD pfet_03v3 L=0.28U W=0.36U AS=0.2097P AD=0.1278P
+ PS=1.38U PD=1.07U
M$2714 \$5099 \$4988 \$4987 VDD pfet_03v3 L=0.28U W=0.36U AS=0.1278P AD=0.0567P
+ PS=1.07U PD=0.675U
M$2715 VDD \$4940 \$5099 VDD pfet_03v3 L=0.28U W=0.36U AS=0.0567P AD=0.1584P
+ PS=0.675U PD=1.6U
M$2716 \$4986 \$127 VDD VDD pfet_03v3 L=0.28U W=0.72U AS=0.3168P AD=0.2097P
+ PS=2.32U PD=1.38U
M$2717 VDD \$4987 \$4988 VDD pfet_03v3 L=0.28U W=0.36U AS=0.1584P AD=0.1764P
+ PS=1.6U PD=1.26U
M$2718 \$4989 \$4987 VDD VDD pfet_03v3 L=0.28U W=0.72U AS=0.1764P AD=0.36P
+ PS=1.26U PD=2.44U
M$2719 \$4990 RB0 VDD VDD pfet_03v3 L=0.28U W=0.72U AS=0.3312P AD=0.3888P
+ PS=2.36U PD=2.52U
M$2720 \$4989 \$4990 \$65 VDD pfet_03v3 L=0.28U W=0.36U AS=0.1584P AD=0.1152P
+ PS=1.6U PD=1U
M$2721 \$66 \$4991 \$4989 VDD pfet_03v3 L=0.28U W=0.36U AS=0.1152P AD=0.1584P
+ PS=1U PD=1.6U
M$2722 VDD RA0 \$4991 VDD pfet_03v3 L=0.28U W=0.72U AS=0.3708P AD=0.3168P
+ PS=2.47U PD=2.32U
M$2723 \$4993 \$4941 \$4992 VDD pfet_03v3 L=0.28U W=0.36U AS=0.2097P AD=0.1278P
+ PS=1.38U PD=1.07U
M$2724 \$5105 \$4994 \$4993 VDD pfet_03v3 L=0.28U W=0.36U AS=0.1278P AD=0.0567P
+ PS=1.07U PD=0.675U
M$2725 VDD \$4940 \$5105 VDD pfet_03v3 L=0.28U W=0.36U AS=0.0567P AD=0.1584P
+ PS=0.675U PD=1.6U
M$2726 \$4992 \$130 VDD VDD pfet_03v3 L=0.28U W=0.72U AS=0.3168P AD=0.2097P
+ PS=2.32U PD=1.38U
M$2727 VDD \$4993 \$4994 VDD pfet_03v3 L=0.28U W=0.36U AS=0.1584P AD=0.1764P
+ PS=1.6U PD=1.26U
M$2728 \$4995 \$4993 VDD VDD pfet_03v3 L=0.28U W=0.72U AS=0.1764P AD=0.36P
+ PS=1.26U PD=2.44U
M$2729 \$4996 RB0 VDD VDD pfet_03v3 L=0.28U W=0.72U AS=0.3312P AD=0.3888P
+ PS=2.36U PD=2.52U
M$2730 \$4995 \$4996 \$67 VDD pfet_03v3 L=0.28U W=0.36U AS=0.1584P AD=0.1152P
+ PS=1.6U PD=1U
M$2731 \$68 \$4997 \$4995 VDD pfet_03v3 L=0.28U W=0.36U AS=0.1152P AD=0.1584P
+ PS=1U PD=1.6U
M$2732 VDD RA0 \$4997 VDD pfet_03v3 L=0.28U W=0.72U AS=0.3708P AD=0.3168P
+ PS=2.47U PD=2.32U
M$2733 \$4999 \$4941 \$4998 VDD pfet_03v3 L=0.28U W=0.36U AS=0.2097P AD=0.1278P
+ PS=1.38U PD=1.07U
M$2734 \$5112 \$5000 \$4999 VDD pfet_03v3 L=0.28U W=0.36U AS=0.1278P AD=0.0567P
+ PS=1.07U PD=0.675U
M$2735 VDD \$4940 \$5112 VDD pfet_03v3 L=0.28U W=0.36U AS=0.0567P AD=0.1584P
+ PS=0.675U PD=1.6U
M$2736 \$4998 \$133 VDD VDD pfet_03v3 L=0.28U W=0.72U AS=0.3168P AD=0.2097P
+ PS=2.32U PD=1.38U
M$2737 VDD \$4999 \$5000 VDD pfet_03v3 L=0.28U W=0.36U AS=0.1584P AD=0.1764P
+ PS=1.6U PD=1.26U
M$2738 \$5001 \$4999 VDD VDD pfet_03v3 L=0.28U W=0.72U AS=0.1764P AD=0.36P
+ PS=1.26U PD=2.44U
M$2739 \$5002 RB0 VDD VDD pfet_03v3 L=0.28U W=0.72U AS=0.3312P AD=0.3888P
+ PS=2.36U PD=2.52U
M$2740 \$5001 \$5002 \$69 VDD pfet_03v3 L=0.28U W=0.36U AS=0.1584P AD=0.1152P
+ PS=1.6U PD=1U
M$2741 \$70 \$5003 \$5001 VDD pfet_03v3 L=0.28U W=0.36U AS=0.1152P AD=0.1584P
+ PS=1U PD=1.6U
M$2742 VDD RA0 \$5003 VDD pfet_03v3 L=0.28U W=0.72U AS=0.3708P AD=0.3168P
+ PS=2.47U PD=2.32U
M$2743 \$5005 \$4941 \$5004 VDD pfet_03v3 L=0.28U W=0.36U AS=0.2097P AD=0.1278P
+ PS=1.38U PD=1.07U
M$2744 \$5120 \$5006 \$5005 VDD pfet_03v3 L=0.28U W=0.36U AS=0.1278P AD=0.0567P
+ PS=1.07U PD=0.675U
M$2745 VDD \$4940 \$5120 VDD pfet_03v3 L=0.28U W=0.36U AS=0.0567P AD=0.1584P
+ PS=0.675U PD=1.6U
M$2746 \$5004 \$136 VDD VDD pfet_03v3 L=0.28U W=0.72U AS=0.3168P AD=0.2097P
+ PS=2.32U PD=1.38U
M$2747 VDD \$5005 \$5006 VDD pfet_03v3 L=0.28U W=0.36U AS=0.1584P AD=0.1764P
+ PS=1.6U PD=1.26U
M$2748 \$5007 \$5005 VDD VDD pfet_03v3 L=0.28U W=0.72U AS=0.1764P AD=0.36P
+ PS=1.26U PD=2.44U
M$2749 \$5008 RB0 VDD VDD pfet_03v3 L=0.28U W=0.72U AS=0.3312P AD=0.3888P
+ PS=2.36U PD=2.52U
M$2750 \$5007 \$5008 \$71 VDD pfet_03v3 L=0.28U W=0.36U AS=0.1584P AD=0.1152P
+ PS=1.6U PD=1U
M$2751 \$72 \$5009 \$5007 VDD pfet_03v3 L=0.28U W=0.36U AS=0.1152P AD=0.1584P
+ PS=1U PD=1.6U
M$2752 VDD RA0 \$5009 VDD pfet_03v3 L=0.28U W=0.72U AS=0.3708P AD=0.3168P
+ PS=2.47U PD=2.32U
M$2753 \$5011 \$4941 \$5010 VDD pfet_03v3 L=0.28U W=0.36U AS=0.2097P AD=0.1278P
+ PS=1.38U PD=1.07U
M$2754 \$5128 \$5012 \$5011 VDD pfet_03v3 L=0.28U W=0.36U AS=0.1278P AD=0.0567P
+ PS=1.07U PD=0.675U
M$2755 VDD \$4940 \$5128 VDD pfet_03v3 L=0.28U W=0.36U AS=0.0567P AD=0.1584P
+ PS=0.675U PD=1.6U
M$2756 \$5010 \$139 VDD VDD pfet_03v3 L=0.28U W=0.72U AS=0.3168P AD=0.2097P
+ PS=2.32U PD=1.38U
M$2757 VDD \$5011 \$5012 VDD pfet_03v3 L=0.28U W=0.36U AS=0.1584P AD=0.1764P
+ PS=1.6U PD=1.26U
M$2758 \$5013 \$5011 VDD VDD pfet_03v3 L=0.28U W=0.72U AS=0.1764P AD=0.36P
+ PS=1.26U PD=2.44U
M$2759 \$5014 RB0 VDD VDD pfet_03v3 L=0.28U W=0.72U AS=0.3312P AD=0.3888P
+ PS=2.36U PD=2.52U
M$2760 \$5013 \$5014 \$73 VDD pfet_03v3 L=0.28U W=0.36U AS=0.1584P AD=0.1152P
+ PS=1.6U PD=1U
M$2761 \$74 \$5015 \$5013 VDD pfet_03v3 L=0.28U W=0.36U AS=0.1152P AD=0.1584P
+ PS=1U PD=1.6U
M$2762 VDD RA0 \$5015 VDD pfet_03v3 L=0.28U W=0.72U AS=0.3708P AD=0.3168P
+ PS=2.47U PD=2.32U
M$2763 \$5017 \$4941 \$5016 VDD pfet_03v3 L=0.28U W=0.36U AS=0.2097P AD=0.1278P
+ PS=1.38U PD=1.07U
M$2764 \$5135 \$5018 \$5017 VDD pfet_03v3 L=0.28U W=0.36U AS=0.1278P AD=0.0567P
+ PS=1.07U PD=0.675U
M$2765 VDD \$4940 \$5135 VDD pfet_03v3 L=0.28U W=0.36U AS=0.0567P AD=0.1584P
+ PS=0.675U PD=1.6U
M$2766 \$5016 \$142 VDD VDD pfet_03v3 L=0.28U W=0.72U AS=0.3168P AD=0.2097P
+ PS=2.32U PD=1.38U
M$2767 VDD \$5017 \$5018 VDD pfet_03v3 L=0.28U W=0.36U AS=0.1584P AD=0.1764P
+ PS=1.6U PD=1.26U
M$2768 \$5019 \$5017 VDD VDD pfet_03v3 L=0.28U W=0.72U AS=0.1764P AD=0.36P
+ PS=1.26U PD=2.44U
M$2769 \$5020 RB0 VDD VDD pfet_03v3 L=0.28U W=0.72U AS=0.3312P AD=0.3888P
+ PS=2.36U PD=2.52U
M$2770 \$5019 \$5020 \$75 VDD pfet_03v3 L=0.28U W=0.36U AS=0.1584P AD=0.1152P
+ PS=1.6U PD=1U
M$2771 \$76 \$5021 \$5019 VDD pfet_03v3 L=0.28U W=0.36U AS=0.1152P AD=0.1584P
+ PS=1U PD=1.6U
M$2772 VDD RA0 \$5021 VDD pfet_03v3 L=0.28U W=0.72U AS=0.3708P AD=0.3168P
+ PS=2.47U PD=2.32U
M$2773 \$5023 \$4941 \$5022 VDD pfet_03v3 L=0.28U W=0.36U AS=0.2097P AD=0.1278P
+ PS=1.38U PD=1.07U
M$2774 \$5134 \$5024 \$5023 VDD pfet_03v3 L=0.28U W=0.36U AS=0.1278P AD=0.0567P
+ PS=1.07U PD=0.675U
M$2775 VDD \$4940 \$5134 VDD pfet_03v3 L=0.28U W=0.36U AS=0.0567P AD=0.1584P
+ PS=0.675U PD=1.6U
M$2776 \$5022 \$145 VDD VDD pfet_03v3 L=0.28U W=0.72U AS=0.3168P AD=0.2097P
+ PS=2.32U PD=1.38U
M$2777 VDD \$5023 \$5024 VDD pfet_03v3 L=0.28U W=0.36U AS=0.1584P AD=0.1764P
+ PS=1.6U PD=1.26U
M$2778 \$5025 \$5023 VDD VDD pfet_03v3 L=0.28U W=0.72U AS=0.1764P AD=0.36P
+ PS=1.26U PD=2.44U
M$2779 \$5026 RB0 VDD VDD pfet_03v3 L=0.28U W=0.72U AS=0.3312P AD=0.3888P
+ PS=2.36U PD=2.52U
M$2780 \$5025 \$5026 \$77 VDD pfet_03v3 L=0.28U W=0.36U AS=0.1584P AD=0.1152P
+ PS=1.6U PD=1U
M$2781 \$78 \$5027 \$5025 VDD pfet_03v3 L=0.28U W=0.36U AS=0.1152P AD=0.1584P
+ PS=1U PD=1.6U
M$2782 VDD RA0 \$5027 VDD pfet_03v3 L=0.28U W=0.72U AS=0.3708P AD=0.3168P
+ PS=2.47U PD=2.32U
M$2783 \$5029 \$4941 \$5028 VDD pfet_03v3 L=0.28U W=0.36U AS=0.2097P AD=0.1278P
+ PS=1.38U PD=1.07U
M$2784 \$5101 \$5030 \$5029 VDD pfet_03v3 L=0.28U W=0.36U AS=0.1278P AD=0.0567P
+ PS=1.07U PD=0.675U
M$2785 VDD \$4940 \$5101 VDD pfet_03v3 L=0.28U W=0.36U AS=0.0567P AD=0.1584P
+ PS=0.675U PD=1.6U
M$2786 \$5028 \$148 VDD VDD pfet_03v3 L=0.28U W=0.72U AS=0.3168P AD=0.2097P
+ PS=2.32U PD=1.38U
M$2787 VDD \$5029 \$5030 VDD pfet_03v3 L=0.28U W=0.36U AS=0.1584P AD=0.1764P
+ PS=1.6U PD=1.26U
M$2788 \$5031 \$5029 VDD VDD pfet_03v3 L=0.28U W=0.72U AS=0.1764P AD=0.36P
+ PS=1.26U PD=2.44U
M$2789 \$5032 RB0 VDD VDD pfet_03v3 L=0.28U W=0.72U AS=0.3312P AD=0.3888P
+ PS=2.36U PD=2.52U
M$2790 \$5031 \$5032 \$79 VDD pfet_03v3 L=0.28U W=0.36U AS=0.1584P AD=0.1152P
+ PS=1.6U PD=1U
M$2791 \$80 \$5033 \$5031 VDD pfet_03v3 L=0.28U W=0.36U AS=0.1152P AD=0.1584P
+ PS=1U PD=1.6U
M$2792 VDD RA0 \$5033 VDD pfet_03v3 L=0.28U W=0.72U AS=0.3708P AD=0.3168P
+ PS=2.47U PD=2.32U
M$2793 \$5035 \$4941 \$5034 VDD pfet_03v3 L=0.28U W=0.36U AS=0.2097P AD=0.1278P
+ PS=1.38U PD=1.07U
M$2794 \$5069 \$5036 \$5035 VDD pfet_03v3 L=0.28U W=0.36U AS=0.1278P AD=0.0567P
+ PS=1.07U PD=0.675U
M$2795 VDD \$4940 \$5069 VDD pfet_03v3 L=0.28U W=0.36U AS=0.0567P AD=0.1584P
+ PS=0.675U PD=1.6U
M$2796 \$5034 \$151 VDD VDD pfet_03v3 L=0.28U W=0.72U AS=0.3168P AD=0.2097P
+ PS=2.32U PD=1.38U
M$2797 VDD \$5035 \$5036 VDD pfet_03v3 L=0.28U W=0.36U AS=0.1584P AD=0.1764P
+ PS=1.6U PD=1.26U
M$2798 \$5037 \$5035 VDD VDD pfet_03v3 L=0.28U W=0.72U AS=0.1764P AD=0.36P
+ PS=1.26U PD=2.44U
M$2799 \$5038 RB0 VDD VDD pfet_03v3 L=0.28U W=0.72U AS=0.3312P AD=0.3888P
+ PS=2.36U PD=2.52U
M$2800 \$5037 \$5038 \$81 VDD pfet_03v3 L=0.28U W=0.36U AS=0.1584P AD=0.1152P
+ PS=1.6U PD=1U
M$2801 \$82 \$5039 \$5037 VDD pfet_03v3 L=0.28U W=0.36U AS=0.1152P AD=0.1584P
+ PS=1U PD=1.6U
M$2802 VDD RA0 \$5039 VDD pfet_03v3 L=0.28U W=0.72U AS=0.3708P AD=0.3168P
+ PS=2.47U PD=2.32U
M$2803 VSS \$51 QA0 VSS nfet_03v3 L=0.28U W=0.36U AS=0.2052P AD=0.1242P
+ PS=1.86U PD=1.05U
M$2804 QB0 \$52 VSS VSS nfet_03v3 L=0.28U W=0.36U AS=0.1242P AD=0.2052P
+ PS=1.05U PD=1.86U
M$2805 VSS \$53 QA1 VSS nfet_03v3 L=0.28U W=0.36U AS=0.2052P AD=0.1242P
+ PS=1.86U PD=1.05U
M$2806 QB1 \$54 VSS VSS nfet_03v3 L=0.28U W=0.36U AS=0.1242P AD=0.2052P
+ PS=1.05U PD=1.86U
M$2807 VSS \$55 QA2 VSS nfet_03v3 L=0.28U W=0.36U AS=0.2052P AD=0.1242P
+ PS=1.86U PD=1.05U
M$2808 QB2 \$56 VSS VSS nfet_03v3 L=0.28U W=0.36U AS=0.1242P AD=0.2052P
+ PS=1.05U PD=1.86U
M$2809 VSS \$57 QA3 VSS nfet_03v3 L=0.28U W=0.36U AS=0.2052P AD=0.1242P
+ PS=1.86U PD=1.05U
M$2810 QB3 \$58 VSS VSS nfet_03v3 L=0.28U W=0.36U AS=0.1242P AD=0.2052P
+ PS=1.05U PD=1.86U
M$2811 VSS \$59 QA4 VSS nfet_03v3 L=0.28U W=0.36U AS=0.2052P AD=0.1242P
+ PS=1.86U PD=1.05U
M$2812 QB4 \$60 VSS VSS nfet_03v3 L=0.28U W=0.36U AS=0.1242P AD=0.2052P
+ PS=1.05U PD=1.86U
M$2813 VSS \$61 QA5 VSS nfet_03v3 L=0.28U W=0.36U AS=0.2052P AD=0.1242P
+ PS=1.86U PD=1.05U
M$2814 QB5 \$62 VSS VSS nfet_03v3 L=0.28U W=0.36U AS=0.1242P AD=0.2052P
+ PS=1.05U PD=1.86U
M$2815 VSS \$63 QA6 VSS nfet_03v3 L=0.28U W=0.36U AS=0.2052P AD=0.1242P
+ PS=1.86U PD=1.05U
M$2816 QB6 \$64 VSS VSS nfet_03v3 L=0.28U W=0.36U AS=0.1242P AD=0.2052P
+ PS=1.05U PD=1.86U
M$2817 VSS \$65 QA7 VSS nfet_03v3 L=0.28U W=0.36U AS=0.2052P AD=0.1242P
+ PS=1.86U PD=1.05U
M$2818 QB7 \$66 VSS VSS nfet_03v3 L=0.28U W=0.36U AS=0.1242P AD=0.2052P
+ PS=1.05U PD=1.86U
M$2819 VSS \$67 QA8 VSS nfet_03v3 L=0.28U W=0.36U AS=0.2052P AD=0.1242P
+ PS=1.86U PD=1.05U
M$2820 QB8 \$68 VSS VSS nfet_03v3 L=0.28U W=0.36U AS=0.1242P AD=0.2052P
+ PS=1.05U PD=1.86U
M$2821 VSS \$69 QA9 VSS nfet_03v3 L=0.28U W=0.36U AS=0.2052P AD=0.1242P
+ PS=1.86U PD=1.05U
M$2822 QB9 \$70 VSS VSS nfet_03v3 L=0.28U W=0.36U AS=0.1242P AD=0.2052P
+ PS=1.05U PD=1.86U
M$2823 VSS \$71 QA10 VSS nfet_03v3 L=0.28U W=0.36U AS=0.2052P AD=0.1242P
+ PS=1.86U PD=1.05U
M$2824 QB10 \$72 VSS VSS nfet_03v3 L=0.28U W=0.36U AS=0.1242P AD=0.2052P
+ PS=1.05U PD=1.86U
M$2825 VSS \$73 QA11 VSS nfet_03v3 L=0.28U W=0.36U AS=0.2052P AD=0.1242P
+ PS=1.86U PD=1.05U
M$2826 QB11 \$74 VSS VSS nfet_03v3 L=0.28U W=0.36U AS=0.1242P AD=0.2052P
+ PS=1.05U PD=1.86U
M$2827 VSS \$75 QA12 VSS nfet_03v3 L=0.28U W=0.36U AS=0.2052P AD=0.1242P
+ PS=1.86U PD=1.05U
M$2828 QB12 \$76 VSS VSS nfet_03v3 L=0.28U W=0.36U AS=0.1242P AD=0.2052P
+ PS=1.05U PD=1.86U
M$2829 VSS \$77 QA13 VSS nfet_03v3 L=0.28U W=0.36U AS=0.2052P AD=0.1242P
+ PS=1.86U PD=1.05U
M$2830 QB13 \$78 VSS VSS nfet_03v3 L=0.28U W=0.36U AS=0.1242P AD=0.2052P
+ PS=1.05U PD=1.86U
M$2831 VSS \$79 QA14 VSS nfet_03v3 L=0.28U W=0.36U AS=0.2052P AD=0.1242P
+ PS=1.86U PD=1.05U
M$2832 QB14 \$80 VSS VSS nfet_03v3 L=0.28U W=0.36U AS=0.1242P AD=0.2052P
+ PS=1.05U PD=1.86U
M$2833 VSS \$81 QA15 VSS nfet_03v3 L=0.28U W=0.36U AS=0.2052P AD=0.1242P
+ PS=1.86U PD=1.05U
M$2834 QB15 \$82 VSS VSS nfet_03v3 L=0.28U W=0.36U AS=0.1242P AD=0.2052P
+ PS=1.05U PD=1.86U
M$2835 \$105 WEM VSS VSS nfet_03v3 L=0.28U W=0.63U AS=0.2772P AD=0.1827P
+ PS=2.14U PD=1.21U
M$2836 VSS WEM \$105 VSS nfet_03v3 L=0.28U W=0.63U AS=0.1827P AD=0.2772P
+ PS=1.21U PD=2.14U
M$2837 \$106 \$220 VSS VSS nfet_03v3 L=0.28U W=0.62U AS=0.2728P AD=0.1612P
+ PS=2.12U PD=1.14U
M$2838 VSS \$220 \$106 VSS nfet_03v3 L=0.28U W=0.62U AS=0.1612P AD=0.2728P
+ PS=1.14U PD=2.12U
M$2839 \$109 \$222 VSS VSS nfet_03v3 L=0.28U W=0.62U AS=0.2728P AD=0.1612P
+ PS=2.12U PD=1.14U
M$2840 VSS \$222 \$109 VSS nfet_03v3 L=0.28U W=0.62U AS=0.1612P AD=0.2728P
+ PS=1.14U PD=2.12U
M$2841 \$112 \$224 VSS VSS nfet_03v3 L=0.28U W=0.62U AS=0.2728P AD=0.1612P
+ PS=2.12U PD=1.14U
M$2842 VSS \$224 \$112 VSS nfet_03v3 L=0.28U W=0.62U AS=0.1612P AD=0.2728P
+ PS=1.14U PD=2.12U
M$2843 \$115 \$226 VSS VSS nfet_03v3 L=0.28U W=0.62U AS=0.2728P AD=0.1612P
+ PS=2.12U PD=1.14U
M$2844 VSS \$226 \$115 VSS nfet_03v3 L=0.28U W=0.62U AS=0.1612P AD=0.2728P
+ PS=1.14U PD=2.12U
M$2845 \$118 \$228 VSS VSS nfet_03v3 L=0.28U W=0.62U AS=0.2728P AD=0.1612P
+ PS=2.12U PD=1.14U
M$2846 VSS \$228 \$118 VSS nfet_03v3 L=0.28U W=0.62U AS=0.1612P AD=0.2728P
+ PS=1.14U PD=2.12U
M$2847 \$121 \$230 VSS VSS nfet_03v3 L=0.28U W=0.62U AS=0.2728P AD=0.1612P
+ PS=2.12U PD=1.14U
M$2848 VSS \$230 \$121 VSS nfet_03v3 L=0.28U W=0.62U AS=0.1612P AD=0.2728P
+ PS=1.14U PD=2.12U
M$2849 \$124 \$232 VSS VSS nfet_03v3 L=0.28U W=0.62U AS=0.2728P AD=0.1612P
+ PS=2.12U PD=1.14U
M$2850 VSS \$232 \$124 VSS nfet_03v3 L=0.28U W=0.62U AS=0.1612P AD=0.2728P
+ PS=1.14U PD=2.12U
M$2851 \$127 \$234 VSS VSS nfet_03v3 L=0.28U W=0.62U AS=0.2728P AD=0.1612P
+ PS=2.12U PD=1.14U
M$2852 VSS \$234 \$127 VSS nfet_03v3 L=0.28U W=0.62U AS=0.1612P AD=0.2728P
+ PS=1.14U PD=2.12U
M$2853 \$130 \$236 VSS VSS nfet_03v3 L=0.28U W=0.62U AS=0.2728P AD=0.1612P
+ PS=2.12U PD=1.14U
M$2854 VSS \$236 \$130 VSS nfet_03v3 L=0.28U W=0.62U AS=0.1612P AD=0.2728P
+ PS=1.14U PD=2.12U
M$2855 \$133 \$238 VSS VSS nfet_03v3 L=0.28U W=0.62U AS=0.2728P AD=0.1612P
+ PS=2.12U PD=1.14U
M$2856 VSS \$238 \$133 VSS nfet_03v3 L=0.28U W=0.62U AS=0.1612P AD=0.2728P
+ PS=1.14U PD=2.12U
M$2857 \$136 \$240 VSS VSS nfet_03v3 L=0.28U W=0.62U AS=0.2728P AD=0.1612P
+ PS=2.12U PD=1.14U
M$2858 VSS \$240 \$136 VSS nfet_03v3 L=0.28U W=0.62U AS=0.1612P AD=0.2728P
+ PS=1.14U PD=2.12U
M$2859 \$139 \$242 VSS VSS nfet_03v3 L=0.28U W=0.62U AS=0.2728P AD=0.1612P
+ PS=2.12U PD=1.14U
M$2860 VSS \$242 \$139 VSS nfet_03v3 L=0.28U W=0.62U AS=0.1612P AD=0.2728P
+ PS=1.14U PD=2.12U
M$2861 \$142 \$244 VSS VSS nfet_03v3 L=0.28U W=0.62U AS=0.2728P AD=0.1612P
+ PS=2.12U PD=1.14U
M$2862 VSS \$244 \$142 VSS nfet_03v3 L=0.28U W=0.62U AS=0.1612P AD=0.2728P
+ PS=1.14U PD=2.12U
M$2863 \$145 \$246 VSS VSS nfet_03v3 L=0.28U W=0.62U AS=0.2728P AD=0.1612P
+ PS=2.12U PD=1.14U
M$2864 VSS \$246 \$145 VSS nfet_03v3 L=0.28U W=0.62U AS=0.1612P AD=0.2728P
+ PS=1.14U PD=2.12U
M$2865 \$148 \$248 VSS VSS nfet_03v3 L=0.28U W=0.62U AS=0.2728P AD=0.1612P
+ PS=2.12U PD=1.14U
M$2866 VSS \$248 \$148 VSS nfet_03v3 L=0.28U W=0.62U AS=0.1612P AD=0.2728P
+ PS=1.14U PD=2.12U
M$2867 \$151 \$250 VSS VSS nfet_03v3 L=0.28U W=0.62U AS=0.2728P AD=0.1612P
+ PS=2.12U PD=1.14U
M$2868 VSS \$250 \$151 VSS nfet_03v3 L=0.28U W=0.62U AS=0.1612P AD=0.2728P
+ PS=1.14U PD=2.12U
M$2869 \$107 \$220 VSS VSS nfet_03v3 L=0.28U W=0.36U AS=0.1584P AD=0.1584P
+ PS=1.6U PD=1.6U
M$2870 \$329 \$105 VSS VSS nfet_03v3 L=0.28U W=0.36U AS=0.1584P AD=0.0567P
+ PS=1.6U PD=0.675U
M$2871 \$220 \$107 \$329 VSS nfet_03v3 L=0.28U W=0.36U AS=0.0567P AD=0.1278P
+ PS=0.675U PD=1.07U
M$2872 \$108 WEM \$220 VSS nfet_03v3 L=0.28U W=0.36U AS=0.1278P AD=0.1188P
+ PS=1.07U PD=1.02U
M$2873 VSS D0 \$108 VSS nfet_03v3 L=0.28U W=0.36U AS=0.1188P AD=0.1584P
+ PS=1.02U PD=1.6U
M$2874 \$110 \$222 VSS VSS nfet_03v3 L=0.28U W=0.36U AS=0.1584P AD=0.1584P
+ PS=1.6U PD=1.6U
M$2875 \$337 \$105 VSS VSS nfet_03v3 L=0.28U W=0.36U AS=0.1584P AD=0.0567P
+ PS=1.6U PD=0.675U
M$2876 \$222 \$110 \$337 VSS nfet_03v3 L=0.28U W=0.36U AS=0.0567P AD=0.1278P
+ PS=0.675U PD=1.07U
M$2877 \$111 WEM \$222 VSS nfet_03v3 L=0.28U W=0.36U AS=0.1278P AD=0.1188P
+ PS=1.07U PD=1.02U
M$2878 VSS D1 \$111 VSS nfet_03v3 L=0.28U W=0.36U AS=0.1188P AD=0.1584P
+ PS=1.02U PD=1.6U
M$2879 \$113 \$224 VSS VSS nfet_03v3 L=0.28U W=0.36U AS=0.1584P AD=0.1584P
+ PS=1.6U PD=1.6U
M$2880 \$345 \$105 VSS VSS nfet_03v3 L=0.28U W=0.36U AS=0.1584P AD=0.0567P
+ PS=1.6U PD=0.675U
M$2881 \$224 \$113 \$345 VSS nfet_03v3 L=0.28U W=0.36U AS=0.0567P AD=0.1278P
+ PS=0.675U PD=1.07U
M$2882 \$114 WEM \$224 VSS nfet_03v3 L=0.28U W=0.36U AS=0.1278P AD=0.1188P
+ PS=1.07U PD=1.02U
M$2883 VSS D2 \$114 VSS nfet_03v3 L=0.28U W=0.36U AS=0.1188P AD=0.1584P
+ PS=1.02U PD=1.6U
M$2884 \$116 \$226 VSS VSS nfet_03v3 L=0.28U W=0.36U AS=0.1584P AD=0.1584P
+ PS=1.6U PD=1.6U
M$2885 \$353 \$105 VSS VSS nfet_03v3 L=0.28U W=0.36U AS=0.1584P AD=0.0567P
+ PS=1.6U PD=0.675U
M$2886 \$226 \$116 \$353 VSS nfet_03v3 L=0.28U W=0.36U AS=0.0567P AD=0.1278P
+ PS=0.675U PD=1.07U
M$2887 \$117 WEM \$226 VSS nfet_03v3 L=0.28U W=0.36U AS=0.1278P AD=0.1188P
+ PS=1.07U PD=1.02U
M$2888 VSS D3 \$117 VSS nfet_03v3 L=0.28U W=0.36U AS=0.1188P AD=0.1584P
+ PS=1.02U PD=1.6U
M$2889 \$119 \$228 VSS VSS nfet_03v3 L=0.28U W=0.36U AS=0.1584P AD=0.1584P
+ PS=1.6U PD=1.6U
M$2890 \$362 \$105 VSS VSS nfet_03v3 L=0.28U W=0.36U AS=0.1584P AD=0.0567P
+ PS=1.6U PD=0.675U
M$2891 \$228 \$119 \$362 VSS nfet_03v3 L=0.28U W=0.36U AS=0.0567P AD=0.1278P
+ PS=0.675U PD=1.07U
M$2892 \$120 WEM \$228 VSS nfet_03v3 L=0.28U W=0.36U AS=0.1278P AD=0.1188P
+ PS=1.07U PD=1.02U
M$2893 VSS D4 \$120 VSS nfet_03v3 L=0.28U W=0.36U AS=0.1188P AD=0.1584P
+ PS=1.02U PD=1.6U
M$2894 \$122 \$230 VSS VSS nfet_03v3 L=0.28U W=0.36U AS=0.1584P AD=0.1584P
+ PS=1.6U PD=1.6U
M$2895 \$370 \$105 VSS VSS nfet_03v3 L=0.28U W=0.36U AS=0.1584P AD=0.0567P
+ PS=1.6U PD=0.675U
M$2896 \$230 \$122 \$370 VSS nfet_03v3 L=0.28U W=0.36U AS=0.0567P AD=0.1278P
+ PS=0.675U PD=1.07U
M$2897 \$123 WEM \$230 VSS nfet_03v3 L=0.28U W=0.36U AS=0.1278P AD=0.1188P
+ PS=1.07U PD=1.02U
M$2898 VSS D5 \$123 VSS nfet_03v3 L=0.28U W=0.36U AS=0.1188P AD=0.1584P
+ PS=1.02U PD=1.6U
M$2899 \$125 \$232 VSS VSS nfet_03v3 L=0.28U W=0.36U AS=0.1584P AD=0.1584P
+ PS=1.6U PD=1.6U
M$2900 \$379 \$105 VSS VSS nfet_03v3 L=0.28U W=0.36U AS=0.1584P AD=0.0567P
+ PS=1.6U PD=0.675U
M$2901 \$232 \$125 \$379 VSS nfet_03v3 L=0.28U W=0.36U AS=0.0567P AD=0.1278P
+ PS=0.675U PD=1.07U
M$2902 \$126 WEM \$232 VSS nfet_03v3 L=0.28U W=0.36U AS=0.1278P AD=0.1188P
+ PS=1.07U PD=1.02U
M$2903 VSS D6 \$126 VSS nfet_03v3 L=0.28U W=0.36U AS=0.1188P AD=0.1584P
+ PS=1.02U PD=1.6U
M$2904 \$128 \$234 VSS VSS nfet_03v3 L=0.28U W=0.36U AS=0.1584P AD=0.1584P
+ PS=1.6U PD=1.6U
M$2905 \$382 \$105 VSS VSS nfet_03v3 L=0.28U W=0.36U AS=0.1584P AD=0.0567P
+ PS=1.6U PD=0.675U
M$2906 \$234 \$128 \$382 VSS nfet_03v3 L=0.28U W=0.36U AS=0.0567P AD=0.1278P
+ PS=0.675U PD=1.07U
M$2907 \$129 WEM \$234 VSS nfet_03v3 L=0.28U W=0.36U AS=0.1278P AD=0.1188P
+ PS=1.07U PD=1.02U
M$2908 VSS D7 \$129 VSS nfet_03v3 L=0.28U W=0.36U AS=0.1188P AD=0.1584P
+ PS=1.02U PD=1.6U
M$2909 \$131 \$236 VSS VSS nfet_03v3 L=0.28U W=0.36U AS=0.1584P AD=0.1584P
+ PS=1.6U PD=1.6U
M$2910 \$374 \$105 VSS VSS nfet_03v3 L=0.28U W=0.36U AS=0.1584P AD=0.0567P
+ PS=1.6U PD=0.675U
M$2911 \$236 \$131 \$374 VSS nfet_03v3 L=0.28U W=0.36U AS=0.0567P AD=0.1278P
+ PS=0.675U PD=1.07U
M$2912 \$132 WEM \$236 VSS nfet_03v3 L=0.28U W=0.36U AS=0.1278P AD=0.1188P
+ PS=1.07U PD=1.02U
M$2913 VSS D8 \$132 VSS nfet_03v3 L=0.28U W=0.36U AS=0.1188P AD=0.1584P
+ PS=1.02U PD=1.6U
M$2914 \$134 \$238 VSS VSS nfet_03v3 L=0.28U W=0.36U AS=0.1584P AD=0.1584P
+ PS=1.6U PD=1.6U
M$2915 \$367 \$105 VSS VSS nfet_03v3 L=0.28U W=0.36U AS=0.1584P AD=0.0567P
+ PS=1.6U PD=0.675U
M$2916 \$238 \$134 \$367 VSS nfet_03v3 L=0.28U W=0.36U AS=0.0567P AD=0.1278P
+ PS=0.675U PD=1.07U
M$2917 \$135 WEM \$238 VSS nfet_03v3 L=0.28U W=0.36U AS=0.1278P AD=0.1188P
+ PS=1.07U PD=1.02U
M$2918 VSS D9 \$135 VSS nfet_03v3 L=0.28U W=0.36U AS=0.1188P AD=0.1584P
+ PS=1.02U PD=1.6U
M$2919 \$137 \$240 VSS VSS nfet_03v3 L=0.28U W=0.36U AS=0.1584P AD=0.1584P
+ PS=1.6U PD=1.6U
M$2920 \$360 \$105 VSS VSS nfet_03v3 L=0.28U W=0.36U AS=0.1584P AD=0.0567P
+ PS=1.6U PD=0.675U
M$2921 \$240 \$137 \$360 VSS nfet_03v3 L=0.28U W=0.36U AS=0.0567P AD=0.1278P
+ PS=0.675U PD=1.07U
M$2922 \$138 WEM \$240 VSS nfet_03v3 L=0.28U W=0.36U AS=0.1278P AD=0.1188P
+ PS=1.07U PD=1.02U
M$2923 VSS D10 \$138 VSS nfet_03v3 L=0.28U W=0.36U AS=0.1188P AD=0.1584P
+ PS=1.02U PD=1.6U
M$2924 \$140 \$242 VSS VSS nfet_03v3 L=0.28U W=0.36U AS=0.1584P AD=0.1584P
+ PS=1.6U PD=1.6U
M$2925 \$352 \$105 VSS VSS nfet_03v3 L=0.28U W=0.36U AS=0.1584P AD=0.0567P
+ PS=1.6U PD=0.675U
M$2926 \$242 \$140 \$352 VSS nfet_03v3 L=0.28U W=0.36U AS=0.0567P AD=0.1278P
+ PS=0.675U PD=1.07U
M$2927 \$141 WEM \$242 VSS nfet_03v3 L=0.28U W=0.36U AS=0.1278P AD=0.1188P
+ PS=1.07U PD=1.02U
M$2928 VSS D11 \$141 VSS nfet_03v3 L=0.28U W=0.36U AS=0.1188P AD=0.1584P
+ PS=1.02U PD=1.6U
M$2929 \$143 \$244 VSS VSS nfet_03v3 L=0.28U W=0.36U AS=0.1584P AD=0.1584P
+ PS=1.6U PD=1.6U
M$2930 \$344 \$105 VSS VSS nfet_03v3 L=0.28U W=0.36U AS=0.1584P AD=0.0567P
+ PS=1.6U PD=0.675U
M$2931 \$244 \$143 \$344 VSS nfet_03v3 L=0.28U W=0.36U AS=0.0567P AD=0.1278P
+ PS=0.675U PD=1.07U
M$2932 \$144 WEM \$244 VSS nfet_03v3 L=0.28U W=0.36U AS=0.1278P AD=0.1188P
+ PS=1.07U PD=1.02U
M$2933 VSS D12 \$144 VSS nfet_03v3 L=0.28U W=0.36U AS=0.1188P AD=0.1584P
+ PS=1.02U PD=1.6U
M$2934 \$146 \$246 VSS VSS nfet_03v3 L=0.28U W=0.36U AS=0.1584P AD=0.1584P
+ PS=1.6U PD=1.6U
M$2935 \$336 \$105 VSS VSS nfet_03v3 L=0.28U W=0.36U AS=0.1584P AD=0.0567P
+ PS=1.6U PD=0.675U
M$2936 \$246 \$146 \$336 VSS nfet_03v3 L=0.28U W=0.36U AS=0.0567P AD=0.1278P
+ PS=0.675U PD=1.07U
M$2937 \$147 WEM \$246 VSS nfet_03v3 L=0.28U W=0.36U AS=0.1278P AD=0.1188P
+ PS=1.07U PD=1.02U
M$2938 VSS D13 \$147 VSS nfet_03v3 L=0.28U W=0.36U AS=0.1188P AD=0.1584P
+ PS=1.02U PD=1.6U
M$2939 \$149 \$248 VSS VSS nfet_03v3 L=0.28U W=0.36U AS=0.1584P AD=0.1584P
+ PS=1.6U PD=1.6U
M$2940 \$328 \$105 VSS VSS nfet_03v3 L=0.28U W=0.36U AS=0.1584P AD=0.0567P
+ PS=1.6U PD=0.675U
M$2941 \$248 \$149 \$328 VSS nfet_03v3 L=0.28U W=0.36U AS=0.0567P AD=0.1278P
+ PS=0.675U PD=1.07U
M$2942 \$150 WEM \$248 VSS nfet_03v3 L=0.28U W=0.36U AS=0.1278P AD=0.1188P
+ PS=1.07U PD=1.02U
M$2943 VSS D14 \$150 VSS nfet_03v3 L=0.28U W=0.36U AS=0.1188P AD=0.1584P
+ PS=1.02U PD=1.6U
M$2944 \$152 \$250 VSS VSS nfet_03v3 L=0.28U W=0.36U AS=0.1584P AD=0.1584P
+ PS=1.6U PD=1.6U
M$2945 \$321 \$105 VSS VSS nfet_03v3 L=0.28U W=0.36U AS=0.1584P AD=0.0567P
+ PS=1.6U PD=0.675U
M$2946 \$250 \$152 \$321 VSS nfet_03v3 L=0.28U W=0.36U AS=0.0567P AD=0.1278P
+ PS=0.675U PD=1.07U
M$2947 \$153 WEM \$250 VSS nfet_03v3 L=0.28U W=0.36U AS=0.1278P AD=0.1188P
+ PS=1.07U PD=1.02U
M$2948 VSS D15 \$153 VSS nfet_03v3 L=0.28U W=0.36U AS=0.1188P AD=0.1584P
+ PS=1.02U PD=1.6U
M$2949 \$417 WE15 VSS VSS nfet_03v3 L=0.28U W=0.72U AS=0.3168P AD=0.1872P
+ PS=2.32U PD=1.24U
M$2950 \$254 CLK \$417 VSS nfet_03v3 L=0.28U W=0.72U AS=0.1872P AD=0.3168P
+ PS=1.24U PD=2.32U
M$2951 \$255 \$254 VSS VSS nfet_03v3 L=0.28U W=0.635U AS=0.2794P AD=0.1651P
+ PS=2.15U PD=1.155U
M$2952 VSS \$254 \$255 VSS nfet_03v3 L=0.28U W=0.635U AS=0.1651P AD=0.1693P
+ PS=1.155U PD=1.19U
M$2953 \$523 \$255 VSS VSS nfet_03v3 L=0.28U W=0.67U AS=0.1693P AD=0.1943P
+ PS=1.19U PD=1.25U
M$2954 VSS \$255 \$523 VSS nfet_03v3 L=0.28U W=0.67U AS=0.1943P AD=0.2948P
+ PS=1.25U PD=2.22U
M$2955 \$256 \$106 VSS VSS nfet_03v3 L=0.28U W=0.36U AS=0.1584P AD=0.1188P
+ PS=1.6U PD=1.02U
M$2956 \$257 \$255 \$256 VSS nfet_03v3 L=0.28U W=0.36U AS=0.1188P AD=0.1278P
+ PS=1.02U PD=1.07U
M$2957 \$422 \$258 \$257 VSS nfet_03v3 L=0.28U W=0.36U AS=0.1278P AD=0.0567P
+ PS=1.07U PD=0.675U
M$2958 VSS \$523 \$422 VSS nfet_03v3 L=0.28U W=0.36U AS=0.0567P AD=0.1584P
+ PS=0.675U PD=1.6U
M$2959 VSS \$257 \$258 VSS nfet_03v3 L=0.28U W=0.36U AS=0.1584P AD=0.0972P
+ PS=1.6U PD=0.9U
M$2960 \$259 \$257 VSS VSS nfet_03v3 L=0.28U W=0.36U AS=0.0972P AD=0.18P
+ PS=0.9U PD=1.72U
M$2961 \$385 RA15 VSS VSS nfet_03v3 L=0.28U W=0.36U AS=0.1656P AD=0.1944P
+ PS=1.64U PD=1.8U
M$2962 \$259 RA15 \$51 VSS nfet_03v3 L=0.28U W=0.36U AS=0.1584P AD=0.1152P
+ PS=1.6U PD=1U
M$2963 \$52 RB15 \$259 VSS nfet_03v3 L=0.28U W=0.36U AS=0.1152P AD=0.1584P
+ PS=1U PD=1.6U
M$2964 VSS RB15 \$386 VSS nfet_03v3 L=0.28U W=0.36U AS=0.1854P AD=0.1584P
+ PS=1.75U PD=1.6U
M$2965 \$260 \$109 VSS VSS nfet_03v3 L=0.28U W=0.36U AS=0.1584P AD=0.1188P
+ PS=1.6U PD=1.02U
M$2966 \$261 \$255 \$260 VSS nfet_03v3 L=0.28U W=0.36U AS=0.1188P AD=0.1278P
+ PS=1.02U PD=1.07U
M$2967 \$430 \$262 \$261 VSS nfet_03v3 L=0.28U W=0.36U AS=0.1278P AD=0.0567P
+ PS=1.07U PD=0.675U
M$2968 VSS \$523 \$430 VSS nfet_03v3 L=0.28U W=0.36U AS=0.0567P AD=0.1584P
+ PS=0.675U PD=1.6U
M$2969 VSS \$261 \$262 VSS nfet_03v3 L=0.28U W=0.36U AS=0.1584P AD=0.0972P
+ PS=1.6U PD=0.9U
M$2970 \$263 \$261 VSS VSS nfet_03v3 L=0.28U W=0.36U AS=0.0972P AD=0.18P
+ PS=0.9U PD=1.72U
M$2971 \$387 RA15 VSS VSS nfet_03v3 L=0.28U W=0.36U AS=0.1656P AD=0.1944P
+ PS=1.64U PD=1.8U
M$2972 \$263 RA15 \$53 VSS nfet_03v3 L=0.28U W=0.36U AS=0.1584P AD=0.1152P
+ PS=1.6U PD=1U
M$2973 \$54 RB15 \$263 VSS nfet_03v3 L=0.28U W=0.36U AS=0.1152P AD=0.1584P
+ PS=1U PD=1.6U
M$2974 VSS RB15 \$388 VSS nfet_03v3 L=0.28U W=0.36U AS=0.1854P AD=0.1584P
+ PS=1.75U PD=1.6U
M$2975 \$264 \$112 VSS VSS nfet_03v3 L=0.28U W=0.36U AS=0.1584P AD=0.1188P
+ PS=1.6U PD=1.02U
M$2976 \$265 \$255 \$264 VSS nfet_03v3 L=0.28U W=0.36U AS=0.1188P AD=0.1278P
+ PS=1.02U PD=1.07U
M$2977 \$439 \$266 \$265 VSS nfet_03v3 L=0.28U W=0.36U AS=0.1278P AD=0.0567P
+ PS=1.07U PD=0.675U
M$2978 VSS \$523 \$439 VSS nfet_03v3 L=0.28U W=0.36U AS=0.0567P AD=0.1584P
+ PS=0.675U PD=1.6U
M$2979 VSS \$265 \$266 VSS nfet_03v3 L=0.28U W=0.36U AS=0.1584P AD=0.0972P
+ PS=1.6U PD=0.9U
M$2980 \$267 \$265 VSS VSS nfet_03v3 L=0.28U W=0.36U AS=0.0972P AD=0.18P
+ PS=0.9U PD=1.72U
M$2981 \$389 RA15 VSS VSS nfet_03v3 L=0.28U W=0.36U AS=0.1656P AD=0.1944P
+ PS=1.64U PD=1.8U
M$2982 \$267 RA15 \$55 VSS nfet_03v3 L=0.28U W=0.36U AS=0.1584P AD=0.1152P
+ PS=1.6U PD=1U
M$2983 \$56 RB15 \$267 VSS nfet_03v3 L=0.28U W=0.36U AS=0.1152P AD=0.1584P
+ PS=1U PD=1.6U
M$2984 VSS RB15 \$390 VSS nfet_03v3 L=0.28U W=0.36U AS=0.1854P AD=0.1584P
+ PS=1.75U PD=1.6U
M$2985 \$268 \$115 VSS VSS nfet_03v3 L=0.28U W=0.36U AS=0.1584P AD=0.1188P
+ PS=1.6U PD=1.02U
M$2986 \$269 \$255 \$268 VSS nfet_03v3 L=0.28U W=0.36U AS=0.1188P AD=0.1278P
+ PS=1.02U PD=1.07U
M$2987 \$448 \$270 \$269 VSS nfet_03v3 L=0.28U W=0.36U AS=0.1278P AD=0.0567P
+ PS=1.07U PD=0.675U
M$2988 VSS \$523 \$448 VSS nfet_03v3 L=0.28U W=0.36U AS=0.0567P AD=0.1584P
+ PS=0.675U PD=1.6U
M$2989 VSS \$269 \$270 VSS nfet_03v3 L=0.28U W=0.36U AS=0.1584P AD=0.0972P
+ PS=1.6U PD=0.9U
M$2990 \$271 \$269 VSS VSS nfet_03v3 L=0.28U W=0.36U AS=0.0972P AD=0.18P
+ PS=0.9U PD=1.72U
M$2991 \$391 RA15 VSS VSS nfet_03v3 L=0.28U W=0.36U AS=0.1656P AD=0.1944P
+ PS=1.64U PD=1.8U
M$2992 \$271 RA15 \$57 VSS nfet_03v3 L=0.28U W=0.36U AS=0.1584P AD=0.1152P
+ PS=1.6U PD=1U
M$2993 \$58 RB15 \$271 VSS nfet_03v3 L=0.28U W=0.36U AS=0.1152P AD=0.1584P
+ PS=1U PD=1.6U
M$2994 VSS RB15 \$392 VSS nfet_03v3 L=0.28U W=0.36U AS=0.1854P AD=0.1584P
+ PS=1.75U PD=1.6U
M$2995 \$272 \$118 VSS VSS nfet_03v3 L=0.28U W=0.36U AS=0.1584P AD=0.1188P
+ PS=1.6U PD=1.02U
M$2996 \$273 \$255 \$272 VSS nfet_03v3 L=0.28U W=0.36U AS=0.1188P AD=0.1278P
+ PS=1.02U PD=1.07U
M$2997 \$456 \$274 \$273 VSS nfet_03v3 L=0.28U W=0.36U AS=0.1278P AD=0.0567P
+ PS=1.07U PD=0.675U
M$2998 VSS \$523 \$456 VSS nfet_03v3 L=0.28U W=0.36U AS=0.0567P AD=0.1584P
+ PS=0.675U PD=1.6U
M$2999 VSS \$273 \$274 VSS nfet_03v3 L=0.28U W=0.36U AS=0.1584P AD=0.0972P
+ PS=1.6U PD=0.9U
M$3000 \$275 \$273 VSS VSS nfet_03v3 L=0.28U W=0.36U AS=0.0972P AD=0.18P
+ PS=0.9U PD=1.72U
M$3001 \$393 RA15 VSS VSS nfet_03v3 L=0.28U W=0.36U AS=0.1656P AD=0.1944P
+ PS=1.64U PD=1.8U
M$3002 \$275 RA15 \$59 VSS nfet_03v3 L=0.28U W=0.36U AS=0.1584P AD=0.1152P
+ PS=1.6U PD=1U
M$3003 \$60 RB15 \$275 VSS nfet_03v3 L=0.28U W=0.36U AS=0.1152P AD=0.1584P
+ PS=1U PD=1.6U
M$3004 VSS RB15 \$394 VSS nfet_03v3 L=0.28U W=0.36U AS=0.1854P AD=0.1584P
+ PS=1.75U PD=1.6U
M$3005 \$276 \$121 VSS VSS nfet_03v3 L=0.28U W=0.36U AS=0.1584P AD=0.1188P
+ PS=1.6U PD=1.02U
M$3006 \$277 \$255 \$276 VSS nfet_03v3 L=0.28U W=0.36U AS=0.1188P AD=0.1278P
+ PS=1.02U PD=1.07U
M$3007 \$464 \$278 \$277 VSS nfet_03v3 L=0.28U W=0.36U AS=0.1278P AD=0.0567P
+ PS=1.07U PD=0.675U
M$3008 VSS \$523 \$464 VSS nfet_03v3 L=0.28U W=0.36U AS=0.0567P AD=0.1584P
+ PS=0.675U PD=1.6U
M$3009 VSS \$277 \$278 VSS nfet_03v3 L=0.28U W=0.36U AS=0.1584P AD=0.0972P
+ PS=1.6U PD=0.9U
M$3010 \$279 \$277 VSS VSS nfet_03v3 L=0.28U W=0.36U AS=0.0972P AD=0.18P
+ PS=0.9U PD=1.72U
M$3011 \$395 RA15 VSS VSS nfet_03v3 L=0.28U W=0.36U AS=0.1656P AD=0.1944P
+ PS=1.64U PD=1.8U
M$3012 \$279 RA15 \$61 VSS nfet_03v3 L=0.28U W=0.36U AS=0.1584P AD=0.1152P
+ PS=1.6U PD=1U
M$3013 \$62 RB15 \$279 VSS nfet_03v3 L=0.28U W=0.36U AS=0.1152P AD=0.1584P
+ PS=1U PD=1.6U
M$3014 VSS RB15 \$396 VSS nfet_03v3 L=0.28U W=0.36U AS=0.1854P AD=0.1584P
+ PS=1.75U PD=1.6U
M$3015 \$280 \$124 VSS VSS nfet_03v3 L=0.28U W=0.36U AS=0.1584P AD=0.1188P
+ PS=1.6U PD=1.02U
M$3016 \$281 \$255 \$280 VSS nfet_03v3 L=0.28U W=0.36U AS=0.1188P AD=0.1278P
+ PS=1.02U PD=1.07U
M$3017 \$474 \$282 \$281 VSS nfet_03v3 L=0.28U W=0.36U AS=0.1278P AD=0.0567P
+ PS=1.07U PD=0.675U
M$3018 VSS \$523 \$474 VSS nfet_03v3 L=0.28U W=0.36U AS=0.0567P AD=0.1584P
+ PS=0.675U PD=1.6U
M$3019 VSS \$281 \$282 VSS nfet_03v3 L=0.28U W=0.36U AS=0.1584P AD=0.0972P
+ PS=1.6U PD=0.9U
M$3020 \$283 \$281 VSS VSS nfet_03v3 L=0.28U W=0.36U AS=0.0972P AD=0.18P
+ PS=0.9U PD=1.72U
M$3021 \$397 RA15 VSS VSS nfet_03v3 L=0.28U W=0.36U AS=0.1656P AD=0.1944P
+ PS=1.64U PD=1.8U
M$3022 \$283 RA15 \$63 VSS nfet_03v3 L=0.28U W=0.36U AS=0.1584P AD=0.1152P
+ PS=1.6U PD=1U
M$3023 \$64 RB15 \$283 VSS nfet_03v3 L=0.28U W=0.36U AS=0.1152P AD=0.1584P
+ PS=1U PD=1.6U
M$3024 VSS RB15 \$398 VSS nfet_03v3 L=0.28U W=0.36U AS=0.1854P AD=0.1584P
+ PS=1.75U PD=1.6U
M$3025 \$284 \$127 VSS VSS nfet_03v3 L=0.28U W=0.36U AS=0.1584P AD=0.1188P
+ PS=1.6U PD=1.02U
M$3026 \$285 \$255 \$284 VSS nfet_03v3 L=0.28U W=0.36U AS=0.1188P AD=0.1278P
+ PS=1.02U PD=1.07U
M$3027 \$482 \$286 \$285 VSS nfet_03v3 L=0.28U W=0.36U AS=0.1278P AD=0.0567P
+ PS=1.07U PD=0.675U
M$3028 VSS \$523 \$482 VSS nfet_03v3 L=0.28U W=0.36U AS=0.0567P AD=0.1584P
+ PS=0.675U PD=1.6U
M$3029 VSS \$285 \$286 VSS nfet_03v3 L=0.28U W=0.36U AS=0.1584P AD=0.0972P
+ PS=1.6U PD=0.9U
M$3030 \$287 \$285 VSS VSS nfet_03v3 L=0.28U W=0.36U AS=0.0972P AD=0.18P
+ PS=0.9U PD=1.72U
M$3031 \$399 RA15 VSS VSS nfet_03v3 L=0.28U W=0.36U AS=0.1656P AD=0.1944P
+ PS=1.64U PD=1.8U
M$3032 \$287 RA15 \$65 VSS nfet_03v3 L=0.28U W=0.36U AS=0.1584P AD=0.1152P
+ PS=1.6U PD=1U
M$3033 \$66 RB15 \$287 VSS nfet_03v3 L=0.28U W=0.36U AS=0.1152P AD=0.1584P
+ PS=1U PD=1.6U
M$3034 VSS RB15 \$400 VSS nfet_03v3 L=0.28U W=0.36U AS=0.1854P AD=0.1584P
+ PS=1.75U PD=1.6U
M$3035 \$288 \$130 VSS VSS nfet_03v3 L=0.28U W=0.36U AS=0.1584P AD=0.1188P
+ PS=1.6U PD=1.02U
M$3036 \$289 \$255 \$288 VSS nfet_03v3 L=0.28U W=0.36U AS=0.1188P AD=0.1278P
+ PS=1.02U PD=1.07U
M$3037 \$490 \$290 \$289 VSS nfet_03v3 L=0.28U W=0.36U AS=0.1278P AD=0.0567P
+ PS=1.07U PD=0.675U
M$3038 VSS \$523 \$490 VSS nfet_03v3 L=0.28U W=0.36U AS=0.0567P AD=0.1584P
+ PS=0.675U PD=1.6U
M$3039 VSS \$289 \$290 VSS nfet_03v3 L=0.28U W=0.36U AS=0.1584P AD=0.0972P
+ PS=1.6U PD=0.9U
M$3040 \$291 \$289 VSS VSS nfet_03v3 L=0.28U W=0.36U AS=0.0972P AD=0.18P
+ PS=0.9U PD=1.72U
M$3041 \$401 RA15 VSS VSS nfet_03v3 L=0.28U W=0.36U AS=0.1656P AD=0.1944P
+ PS=1.64U PD=1.8U
M$3042 \$291 RA15 \$67 VSS nfet_03v3 L=0.28U W=0.36U AS=0.1584P AD=0.1152P
+ PS=1.6U PD=1U
M$3043 \$68 RB15 \$291 VSS nfet_03v3 L=0.28U W=0.36U AS=0.1152P AD=0.1584P
+ PS=1U PD=1.6U
M$3044 VSS RB15 \$402 VSS nfet_03v3 L=0.28U W=0.36U AS=0.1854P AD=0.1584P
+ PS=1.75U PD=1.6U
M$3045 \$292 \$133 VSS VSS nfet_03v3 L=0.28U W=0.36U AS=0.1584P AD=0.1188P
+ PS=1.6U PD=1.02U
M$3046 \$293 \$255 \$292 VSS nfet_03v3 L=0.28U W=0.36U AS=0.1188P AD=0.1278P
+ PS=1.02U PD=1.07U
M$3047 \$498 \$294 \$293 VSS nfet_03v3 L=0.28U W=0.36U AS=0.1278P AD=0.0567P
+ PS=1.07U PD=0.675U
M$3048 VSS \$523 \$498 VSS nfet_03v3 L=0.28U W=0.36U AS=0.0567P AD=0.1584P
+ PS=0.675U PD=1.6U
M$3049 VSS \$293 \$294 VSS nfet_03v3 L=0.28U W=0.36U AS=0.1584P AD=0.0972P
+ PS=1.6U PD=0.9U
M$3050 \$295 \$293 VSS VSS nfet_03v3 L=0.28U W=0.36U AS=0.0972P AD=0.18P
+ PS=0.9U PD=1.72U
M$3051 \$403 RA15 VSS VSS nfet_03v3 L=0.28U W=0.36U AS=0.1656P AD=0.1944P
+ PS=1.64U PD=1.8U
M$3052 \$295 RA15 \$69 VSS nfet_03v3 L=0.28U W=0.36U AS=0.1584P AD=0.1152P
+ PS=1.6U PD=1U
M$3053 \$70 RB15 \$295 VSS nfet_03v3 L=0.28U W=0.36U AS=0.1152P AD=0.1584P
+ PS=1U PD=1.6U
M$3054 VSS RB15 \$404 VSS nfet_03v3 L=0.28U W=0.36U AS=0.1854P AD=0.1584P
+ PS=1.75U PD=1.6U
M$3055 \$296 \$136 VSS VSS nfet_03v3 L=0.28U W=0.36U AS=0.1584P AD=0.1188P
+ PS=1.6U PD=1.02U
M$3056 \$297 \$255 \$296 VSS nfet_03v3 L=0.28U W=0.36U AS=0.1188P AD=0.1278P
+ PS=1.02U PD=1.07U
M$3057 \$507 \$298 \$297 VSS nfet_03v3 L=0.28U W=0.36U AS=0.1278P AD=0.0567P
+ PS=1.07U PD=0.675U
M$3058 VSS \$523 \$507 VSS nfet_03v3 L=0.28U W=0.36U AS=0.0567P AD=0.1584P
+ PS=0.675U PD=1.6U
M$3059 VSS \$297 \$298 VSS nfet_03v3 L=0.28U W=0.36U AS=0.1584P AD=0.0972P
+ PS=1.6U PD=0.9U
M$3060 \$299 \$297 VSS VSS nfet_03v3 L=0.28U W=0.36U AS=0.0972P AD=0.18P
+ PS=0.9U PD=1.72U
M$3061 \$405 RA15 VSS VSS nfet_03v3 L=0.28U W=0.36U AS=0.1656P AD=0.1944P
+ PS=1.64U PD=1.8U
M$3062 \$299 RA15 \$71 VSS nfet_03v3 L=0.28U W=0.36U AS=0.1584P AD=0.1152P
+ PS=1.6U PD=1U
M$3063 \$72 RB15 \$299 VSS nfet_03v3 L=0.28U W=0.36U AS=0.1152P AD=0.1584P
+ PS=1U PD=1.6U
M$3064 VSS RB15 \$406 VSS nfet_03v3 L=0.28U W=0.36U AS=0.1854P AD=0.1584P
+ PS=1.75U PD=1.6U
M$3065 \$300 \$139 VSS VSS nfet_03v3 L=0.28U W=0.36U AS=0.1584P AD=0.1188P
+ PS=1.6U PD=1.02U
M$3066 \$301 \$255 \$300 VSS nfet_03v3 L=0.28U W=0.36U AS=0.1188P AD=0.1278P
+ PS=1.02U PD=1.07U
M$3067 \$515 \$302 \$301 VSS nfet_03v3 L=0.28U W=0.36U AS=0.1278P AD=0.0567P
+ PS=1.07U PD=0.675U
M$3068 VSS \$523 \$515 VSS nfet_03v3 L=0.28U W=0.36U AS=0.0567P AD=0.1584P
+ PS=0.675U PD=1.6U
M$3069 VSS \$301 \$302 VSS nfet_03v3 L=0.28U W=0.36U AS=0.1584P AD=0.0972P
+ PS=1.6U PD=0.9U
M$3070 \$303 \$301 VSS VSS nfet_03v3 L=0.28U W=0.36U AS=0.0972P AD=0.18P
+ PS=0.9U PD=1.72U
M$3071 \$407 RA15 VSS VSS nfet_03v3 L=0.28U W=0.36U AS=0.1656P AD=0.1944P
+ PS=1.64U PD=1.8U
M$3072 \$303 RA15 \$73 VSS nfet_03v3 L=0.28U W=0.36U AS=0.1584P AD=0.1152P
+ PS=1.6U PD=1U
M$3073 \$74 RB15 \$303 VSS nfet_03v3 L=0.28U W=0.36U AS=0.1152P AD=0.1584P
+ PS=1U PD=1.6U
M$3074 VSS RB15 \$408 VSS nfet_03v3 L=0.28U W=0.36U AS=0.1854P AD=0.1584P
+ PS=1.75U PD=1.6U
M$3075 \$304 \$142 VSS VSS nfet_03v3 L=0.28U W=0.36U AS=0.1584P AD=0.1188P
+ PS=1.6U PD=1.02U
M$3076 \$305 \$255 \$304 VSS nfet_03v3 L=0.28U W=0.36U AS=0.1188P AD=0.1278P
+ PS=1.02U PD=1.07U
M$3077 \$494 \$306 \$305 VSS nfet_03v3 L=0.28U W=0.36U AS=0.1278P AD=0.0567P
+ PS=1.07U PD=0.675U
M$3078 VSS \$523 \$494 VSS nfet_03v3 L=0.28U W=0.36U AS=0.0567P AD=0.1584P
+ PS=0.675U PD=1.6U
M$3079 VSS \$305 \$306 VSS nfet_03v3 L=0.28U W=0.36U AS=0.1584P AD=0.0972P
+ PS=1.6U PD=0.9U
M$3080 \$307 \$305 VSS VSS nfet_03v3 L=0.28U W=0.36U AS=0.0972P AD=0.18P
+ PS=0.9U PD=1.72U
M$3081 \$409 RA15 VSS VSS nfet_03v3 L=0.28U W=0.36U AS=0.1656P AD=0.1944P
+ PS=1.64U PD=1.8U
M$3082 \$307 RA15 \$75 VSS nfet_03v3 L=0.28U W=0.36U AS=0.1584P AD=0.1152P
+ PS=1.6U PD=1U
M$3083 \$76 RB15 \$307 VSS nfet_03v3 L=0.28U W=0.36U AS=0.1152P AD=0.1584P
+ PS=1U PD=1.6U
M$3084 VSS RB15 \$410 VSS nfet_03v3 L=0.28U W=0.36U AS=0.1854P AD=0.1584P
+ PS=1.75U PD=1.6U
M$3085 \$308 \$145 VSS VSS nfet_03v3 L=0.28U W=0.36U AS=0.1584P AD=0.1188P
+ PS=1.6U PD=1.02U
M$3086 \$309 \$255 \$308 VSS nfet_03v3 L=0.28U W=0.36U AS=0.1188P AD=0.1278P
+ PS=1.02U PD=1.07U
M$3087 \$473 \$310 \$309 VSS nfet_03v3 L=0.28U W=0.36U AS=0.1278P AD=0.0567P
+ PS=1.07U PD=0.675U
M$3088 VSS \$523 \$473 VSS nfet_03v3 L=0.28U W=0.36U AS=0.0567P AD=0.1584P
+ PS=0.675U PD=1.6U
M$3089 VSS \$309 \$310 VSS nfet_03v3 L=0.28U W=0.36U AS=0.1584P AD=0.0972P
+ PS=1.6U PD=0.9U
M$3090 \$311 \$309 VSS VSS nfet_03v3 L=0.28U W=0.36U AS=0.0972P AD=0.18P
+ PS=0.9U PD=1.72U
M$3091 \$411 RA15 VSS VSS nfet_03v3 L=0.28U W=0.36U AS=0.1656P AD=0.1944P
+ PS=1.64U PD=1.8U
M$3092 \$311 RA15 \$77 VSS nfet_03v3 L=0.28U W=0.36U AS=0.1584P AD=0.1152P
+ PS=1.6U PD=1U
M$3093 \$78 RB15 \$311 VSS nfet_03v3 L=0.28U W=0.36U AS=0.1152P AD=0.1584P
+ PS=1U PD=1.6U
M$3094 VSS RB15 \$412 VSS nfet_03v3 L=0.28U W=0.36U AS=0.1854P AD=0.1584P
+ PS=1.75U PD=1.6U
M$3095 \$312 \$148 VSS VSS nfet_03v3 L=0.28U W=0.36U AS=0.1584P AD=0.1188P
+ PS=1.6U PD=1.02U
M$3096 \$313 \$255 \$312 VSS nfet_03v3 L=0.28U W=0.36U AS=0.1188P AD=0.1278P
+ PS=1.02U PD=1.07U
M$3097 \$454 \$314 \$313 VSS nfet_03v3 L=0.28U W=0.36U AS=0.1278P AD=0.0567P
+ PS=1.07U PD=0.675U
M$3098 VSS \$523 \$454 VSS nfet_03v3 L=0.28U W=0.36U AS=0.0567P AD=0.1584P
+ PS=0.675U PD=1.6U
M$3099 VSS \$313 \$314 VSS nfet_03v3 L=0.28U W=0.36U AS=0.1584P AD=0.0972P
+ PS=1.6U PD=0.9U
M$3100 \$315 \$313 VSS VSS nfet_03v3 L=0.28U W=0.36U AS=0.0972P AD=0.18P
+ PS=0.9U PD=1.72U
M$3101 \$413 RA15 VSS VSS nfet_03v3 L=0.28U W=0.36U AS=0.1656P AD=0.1944P
+ PS=1.64U PD=1.8U
M$3102 \$315 RA15 \$79 VSS nfet_03v3 L=0.28U W=0.36U AS=0.1584P AD=0.1152P
+ PS=1.6U PD=1U
M$3103 \$80 RB15 \$315 VSS nfet_03v3 L=0.28U W=0.36U AS=0.1152P AD=0.1584P
+ PS=1U PD=1.6U
M$3104 VSS RB15 \$414 VSS nfet_03v3 L=0.28U W=0.36U AS=0.1854P AD=0.1584P
+ PS=1.75U PD=1.6U
M$3105 \$316 \$151 VSS VSS nfet_03v3 L=0.28U W=0.36U AS=0.1584P AD=0.1188P
+ PS=1.6U PD=1.02U
M$3106 \$317 \$255 \$316 VSS nfet_03v3 L=0.28U W=0.36U AS=0.1188P AD=0.1278P
+ PS=1.02U PD=1.07U
M$3107 \$433 \$318 \$317 VSS nfet_03v3 L=0.28U W=0.36U AS=0.1278P AD=0.0567P
+ PS=1.07U PD=0.675U
M$3108 VSS \$523 \$433 VSS nfet_03v3 L=0.28U W=0.36U AS=0.0567P AD=0.1584P
+ PS=0.675U PD=1.6U
M$3109 VSS \$317 \$318 VSS nfet_03v3 L=0.28U W=0.36U AS=0.1584P AD=0.0972P
+ PS=1.6U PD=0.9U
M$3110 \$319 \$317 VSS VSS nfet_03v3 L=0.28U W=0.36U AS=0.0972P AD=0.18P
+ PS=0.9U PD=1.72U
M$3111 \$415 RA15 VSS VSS nfet_03v3 L=0.28U W=0.36U AS=0.1656P AD=0.1944P
+ PS=1.64U PD=1.8U
M$3112 \$319 RA15 \$81 VSS nfet_03v3 L=0.28U W=0.36U AS=0.1584P AD=0.1152P
+ PS=1.6U PD=1U
M$3113 \$82 RB15 \$319 VSS nfet_03v3 L=0.28U W=0.36U AS=0.1152P AD=0.1584P
+ PS=1U PD=1.6U
M$3114 VSS RB15 \$416 VSS nfet_03v3 L=0.28U W=0.36U AS=0.1854P AD=0.1584P
+ PS=1.75U PD=1.6U
M$3115 \$834 WE14 VSS VSS nfet_03v3 L=0.28U W=0.72U AS=0.3168P AD=0.1872P
+ PS=2.32U PD=1.24U
M$3116 \$629 CLK \$834 VSS nfet_03v3 L=0.28U W=0.72U AS=0.1872P AD=0.3168P
+ PS=1.24U PD=2.32U
M$3117 \$630 \$629 VSS VSS nfet_03v3 L=0.28U W=0.635U AS=0.2794P AD=0.1651P
+ PS=2.15U PD=1.155U
M$3118 \$630 \$629 VSS VSS nfet_03v3 L=0.28U W=0.635U AS=0.1693P AD=0.1651P
+ PS=1.19U PD=1.155U
M$3119 \$631 \$630 VSS VSS nfet_03v3 L=0.28U W=0.67U AS=0.1693P AD=0.1943P
+ PS=1.19U PD=1.25U
M$3120 VSS \$630 \$631 VSS nfet_03v3 L=0.28U W=0.67U AS=0.1943P AD=0.2948P
+ PS=1.25U PD=2.22U
M$3121 \$637 RB14 VSS VSS nfet_03v3 L=0.28U W=0.36U AS=0.1656P AD=0.1944P
+ PS=1.64U PD=1.8U
M$3122 \$635 RB14 \$51 VSS nfet_03v3 L=0.28U W=0.36U AS=0.1584P AD=0.1152P
+ PS=1.6U PD=1U
M$3123 \$52 RA14 \$635 VSS nfet_03v3 L=0.28U W=0.36U AS=0.1152P AD=0.1584P
+ PS=1U PD=1.6U
M$3124 VSS RA14 \$638 VSS nfet_03v3 L=0.28U W=0.36U AS=0.1854P AD=0.1584P
+ PS=1.75U PD=1.6U
M$3125 \$643 RB14 VSS VSS nfet_03v3 L=0.28U W=0.36U AS=0.1656P AD=0.1944P
+ PS=1.64U PD=1.8U
M$3126 \$642 RB14 \$53 VSS nfet_03v3 L=0.28U W=0.36U AS=0.1584P AD=0.1152P
+ PS=1.6U PD=1U
M$3127 \$54 RA14 \$642 VSS nfet_03v3 L=0.28U W=0.36U AS=0.1152P AD=0.1584P
+ PS=1U PD=1.6U
M$3128 VSS RA14 \$644 VSS nfet_03v3 L=0.28U W=0.36U AS=0.1854P AD=0.1584P
+ PS=1.75U PD=1.6U
M$3129 \$649 RB14 VSS VSS nfet_03v3 L=0.28U W=0.36U AS=0.1656P AD=0.1944P
+ PS=1.64U PD=1.8U
M$3130 \$648 RB14 \$55 VSS nfet_03v3 L=0.28U W=0.36U AS=0.1584P AD=0.1152P
+ PS=1.6U PD=1U
M$3131 \$56 RA14 \$648 VSS nfet_03v3 L=0.28U W=0.36U AS=0.1152P AD=0.1584P
+ PS=1U PD=1.6U
M$3132 VSS RA14 \$650 VSS nfet_03v3 L=0.28U W=0.36U AS=0.1854P AD=0.1584P
+ PS=1.75U PD=1.6U
M$3133 \$655 RB14 VSS VSS nfet_03v3 L=0.28U W=0.36U AS=0.1656P AD=0.1944P
+ PS=1.64U PD=1.8U
M$3134 \$654 RB14 \$57 VSS nfet_03v3 L=0.28U W=0.36U AS=0.1584P AD=0.1152P
+ PS=1.6U PD=1U
M$3135 \$58 RA14 \$654 VSS nfet_03v3 L=0.28U W=0.36U AS=0.1152P AD=0.1584P
+ PS=1U PD=1.6U
M$3136 VSS RA14 \$656 VSS nfet_03v3 L=0.28U W=0.36U AS=0.1854P AD=0.1584P
+ PS=1.75U PD=1.6U
M$3137 \$661 RB14 VSS VSS nfet_03v3 L=0.28U W=0.36U AS=0.1656P AD=0.1944P
+ PS=1.64U PD=1.8U
M$3138 \$660 RB14 \$59 VSS nfet_03v3 L=0.28U W=0.36U AS=0.1584P AD=0.1152P
+ PS=1.6U PD=1U
M$3139 \$60 RA14 \$660 VSS nfet_03v3 L=0.28U W=0.36U AS=0.1152P AD=0.1584P
+ PS=1U PD=1.6U
M$3140 VSS RA14 \$662 VSS nfet_03v3 L=0.28U W=0.36U AS=0.1854P AD=0.1584P
+ PS=1.75U PD=1.6U
M$3141 \$667 RB14 VSS VSS nfet_03v3 L=0.28U W=0.36U AS=0.1656P AD=0.1944P
+ PS=1.64U PD=1.8U
M$3142 \$666 RB14 \$61 VSS nfet_03v3 L=0.28U W=0.36U AS=0.1584P AD=0.1152P
+ PS=1.6U PD=1U
M$3143 \$62 RA14 \$666 VSS nfet_03v3 L=0.28U W=0.36U AS=0.1152P AD=0.1584P
+ PS=1U PD=1.6U
M$3144 VSS RA14 \$668 VSS nfet_03v3 L=0.28U W=0.36U AS=0.1854P AD=0.1584P
+ PS=1.75U PD=1.6U
M$3145 \$673 RB14 VSS VSS nfet_03v3 L=0.28U W=0.36U AS=0.1656P AD=0.1944P
+ PS=1.64U PD=1.8U
M$3146 \$672 RB14 \$63 VSS nfet_03v3 L=0.28U W=0.36U AS=0.1584P AD=0.1152P
+ PS=1.6U PD=1U
M$3147 \$64 RA14 \$672 VSS nfet_03v3 L=0.28U W=0.36U AS=0.1152P AD=0.1584P
+ PS=1U PD=1.6U
M$3148 VSS RA14 \$674 VSS nfet_03v3 L=0.28U W=0.36U AS=0.1854P AD=0.1584P
+ PS=1.75U PD=1.6U
M$3149 \$679 RB14 VSS VSS nfet_03v3 L=0.28U W=0.36U AS=0.1656P AD=0.1944P
+ PS=1.64U PD=1.8U
M$3150 \$678 RB14 \$65 VSS nfet_03v3 L=0.28U W=0.36U AS=0.1584P AD=0.1152P
+ PS=1.6U PD=1U
M$3151 \$66 RA14 \$678 VSS nfet_03v3 L=0.28U W=0.36U AS=0.1152P AD=0.1584P
+ PS=1U PD=1.6U
M$3152 VSS RA14 \$680 VSS nfet_03v3 L=0.28U W=0.36U AS=0.1854P AD=0.1584P
+ PS=1.75U PD=1.6U
M$3153 \$685 RB14 VSS VSS nfet_03v3 L=0.28U W=0.36U AS=0.1656P AD=0.1944P
+ PS=1.64U PD=1.8U
M$3154 \$684 RB14 \$67 VSS nfet_03v3 L=0.28U W=0.36U AS=0.1584P AD=0.1152P
+ PS=1.6U PD=1U
M$3155 \$68 RA14 \$684 VSS nfet_03v3 L=0.28U W=0.36U AS=0.1152P AD=0.1584P
+ PS=1U PD=1.6U
M$3156 VSS RA14 \$686 VSS nfet_03v3 L=0.28U W=0.36U AS=0.1854P AD=0.1584P
+ PS=1.75U PD=1.6U
M$3157 \$691 RB14 VSS VSS nfet_03v3 L=0.28U W=0.36U AS=0.1656P AD=0.1944P
+ PS=1.64U PD=1.8U
M$3158 \$690 RB14 \$69 VSS nfet_03v3 L=0.28U W=0.36U AS=0.1584P AD=0.1152P
+ PS=1.6U PD=1U
M$3159 \$70 RA14 \$690 VSS nfet_03v3 L=0.28U W=0.36U AS=0.1152P AD=0.1584P
+ PS=1U PD=1.6U
M$3160 VSS RA14 \$692 VSS nfet_03v3 L=0.28U W=0.36U AS=0.1854P AD=0.1584P
+ PS=1.75U PD=1.6U
M$3161 \$697 RB14 VSS VSS nfet_03v3 L=0.28U W=0.36U AS=0.1656P AD=0.1944P
+ PS=1.64U PD=1.8U
M$3162 \$696 RB14 \$71 VSS nfet_03v3 L=0.28U W=0.36U AS=0.1584P AD=0.1152P
+ PS=1.6U PD=1U
M$3163 \$72 RA14 \$696 VSS nfet_03v3 L=0.28U W=0.36U AS=0.1152P AD=0.1584P
+ PS=1U PD=1.6U
M$3164 VSS RA14 \$698 VSS nfet_03v3 L=0.28U W=0.36U AS=0.1854P AD=0.1584P
+ PS=1.75U PD=1.6U
M$3165 \$703 RB14 VSS VSS nfet_03v3 L=0.28U W=0.36U AS=0.1656P AD=0.1944P
+ PS=1.64U PD=1.8U
M$3166 \$702 RB14 \$73 VSS nfet_03v3 L=0.28U W=0.36U AS=0.1584P AD=0.1152P
+ PS=1.6U PD=1U
M$3167 \$74 RA14 \$702 VSS nfet_03v3 L=0.28U W=0.36U AS=0.1152P AD=0.1584P
+ PS=1U PD=1.6U
M$3168 VSS RA14 \$704 VSS nfet_03v3 L=0.28U W=0.36U AS=0.1854P AD=0.1584P
+ PS=1.75U PD=1.6U
M$3169 \$709 RB14 VSS VSS nfet_03v3 L=0.28U W=0.36U AS=0.1656P AD=0.1944P
+ PS=1.64U PD=1.8U
M$3170 \$708 RB14 \$75 VSS nfet_03v3 L=0.28U W=0.36U AS=0.1584P AD=0.1152P
+ PS=1.6U PD=1U
M$3171 \$76 RA14 \$708 VSS nfet_03v3 L=0.28U W=0.36U AS=0.1152P AD=0.1584P
+ PS=1U PD=1.6U
M$3172 VSS RA14 \$710 VSS nfet_03v3 L=0.28U W=0.36U AS=0.1854P AD=0.1584P
+ PS=1.75U PD=1.6U
M$3173 \$715 RB14 VSS VSS nfet_03v3 L=0.28U W=0.36U AS=0.1656P AD=0.1944P
+ PS=1.64U PD=1.8U
M$3174 \$714 RB14 \$77 VSS nfet_03v3 L=0.28U W=0.36U AS=0.1584P AD=0.1152P
+ PS=1.6U PD=1U
M$3175 \$78 RA14 \$714 VSS nfet_03v3 L=0.28U W=0.36U AS=0.1152P AD=0.1584P
+ PS=1U PD=1.6U
M$3176 VSS RA14 \$716 VSS nfet_03v3 L=0.28U W=0.36U AS=0.1854P AD=0.1584P
+ PS=1.75U PD=1.6U
M$3177 \$721 RB14 VSS VSS nfet_03v3 L=0.28U W=0.36U AS=0.1656P AD=0.1944P
+ PS=1.64U PD=1.8U
M$3178 \$720 RB14 \$79 VSS nfet_03v3 L=0.28U W=0.36U AS=0.1584P AD=0.1152P
+ PS=1.6U PD=1U
M$3179 \$80 RA14 \$720 VSS nfet_03v3 L=0.28U W=0.36U AS=0.1152P AD=0.1584P
+ PS=1U PD=1.6U
M$3180 VSS RA14 \$722 VSS nfet_03v3 L=0.28U W=0.36U AS=0.1854P AD=0.1584P
+ PS=1.75U PD=1.6U
M$3181 \$727 RB14 VSS VSS nfet_03v3 L=0.28U W=0.36U AS=0.1656P AD=0.1944P
+ PS=1.64U PD=1.8U
M$3182 \$726 RB14 \$81 VSS nfet_03v3 L=0.28U W=0.36U AS=0.1584P AD=0.1152P
+ PS=1.6U PD=1U
M$3183 \$82 RA14 \$726 VSS nfet_03v3 L=0.28U W=0.36U AS=0.1152P AD=0.1584P
+ PS=1U PD=1.6U
M$3184 VSS RA14 \$728 VSS nfet_03v3 L=0.28U W=0.36U AS=0.1854P AD=0.1584P
+ PS=1.75U PD=1.6U
M$3185 \$632 \$106 VSS VSS nfet_03v3 L=0.28U W=0.36U AS=0.1584P AD=0.1188P
+ PS=1.6U PD=1.02U
M$3186 \$633 \$630 \$632 VSS nfet_03v3 L=0.28U W=0.36U AS=0.1188P AD=0.1278P
+ PS=1.02U PD=1.07U
M$3187 \$838 \$634 \$633 VSS nfet_03v3 L=0.28U W=0.36U AS=0.1278P AD=0.0567P
+ PS=1.07U PD=0.675U
M$3188 VSS \$631 \$838 VSS nfet_03v3 L=0.28U W=0.36U AS=0.0567P AD=0.1584P
+ PS=0.675U PD=1.6U
M$3189 VSS \$633 \$634 VSS nfet_03v3 L=0.28U W=0.36U AS=0.1584P AD=0.0972P
+ PS=1.6U PD=0.9U
M$3190 \$635 \$633 VSS VSS nfet_03v3 L=0.28U W=0.36U AS=0.0972P AD=0.18P
+ PS=0.9U PD=1.72U
M$3191 \$639 \$109 VSS VSS nfet_03v3 L=0.28U W=0.36U AS=0.1584P AD=0.1188P
+ PS=1.6U PD=1.02U
M$3192 \$640 \$630 \$639 VSS nfet_03v3 L=0.28U W=0.36U AS=0.1188P AD=0.1278P
+ PS=1.02U PD=1.07U
M$3193 \$845 \$641 \$640 VSS nfet_03v3 L=0.28U W=0.36U AS=0.1278P AD=0.0567P
+ PS=1.07U PD=0.675U
M$3194 VSS \$631 \$845 VSS nfet_03v3 L=0.28U W=0.36U AS=0.0567P AD=0.1584P
+ PS=0.675U PD=1.6U
M$3195 VSS \$640 \$641 VSS nfet_03v3 L=0.28U W=0.36U AS=0.1584P AD=0.0972P
+ PS=1.6U PD=0.9U
M$3196 \$642 \$640 VSS VSS nfet_03v3 L=0.28U W=0.36U AS=0.0972P AD=0.18P
+ PS=0.9U PD=1.72U
M$3197 \$645 \$112 VSS VSS nfet_03v3 L=0.28U W=0.36U AS=0.1584P AD=0.1188P
+ PS=1.6U PD=1.02U
M$3198 \$646 \$630 \$645 VSS nfet_03v3 L=0.28U W=0.36U AS=0.1188P AD=0.1278P
+ PS=1.02U PD=1.07U
M$3199 \$852 \$647 \$646 VSS nfet_03v3 L=0.28U W=0.36U AS=0.1278P AD=0.0567P
+ PS=1.07U PD=0.675U
M$3200 VSS \$631 \$852 VSS nfet_03v3 L=0.28U W=0.36U AS=0.0567P AD=0.1584P
+ PS=0.675U PD=1.6U
M$3201 VSS \$646 \$647 VSS nfet_03v3 L=0.28U W=0.36U AS=0.1584P AD=0.0972P
+ PS=1.6U PD=0.9U
M$3202 \$648 \$646 VSS VSS nfet_03v3 L=0.28U W=0.36U AS=0.0972P AD=0.18P
+ PS=0.9U PD=1.72U
M$3203 \$651 \$115 VSS VSS nfet_03v3 L=0.28U W=0.36U AS=0.1584P AD=0.1188P
+ PS=1.6U PD=1.02U
M$3204 \$652 \$630 \$651 VSS nfet_03v3 L=0.28U W=0.36U AS=0.1188P AD=0.1278P
+ PS=1.02U PD=1.07U
M$3205 \$860 \$653 \$652 VSS nfet_03v3 L=0.28U W=0.36U AS=0.1278P AD=0.0567P
+ PS=1.07U PD=0.675U
M$3206 VSS \$631 \$860 VSS nfet_03v3 L=0.28U W=0.36U AS=0.0567P AD=0.1584P
+ PS=0.675U PD=1.6U
M$3207 VSS \$652 \$653 VSS nfet_03v3 L=0.28U W=0.36U AS=0.1584P AD=0.0972P
+ PS=1.6U PD=0.9U
M$3208 \$654 \$652 VSS VSS nfet_03v3 L=0.28U W=0.36U AS=0.0972P AD=0.18P
+ PS=0.9U PD=1.72U
M$3209 \$657 \$118 VSS VSS nfet_03v3 L=0.28U W=0.36U AS=0.1584P AD=0.1188P
+ PS=1.6U PD=1.02U
M$3210 \$658 \$630 \$657 VSS nfet_03v3 L=0.28U W=0.36U AS=0.1188P AD=0.1278P
+ PS=1.02U PD=1.07U
M$3211 \$866 \$659 \$658 VSS nfet_03v3 L=0.28U W=0.36U AS=0.1278P AD=0.0567P
+ PS=1.07U PD=0.675U
M$3212 VSS \$631 \$866 VSS nfet_03v3 L=0.28U W=0.36U AS=0.0567P AD=0.1584P
+ PS=0.675U PD=1.6U
M$3213 VSS \$658 \$659 VSS nfet_03v3 L=0.28U W=0.36U AS=0.1584P AD=0.0972P
+ PS=1.6U PD=0.9U
M$3214 \$660 \$658 VSS VSS nfet_03v3 L=0.28U W=0.36U AS=0.0972P AD=0.18P
+ PS=0.9U PD=1.72U
M$3215 \$663 \$121 VSS VSS nfet_03v3 L=0.28U W=0.36U AS=0.1584P AD=0.1188P
+ PS=1.6U PD=1.02U
M$3216 \$664 \$630 \$663 VSS nfet_03v3 L=0.28U W=0.36U AS=0.1188P AD=0.1278P
+ PS=1.02U PD=1.07U
M$3217 \$874 \$665 \$664 VSS nfet_03v3 L=0.28U W=0.36U AS=0.1278P AD=0.0567P
+ PS=1.07U PD=0.675U
M$3218 VSS \$631 \$874 VSS nfet_03v3 L=0.28U W=0.36U AS=0.0567P AD=0.1584P
+ PS=0.675U PD=1.6U
M$3219 VSS \$664 \$665 VSS nfet_03v3 L=0.28U W=0.36U AS=0.1584P AD=0.0972P
+ PS=1.6U PD=0.9U
M$3220 \$666 \$664 VSS VSS nfet_03v3 L=0.28U W=0.36U AS=0.0972P AD=0.18P
+ PS=0.9U PD=1.72U
M$3221 \$669 \$124 VSS VSS nfet_03v3 L=0.28U W=0.36U AS=0.1584P AD=0.1188P
+ PS=1.6U PD=1.02U
M$3222 \$670 \$630 \$669 VSS nfet_03v3 L=0.28U W=0.36U AS=0.1188P AD=0.1278P
+ PS=1.02U PD=1.07U
M$3223 \$880 \$671 \$670 VSS nfet_03v3 L=0.28U W=0.36U AS=0.1278P AD=0.0567P
+ PS=1.07U PD=0.675U
M$3224 VSS \$631 \$880 VSS nfet_03v3 L=0.28U W=0.36U AS=0.0567P AD=0.1584P
+ PS=0.675U PD=1.6U
M$3225 VSS \$670 \$671 VSS nfet_03v3 L=0.28U W=0.36U AS=0.1584P AD=0.0972P
+ PS=1.6U PD=0.9U
M$3226 \$672 \$670 VSS VSS nfet_03v3 L=0.28U W=0.36U AS=0.0972P AD=0.18P
+ PS=0.9U PD=1.72U
M$3227 \$675 \$127 VSS VSS nfet_03v3 L=0.28U W=0.36U AS=0.1584P AD=0.1188P
+ PS=1.6U PD=1.02U
M$3228 \$676 \$630 \$675 VSS nfet_03v3 L=0.28U W=0.36U AS=0.1188P AD=0.1278P
+ PS=1.02U PD=1.07U
M$3229 \$888 \$677 \$676 VSS nfet_03v3 L=0.28U W=0.36U AS=0.1278P AD=0.0567P
+ PS=1.07U PD=0.675U
M$3230 VSS \$631 \$888 VSS nfet_03v3 L=0.28U W=0.36U AS=0.0567P AD=0.1584P
+ PS=0.675U PD=1.6U
M$3231 VSS \$676 \$677 VSS nfet_03v3 L=0.28U W=0.36U AS=0.1584P AD=0.0972P
+ PS=1.6U PD=0.9U
M$3232 \$678 \$676 VSS VSS nfet_03v3 L=0.28U W=0.36U AS=0.0972P AD=0.18P
+ PS=0.9U PD=1.72U
M$3233 \$681 \$130 VSS VSS nfet_03v3 L=0.28U W=0.36U AS=0.1584P AD=0.1188P
+ PS=1.6U PD=1.02U
M$3234 \$682 \$630 \$681 VSS nfet_03v3 L=0.28U W=0.36U AS=0.1188P AD=0.1278P
+ PS=1.02U PD=1.07U
M$3235 \$896 \$683 \$682 VSS nfet_03v3 L=0.28U W=0.36U AS=0.1278P AD=0.0567P
+ PS=1.07U PD=0.675U
M$3236 VSS \$631 \$896 VSS nfet_03v3 L=0.28U W=0.36U AS=0.0567P AD=0.1584P
+ PS=0.675U PD=1.6U
M$3237 VSS \$682 \$683 VSS nfet_03v3 L=0.28U W=0.36U AS=0.1584P AD=0.0972P
+ PS=1.6U PD=0.9U
M$3238 \$684 \$682 VSS VSS nfet_03v3 L=0.28U W=0.36U AS=0.0972P AD=0.18P
+ PS=0.9U PD=1.72U
M$3239 \$687 \$133 VSS VSS nfet_03v3 L=0.28U W=0.36U AS=0.1584P AD=0.1188P
+ PS=1.6U PD=1.02U
M$3240 \$688 \$630 \$687 VSS nfet_03v3 L=0.28U W=0.36U AS=0.1188P AD=0.1278P
+ PS=1.02U PD=1.07U
M$3241 \$902 \$689 \$688 VSS nfet_03v3 L=0.28U W=0.36U AS=0.1278P AD=0.0567P
+ PS=1.07U PD=0.675U
M$3242 VSS \$631 \$902 VSS nfet_03v3 L=0.28U W=0.36U AS=0.0567P AD=0.1584P
+ PS=0.675U PD=1.6U
M$3243 VSS \$688 \$689 VSS nfet_03v3 L=0.28U W=0.36U AS=0.1584P AD=0.0972P
+ PS=1.6U PD=0.9U
M$3244 \$690 \$688 VSS VSS nfet_03v3 L=0.28U W=0.36U AS=0.0972P AD=0.18P
+ PS=0.9U PD=1.72U
M$3245 \$693 \$136 VSS VSS nfet_03v3 L=0.28U W=0.36U AS=0.1584P AD=0.1188P
+ PS=1.6U PD=1.02U
M$3246 \$694 \$630 \$693 VSS nfet_03v3 L=0.28U W=0.36U AS=0.1188P AD=0.1278P
+ PS=1.02U PD=1.07U
M$3247 \$909 \$695 \$694 VSS nfet_03v3 L=0.28U W=0.36U AS=0.1278P AD=0.0567P
+ PS=1.07U PD=0.675U
M$3248 VSS \$631 \$909 VSS nfet_03v3 L=0.28U W=0.36U AS=0.0567P AD=0.1584P
+ PS=0.675U PD=1.6U
M$3249 VSS \$694 \$695 VSS nfet_03v3 L=0.28U W=0.36U AS=0.1584P AD=0.0972P
+ PS=1.6U PD=0.9U
M$3250 \$696 \$694 VSS VSS nfet_03v3 L=0.28U W=0.36U AS=0.0972P AD=0.18P
+ PS=0.9U PD=1.72U
M$3251 \$699 \$139 VSS VSS nfet_03v3 L=0.28U W=0.36U AS=0.1584P AD=0.1188P
+ PS=1.6U PD=1.02U
M$3252 \$700 \$630 \$699 VSS nfet_03v3 L=0.28U W=0.36U AS=0.1188P AD=0.1278P
+ PS=1.02U PD=1.07U
M$3253 \$916 \$701 \$700 VSS nfet_03v3 L=0.28U W=0.36U AS=0.1278P AD=0.0567P
+ PS=1.07U PD=0.675U
M$3254 VSS \$631 \$916 VSS nfet_03v3 L=0.28U W=0.36U AS=0.0567P AD=0.1584P
+ PS=0.675U PD=1.6U
M$3255 VSS \$700 \$701 VSS nfet_03v3 L=0.28U W=0.36U AS=0.1584P AD=0.0972P
+ PS=1.6U PD=0.9U
M$3256 \$702 \$700 VSS VSS nfet_03v3 L=0.28U W=0.36U AS=0.0972P AD=0.18P
+ PS=0.9U PD=1.72U
M$3257 \$705 \$142 VSS VSS nfet_03v3 L=0.28U W=0.36U AS=0.1584P AD=0.1188P
+ PS=1.6U PD=1.02U
M$3258 \$706 \$630 \$705 VSS nfet_03v3 L=0.28U W=0.36U AS=0.1188P AD=0.1278P
+ PS=1.02U PD=1.07U
M$3259 \$924 \$707 \$706 VSS nfet_03v3 L=0.28U W=0.36U AS=0.1278P AD=0.0567P
+ PS=1.07U PD=0.675U
M$3260 VSS \$631 \$924 VSS nfet_03v3 L=0.28U W=0.36U AS=0.0567P AD=0.1584P
+ PS=0.675U PD=1.6U
M$3261 VSS \$706 \$707 VSS nfet_03v3 L=0.28U W=0.36U AS=0.1584P AD=0.0972P
+ PS=1.6U PD=0.9U
M$3262 \$708 \$706 VSS VSS nfet_03v3 L=0.28U W=0.36U AS=0.0972P AD=0.18P
+ PS=0.9U PD=1.72U
M$3263 \$711 \$145 VSS VSS nfet_03v3 L=0.28U W=0.36U AS=0.1584P AD=0.1188P
+ PS=1.6U PD=1.02U
M$3264 \$712 \$630 \$711 VSS nfet_03v3 L=0.28U W=0.36U AS=0.1188P AD=0.1278P
+ PS=1.02U PD=1.07U
M$3265 \$931 \$713 \$712 VSS nfet_03v3 L=0.28U W=0.36U AS=0.1278P AD=0.0567P
+ PS=1.07U PD=0.675U
M$3266 VSS \$631 \$931 VSS nfet_03v3 L=0.28U W=0.36U AS=0.0567P AD=0.1584P
+ PS=0.675U PD=1.6U
M$3267 VSS \$712 \$713 VSS nfet_03v3 L=0.28U W=0.36U AS=0.1584P AD=0.0972P
+ PS=1.6U PD=0.9U
M$3268 \$714 \$712 VSS VSS nfet_03v3 L=0.28U W=0.36U AS=0.0972P AD=0.18P
+ PS=0.9U PD=1.72U
M$3269 \$717 \$148 VSS VSS nfet_03v3 L=0.28U W=0.36U AS=0.1584P AD=0.1188P
+ PS=1.6U PD=1.02U
M$3270 \$718 \$630 \$717 VSS nfet_03v3 L=0.28U W=0.36U AS=0.1188P AD=0.1278P
+ PS=1.02U PD=1.07U
M$3271 \$895 \$719 \$718 VSS nfet_03v3 L=0.28U W=0.36U AS=0.1278P AD=0.0567P
+ PS=1.07U PD=0.675U
M$3272 VSS \$631 \$895 VSS nfet_03v3 L=0.28U W=0.36U AS=0.0567P AD=0.1584P
+ PS=0.675U PD=1.6U
M$3273 VSS \$718 \$719 VSS nfet_03v3 L=0.28U W=0.36U AS=0.1584P AD=0.0972P
+ PS=1.6U PD=0.9U
M$3274 \$720 \$718 VSS VSS nfet_03v3 L=0.28U W=0.36U AS=0.0972P AD=0.18P
+ PS=0.9U PD=1.72U
M$3275 \$723 \$151 VSS VSS nfet_03v3 L=0.28U W=0.36U AS=0.1584P AD=0.1188P
+ PS=1.6U PD=1.02U
M$3276 \$724 \$630 \$723 VSS nfet_03v3 L=0.28U W=0.36U AS=0.1188P AD=0.1278P
+ PS=1.02U PD=1.07U
M$3277 \$859 \$725 \$724 VSS nfet_03v3 L=0.28U W=0.36U AS=0.1278P AD=0.0567P
+ PS=1.07U PD=0.675U
M$3278 VSS \$631 \$859 VSS nfet_03v3 L=0.28U W=0.36U AS=0.0567P AD=0.1584P
+ PS=0.675U PD=1.6U
M$3279 VSS \$724 \$725 VSS nfet_03v3 L=0.28U W=0.36U AS=0.1584P AD=0.0972P
+ PS=1.6U PD=0.9U
M$3280 \$726 \$724 VSS VSS nfet_03v3 L=0.28U W=0.36U AS=0.0972P AD=0.18P
+ PS=0.9U PD=1.72U
M$3281 \$1089 WE13 VSS VSS nfet_03v3 L=0.28U W=0.72U AS=0.3168P AD=0.1872P
+ PS=2.32U PD=1.24U
M$3282 \$948 CLK \$1089 VSS nfet_03v3 L=0.28U W=0.72U AS=0.1872P AD=0.3168P
+ PS=1.24U PD=2.32U
M$3283 \$949 \$948 VSS VSS nfet_03v3 L=0.28U W=0.635U AS=0.2794P AD=0.1651P
+ PS=2.15U PD=1.155U
M$3284 VSS \$948 \$949 VSS nfet_03v3 L=0.28U W=0.635U AS=0.1651P AD=0.1693P
+ PS=1.155U PD=1.19U
M$3285 \$1142 \$949 VSS VSS nfet_03v3 L=0.28U W=0.67U AS=0.1693P AD=0.1943P
+ PS=1.19U PD=1.25U
M$3286 VSS \$949 \$1142 VSS nfet_03v3 L=0.28U W=0.67U AS=0.1943P AD=0.2948P
+ PS=1.25U PD=2.22U
M$3287 \$950 \$106 VSS VSS nfet_03v3 L=0.28U W=0.36U AS=0.1584P AD=0.1188P
+ PS=1.6U PD=1.02U
M$3288 \$951 \$949 \$950 VSS nfet_03v3 L=0.28U W=0.36U AS=0.1188P AD=0.1278P
+ PS=1.02U PD=1.07U
M$3289 \$988 \$1039 \$951 VSS nfet_03v3 L=0.28U W=0.36U AS=0.1278P AD=0.0567P
+ PS=1.07U PD=0.675U
M$3290 VSS \$1142 \$988 VSS nfet_03v3 L=0.28U W=0.36U AS=0.0567P AD=0.1584P
+ PS=0.675U PD=1.6U
M$3291 VSS \$951 \$1039 VSS nfet_03v3 L=0.28U W=0.36U AS=0.1584P AD=0.0972P
+ PS=1.6U PD=0.9U
M$3292 \$932 \$951 VSS VSS nfet_03v3 L=0.28U W=0.36U AS=0.0972P AD=0.18P
+ PS=0.9U PD=1.72U
M$3293 \$952 \$109 VSS VSS nfet_03v3 L=0.28U W=0.36U AS=0.1584P AD=0.1188P
+ PS=1.6U PD=1.02U
M$3294 \$953 \$949 \$952 VSS nfet_03v3 L=0.28U W=0.36U AS=0.1188P AD=0.1278P
+ PS=1.02U PD=1.07U
M$3295 \$999 \$1043 \$953 VSS nfet_03v3 L=0.28U W=0.36U AS=0.1278P AD=0.0567P
+ PS=1.07U PD=0.675U
M$3296 VSS \$1142 \$999 VSS nfet_03v3 L=0.28U W=0.36U AS=0.0567P AD=0.1584P
+ PS=0.675U PD=1.6U
M$3297 VSS \$953 \$1043 VSS nfet_03v3 L=0.28U W=0.36U AS=0.1584P AD=0.0972P
+ PS=1.6U PD=0.9U
M$3298 \$933 \$953 VSS VSS nfet_03v3 L=0.28U W=0.36U AS=0.0972P AD=0.18P
+ PS=0.9U PD=1.72U
M$3299 \$954 \$112 VSS VSS nfet_03v3 L=0.28U W=0.36U AS=0.1584P AD=0.1188P
+ PS=1.6U PD=1.02U
M$3300 \$955 \$949 \$954 VSS nfet_03v3 L=0.28U W=0.36U AS=0.1188P AD=0.1278P
+ PS=1.02U PD=1.07U
M$3301 \$1008 \$1046 \$955 VSS nfet_03v3 L=0.28U W=0.36U AS=0.1278P AD=0.0567P
+ PS=1.07U PD=0.675U
M$3302 VSS \$1142 \$1008 VSS nfet_03v3 L=0.28U W=0.36U AS=0.0567P AD=0.1584P
+ PS=0.675U PD=1.6U
M$3303 VSS \$955 \$1046 VSS nfet_03v3 L=0.28U W=0.36U AS=0.1584P AD=0.0972P
+ PS=1.6U PD=0.9U
M$3304 \$934 \$955 VSS VSS nfet_03v3 L=0.28U W=0.36U AS=0.0972P AD=0.18P
+ PS=0.9U PD=1.72U
M$3305 \$956 \$115 VSS VSS nfet_03v3 L=0.28U W=0.36U AS=0.1584P AD=0.1188P
+ PS=1.6U PD=1.02U
M$3306 \$957 \$949 \$956 VSS nfet_03v3 L=0.28U W=0.36U AS=0.1188P AD=0.1278P
+ PS=1.02U PD=1.07U
M$3307 \$1018 \$1049 \$957 VSS nfet_03v3 L=0.28U W=0.36U AS=0.1278P AD=0.0567P
+ PS=1.07U PD=0.675U
M$3308 VSS \$1142 \$1018 VSS nfet_03v3 L=0.28U W=0.36U AS=0.0567P AD=0.1584P
+ PS=0.675U PD=1.6U
M$3309 VSS \$957 \$1049 VSS nfet_03v3 L=0.28U W=0.36U AS=0.1584P AD=0.0972P
+ PS=1.6U PD=0.9U
M$3310 \$935 \$957 VSS VSS nfet_03v3 L=0.28U W=0.36U AS=0.0972P AD=0.18P
+ PS=0.9U PD=1.72U
M$3311 \$958 \$118 VSS VSS nfet_03v3 L=0.28U W=0.36U AS=0.1584P AD=0.1188P
+ PS=1.6U PD=1.02U
M$3312 \$959 \$949 \$958 VSS nfet_03v3 L=0.28U W=0.36U AS=0.1188P AD=0.1278P
+ PS=1.02U PD=1.07U
M$3313 \$1029 \$1052 \$959 VSS nfet_03v3 L=0.28U W=0.36U AS=0.1278P AD=0.0567P
+ PS=1.07U PD=0.675U
M$3314 VSS \$1142 \$1029 VSS nfet_03v3 L=0.28U W=0.36U AS=0.0567P AD=0.1584P
+ PS=0.675U PD=1.6U
M$3315 VSS \$959 \$1052 VSS nfet_03v3 L=0.28U W=0.36U AS=0.1584P AD=0.0972P
+ PS=1.6U PD=0.9U
M$3316 \$936 \$959 VSS VSS nfet_03v3 L=0.28U W=0.36U AS=0.0972P AD=0.18P
+ PS=0.9U PD=1.72U
M$3317 \$960 \$121 VSS VSS nfet_03v3 L=0.28U W=0.36U AS=0.1584P AD=0.1188P
+ PS=1.6U PD=1.02U
M$3318 \$961 \$949 \$960 VSS nfet_03v3 L=0.28U W=0.36U AS=0.1188P AD=0.1278P
+ PS=1.02U PD=1.07U
M$3319 \$1034 \$1055 \$961 VSS nfet_03v3 L=0.28U W=0.36U AS=0.1278P AD=0.0567P
+ PS=1.07U PD=0.675U
M$3320 VSS \$1142 \$1034 VSS nfet_03v3 L=0.28U W=0.36U AS=0.0567P AD=0.1584P
+ PS=0.675U PD=1.6U
M$3321 VSS \$961 \$1055 VSS nfet_03v3 L=0.28U W=0.36U AS=0.1584P AD=0.0972P
+ PS=1.6U PD=0.9U
M$3322 \$937 \$961 VSS VSS nfet_03v3 L=0.28U W=0.36U AS=0.0972P AD=0.18P
+ PS=0.9U PD=1.72U
M$3323 \$962 \$124 VSS VSS nfet_03v3 L=0.28U W=0.36U AS=0.1584P AD=0.1188P
+ PS=1.6U PD=1.02U
M$3324 \$963 \$949 \$962 VSS nfet_03v3 L=0.28U W=0.36U AS=0.1188P AD=0.1278P
+ PS=1.02U PD=1.07U
M$3325 \$1030 \$1058 \$963 VSS nfet_03v3 L=0.28U W=0.36U AS=0.1278P AD=0.0567P
+ PS=1.07U PD=0.675U
M$3326 VSS \$1142 \$1030 VSS nfet_03v3 L=0.28U W=0.36U AS=0.0567P AD=0.1584P
+ PS=0.675U PD=1.6U
M$3327 VSS \$963 \$1058 VSS nfet_03v3 L=0.28U W=0.36U AS=0.1584P AD=0.0972P
+ PS=1.6U PD=0.9U
M$3328 \$938 \$963 VSS VSS nfet_03v3 L=0.28U W=0.36U AS=0.0972P AD=0.18P
+ PS=0.9U PD=1.72U
M$3329 \$964 \$127 VSS VSS nfet_03v3 L=0.28U W=0.36U AS=0.1584P AD=0.1188P
+ PS=1.6U PD=1.02U
M$3330 \$965 \$949 \$964 VSS nfet_03v3 L=0.28U W=0.36U AS=0.1188P AD=0.1278P
+ PS=1.02U PD=1.07U
M$3331 \$1023 \$1061 \$965 VSS nfet_03v3 L=0.28U W=0.36U AS=0.1278P AD=0.0567P
+ PS=1.07U PD=0.675U
M$3332 VSS \$1142 \$1023 VSS nfet_03v3 L=0.28U W=0.36U AS=0.0567P AD=0.1584P
+ PS=0.675U PD=1.6U
M$3333 VSS \$965 \$1061 VSS nfet_03v3 L=0.28U W=0.36U AS=0.1584P AD=0.0972P
+ PS=1.6U PD=0.9U
M$3334 \$939 \$965 VSS VSS nfet_03v3 L=0.28U W=0.36U AS=0.0972P AD=0.18P
+ PS=0.9U PD=1.72U
M$3335 \$966 \$130 VSS VSS nfet_03v3 L=0.28U W=0.36U AS=0.1584P AD=0.1188P
+ PS=1.6U PD=1.02U
M$3336 \$967 \$949 \$966 VSS nfet_03v3 L=0.28U W=0.36U AS=0.1188P AD=0.1278P
+ PS=1.02U PD=1.07U
M$3337 \$1020 \$1064 \$967 VSS nfet_03v3 L=0.28U W=0.36U AS=0.1278P AD=0.0567P
+ PS=1.07U PD=0.675U
M$3338 VSS \$1142 \$1020 VSS nfet_03v3 L=0.28U W=0.36U AS=0.0567P AD=0.1584P
+ PS=0.675U PD=1.6U
M$3339 VSS \$967 \$1064 VSS nfet_03v3 L=0.28U W=0.36U AS=0.1584P AD=0.0972P
+ PS=1.6U PD=0.9U
M$3340 \$940 \$967 VSS VSS nfet_03v3 L=0.28U W=0.36U AS=0.0972P AD=0.18P
+ PS=0.9U PD=1.72U
M$3341 \$968 \$133 VSS VSS nfet_03v3 L=0.28U W=0.36U AS=0.1584P AD=0.1188P
+ PS=1.6U PD=1.02U
M$3342 \$969 \$949 \$968 VSS nfet_03v3 L=0.28U W=0.36U AS=0.1188P AD=0.1278P
+ PS=1.02U PD=1.07U
M$3343 \$1015 \$1067 \$969 VSS nfet_03v3 L=0.28U W=0.36U AS=0.1278P AD=0.0567P
+ PS=1.07U PD=0.675U
M$3344 VSS \$1142 \$1015 VSS nfet_03v3 L=0.28U W=0.36U AS=0.0567P AD=0.1584P
+ PS=0.675U PD=1.6U
M$3345 VSS \$969 \$1067 VSS nfet_03v3 L=0.28U W=0.36U AS=0.1584P AD=0.0972P
+ PS=1.6U PD=0.9U
M$3346 \$941 \$969 VSS VSS nfet_03v3 L=0.28U W=0.36U AS=0.0972P AD=0.18P
+ PS=0.9U PD=1.72U
M$3347 \$970 \$136 VSS VSS nfet_03v3 L=0.28U W=0.36U AS=0.1584P AD=0.1188P
+ PS=1.6U PD=1.02U
M$3348 \$971 \$949 \$970 VSS nfet_03v3 L=0.28U W=0.36U AS=0.1188P AD=0.1278P
+ PS=1.02U PD=1.07U
M$3349 \$1009 \$1070 \$971 VSS nfet_03v3 L=0.28U W=0.36U AS=0.1278P AD=0.0567P
+ PS=1.07U PD=0.675U
M$3350 VSS \$1142 \$1009 VSS nfet_03v3 L=0.28U W=0.36U AS=0.0567P AD=0.1584P
+ PS=0.675U PD=1.6U
M$3351 VSS \$971 \$1070 VSS nfet_03v3 L=0.28U W=0.36U AS=0.1584P AD=0.0972P
+ PS=1.6U PD=0.9U
M$3352 \$942 \$971 VSS VSS nfet_03v3 L=0.28U W=0.36U AS=0.0972P AD=0.18P
+ PS=0.9U PD=1.72U
M$3353 \$972 \$139 VSS VSS nfet_03v3 L=0.28U W=0.36U AS=0.1584P AD=0.1188P
+ PS=1.6U PD=1.02U
M$3354 \$973 \$949 \$972 VSS nfet_03v3 L=0.28U W=0.36U AS=0.1188P AD=0.1278P
+ PS=1.02U PD=1.07U
M$3355 \$1005 \$1073 \$973 VSS nfet_03v3 L=0.28U W=0.36U AS=0.1278P AD=0.0567P
+ PS=1.07U PD=0.675U
M$3356 VSS \$1142 \$1005 VSS nfet_03v3 L=0.28U W=0.36U AS=0.0567P AD=0.1584P
+ PS=0.675U PD=1.6U
M$3357 VSS \$973 \$1073 VSS nfet_03v3 L=0.28U W=0.36U AS=0.1584P AD=0.0972P
+ PS=1.6U PD=0.9U
M$3358 \$943 \$973 VSS VSS nfet_03v3 L=0.28U W=0.36U AS=0.0972P AD=0.18P
+ PS=0.9U PD=1.72U
M$3359 \$974 \$142 VSS VSS nfet_03v3 L=0.28U W=0.36U AS=0.1584P AD=0.1188P
+ PS=1.6U PD=1.02U
M$3360 \$975 \$949 \$974 VSS nfet_03v3 L=0.28U W=0.36U AS=0.1188P AD=0.1278P
+ PS=1.02U PD=1.07U
M$3361 \$1001 \$1076 \$975 VSS nfet_03v3 L=0.28U W=0.36U AS=0.1278P AD=0.0567P
+ PS=1.07U PD=0.675U
M$3362 VSS \$1142 \$1001 VSS nfet_03v3 L=0.28U W=0.36U AS=0.0567P AD=0.1584P
+ PS=0.675U PD=1.6U
M$3363 VSS \$975 \$1076 VSS nfet_03v3 L=0.28U W=0.36U AS=0.1584P AD=0.0972P
+ PS=1.6U PD=0.9U
M$3364 \$944 \$975 VSS VSS nfet_03v3 L=0.28U W=0.36U AS=0.0972P AD=0.18P
+ PS=0.9U PD=1.72U
M$3365 \$976 \$145 VSS VSS nfet_03v3 L=0.28U W=0.36U AS=0.1584P AD=0.1188P
+ PS=1.6U PD=1.02U
M$3366 \$977 \$949 \$976 VSS nfet_03v3 L=0.28U W=0.36U AS=0.1188P AD=0.1278P
+ PS=1.02U PD=1.07U
M$3367 \$994 \$1079 \$977 VSS nfet_03v3 L=0.28U W=0.36U AS=0.1278P AD=0.0567P
+ PS=1.07U PD=0.675U
M$3368 VSS \$1142 \$994 VSS nfet_03v3 L=0.28U W=0.36U AS=0.0567P AD=0.1584P
+ PS=0.675U PD=1.6U
M$3369 VSS \$977 \$1079 VSS nfet_03v3 L=0.28U W=0.36U AS=0.1584P AD=0.0972P
+ PS=1.6U PD=0.9U
M$3370 \$945 \$977 VSS VSS nfet_03v3 L=0.28U W=0.36U AS=0.0972P AD=0.18P
+ PS=0.9U PD=1.72U
M$3371 \$978 \$148 VSS VSS nfet_03v3 L=0.28U W=0.36U AS=0.1584P AD=0.1188P
+ PS=1.6U PD=1.02U
M$3372 \$979 \$949 \$978 VSS nfet_03v3 L=0.28U W=0.36U AS=0.1188P AD=0.1278P
+ PS=1.02U PD=1.07U
M$3373 \$989 \$1082 \$979 VSS nfet_03v3 L=0.28U W=0.36U AS=0.1278P AD=0.0567P
+ PS=1.07U PD=0.675U
M$3374 VSS \$1142 \$989 VSS nfet_03v3 L=0.28U W=0.36U AS=0.0567P AD=0.1584P
+ PS=0.675U PD=1.6U
M$3375 VSS \$979 \$1082 VSS nfet_03v3 L=0.28U W=0.36U AS=0.1584P AD=0.0972P
+ PS=1.6U PD=0.9U
M$3376 \$946 \$979 VSS VSS nfet_03v3 L=0.28U W=0.36U AS=0.0972P AD=0.18P
+ PS=0.9U PD=1.72U
M$3377 \$980 \$151 VSS VSS nfet_03v3 L=0.28U W=0.36U AS=0.1584P AD=0.1188P
+ PS=1.6U PD=1.02U
M$3378 \$981 \$949 \$980 VSS nfet_03v3 L=0.28U W=0.36U AS=0.1188P AD=0.1278P
+ PS=1.02U PD=1.07U
M$3379 \$984 \$1085 \$981 VSS nfet_03v3 L=0.28U W=0.36U AS=0.1278P AD=0.0567P
+ PS=1.07U PD=0.675U
M$3380 VSS \$1142 \$984 VSS nfet_03v3 L=0.28U W=0.36U AS=0.0567P AD=0.1584P
+ PS=0.675U PD=1.6U
M$3381 VSS \$981 \$1085 VSS nfet_03v3 L=0.28U W=0.36U AS=0.1584P AD=0.0972P
+ PS=1.6U PD=0.9U
M$3382 \$947 \$981 VSS VSS nfet_03v3 L=0.28U W=0.36U AS=0.0972P AD=0.18P
+ PS=0.9U PD=1.72U
M$3383 \$1258 RB12 VSS VSS nfet_03v3 L=0.28U W=0.36U AS=0.1656P AD=0.1944P
+ PS=1.64U PD=1.8U
M$3384 \$1041 RA13 VSS VSS nfet_03v3 L=0.28U W=0.36U AS=0.1656P AD=0.1944P
+ PS=1.64U PD=1.8U
M$3385 \$1257 RB12 \$51 VSS nfet_03v3 L=0.28U W=0.36U AS=0.1584P AD=0.1152P
+ PS=1.6U PD=1U
M$3386 \$52 RA12 \$1257 VSS nfet_03v3 L=0.28U W=0.36U AS=0.1152P AD=0.1584P
+ PS=1U PD=1.6U
M$3387 \$932 RA13 \$51 VSS nfet_03v3 L=0.28U W=0.36U AS=0.1584P AD=0.1152P
+ PS=1.6U PD=1U
M$3388 \$52 RB13 \$932 VSS nfet_03v3 L=0.28U W=0.36U AS=0.1152P AD=0.1584P
+ PS=1U PD=1.6U
M$3389 VSS RB13 \$1042 VSS nfet_03v3 L=0.28U W=0.36U AS=0.1854P AD=0.1584P
+ PS=1.75U PD=1.6U
M$3390 VSS RA12 \$1259 VSS nfet_03v3 L=0.28U W=0.36U AS=0.1854P AD=0.1584P
+ PS=1.75U PD=1.6U
M$3391 \$1264 RB12 VSS VSS nfet_03v3 L=0.28U W=0.36U AS=0.1656P AD=0.1944P
+ PS=1.64U PD=1.8U
M$3392 \$1044 RA13 VSS VSS nfet_03v3 L=0.28U W=0.36U AS=0.1656P AD=0.1944P
+ PS=1.64U PD=1.8U
M$3393 \$1263 RB12 \$53 VSS nfet_03v3 L=0.28U W=0.36U AS=0.1584P AD=0.1152P
+ PS=1.6U PD=1U
M$3394 \$54 RA12 \$1263 VSS nfet_03v3 L=0.28U W=0.36U AS=0.1152P AD=0.1584P
+ PS=1U PD=1.6U
M$3395 \$933 RA13 \$53 VSS nfet_03v3 L=0.28U W=0.36U AS=0.1584P AD=0.1152P
+ PS=1.6U PD=1U
M$3396 \$54 RB13 \$933 VSS nfet_03v3 L=0.28U W=0.36U AS=0.1152P AD=0.1584P
+ PS=1U PD=1.6U
M$3397 VSS RB13 \$1045 VSS nfet_03v3 L=0.28U W=0.36U AS=0.1854P AD=0.1584P
+ PS=1.75U PD=1.6U
M$3398 VSS RA12 \$1265 VSS nfet_03v3 L=0.28U W=0.36U AS=0.1854P AD=0.1584P
+ PS=1.75U PD=1.6U
M$3399 \$1047 RA13 VSS VSS nfet_03v3 L=0.28U W=0.36U AS=0.1656P AD=0.1944P
+ PS=1.64U PD=1.8U
M$3400 \$1270 RB12 VSS VSS nfet_03v3 L=0.28U W=0.36U AS=0.1656P AD=0.1944P
+ PS=1.64U PD=1.8U
M$3401 \$1269 RB12 \$55 VSS nfet_03v3 L=0.28U W=0.36U AS=0.1584P AD=0.1152P
+ PS=1.6U PD=1U
M$3402 \$56 RA12 \$1269 VSS nfet_03v3 L=0.28U W=0.36U AS=0.1152P AD=0.1584P
+ PS=1U PD=1.6U
M$3403 \$934 RA13 \$55 VSS nfet_03v3 L=0.28U W=0.36U AS=0.1584P AD=0.1152P
+ PS=1.6U PD=1U
M$3404 \$56 RB13 \$934 VSS nfet_03v3 L=0.28U W=0.36U AS=0.1152P AD=0.1584P
+ PS=1U PD=1.6U
M$3405 VSS RB13 \$1048 VSS nfet_03v3 L=0.28U W=0.36U AS=0.1854P AD=0.1584P
+ PS=1.75U PD=1.6U
M$3406 VSS RA12 \$1271 VSS nfet_03v3 L=0.28U W=0.36U AS=0.1854P AD=0.1584P
+ PS=1.75U PD=1.6U
M$3407 \$1276 RB12 VSS VSS nfet_03v3 L=0.28U W=0.36U AS=0.1656P AD=0.1944P
+ PS=1.64U PD=1.8U
M$3408 \$1050 RA13 VSS VSS nfet_03v3 L=0.28U W=0.36U AS=0.1656P AD=0.1944P
+ PS=1.64U PD=1.8U
M$3409 \$935 RA13 \$57 VSS nfet_03v3 L=0.28U W=0.36U AS=0.1584P AD=0.1152P
+ PS=1.6U PD=1U
M$3410 \$58 RB13 \$935 VSS nfet_03v3 L=0.28U W=0.36U AS=0.1152P AD=0.1584P
+ PS=1U PD=1.6U
M$3411 \$1275 RB12 \$57 VSS nfet_03v3 L=0.28U W=0.36U AS=0.1584P AD=0.1152P
+ PS=1.6U PD=1U
M$3412 \$58 RA12 \$1275 VSS nfet_03v3 L=0.28U W=0.36U AS=0.1152P AD=0.1584P
+ PS=1U PD=1.6U
M$3413 VSS RB13 \$1051 VSS nfet_03v3 L=0.28U W=0.36U AS=0.1854P AD=0.1584P
+ PS=1.75U PD=1.6U
M$3414 VSS RA12 \$1277 VSS nfet_03v3 L=0.28U W=0.36U AS=0.1854P AD=0.1584P
+ PS=1.75U PD=1.6U
M$3415 \$1053 RA13 VSS VSS nfet_03v3 L=0.28U W=0.36U AS=0.1656P AD=0.1944P
+ PS=1.64U PD=1.8U
M$3416 \$1282 RB12 VSS VSS nfet_03v3 L=0.28U W=0.36U AS=0.1656P AD=0.1944P
+ PS=1.64U PD=1.8U
M$3417 \$936 RA13 \$59 VSS nfet_03v3 L=0.28U W=0.36U AS=0.1584P AD=0.1152P
+ PS=1.6U PD=1U
M$3418 \$60 RB13 \$936 VSS nfet_03v3 L=0.28U W=0.36U AS=0.1152P AD=0.1584P
+ PS=1U PD=1.6U
M$3419 \$1281 RB12 \$59 VSS nfet_03v3 L=0.28U W=0.36U AS=0.1584P AD=0.1152P
+ PS=1.6U PD=1U
M$3420 \$60 RA12 \$1281 VSS nfet_03v3 L=0.28U W=0.36U AS=0.1152P AD=0.1584P
+ PS=1U PD=1.6U
M$3421 VSS RA12 \$1283 VSS nfet_03v3 L=0.28U W=0.36U AS=0.1854P AD=0.1584P
+ PS=1.75U PD=1.6U
M$3422 VSS RB13 \$1054 VSS nfet_03v3 L=0.28U W=0.36U AS=0.1854P AD=0.1584P
+ PS=1.75U PD=1.6U
M$3423 \$1056 RA13 VSS VSS nfet_03v3 L=0.28U W=0.36U AS=0.1656P AD=0.1944P
+ PS=1.64U PD=1.8U
M$3424 \$1288 RB12 VSS VSS nfet_03v3 L=0.28U W=0.36U AS=0.1656P AD=0.1944P
+ PS=1.64U PD=1.8U
M$3425 \$937 RA13 \$61 VSS nfet_03v3 L=0.28U W=0.36U AS=0.1584P AD=0.1152P
+ PS=1.6U PD=1U
M$3426 \$62 RB13 \$937 VSS nfet_03v3 L=0.28U W=0.36U AS=0.1152P AD=0.1584P
+ PS=1U PD=1.6U
M$3427 \$1287 RB12 \$61 VSS nfet_03v3 L=0.28U W=0.36U AS=0.1584P AD=0.1152P
+ PS=1.6U PD=1U
M$3428 \$62 RA12 \$1287 VSS nfet_03v3 L=0.28U W=0.36U AS=0.1152P AD=0.1584P
+ PS=1U PD=1.6U
M$3429 VSS RA12 \$1289 VSS nfet_03v3 L=0.28U W=0.36U AS=0.1854P AD=0.1584P
+ PS=1.75U PD=1.6U
M$3430 VSS RB13 \$1057 VSS nfet_03v3 L=0.28U W=0.36U AS=0.1854P AD=0.1584P
+ PS=1.75U PD=1.6U
M$3431 \$1294 RB12 VSS VSS nfet_03v3 L=0.28U W=0.36U AS=0.1656P AD=0.1944P
+ PS=1.64U PD=1.8U
M$3432 \$1059 RA13 VSS VSS nfet_03v3 L=0.28U W=0.36U AS=0.1656P AD=0.1944P
+ PS=1.64U PD=1.8U
M$3433 \$1293 RB12 \$63 VSS nfet_03v3 L=0.28U W=0.36U AS=0.1584P AD=0.1152P
+ PS=1.6U PD=1U
M$3434 \$64 RA12 \$1293 VSS nfet_03v3 L=0.28U W=0.36U AS=0.1152P AD=0.1584P
+ PS=1U PD=1.6U
M$3435 \$938 RA13 \$63 VSS nfet_03v3 L=0.28U W=0.36U AS=0.1584P AD=0.1152P
+ PS=1.6U PD=1U
M$3436 \$64 RB13 \$938 VSS nfet_03v3 L=0.28U W=0.36U AS=0.1152P AD=0.1584P
+ PS=1U PD=1.6U
M$3437 VSS RB13 \$1060 VSS nfet_03v3 L=0.28U W=0.36U AS=0.1854P AD=0.1584P
+ PS=1.75U PD=1.6U
M$3438 VSS RA12 \$1295 VSS nfet_03v3 L=0.28U W=0.36U AS=0.1854P AD=0.1584P
+ PS=1.75U PD=1.6U
M$3439 \$1300 RB12 VSS VSS nfet_03v3 L=0.28U W=0.36U AS=0.1656P AD=0.1944P
+ PS=1.64U PD=1.8U
M$3440 \$1062 RA13 VSS VSS nfet_03v3 L=0.28U W=0.36U AS=0.1656P AD=0.1944P
+ PS=1.64U PD=1.8U
M$3441 \$939 RA13 \$65 VSS nfet_03v3 L=0.28U W=0.36U AS=0.1584P AD=0.1152P
+ PS=1.6U PD=1U
M$3442 \$66 RB13 \$939 VSS nfet_03v3 L=0.28U W=0.36U AS=0.1152P AD=0.1584P
+ PS=1U PD=1.6U
M$3443 \$1299 RB12 \$65 VSS nfet_03v3 L=0.28U W=0.36U AS=0.1584P AD=0.1152P
+ PS=1.6U PD=1U
M$3444 \$66 RA12 \$1299 VSS nfet_03v3 L=0.28U W=0.36U AS=0.1152P AD=0.1584P
+ PS=1U PD=1.6U
M$3445 VSS RB13 \$1063 VSS nfet_03v3 L=0.28U W=0.36U AS=0.1854P AD=0.1584P
+ PS=1.75U PD=1.6U
M$3446 VSS RA12 \$1301 VSS nfet_03v3 L=0.28U W=0.36U AS=0.1854P AD=0.1584P
+ PS=1.75U PD=1.6U
M$3447 \$1306 RB12 VSS VSS nfet_03v3 L=0.28U W=0.36U AS=0.1656P AD=0.1944P
+ PS=1.64U PD=1.8U
M$3448 \$1065 RA13 VSS VSS nfet_03v3 L=0.28U W=0.36U AS=0.1656P AD=0.1944P
+ PS=1.64U PD=1.8U
M$3449 \$940 RA13 \$67 VSS nfet_03v3 L=0.28U W=0.36U AS=0.1584P AD=0.1152P
+ PS=1.6U PD=1U
M$3450 \$68 RB13 \$940 VSS nfet_03v3 L=0.28U W=0.36U AS=0.1152P AD=0.1584P
+ PS=1U PD=1.6U
M$3451 \$1305 RB12 \$67 VSS nfet_03v3 L=0.28U W=0.36U AS=0.1584P AD=0.1152P
+ PS=1.6U PD=1U
M$3452 \$68 RA12 \$1305 VSS nfet_03v3 L=0.28U W=0.36U AS=0.1152P AD=0.1584P
+ PS=1U PD=1.6U
M$3453 VSS RA12 \$1307 VSS nfet_03v3 L=0.28U W=0.36U AS=0.1854P AD=0.1584P
+ PS=1.75U PD=1.6U
M$3454 VSS RB13 \$1066 VSS nfet_03v3 L=0.28U W=0.36U AS=0.1854P AD=0.1584P
+ PS=1.75U PD=1.6U
M$3455 \$1068 RA13 VSS VSS nfet_03v3 L=0.28U W=0.36U AS=0.1656P AD=0.1944P
+ PS=1.64U PD=1.8U
M$3456 \$1312 RB12 VSS VSS nfet_03v3 L=0.28U W=0.36U AS=0.1656P AD=0.1944P
+ PS=1.64U PD=1.8U
M$3457 \$1311 RB12 \$69 VSS nfet_03v3 L=0.28U W=0.36U AS=0.1584P AD=0.1152P
+ PS=1.6U PD=1U
M$3458 \$70 RA12 \$1311 VSS nfet_03v3 L=0.28U W=0.36U AS=0.1152P AD=0.1584P
+ PS=1U PD=1.6U
M$3459 \$941 RA13 \$69 VSS nfet_03v3 L=0.28U W=0.36U AS=0.1584P AD=0.1152P
+ PS=1.6U PD=1U
M$3460 \$70 RB13 \$941 VSS nfet_03v3 L=0.28U W=0.36U AS=0.1152P AD=0.1584P
+ PS=1U PD=1.6U
M$3461 VSS RA12 \$1313 VSS nfet_03v3 L=0.28U W=0.36U AS=0.1854P AD=0.1584P
+ PS=1.75U PD=1.6U
M$3462 VSS RB13 \$1069 VSS nfet_03v3 L=0.28U W=0.36U AS=0.1854P AD=0.1584P
+ PS=1.75U PD=1.6U
M$3463 \$1071 RA13 VSS VSS nfet_03v3 L=0.28U W=0.36U AS=0.1656P AD=0.1944P
+ PS=1.64U PD=1.8U
M$3464 \$1318 RB12 VSS VSS nfet_03v3 L=0.28U W=0.36U AS=0.1656P AD=0.1944P
+ PS=1.64U PD=1.8U
M$3465 \$942 RA13 \$71 VSS nfet_03v3 L=0.28U W=0.36U AS=0.1584P AD=0.1152P
+ PS=1.6U PD=1U
M$3466 \$72 RB13 \$942 VSS nfet_03v3 L=0.28U W=0.36U AS=0.1152P AD=0.1584P
+ PS=1U PD=1.6U
M$3467 \$1317 RB12 \$71 VSS nfet_03v3 L=0.28U W=0.36U AS=0.1584P AD=0.1152P
+ PS=1.6U PD=1U
M$3468 \$72 RA12 \$1317 VSS nfet_03v3 L=0.28U W=0.36U AS=0.1152P AD=0.1584P
+ PS=1U PD=1.6U
M$3469 VSS RA12 \$1319 VSS nfet_03v3 L=0.28U W=0.36U AS=0.1854P AD=0.1584P
+ PS=1.75U PD=1.6U
M$3470 VSS RB13 \$1072 VSS nfet_03v3 L=0.28U W=0.36U AS=0.1854P AD=0.1584P
+ PS=1.75U PD=1.6U
M$3471 \$1074 RA13 VSS VSS nfet_03v3 L=0.28U W=0.36U AS=0.1656P AD=0.1944P
+ PS=1.64U PD=1.8U
M$3472 \$1324 RB12 VSS VSS nfet_03v3 L=0.28U W=0.36U AS=0.1656P AD=0.1944P
+ PS=1.64U PD=1.8U
M$3473 \$943 RA13 \$73 VSS nfet_03v3 L=0.28U W=0.36U AS=0.1584P AD=0.1152P
+ PS=1.6U PD=1U
M$3474 \$74 RB13 \$943 VSS nfet_03v3 L=0.28U W=0.36U AS=0.1152P AD=0.1584P
+ PS=1U PD=1.6U
M$3475 \$1323 RB12 \$73 VSS nfet_03v3 L=0.28U W=0.36U AS=0.1584P AD=0.1152P
+ PS=1.6U PD=1U
M$3476 \$74 RA12 \$1323 VSS nfet_03v3 L=0.28U W=0.36U AS=0.1152P AD=0.1584P
+ PS=1U PD=1.6U
M$3477 VSS RA12 \$1325 VSS nfet_03v3 L=0.28U W=0.36U AS=0.1854P AD=0.1584P
+ PS=1.75U PD=1.6U
M$3478 VSS RB13 \$1075 VSS nfet_03v3 L=0.28U W=0.36U AS=0.1854P AD=0.1584P
+ PS=1.75U PD=1.6U
M$3479 \$1077 RA13 VSS VSS nfet_03v3 L=0.28U W=0.36U AS=0.1656P AD=0.1944P
+ PS=1.64U PD=1.8U
M$3480 \$1330 RB12 VSS VSS nfet_03v3 L=0.28U W=0.36U AS=0.1656P AD=0.1944P
+ PS=1.64U PD=1.8U
M$3481 \$944 RA13 \$75 VSS nfet_03v3 L=0.28U W=0.36U AS=0.1584P AD=0.1152P
+ PS=1.6U PD=1U
M$3482 \$76 RB13 \$944 VSS nfet_03v3 L=0.28U W=0.36U AS=0.1152P AD=0.1584P
+ PS=1U PD=1.6U
M$3483 \$1329 RB12 \$75 VSS nfet_03v3 L=0.28U W=0.36U AS=0.1584P AD=0.1152P
+ PS=1.6U PD=1U
M$3484 \$76 RA12 \$1329 VSS nfet_03v3 L=0.28U W=0.36U AS=0.1152P AD=0.1584P
+ PS=1U PD=1.6U
M$3485 VSS RB13 \$1078 VSS nfet_03v3 L=0.28U W=0.36U AS=0.1854P AD=0.1584P
+ PS=1.75U PD=1.6U
M$3486 VSS RA12 \$1331 VSS nfet_03v3 L=0.28U W=0.36U AS=0.1854P AD=0.1584P
+ PS=1.75U PD=1.6U
M$3487 \$1336 RB12 VSS VSS nfet_03v3 L=0.28U W=0.36U AS=0.1656P AD=0.1944P
+ PS=1.64U PD=1.8U
M$3488 \$1080 RA13 VSS VSS nfet_03v3 L=0.28U W=0.36U AS=0.1656P AD=0.1944P
+ PS=1.64U PD=1.8U
M$3489 \$1335 RB12 \$77 VSS nfet_03v3 L=0.28U W=0.36U AS=0.1584P AD=0.1152P
+ PS=1.6U PD=1U
M$3490 \$78 RA12 \$1335 VSS nfet_03v3 L=0.28U W=0.36U AS=0.1152P AD=0.1584P
+ PS=1U PD=1.6U
M$3491 \$945 RA13 \$77 VSS nfet_03v3 L=0.28U W=0.36U AS=0.1584P AD=0.1152P
+ PS=1.6U PD=1U
M$3492 \$78 RB13 \$945 VSS nfet_03v3 L=0.28U W=0.36U AS=0.1152P AD=0.1584P
+ PS=1U PD=1.6U
M$3493 VSS RA12 \$1337 VSS nfet_03v3 L=0.28U W=0.36U AS=0.1854P AD=0.1584P
+ PS=1.75U PD=1.6U
M$3494 VSS RB13 \$1081 VSS nfet_03v3 L=0.28U W=0.36U AS=0.1854P AD=0.1584P
+ PS=1.75U PD=1.6U
M$3495 \$1342 RB12 VSS VSS nfet_03v3 L=0.28U W=0.36U AS=0.1656P AD=0.1944P
+ PS=1.64U PD=1.8U
M$3496 \$1083 RA13 VSS VSS nfet_03v3 L=0.28U W=0.36U AS=0.1656P AD=0.1944P
+ PS=1.64U PD=1.8U
M$3497 \$1341 RB12 \$79 VSS nfet_03v3 L=0.28U W=0.36U AS=0.1584P AD=0.1152P
+ PS=1.6U PD=1U
M$3498 \$80 RA12 \$1341 VSS nfet_03v3 L=0.28U W=0.36U AS=0.1152P AD=0.1584P
+ PS=1U PD=1.6U
M$3499 \$946 RA13 \$79 VSS nfet_03v3 L=0.28U W=0.36U AS=0.1584P AD=0.1152P
+ PS=1.6U PD=1U
M$3500 \$80 RB13 \$946 VSS nfet_03v3 L=0.28U W=0.36U AS=0.1152P AD=0.1584P
+ PS=1U PD=1.6U
M$3501 VSS RB13 \$1084 VSS nfet_03v3 L=0.28U W=0.36U AS=0.1854P AD=0.1584P
+ PS=1.75U PD=1.6U
M$3502 VSS RA12 \$1343 VSS nfet_03v3 L=0.28U W=0.36U AS=0.1854P AD=0.1584P
+ PS=1.75U PD=1.6U
M$3503 \$1086 RA13 VSS VSS nfet_03v3 L=0.28U W=0.36U AS=0.1656P AD=0.1944P
+ PS=1.64U PD=1.8U
M$3504 \$1348 RB12 VSS VSS nfet_03v3 L=0.28U W=0.36U AS=0.1656P AD=0.1944P
+ PS=1.64U PD=1.8U
M$3505 \$947 RA13 \$81 VSS nfet_03v3 L=0.28U W=0.36U AS=0.1584P AD=0.1152P
+ PS=1.6U PD=1U
M$3506 \$82 RB13 \$947 VSS nfet_03v3 L=0.28U W=0.36U AS=0.1152P AD=0.1584P
+ PS=1U PD=1.6U
M$3507 \$1347 RB12 \$81 VSS nfet_03v3 L=0.28U W=0.36U AS=0.1584P AD=0.1152P
+ PS=1.6U PD=1U
M$3508 \$82 RA12 \$1347 VSS nfet_03v3 L=0.28U W=0.36U AS=0.1152P AD=0.1584P
+ PS=1U PD=1.6U
M$3509 VSS RA12 \$1349 VSS nfet_03v3 L=0.28U W=0.36U AS=0.1854P AD=0.1584P
+ PS=1.75U PD=1.6U
M$3510 VSS RB13 \$1087 VSS nfet_03v3 L=0.28U W=0.36U AS=0.1854P AD=0.1584P
+ PS=1.75U PD=1.6U
M$3511 \$1453 WE12 VSS VSS nfet_03v3 L=0.28U W=0.72U AS=0.3168P AD=0.1872P
+ PS=2.32U PD=1.24U
M$3512 \$1248 CLK \$1453 VSS nfet_03v3 L=0.28U W=0.72U AS=0.1872P AD=0.3168P
+ PS=1.24U PD=2.32U
M$3513 \$1250 \$1248 VSS VSS nfet_03v3 L=0.28U W=0.635U AS=0.2794P AD=0.1651P
+ PS=2.15U PD=1.155U
M$3514 \$1250 \$1248 VSS VSS nfet_03v3 L=0.28U W=0.635U AS=0.1693P AD=0.1651P
+ PS=1.19U PD=1.155U
M$3515 \$1251 \$1250 VSS VSS nfet_03v3 L=0.28U W=0.67U AS=0.1693P AD=0.1943P
+ PS=1.19U PD=1.25U
M$3516 VSS \$1250 \$1251 VSS nfet_03v3 L=0.28U W=0.67U AS=0.1943P AD=0.2948P
+ PS=1.25U PD=2.22U
M$3517 \$1254 \$106 VSS VSS nfet_03v3 L=0.28U W=0.36U AS=0.1584P AD=0.1188P
+ PS=1.6U PD=1.02U
M$3518 \$1255 \$1250 \$1254 VSS nfet_03v3 L=0.28U W=0.36U AS=0.1188P AD=0.1278P
+ PS=1.02U PD=1.07U
M$3519 \$1458 \$1256 \$1255 VSS nfet_03v3 L=0.28U W=0.36U AS=0.1278P AD=0.0567P
+ PS=1.07U PD=0.675U
M$3520 VSS \$1251 \$1458 VSS nfet_03v3 L=0.28U W=0.36U AS=0.0567P AD=0.1584P
+ PS=0.675U PD=1.6U
M$3521 VSS \$1255 \$1256 VSS nfet_03v3 L=0.28U W=0.36U AS=0.1584P AD=0.0972P
+ PS=1.6U PD=0.9U
M$3522 \$1257 \$1255 VSS VSS nfet_03v3 L=0.28U W=0.36U AS=0.0972P AD=0.18P
+ PS=0.9U PD=1.72U
M$3523 \$1260 \$109 VSS VSS nfet_03v3 L=0.28U W=0.36U AS=0.1584P AD=0.1188P
+ PS=1.6U PD=1.02U
M$3524 \$1261 \$1250 \$1260 VSS nfet_03v3 L=0.28U W=0.36U AS=0.1188P AD=0.1278P
+ PS=1.02U PD=1.07U
M$3525 \$1467 \$1262 \$1261 VSS nfet_03v3 L=0.28U W=0.36U AS=0.1278P AD=0.0567P
+ PS=1.07U PD=0.675U
M$3526 VSS \$1251 \$1467 VSS nfet_03v3 L=0.28U W=0.36U AS=0.0567P AD=0.1584P
+ PS=0.675U PD=1.6U
M$3527 VSS \$1261 \$1262 VSS nfet_03v3 L=0.28U W=0.36U AS=0.1584P AD=0.0972P
+ PS=1.6U PD=0.9U
M$3528 \$1263 \$1261 VSS VSS nfet_03v3 L=0.28U W=0.36U AS=0.0972P AD=0.18P
+ PS=0.9U PD=1.72U
M$3529 \$1266 \$112 VSS VSS nfet_03v3 L=0.28U W=0.36U AS=0.1584P AD=0.1188P
+ PS=1.6U PD=1.02U
M$3530 \$1267 \$1250 \$1266 VSS nfet_03v3 L=0.28U W=0.36U AS=0.1188P AD=0.1278P
+ PS=1.02U PD=1.07U
M$3531 \$1474 \$1268 \$1267 VSS nfet_03v3 L=0.28U W=0.36U AS=0.1278P AD=0.0567P
+ PS=1.07U PD=0.675U
M$3532 VSS \$1251 \$1474 VSS nfet_03v3 L=0.28U W=0.36U AS=0.0567P AD=0.1584P
+ PS=0.675U PD=1.6U
M$3533 VSS \$1267 \$1268 VSS nfet_03v3 L=0.28U W=0.36U AS=0.1584P AD=0.0972P
+ PS=1.6U PD=0.9U
M$3534 \$1269 \$1267 VSS VSS nfet_03v3 L=0.28U W=0.36U AS=0.0972P AD=0.18P
+ PS=0.9U PD=1.72U
M$3535 \$1272 \$115 VSS VSS nfet_03v3 L=0.28U W=0.36U AS=0.1584P AD=0.1188P
+ PS=1.6U PD=1.02U
M$3536 \$1273 \$1250 \$1272 VSS nfet_03v3 L=0.28U W=0.36U AS=0.1188P AD=0.1278P
+ PS=1.02U PD=1.07U
M$3537 \$1481 \$1274 \$1273 VSS nfet_03v3 L=0.28U W=0.36U AS=0.1278P AD=0.0567P
+ PS=1.07U PD=0.675U
M$3538 VSS \$1251 \$1481 VSS nfet_03v3 L=0.28U W=0.36U AS=0.0567P AD=0.1584P
+ PS=0.675U PD=1.6U
M$3539 VSS \$1273 \$1274 VSS nfet_03v3 L=0.28U W=0.36U AS=0.1584P AD=0.0972P
+ PS=1.6U PD=0.9U
M$3540 \$1275 \$1273 VSS VSS nfet_03v3 L=0.28U W=0.36U AS=0.0972P AD=0.18P
+ PS=0.9U PD=1.72U
M$3541 \$1278 \$118 VSS VSS nfet_03v3 L=0.28U W=0.36U AS=0.1584P AD=0.1188P
+ PS=1.6U PD=1.02U
M$3542 \$1279 \$1250 \$1278 VSS nfet_03v3 L=0.28U W=0.36U AS=0.1188P AD=0.1278P
+ PS=1.02U PD=1.07U
M$3543 \$1491 \$1280 \$1279 VSS nfet_03v3 L=0.28U W=0.36U AS=0.1278P AD=0.0567P
+ PS=1.07U PD=0.675U
M$3544 VSS \$1251 \$1491 VSS nfet_03v3 L=0.28U W=0.36U AS=0.0567P AD=0.1584P
+ PS=0.675U PD=1.6U
M$3545 VSS \$1279 \$1280 VSS nfet_03v3 L=0.28U W=0.36U AS=0.1584P AD=0.0972P
+ PS=1.6U PD=0.9U
M$3546 \$1281 \$1279 VSS VSS nfet_03v3 L=0.28U W=0.36U AS=0.0972P AD=0.18P
+ PS=0.9U PD=1.72U
M$3547 \$1284 \$121 VSS VSS nfet_03v3 L=0.28U W=0.36U AS=0.1584P AD=0.1188P
+ PS=1.6U PD=1.02U
M$3548 \$1285 \$1250 \$1284 VSS nfet_03v3 L=0.28U W=0.36U AS=0.1188P AD=0.1278P
+ PS=1.02U PD=1.07U
M$3549 \$1497 \$1286 \$1285 VSS nfet_03v3 L=0.28U W=0.36U AS=0.1278P AD=0.0567P
+ PS=1.07U PD=0.675U
M$3550 VSS \$1251 \$1497 VSS nfet_03v3 L=0.28U W=0.36U AS=0.0567P AD=0.1584P
+ PS=0.675U PD=1.6U
M$3551 VSS \$1285 \$1286 VSS nfet_03v3 L=0.28U W=0.36U AS=0.1584P AD=0.0972P
+ PS=1.6U PD=0.9U
M$3552 \$1287 \$1285 VSS VSS nfet_03v3 L=0.28U W=0.36U AS=0.0972P AD=0.18P
+ PS=0.9U PD=1.72U
M$3553 \$1290 \$124 VSS VSS nfet_03v3 L=0.28U W=0.36U AS=0.1584P AD=0.1188P
+ PS=1.6U PD=1.02U
M$3554 \$1291 \$1250 \$1290 VSS nfet_03v3 L=0.28U W=0.36U AS=0.1188P AD=0.1278P
+ PS=1.02U PD=1.07U
M$3555 \$1505 \$1292 \$1291 VSS nfet_03v3 L=0.28U W=0.36U AS=0.1278P AD=0.0567P
+ PS=1.07U PD=0.675U
M$3556 VSS \$1251 \$1505 VSS nfet_03v3 L=0.28U W=0.36U AS=0.0567P AD=0.1584P
+ PS=0.675U PD=1.6U
M$3557 VSS \$1291 \$1292 VSS nfet_03v3 L=0.28U W=0.36U AS=0.1584P AD=0.0972P
+ PS=1.6U PD=0.9U
M$3558 \$1293 \$1291 VSS VSS nfet_03v3 L=0.28U W=0.36U AS=0.0972P AD=0.18P
+ PS=0.9U PD=1.72U
M$3559 \$1296 \$127 VSS VSS nfet_03v3 L=0.28U W=0.36U AS=0.1584P AD=0.1188P
+ PS=1.6U PD=1.02U
M$3560 \$1297 \$1250 \$1296 VSS nfet_03v3 L=0.28U W=0.36U AS=0.1188P AD=0.1278P
+ PS=1.02U PD=1.07U
M$3561 \$1515 \$1298 \$1297 VSS nfet_03v3 L=0.28U W=0.36U AS=0.1278P AD=0.0567P
+ PS=1.07U PD=0.675U
M$3562 VSS \$1251 \$1515 VSS nfet_03v3 L=0.28U W=0.36U AS=0.0567P AD=0.1584P
+ PS=0.675U PD=1.6U
M$3563 VSS \$1297 \$1298 VSS nfet_03v3 L=0.28U W=0.36U AS=0.1584P AD=0.0972P
+ PS=1.6U PD=0.9U
M$3564 \$1299 \$1297 VSS VSS nfet_03v3 L=0.28U W=0.36U AS=0.0972P AD=0.18P
+ PS=0.9U PD=1.72U
M$3565 \$1302 \$130 VSS VSS nfet_03v3 L=0.28U W=0.36U AS=0.1584P AD=0.1188P
+ PS=1.6U PD=1.02U
M$3566 \$1303 \$1250 \$1302 VSS nfet_03v3 L=0.28U W=0.36U AS=0.1188P AD=0.1278P
+ PS=1.02U PD=1.07U
M$3567 \$1521 \$1304 \$1303 VSS nfet_03v3 L=0.28U W=0.36U AS=0.1278P AD=0.0567P
+ PS=1.07U PD=0.675U
M$3568 VSS \$1251 \$1521 VSS nfet_03v3 L=0.28U W=0.36U AS=0.0567P AD=0.1584P
+ PS=0.675U PD=1.6U
M$3569 VSS \$1303 \$1304 VSS nfet_03v3 L=0.28U W=0.36U AS=0.1584P AD=0.0972P
+ PS=1.6U PD=0.9U
M$3570 \$1305 \$1303 VSS VSS nfet_03v3 L=0.28U W=0.36U AS=0.0972P AD=0.18P
+ PS=0.9U PD=1.72U
M$3571 \$1308 \$133 VSS VSS nfet_03v3 L=0.28U W=0.36U AS=0.1584P AD=0.1188P
+ PS=1.6U PD=1.02U
M$3572 \$1309 \$1250 \$1308 VSS nfet_03v3 L=0.28U W=0.36U AS=0.1188P AD=0.1278P
+ PS=1.02U PD=1.07U
M$3573 \$1529 \$1310 \$1309 VSS nfet_03v3 L=0.28U W=0.36U AS=0.1278P AD=0.0567P
+ PS=1.07U PD=0.675U
M$3574 VSS \$1251 \$1529 VSS nfet_03v3 L=0.28U W=0.36U AS=0.0567P AD=0.1584P
+ PS=0.675U PD=1.6U
M$3575 VSS \$1309 \$1310 VSS nfet_03v3 L=0.28U W=0.36U AS=0.1584P AD=0.0972P
+ PS=1.6U PD=0.9U
M$3576 \$1311 \$1309 VSS VSS nfet_03v3 L=0.28U W=0.36U AS=0.0972P AD=0.18P
+ PS=0.9U PD=1.72U
M$3577 \$1314 \$136 VSS VSS nfet_03v3 L=0.28U W=0.36U AS=0.1584P AD=0.1188P
+ PS=1.6U PD=1.02U
M$3578 \$1315 \$1250 \$1314 VSS nfet_03v3 L=0.28U W=0.36U AS=0.1188P AD=0.1278P
+ PS=1.02U PD=1.07U
M$3579 \$1537 \$1316 \$1315 VSS nfet_03v3 L=0.28U W=0.36U AS=0.1278P AD=0.0567P
+ PS=1.07U PD=0.675U
M$3580 VSS \$1251 \$1537 VSS nfet_03v3 L=0.28U W=0.36U AS=0.0567P AD=0.1584P
+ PS=0.675U PD=1.6U
M$3581 VSS \$1315 \$1316 VSS nfet_03v3 L=0.28U W=0.36U AS=0.1584P AD=0.0972P
+ PS=1.6U PD=0.9U
M$3582 \$1317 \$1315 VSS VSS nfet_03v3 L=0.28U W=0.36U AS=0.0972P AD=0.18P
+ PS=0.9U PD=1.72U
M$3583 \$1320 \$139 VSS VSS nfet_03v3 L=0.28U W=0.36U AS=0.1584P AD=0.1188P
+ PS=1.6U PD=1.02U
M$3584 \$1321 \$1250 \$1320 VSS nfet_03v3 L=0.28U W=0.36U AS=0.1188P AD=0.1278P
+ PS=1.02U PD=1.07U
M$3585 \$1545 \$1322 \$1321 VSS nfet_03v3 L=0.28U W=0.36U AS=0.1278P AD=0.0567P
+ PS=1.07U PD=0.675U
M$3586 VSS \$1251 \$1545 VSS nfet_03v3 L=0.28U W=0.36U AS=0.0567P AD=0.1584P
+ PS=0.675U PD=1.6U
M$3587 VSS \$1321 \$1322 VSS nfet_03v3 L=0.28U W=0.36U AS=0.1584P AD=0.0972P
+ PS=1.6U PD=0.9U
M$3588 \$1323 \$1321 VSS VSS nfet_03v3 L=0.28U W=0.36U AS=0.0972P AD=0.18P
+ PS=0.9U PD=1.72U
M$3589 \$1326 \$142 VSS VSS nfet_03v3 L=0.28U W=0.36U AS=0.1584P AD=0.1188P
+ PS=1.6U PD=1.02U
M$3590 \$1327 \$1250 \$1326 VSS nfet_03v3 L=0.28U W=0.36U AS=0.1188P AD=0.1278P
+ PS=1.02U PD=1.07U
M$3591 \$1540 \$1328 \$1327 VSS nfet_03v3 L=0.28U W=0.36U AS=0.1278P AD=0.0567P
+ PS=1.07U PD=0.675U
M$3592 VSS \$1251 \$1540 VSS nfet_03v3 L=0.28U W=0.36U AS=0.0567P AD=0.1584P
+ PS=0.675U PD=1.6U
M$3593 VSS \$1327 \$1328 VSS nfet_03v3 L=0.28U W=0.36U AS=0.1584P AD=0.0972P
+ PS=1.6U PD=0.9U
M$3594 \$1329 \$1327 VSS VSS nfet_03v3 L=0.28U W=0.36U AS=0.0972P AD=0.18P
+ PS=0.9U PD=1.72U
M$3595 \$1332 \$145 VSS VSS nfet_03v3 L=0.28U W=0.36U AS=0.1584P AD=0.1188P
+ PS=1.6U PD=1.02U
M$3596 \$1333 \$1250 \$1332 VSS nfet_03v3 L=0.28U W=0.36U AS=0.1188P AD=0.1278P
+ PS=1.02U PD=1.07U
M$3597 \$1514 \$1334 \$1333 VSS nfet_03v3 L=0.28U W=0.36U AS=0.1278P AD=0.0567P
+ PS=1.07U PD=0.675U
M$3598 VSS \$1251 \$1514 VSS nfet_03v3 L=0.28U W=0.36U AS=0.0567P AD=0.1584P
+ PS=0.675U PD=1.6U
M$3599 VSS \$1333 \$1334 VSS nfet_03v3 L=0.28U W=0.36U AS=0.1584P AD=0.0972P
+ PS=1.6U PD=0.9U
M$3600 \$1335 \$1333 VSS VSS nfet_03v3 L=0.28U W=0.36U AS=0.0972P AD=0.18P
+ PS=0.9U PD=1.72U
M$3601 \$1338 \$148 VSS VSS nfet_03v3 L=0.28U W=0.36U AS=0.1584P AD=0.1188P
+ PS=1.6U PD=1.02U
M$3602 \$1339 \$1250 \$1338 VSS nfet_03v3 L=0.28U W=0.36U AS=0.1188P AD=0.1278P
+ PS=1.02U PD=1.07U
M$3603 \$1490 \$1340 \$1339 VSS nfet_03v3 L=0.28U W=0.36U AS=0.1278P AD=0.0567P
+ PS=1.07U PD=0.675U
M$3604 VSS \$1251 \$1490 VSS nfet_03v3 L=0.28U W=0.36U AS=0.0567P AD=0.1584P
+ PS=0.675U PD=1.6U
M$3605 VSS \$1339 \$1340 VSS nfet_03v3 L=0.28U W=0.36U AS=0.1584P AD=0.0972P
+ PS=1.6U PD=0.9U
M$3606 \$1341 \$1339 VSS VSS nfet_03v3 L=0.28U W=0.36U AS=0.0972P AD=0.18P
+ PS=0.9U PD=1.72U
M$3607 \$1344 \$151 VSS VSS nfet_03v3 L=0.28U W=0.36U AS=0.1584P AD=0.1188P
+ PS=1.6U PD=1.02U
M$3608 \$1345 \$1250 \$1344 VSS nfet_03v3 L=0.28U W=0.36U AS=0.1188P AD=0.1278P
+ PS=1.02U PD=1.07U
M$3609 \$1466 \$1346 \$1345 VSS nfet_03v3 L=0.28U W=0.36U AS=0.1278P AD=0.0567P
+ PS=1.07U PD=0.675U
M$3610 VSS \$1251 \$1466 VSS nfet_03v3 L=0.28U W=0.36U AS=0.0567P AD=0.1584P
+ PS=0.675U PD=1.6U
M$3611 VSS \$1345 \$1346 VSS nfet_03v3 L=0.28U W=0.36U AS=0.1584P AD=0.0972P
+ PS=1.6U PD=0.9U
M$3612 \$1347 \$1345 VSS VSS nfet_03v3 L=0.28U W=0.36U AS=0.0972P AD=0.18P
+ PS=0.9U PD=1.72U
M$3613 \$1700 WE11 VSS VSS nfet_03v3 L=0.28U W=0.72U AS=0.3168P AD=0.1872P
+ PS=2.32U PD=1.24U
M$3614 \$1551 CLK \$1700 VSS nfet_03v3 L=0.28U W=0.72U AS=0.1872P AD=0.3168P
+ PS=1.24U PD=2.32U
M$3615 \$1552 \$1551 VSS VSS nfet_03v3 L=0.28U W=0.635U AS=0.2794P AD=0.1651P
+ PS=2.15U PD=1.155U
M$3616 VSS \$1551 \$1552 VSS nfet_03v3 L=0.28U W=0.635U AS=0.1651P AD=0.1693P
+ PS=1.155U PD=1.19U
M$3617 \$1553 \$1552 VSS VSS nfet_03v3 L=0.28U W=0.67U AS=0.1693P AD=0.1943P
+ PS=1.19U PD=1.25U
M$3618 VSS \$1552 \$1553 VSS nfet_03v3 L=0.28U W=0.67U AS=0.1943P AD=0.2948P
+ PS=1.25U PD=2.22U
M$3619 \$1554 \$106 VSS VSS nfet_03v3 L=0.28U W=0.36U AS=0.1584P AD=0.1188P
+ PS=1.6U PD=1.02U
M$3620 \$1555 \$1552 \$1554 VSS nfet_03v3 L=0.28U W=0.36U AS=0.1188P AD=0.1278P
+ PS=1.02U PD=1.07U
M$3621 \$1622 \$1556 \$1555 VSS nfet_03v3 L=0.28U W=0.36U AS=0.1278P AD=0.0567P
+ PS=1.07U PD=0.675U
M$3622 VSS \$1553 \$1622 VSS nfet_03v3 L=0.28U W=0.36U AS=0.0567P AD=0.1584P
+ PS=0.675U PD=1.6U
M$3623 VSS \$1555 \$1556 VSS nfet_03v3 L=0.28U W=0.36U AS=0.1584P AD=0.0972P
+ PS=1.6U PD=0.9U
M$3624 \$1557 \$1555 VSS VSS nfet_03v3 L=0.28U W=0.36U AS=0.0972P AD=0.18P
+ PS=0.9U PD=1.72U
M$3625 \$1558 \$109 VSS VSS nfet_03v3 L=0.28U W=0.36U AS=0.1584P AD=0.1188P
+ PS=1.6U PD=1.02U
M$3626 \$1559 \$1552 \$1558 VSS nfet_03v3 L=0.28U W=0.36U AS=0.1188P AD=0.1278P
+ PS=1.02U PD=1.07U
M$3627 \$1631 \$1560 \$1559 VSS nfet_03v3 L=0.28U W=0.36U AS=0.1278P AD=0.0567P
+ PS=1.07U PD=0.675U
M$3628 VSS \$1553 \$1631 VSS nfet_03v3 L=0.28U W=0.36U AS=0.0567P AD=0.1584P
+ PS=0.675U PD=1.6U
M$3629 VSS \$1559 \$1560 VSS nfet_03v3 L=0.28U W=0.36U AS=0.1584P AD=0.0972P
+ PS=1.6U PD=0.9U
M$3630 \$1561 \$1559 VSS VSS nfet_03v3 L=0.28U W=0.36U AS=0.0972P AD=0.18P
+ PS=0.9U PD=1.72U
M$3631 \$1562 \$112 VSS VSS nfet_03v3 L=0.28U W=0.36U AS=0.1584P AD=0.1188P
+ PS=1.6U PD=1.02U
M$3632 \$1563 \$1552 \$1562 VSS nfet_03v3 L=0.28U W=0.36U AS=0.1188P AD=0.1278P
+ PS=1.02U PD=1.07U
M$3633 \$1639 \$1564 \$1563 VSS nfet_03v3 L=0.28U W=0.36U AS=0.1278P AD=0.0567P
+ PS=1.07U PD=0.675U
M$3634 VSS \$1553 \$1639 VSS nfet_03v3 L=0.28U W=0.36U AS=0.0567P AD=0.1584P
+ PS=0.675U PD=1.6U
M$3635 VSS \$1563 \$1564 VSS nfet_03v3 L=0.28U W=0.36U AS=0.1584P AD=0.0972P
+ PS=1.6U PD=0.9U
M$3636 \$1565 \$1563 VSS VSS nfet_03v3 L=0.28U W=0.36U AS=0.0972P AD=0.18P
+ PS=0.9U PD=1.72U
M$3637 \$1566 \$115 VSS VSS nfet_03v3 L=0.28U W=0.36U AS=0.1584P AD=0.1188P
+ PS=1.6U PD=1.02U
M$3638 \$1567 \$1552 \$1566 VSS nfet_03v3 L=0.28U W=0.36U AS=0.1188P AD=0.1278P
+ PS=1.02U PD=1.07U
M$3639 \$1648 \$1568 \$1567 VSS nfet_03v3 L=0.28U W=0.36U AS=0.1278P AD=0.0567P
+ PS=1.07U PD=0.675U
M$3640 VSS \$1553 \$1648 VSS nfet_03v3 L=0.28U W=0.36U AS=0.0567P AD=0.1584P
+ PS=0.675U PD=1.6U
M$3641 VSS \$1567 \$1568 VSS nfet_03v3 L=0.28U W=0.36U AS=0.1584P AD=0.0972P
+ PS=1.6U PD=0.9U
M$3642 \$1569 \$1567 VSS VSS nfet_03v3 L=0.28U W=0.36U AS=0.0972P AD=0.18P
+ PS=0.9U PD=1.72U
M$3643 \$1570 \$118 VSS VSS nfet_03v3 L=0.28U W=0.36U AS=0.1584P AD=0.1188P
+ PS=1.6U PD=1.02U
M$3644 \$1571 \$1552 \$1570 VSS nfet_03v3 L=0.28U W=0.36U AS=0.1188P AD=0.1278P
+ PS=1.02U PD=1.07U
M$3645 \$1655 \$1572 \$1571 VSS nfet_03v3 L=0.28U W=0.36U AS=0.1278P AD=0.0567P
+ PS=1.07U PD=0.675U
M$3646 VSS \$1553 \$1655 VSS nfet_03v3 L=0.28U W=0.36U AS=0.0567P AD=0.1584P
+ PS=0.675U PD=1.6U
M$3647 VSS \$1571 \$1572 VSS nfet_03v3 L=0.28U W=0.36U AS=0.1584P AD=0.0972P
+ PS=1.6U PD=0.9U
M$3648 \$1573 \$1571 VSS VSS nfet_03v3 L=0.28U W=0.36U AS=0.0972P AD=0.18P
+ PS=0.9U PD=1.72U
M$3649 \$1574 \$121 VSS VSS nfet_03v3 L=0.28U W=0.36U AS=0.1584P AD=0.1188P
+ PS=1.6U PD=1.02U
M$3650 \$1575 \$1552 \$1574 VSS nfet_03v3 L=0.28U W=0.36U AS=0.1188P AD=0.1278P
+ PS=1.02U PD=1.07U
M$3651 \$1663 \$1576 \$1575 VSS nfet_03v3 L=0.28U W=0.36U AS=0.1278P AD=0.0567P
+ PS=1.07U PD=0.675U
M$3652 VSS \$1553 \$1663 VSS nfet_03v3 L=0.28U W=0.36U AS=0.0567P AD=0.1584P
+ PS=0.675U PD=1.6U
M$3653 VSS \$1575 \$1576 VSS nfet_03v3 L=0.28U W=0.36U AS=0.1584P AD=0.0972P
+ PS=1.6U PD=0.9U
M$3654 \$1577 \$1575 VSS VSS nfet_03v3 L=0.28U W=0.36U AS=0.0972P AD=0.18P
+ PS=0.9U PD=1.72U
M$3655 \$1578 \$124 VSS VSS nfet_03v3 L=0.28U W=0.36U AS=0.1584P AD=0.1188P
+ PS=1.6U PD=1.02U
M$3656 \$1579 \$1552 \$1578 VSS nfet_03v3 L=0.28U W=0.36U AS=0.1188P AD=0.1278P
+ PS=1.02U PD=1.07U
M$3657 \$1662 \$1580 \$1579 VSS nfet_03v3 L=0.28U W=0.36U AS=0.1278P AD=0.0567P
+ PS=1.07U PD=0.675U
M$3658 VSS \$1553 \$1662 VSS nfet_03v3 L=0.28U W=0.36U AS=0.0567P AD=0.1584P
+ PS=0.675U PD=1.6U
M$3659 VSS \$1579 \$1580 VSS nfet_03v3 L=0.28U W=0.36U AS=0.1584P AD=0.0972P
+ PS=1.6U PD=0.9U
M$3660 \$1581 \$1579 VSS VSS nfet_03v3 L=0.28U W=0.36U AS=0.0972P AD=0.18P
+ PS=0.9U PD=1.72U
M$3661 \$1582 \$127 VSS VSS nfet_03v3 L=0.28U W=0.36U AS=0.1584P AD=0.1188P
+ PS=1.6U PD=1.02U
M$3662 \$1583 \$1552 \$1582 VSS nfet_03v3 L=0.28U W=0.36U AS=0.1188P AD=0.1278P
+ PS=1.02U PD=1.07U
M$3663 \$1659 \$1584 \$1583 VSS nfet_03v3 L=0.28U W=0.36U AS=0.1278P AD=0.0567P
+ PS=1.07U PD=0.675U
M$3664 VSS \$1553 \$1659 VSS nfet_03v3 L=0.28U W=0.36U AS=0.0567P AD=0.1584P
+ PS=0.675U PD=1.6U
M$3665 VSS \$1583 \$1584 VSS nfet_03v3 L=0.28U W=0.36U AS=0.1584P AD=0.0972P
+ PS=1.6U PD=0.9U
M$3666 \$1585 \$1583 VSS VSS nfet_03v3 L=0.28U W=0.36U AS=0.0972P AD=0.18P
+ PS=0.9U PD=1.72U
M$3667 \$1586 \$130 VSS VSS nfet_03v3 L=0.28U W=0.36U AS=0.1584P AD=0.1188P
+ PS=1.6U PD=1.02U
M$3668 \$1587 \$1552 \$1586 VSS nfet_03v3 L=0.28U W=0.36U AS=0.1188P AD=0.1278P
+ PS=1.02U PD=1.07U
M$3669 \$1653 \$1588 \$1587 VSS nfet_03v3 L=0.28U W=0.36U AS=0.1278P AD=0.0567P
+ PS=1.07U PD=0.675U
M$3670 VSS \$1553 \$1653 VSS nfet_03v3 L=0.28U W=0.36U AS=0.0567P AD=0.1584P
+ PS=0.675U PD=1.6U
M$3671 VSS \$1587 \$1588 VSS nfet_03v3 L=0.28U W=0.36U AS=0.1584P AD=0.0972P
+ PS=1.6U PD=0.9U
M$3672 \$1589 \$1587 VSS VSS nfet_03v3 L=0.28U W=0.36U AS=0.0972P AD=0.18P
+ PS=0.9U PD=1.72U
M$3673 \$1590 \$133 VSS VSS nfet_03v3 L=0.28U W=0.36U AS=0.1584P AD=0.1188P
+ PS=1.6U PD=1.02U
M$3674 \$1591 \$1552 \$1590 VSS nfet_03v3 L=0.28U W=0.36U AS=0.1188P AD=0.1278P
+ PS=1.02U PD=1.07U
M$3675 \$1647 \$1592 \$1591 VSS nfet_03v3 L=0.28U W=0.36U AS=0.1278P AD=0.0567P
+ PS=1.07U PD=0.675U
M$3676 VSS \$1553 \$1647 VSS nfet_03v3 L=0.28U W=0.36U AS=0.0567P AD=0.1584P
+ PS=0.675U PD=1.6U
M$3677 VSS \$1591 \$1592 VSS nfet_03v3 L=0.28U W=0.36U AS=0.1584P AD=0.0972P
+ PS=1.6U PD=0.9U
M$3678 \$1593 \$1591 VSS VSS nfet_03v3 L=0.28U W=0.36U AS=0.0972P AD=0.18P
+ PS=0.9U PD=1.72U
M$3679 \$1594 \$136 VSS VSS nfet_03v3 L=0.28U W=0.36U AS=0.1584P AD=0.1188P
+ PS=1.6U PD=1.02U
M$3680 \$1595 \$1552 \$1594 VSS nfet_03v3 L=0.28U W=0.36U AS=0.1188P AD=0.1278P
+ PS=1.02U PD=1.07U
M$3681 \$1644 \$1596 \$1595 VSS nfet_03v3 L=0.28U W=0.36U AS=0.1278P AD=0.0567P
+ PS=1.07U PD=0.675U
M$3682 VSS \$1553 \$1644 VSS nfet_03v3 L=0.28U W=0.36U AS=0.0567P AD=0.1584P
+ PS=0.675U PD=1.6U
M$3683 VSS \$1595 \$1596 VSS nfet_03v3 L=0.28U W=0.36U AS=0.1584P AD=0.0972P
+ PS=1.6U PD=0.9U
M$3684 \$1597 \$1595 VSS VSS nfet_03v3 L=0.28U W=0.36U AS=0.0972P AD=0.18P
+ PS=0.9U PD=1.72U
M$3685 \$1598 \$139 VSS VSS nfet_03v3 L=0.28U W=0.36U AS=0.1584P AD=0.1188P
+ PS=1.6U PD=1.02U
M$3686 \$1599 \$1552 \$1598 VSS nfet_03v3 L=0.28U W=0.36U AS=0.1188P AD=0.1278P
+ PS=1.02U PD=1.07U
M$3687 \$1638 \$1600 \$1599 VSS nfet_03v3 L=0.28U W=0.36U AS=0.1278P AD=0.0567P
+ PS=1.07U PD=0.675U
M$3688 VSS \$1553 \$1638 VSS nfet_03v3 L=0.28U W=0.36U AS=0.0567P AD=0.1584P
+ PS=0.675U PD=1.6U
M$3689 VSS \$1599 \$1600 VSS nfet_03v3 L=0.28U W=0.36U AS=0.1584P AD=0.0972P
+ PS=1.6U PD=0.9U
M$3690 \$1601 \$1599 VSS VSS nfet_03v3 L=0.28U W=0.36U AS=0.0972P AD=0.18P
+ PS=0.9U PD=1.72U
M$3691 \$1602 \$142 VSS VSS nfet_03v3 L=0.28U W=0.36U AS=0.1584P AD=0.1188P
+ PS=1.6U PD=1.02U
M$3692 \$1603 \$1552 \$1602 VSS nfet_03v3 L=0.28U W=0.36U AS=0.1188P AD=0.1278P
+ PS=1.02U PD=1.07U
M$3693 \$1635 \$1604 \$1603 VSS nfet_03v3 L=0.28U W=0.36U AS=0.1278P AD=0.0567P
+ PS=1.07U PD=0.675U
M$3694 VSS \$1553 \$1635 VSS nfet_03v3 L=0.28U W=0.36U AS=0.0567P AD=0.1584P
+ PS=0.675U PD=1.6U
M$3695 VSS \$1603 \$1604 VSS nfet_03v3 L=0.28U W=0.36U AS=0.1584P AD=0.0972P
+ PS=1.6U PD=0.9U
M$3696 \$1605 \$1603 VSS VSS nfet_03v3 L=0.28U W=0.36U AS=0.0972P AD=0.18P
+ PS=0.9U PD=1.72U
M$3697 \$1606 \$145 VSS VSS nfet_03v3 L=0.28U W=0.36U AS=0.1584P AD=0.1188P
+ PS=1.6U PD=1.02U
M$3698 \$1607 \$1552 \$1606 VSS nfet_03v3 L=0.28U W=0.36U AS=0.1188P AD=0.1278P
+ PS=1.02U PD=1.07U
M$3699 \$1629 \$1608 \$1607 VSS nfet_03v3 L=0.28U W=0.36U AS=0.1278P AD=0.0567P
+ PS=1.07U PD=0.675U
M$3700 VSS \$1553 \$1629 VSS nfet_03v3 L=0.28U W=0.36U AS=0.0567P AD=0.1584P
+ PS=0.675U PD=1.6U
M$3701 VSS \$1607 \$1608 VSS nfet_03v3 L=0.28U W=0.36U AS=0.1584P AD=0.0972P
+ PS=1.6U PD=0.9U
M$3702 \$1609 \$1607 VSS VSS nfet_03v3 L=0.28U W=0.36U AS=0.0972P AD=0.18P
+ PS=0.9U PD=1.72U
M$3703 \$1610 \$148 VSS VSS nfet_03v3 L=0.28U W=0.36U AS=0.1584P AD=0.1188P
+ PS=1.6U PD=1.02U
M$3704 \$1611 \$1552 \$1610 VSS nfet_03v3 L=0.28U W=0.36U AS=0.1188P AD=0.1278P
+ PS=1.02U PD=1.07U
M$3705 \$1625 \$1612 \$1611 VSS nfet_03v3 L=0.28U W=0.36U AS=0.1278P AD=0.0567P
+ PS=1.07U PD=0.675U
M$3706 VSS \$1553 \$1625 VSS nfet_03v3 L=0.28U W=0.36U AS=0.0567P AD=0.1584P
+ PS=0.675U PD=1.6U
M$3707 VSS \$1611 \$1612 VSS nfet_03v3 L=0.28U W=0.36U AS=0.1584P AD=0.0972P
+ PS=1.6U PD=0.9U
M$3708 \$1613 \$1611 VSS VSS nfet_03v3 L=0.28U W=0.36U AS=0.0972P AD=0.18P
+ PS=0.9U PD=1.72U
M$3709 \$1614 \$151 VSS VSS nfet_03v3 L=0.28U W=0.36U AS=0.1584P AD=0.1188P
+ PS=1.6U PD=1.02U
M$3710 \$1615 \$1552 \$1614 VSS nfet_03v3 L=0.28U W=0.36U AS=0.1188P AD=0.1278P
+ PS=1.02U PD=1.07U
M$3711 \$1620 \$1616 \$1615 VSS nfet_03v3 L=0.28U W=0.36U AS=0.1278P AD=0.0567P
+ PS=1.07U PD=0.675U
M$3712 VSS \$1553 \$1620 VSS nfet_03v3 L=0.28U W=0.36U AS=0.0567P AD=0.1584P
+ PS=0.675U PD=1.6U
M$3713 VSS \$1615 \$1616 VSS nfet_03v3 L=0.28U W=0.36U AS=0.1584P AD=0.0972P
+ PS=1.6U PD=0.9U
M$3714 \$1617 \$1615 VSS VSS nfet_03v3 L=0.28U W=0.36U AS=0.0972P AD=0.18P
+ PS=0.9U PD=1.72U
M$3715 \$1871 RB10 VSS VSS nfet_03v3 L=0.28U W=0.36U AS=0.1656P AD=0.1944P
+ PS=1.64U PD=1.8U
M$3716 \$1668 RA11 VSS VSS nfet_03v3 L=0.28U W=0.36U AS=0.1656P AD=0.1944P
+ PS=1.64U PD=1.8U
M$3717 \$1870 RB10 \$51 VSS nfet_03v3 L=0.28U W=0.36U AS=0.1584P AD=0.1152P
+ PS=1.6U PD=1U
M$3718 \$52 RA10 \$1870 VSS nfet_03v3 L=0.28U W=0.36U AS=0.1152P AD=0.1584P
+ PS=1U PD=1.6U
M$3719 \$1557 RA11 \$51 VSS nfet_03v3 L=0.28U W=0.36U AS=0.1584P AD=0.1152P
+ PS=1.6U PD=1U
M$3720 \$52 RB11 \$1557 VSS nfet_03v3 L=0.28U W=0.36U AS=0.1152P AD=0.1584P
+ PS=1U PD=1.6U
M$3721 VSS RB11 \$1669 VSS nfet_03v3 L=0.28U W=0.36U AS=0.1854P AD=0.1584P
+ PS=1.75U PD=1.6U
M$3722 VSS RA10 \$1872 VSS nfet_03v3 L=0.28U W=0.36U AS=0.1854P AD=0.1584P
+ PS=1.75U PD=1.6U
M$3723 \$1877 RB10 VSS VSS nfet_03v3 L=0.28U W=0.36U AS=0.1656P AD=0.1944P
+ PS=1.64U PD=1.8U
M$3724 \$1670 RA11 VSS VSS nfet_03v3 L=0.28U W=0.36U AS=0.1656P AD=0.1944P
+ PS=1.64U PD=1.8U
M$3725 \$1561 RA11 \$53 VSS nfet_03v3 L=0.28U W=0.36U AS=0.1584P AD=0.1152P
+ PS=1.6U PD=1U
M$3726 \$54 RB11 \$1561 VSS nfet_03v3 L=0.28U W=0.36U AS=0.1152P AD=0.1584P
+ PS=1U PD=1.6U
M$3727 \$1876 RB10 \$53 VSS nfet_03v3 L=0.28U W=0.36U AS=0.1584P AD=0.1152P
+ PS=1.6U PD=1U
M$3728 \$54 RA10 \$1876 VSS nfet_03v3 L=0.28U W=0.36U AS=0.1152P AD=0.1584P
+ PS=1U PD=1.6U
M$3729 VSS RA10 \$1878 VSS nfet_03v3 L=0.28U W=0.36U AS=0.1854P AD=0.1584P
+ PS=1.75U PD=1.6U
M$3730 VSS RB11 \$1671 VSS nfet_03v3 L=0.28U W=0.36U AS=0.1854P AD=0.1584P
+ PS=1.75U PD=1.6U
M$3731 \$1672 RA11 VSS VSS nfet_03v3 L=0.28U W=0.36U AS=0.1656P AD=0.1944P
+ PS=1.64U PD=1.8U
M$3732 \$1883 RB10 VSS VSS nfet_03v3 L=0.28U W=0.36U AS=0.1656P AD=0.1944P
+ PS=1.64U PD=1.8U
M$3733 \$1565 RA11 \$55 VSS nfet_03v3 L=0.28U W=0.36U AS=0.1584P AD=0.1152P
+ PS=1.6U PD=1U
M$3734 \$56 RB11 \$1565 VSS nfet_03v3 L=0.28U W=0.36U AS=0.1152P AD=0.1584P
+ PS=1U PD=1.6U
M$3735 \$1882 RB10 \$55 VSS nfet_03v3 L=0.28U W=0.36U AS=0.1584P AD=0.1152P
+ PS=1.6U PD=1U
M$3736 \$56 RA10 \$1882 VSS nfet_03v3 L=0.28U W=0.36U AS=0.1152P AD=0.1584P
+ PS=1U PD=1.6U
M$3737 VSS RB11 \$1673 VSS nfet_03v3 L=0.28U W=0.36U AS=0.1854P AD=0.1584P
+ PS=1.75U PD=1.6U
M$3738 VSS RA10 \$1884 VSS nfet_03v3 L=0.28U W=0.36U AS=0.1854P AD=0.1584P
+ PS=1.75U PD=1.6U
M$3739 \$1889 RB10 VSS VSS nfet_03v3 L=0.28U W=0.36U AS=0.1656P AD=0.1944P
+ PS=1.64U PD=1.8U
M$3740 \$1674 RA11 VSS VSS nfet_03v3 L=0.28U W=0.36U AS=0.1656P AD=0.1944P
+ PS=1.64U PD=1.8U
M$3741 \$1569 RA11 \$57 VSS nfet_03v3 L=0.28U W=0.36U AS=0.1584P AD=0.1152P
+ PS=1.6U PD=1U
M$3742 \$58 RB11 \$1569 VSS nfet_03v3 L=0.28U W=0.36U AS=0.1152P AD=0.1584P
+ PS=1U PD=1.6U
M$3743 \$1888 RB10 \$57 VSS nfet_03v3 L=0.28U W=0.36U AS=0.1584P AD=0.1152P
+ PS=1.6U PD=1U
M$3744 \$58 RA10 \$1888 VSS nfet_03v3 L=0.28U W=0.36U AS=0.1152P AD=0.1584P
+ PS=1U PD=1.6U
M$3745 VSS RB11 \$1675 VSS nfet_03v3 L=0.28U W=0.36U AS=0.1854P AD=0.1584P
+ PS=1.75U PD=1.6U
M$3746 VSS RA10 \$1890 VSS nfet_03v3 L=0.28U W=0.36U AS=0.1854P AD=0.1584P
+ PS=1.75U PD=1.6U
M$3747 \$1895 RB10 VSS VSS nfet_03v3 L=0.28U W=0.36U AS=0.1656P AD=0.1944P
+ PS=1.64U PD=1.8U
M$3748 \$1676 RA11 VSS VSS nfet_03v3 L=0.28U W=0.36U AS=0.1656P AD=0.1944P
+ PS=1.64U PD=1.8U
M$3749 \$1573 RA11 \$59 VSS nfet_03v3 L=0.28U W=0.36U AS=0.1584P AD=0.1152P
+ PS=1.6U PD=1U
M$3750 \$60 RB11 \$1573 VSS nfet_03v3 L=0.28U W=0.36U AS=0.1152P AD=0.1584P
+ PS=1U PD=1.6U
M$3751 \$1894 RB10 \$59 VSS nfet_03v3 L=0.28U W=0.36U AS=0.1584P AD=0.1152P
+ PS=1.6U PD=1U
M$3752 \$60 RA10 \$1894 VSS nfet_03v3 L=0.28U W=0.36U AS=0.1152P AD=0.1584P
+ PS=1U PD=1.6U
M$3753 VSS RB11 \$1677 VSS nfet_03v3 L=0.28U W=0.36U AS=0.1854P AD=0.1584P
+ PS=1.75U PD=1.6U
M$3754 VSS RA10 \$1896 VSS nfet_03v3 L=0.28U W=0.36U AS=0.1854P AD=0.1584P
+ PS=1.75U PD=1.6U
M$3755 \$1901 RB10 VSS VSS nfet_03v3 L=0.28U W=0.36U AS=0.1656P AD=0.1944P
+ PS=1.64U PD=1.8U
M$3756 \$1678 RA11 VSS VSS nfet_03v3 L=0.28U W=0.36U AS=0.1656P AD=0.1944P
+ PS=1.64U PD=1.8U
M$3757 \$1900 RB10 \$61 VSS nfet_03v3 L=0.28U W=0.36U AS=0.1584P AD=0.1152P
+ PS=1.6U PD=1U
M$3758 \$62 RA10 \$1900 VSS nfet_03v3 L=0.28U W=0.36U AS=0.1152P AD=0.1584P
+ PS=1U PD=1.6U
M$3759 \$1577 RA11 \$61 VSS nfet_03v3 L=0.28U W=0.36U AS=0.1584P AD=0.1152P
+ PS=1.6U PD=1U
M$3760 \$62 RB11 \$1577 VSS nfet_03v3 L=0.28U W=0.36U AS=0.1152P AD=0.1584P
+ PS=1U PD=1.6U
M$3761 VSS RB11 \$1679 VSS nfet_03v3 L=0.28U W=0.36U AS=0.1854P AD=0.1584P
+ PS=1.75U PD=1.6U
M$3762 VSS RA10 \$1902 VSS nfet_03v3 L=0.28U W=0.36U AS=0.1854P AD=0.1584P
+ PS=1.75U PD=1.6U
M$3763 \$1907 RB10 VSS VSS nfet_03v3 L=0.28U W=0.36U AS=0.1656P AD=0.1944P
+ PS=1.64U PD=1.8U
M$3764 \$1680 RA11 VSS VSS nfet_03v3 L=0.28U W=0.36U AS=0.1656P AD=0.1944P
+ PS=1.64U PD=1.8U
M$3765 \$1906 RB10 \$63 VSS nfet_03v3 L=0.28U W=0.36U AS=0.1584P AD=0.1152P
+ PS=1.6U PD=1U
M$3766 \$64 RA10 \$1906 VSS nfet_03v3 L=0.28U W=0.36U AS=0.1152P AD=0.1584P
+ PS=1U PD=1.6U
M$3767 \$1581 RA11 \$63 VSS nfet_03v3 L=0.28U W=0.36U AS=0.1584P AD=0.1152P
+ PS=1.6U PD=1U
M$3768 \$64 RB11 \$1581 VSS nfet_03v3 L=0.28U W=0.36U AS=0.1152P AD=0.1584P
+ PS=1U PD=1.6U
M$3769 VSS RA10 \$1908 VSS nfet_03v3 L=0.28U W=0.36U AS=0.1854P AD=0.1584P
+ PS=1.75U PD=1.6U
M$3770 VSS RB11 \$1681 VSS nfet_03v3 L=0.28U W=0.36U AS=0.1854P AD=0.1584P
+ PS=1.75U PD=1.6U
M$3771 \$1913 RB10 VSS VSS nfet_03v3 L=0.28U W=0.36U AS=0.1656P AD=0.1944P
+ PS=1.64U PD=1.8U
M$3772 \$1682 RA11 VSS VSS nfet_03v3 L=0.28U W=0.36U AS=0.1656P AD=0.1944P
+ PS=1.64U PD=1.8U
M$3773 \$1912 RB10 \$65 VSS nfet_03v3 L=0.28U W=0.36U AS=0.1584P AD=0.1152P
+ PS=1.6U PD=1U
M$3774 \$66 RA10 \$1912 VSS nfet_03v3 L=0.28U W=0.36U AS=0.1152P AD=0.1584P
+ PS=1U PD=1.6U
M$3775 \$1585 RA11 \$65 VSS nfet_03v3 L=0.28U W=0.36U AS=0.1584P AD=0.1152P
+ PS=1.6U PD=1U
M$3776 \$66 RB11 \$1585 VSS nfet_03v3 L=0.28U W=0.36U AS=0.1152P AD=0.1584P
+ PS=1U PD=1.6U
M$3777 VSS RB11 \$1683 VSS nfet_03v3 L=0.28U W=0.36U AS=0.1854P AD=0.1584P
+ PS=1.75U PD=1.6U
M$3778 VSS RA10 \$1914 VSS nfet_03v3 L=0.28U W=0.36U AS=0.1854P AD=0.1584P
+ PS=1.75U PD=1.6U
M$3779 \$1684 RA11 VSS VSS nfet_03v3 L=0.28U W=0.36U AS=0.1656P AD=0.1944P
+ PS=1.64U PD=1.8U
M$3780 \$1919 RB10 VSS VSS nfet_03v3 L=0.28U W=0.36U AS=0.1656P AD=0.1944P
+ PS=1.64U PD=1.8U
M$3781 \$1918 RB10 \$67 VSS nfet_03v3 L=0.28U W=0.36U AS=0.1584P AD=0.1152P
+ PS=1.6U PD=1U
M$3782 \$68 RA10 \$1918 VSS nfet_03v3 L=0.28U W=0.36U AS=0.1152P AD=0.1584P
+ PS=1U PD=1.6U
M$3783 \$1589 RA11 \$67 VSS nfet_03v3 L=0.28U W=0.36U AS=0.1584P AD=0.1152P
+ PS=1.6U PD=1U
M$3784 \$68 RB11 \$1589 VSS nfet_03v3 L=0.28U W=0.36U AS=0.1152P AD=0.1584P
+ PS=1U PD=1.6U
M$3785 VSS RA10 \$1920 VSS nfet_03v3 L=0.28U W=0.36U AS=0.1854P AD=0.1584P
+ PS=1.75U PD=1.6U
M$3786 VSS RB11 \$1685 VSS nfet_03v3 L=0.28U W=0.36U AS=0.1854P AD=0.1584P
+ PS=1.75U PD=1.6U
M$3787 \$1925 RB10 VSS VSS nfet_03v3 L=0.28U W=0.36U AS=0.1656P AD=0.1944P
+ PS=1.64U PD=1.8U
M$3788 \$1686 RA11 VSS VSS nfet_03v3 L=0.28U W=0.36U AS=0.1656P AD=0.1944P
+ PS=1.64U PD=1.8U
M$3789 \$1924 RB10 \$69 VSS nfet_03v3 L=0.28U W=0.36U AS=0.1584P AD=0.1152P
+ PS=1.6U PD=1U
M$3790 \$70 RA10 \$1924 VSS nfet_03v3 L=0.28U W=0.36U AS=0.1152P AD=0.1584P
+ PS=1U PD=1.6U
M$3791 \$1593 RA11 \$69 VSS nfet_03v3 L=0.28U W=0.36U AS=0.1584P AD=0.1152P
+ PS=1.6U PD=1U
M$3792 \$70 RB11 \$1593 VSS nfet_03v3 L=0.28U W=0.36U AS=0.1152P AD=0.1584P
+ PS=1U PD=1.6U
M$3793 VSS RB11 \$1687 VSS nfet_03v3 L=0.28U W=0.36U AS=0.1854P AD=0.1584P
+ PS=1.75U PD=1.6U
M$3794 VSS RA10 \$1926 VSS nfet_03v3 L=0.28U W=0.36U AS=0.1854P AD=0.1584P
+ PS=1.75U PD=1.6U
M$3795 \$1931 RB10 VSS VSS nfet_03v3 L=0.28U W=0.36U AS=0.1656P AD=0.1944P
+ PS=1.64U PD=1.8U
M$3796 \$1688 RA11 VSS VSS nfet_03v3 L=0.28U W=0.36U AS=0.1656P AD=0.1944P
+ PS=1.64U PD=1.8U
M$3797 \$1930 RB10 \$71 VSS nfet_03v3 L=0.28U W=0.36U AS=0.1584P AD=0.1152P
+ PS=1.6U PD=1U
M$3798 \$72 RA10 \$1930 VSS nfet_03v3 L=0.28U W=0.36U AS=0.1152P AD=0.1584P
+ PS=1U PD=1.6U
M$3799 \$1597 RA11 \$71 VSS nfet_03v3 L=0.28U W=0.36U AS=0.1584P AD=0.1152P
+ PS=1.6U PD=1U
M$3800 \$72 RB11 \$1597 VSS nfet_03v3 L=0.28U W=0.36U AS=0.1152P AD=0.1584P
+ PS=1U PD=1.6U
M$3801 VSS RA10 \$1932 VSS nfet_03v3 L=0.28U W=0.36U AS=0.1854P AD=0.1584P
+ PS=1.75U PD=1.6U
M$3802 VSS RB11 \$1689 VSS nfet_03v3 L=0.28U W=0.36U AS=0.1854P AD=0.1584P
+ PS=1.75U PD=1.6U
M$3803 \$1690 RA11 VSS VSS nfet_03v3 L=0.28U W=0.36U AS=0.1656P AD=0.1944P
+ PS=1.64U PD=1.8U
M$3804 \$1937 RB10 VSS VSS nfet_03v3 L=0.28U W=0.36U AS=0.1656P AD=0.1944P
+ PS=1.64U PD=1.8U
M$3805 \$1601 RA11 \$73 VSS nfet_03v3 L=0.28U W=0.36U AS=0.1584P AD=0.1152P
+ PS=1.6U PD=1U
M$3806 \$74 RB11 \$1601 VSS nfet_03v3 L=0.28U W=0.36U AS=0.1152P AD=0.1584P
+ PS=1U PD=1.6U
M$3807 \$1936 RB10 \$73 VSS nfet_03v3 L=0.28U W=0.36U AS=0.1584P AD=0.1152P
+ PS=1.6U PD=1U
M$3808 \$74 RA10 \$1936 VSS nfet_03v3 L=0.28U W=0.36U AS=0.1152P AD=0.1584P
+ PS=1U PD=1.6U
M$3809 VSS RA10 \$1938 VSS nfet_03v3 L=0.28U W=0.36U AS=0.1854P AD=0.1584P
+ PS=1.75U PD=1.6U
M$3810 VSS RB11 \$1691 VSS nfet_03v3 L=0.28U W=0.36U AS=0.1854P AD=0.1584P
+ PS=1.75U PD=1.6U
M$3811 \$1692 RA11 VSS VSS nfet_03v3 L=0.28U W=0.36U AS=0.1656P AD=0.1944P
+ PS=1.64U PD=1.8U
M$3812 \$1943 RB10 VSS VSS nfet_03v3 L=0.28U W=0.36U AS=0.1656P AD=0.1944P
+ PS=1.64U PD=1.8U
M$3813 \$1605 RA11 \$75 VSS nfet_03v3 L=0.28U W=0.36U AS=0.1584P AD=0.1152P
+ PS=1.6U PD=1U
M$3814 \$76 RB11 \$1605 VSS nfet_03v3 L=0.28U W=0.36U AS=0.1152P AD=0.1584P
+ PS=1U PD=1.6U
M$3815 \$1942 RB10 \$75 VSS nfet_03v3 L=0.28U W=0.36U AS=0.1584P AD=0.1152P
+ PS=1.6U PD=1U
M$3816 \$76 RA10 \$1942 VSS nfet_03v3 L=0.28U W=0.36U AS=0.1152P AD=0.1584P
+ PS=1U PD=1.6U
M$3817 VSS RA10 \$1944 VSS nfet_03v3 L=0.28U W=0.36U AS=0.1854P AD=0.1584P
+ PS=1.75U PD=1.6U
M$3818 VSS RB11 \$1693 VSS nfet_03v3 L=0.28U W=0.36U AS=0.1854P AD=0.1584P
+ PS=1.75U PD=1.6U
M$3819 \$1694 RA11 VSS VSS nfet_03v3 L=0.28U W=0.36U AS=0.1656P AD=0.1944P
+ PS=1.64U PD=1.8U
M$3820 \$1949 RB10 VSS VSS nfet_03v3 L=0.28U W=0.36U AS=0.1656P AD=0.1944P
+ PS=1.64U PD=1.8U
M$3821 \$1948 RB10 \$77 VSS nfet_03v3 L=0.28U W=0.36U AS=0.1584P AD=0.1152P
+ PS=1.6U PD=1U
M$3822 \$78 RA10 \$1948 VSS nfet_03v3 L=0.28U W=0.36U AS=0.1152P AD=0.1584P
+ PS=1U PD=1.6U
M$3823 \$1609 RA11 \$77 VSS nfet_03v3 L=0.28U W=0.36U AS=0.1584P AD=0.1152P
+ PS=1.6U PD=1U
M$3824 \$78 RB11 \$1609 VSS nfet_03v3 L=0.28U W=0.36U AS=0.1152P AD=0.1584P
+ PS=1U PD=1.6U
M$3825 VSS RB11 \$1695 VSS nfet_03v3 L=0.28U W=0.36U AS=0.1854P AD=0.1584P
+ PS=1.75U PD=1.6U
M$3826 VSS RA10 \$1950 VSS nfet_03v3 L=0.28U W=0.36U AS=0.1854P AD=0.1584P
+ PS=1.75U PD=1.6U
M$3827 \$1955 RB10 VSS VSS nfet_03v3 L=0.28U W=0.36U AS=0.1656P AD=0.1944P
+ PS=1.64U PD=1.8U
M$3828 \$1696 RA11 VSS VSS nfet_03v3 L=0.28U W=0.36U AS=0.1656P AD=0.1944P
+ PS=1.64U PD=1.8U
M$3829 \$1954 RB10 \$79 VSS nfet_03v3 L=0.28U W=0.36U AS=0.1584P AD=0.1152P
+ PS=1.6U PD=1U
M$3830 \$80 RA10 \$1954 VSS nfet_03v3 L=0.28U W=0.36U AS=0.1152P AD=0.1584P
+ PS=1U PD=1.6U
M$3831 \$1613 RA11 \$79 VSS nfet_03v3 L=0.28U W=0.36U AS=0.1584P AD=0.1152P
+ PS=1.6U PD=1U
M$3832 \$80 RB11 \$1613 VSS nfet_03v3 L=0.28U W=0.36U AS=0.1152P AD=0.1584P
+ PS=1U PD=1.6U
M$3833 VSS RA10 \$1956 VSS nfet_03v3 L=0.28U W=0.36U AS=0.1854P AD=0.1584P
+ PS=1.75U PD=1.6U
M$3834 VSS RB11 \$1697 VSS nfet_03v3 L=0.28U W=0.36U AS=0.1854P AD=0.1584P
+ PS=1.75U PD=1.6U
M$3835 \$1698 RA11 VSS VSS nfet_03v3 L=0.28U W=0.36U AS=0.1656P AD=0.1944P
+ PS=1.64U PD=1.8U
M$3836 \$1961 RB10 VSS VSS nfet_03v3 L=0.28U W=0.36U AS=0.1656P AD=0.1944P
+ PS=1.64U PD=1.8U
M$3837 \$1960 RB10 \$81 VSS nfet_03v3 L=0.28U W=0.36U AS=0.1584P AD=0.1152P
+ PS=1.6U PD=1U
M$3838 \$82 RA10 \$1960 VSS nfet_03v3 L=0.28U W=0.36U AS=0.1152P AD=0.1584P
+ PS=1U PD=1.6U
M$3839 \$1617 RA11 \$81 VSS nfet_03v3 L=0.28U W=0.36U AS=0.1584P AD=0.1152P
+ PS=1.6U PD=1U
M$3840 \$82 RB11 \$1617 VSS nfet_03v3 L=0.28U W=0.36U AS=0.1152P AD=0.1584P
+ PS=1U PD=1.6U
M$3841 VSS RB11 \$1699 VSS nfet_03v3 L=0.28U W=0.36U AS=0.1854P AD=0.1584P
+ PS=1.75U PD=1.6U
M$3842 VSS RA10 \$1962 VSS nfet_03v3 L=0.28U W=0.36U AS=0.1854P AD=0.1584P
+ PS=1.75U PD=1.6U
M$3843 \$2066 WE10 VSS VSS nfet_03v3 L=0.28U W=0.72U AS=0.3168P AD=0.1872P
+ PS=2.32U PD=1.24U
M$3844 \$1861 CLK \$2066 VSS nfet_03v3 L=0.28U W=0.72U AS=0.1872P AD=0.3168P
+ PS=1.24U PD=2.32U
M$3845 \$1863 \$1861 VSS VSS nfet_03v3 L=0.28U W=0.635U AS=0.2794P AD=0.1651P
+ PS=2.15U PD=1.155U
M$3846 \$1863 \$1861 VSS VSS nfet_03v3 L=0.28U W=0.635U AS=0.1693P AD=0.1651P
+ PS=1.19U PD=1.155U
M$3847 \$1864 \$1863 VSS VSS nfet_03v3 L=0.28U W=0.67U AS=0.1693P AD=0.1943P
+ PS=1.19U PD=1.25U
M$3848 VSS \$1863 \$1864 VSS nfet_03v3 L=0.28U W=0.67U AS=0.1943P AD=0.2948P
+ PS=1.25U PD=2.22U
M$3849 \$1867 \$106 VSS VSS nfet_03v3 L=0.28U W=0.36U AS=0.1584P AD=0.1188P
+ PS=1.6U PD=1.02U
M$3850 \$1868 \$1863 \$1867 VSS nfet_03v3 L=0.28U W=0.36U AS=0.1188P AD=0.1278P
+ PS=1.02U PD=1.07U
M$3851 \$2071 \$1869 \$1868 VSS nfet_03v3 L=0.28U W=0.36U AS=0.1278P AD=0.0567P
+ PS=1.07U PD=0.675U
M$3852 VSS \$1864 \$2071 VSS nfet_03v3 L=0.28U W=0.36U AS=0.0567P AD=0.1584P
+ PS=0.675U PD=1.6U
M$3853 VSS \$1868 \$1869 VSS nfet_03v3 L=0.28U W=0.36U AS=0.1584P AD=0.0972P
+ PS=1.6U PD=0.9U
M$3854 \$1870 \$1868 VSS VSS nfet_03v3 L=0.28U W=0.36U AS=0.0972P AD=0.18P
+ PS=0.9U PD=1.72U
M$3855 \$1873 \$109 VSS VSS nfet_03v3 L=0.28U W=0.36U AS=0.1584P AD=0.1188P
+ PS=1.6U PD=1.02U
M$3856 \$1874 \$1863 \$1873 VSS nfet_03v3 L=0.28U W=0.36U AS=0.1188P AD=0.1278P
+ PS=1.02U PD=1.07U
M$3857 \$2080 \$1875 \$1874 VSS nfet_03v3 L=0.28U W=0.36U AS=0.1278P AD=0.0567P
+ PS=1.07U PD=0.675U
M$3858 VSS \$1864 \$2080 VSS nfet_03v3 L=0.28U W=0.36U AS=0.0567P AD=0.1584P
+ PS=0.675U PD=1.6U
M$3859 VSS \$1874 \$1875 VSS nfet_03v3 L=0.28U W=0.36U AS=0.1584P AD=0.0972P
+ PS=1.6U PD=0.9U
M$3860 \$1876 \$1874 VSS VSS nfet_03v3 L=0.28U W=0.36U AS=0.0972P AD=0.18P
+ PS=0.9U PD=1.72U
M$3861 \$1879 \$112 VSS VSS nfet_03v3 L=0.28U W=0.36U AS=0.1584P AD=0.1188P
+ PS=1.6U PD=1.02U
M$3862 \$1880 \$1863 \$1879 VSS nfet_03v3 L=0.28U W=0.36U AS=0.1188P AD=0.1278P
+ PS=1.02U PD=1.07U
M$3863 \$2086 \$1881 \$1880 VSS nfet_03v3 L=0.28U W=0.36U AS=0.1278P AD=0.0567P
+ PS=1.07U PD=0.675U
M$3864 VSS \$1864 \$2086 VSS nfet_03v3 L=0.28U W=0.36U AS=0.0567P AD=0.1584P
+ PS=0.675U PD=1.6U
M$3865 VSS \$1880 \$1881 VSS nfet_03v3 L=0.28U W=0.36U AS=0.1584P AD=0.0972P
+ PS=1.6U PD=0.9U
M$3866 \$1882 \$1880 VSS VSS nfet_03v3 L=0.28U W=0.36U AS=0.0972P AD=0.18P
+ PS=0.9U PD=1.72U
M$3867 \$1885 \$115 VSS VSS nfet_03v3 L=0.28U W=0.36U AS=0.1584P AD=0.1188P
+ PS=1.6U PD=1.02U
M$3868 \$1886 \$1863 \$1885 VSS nfet_03v3 L=0.28U W=0.36U AS=0.1188P AD=0.1278P
+ PS=1.02U PD=1.07U
M$3869 \$2094 \$1887 \$1886 VSS nfet_03v3 L=0.28U W=0.36U AS=0.1278P AD=0.0567P
+ PS=1.07U PD=0.675U
M$3870 VSS \$1864 \$2094 VSS nfet_03v3 L=0.28U W=0.36U AS=0.0567P AD=0.1584P
+ PS=0.675U PD=1.6U
M$3871 VSS \$1886 \$1887 VSS nfet_03v3 L=0.28U W=0.36U AS=0.1584P AD=0.0972P
+ PS=1.6U PD=0.9U
M$3872 \$1888 \$1886 VSS VSS nfet_03v3 L=0.28U W=0.36U AS=0.0972P AD=0.18P
+ PS=0.9U PD=1.72U
M$3873 \$1891 \$118 VSS VSS nfet_03v3 L=0.28U W=0.36U AS=0.1584P AD=0.1188P
+ PS=1.6U PD=1.02U
M$3874 \$1892 \$1863 \$1891 VSS nfet_03v3 L=0.28U W=0.36U AS=0.1188P AD=0.1278P
+ PS=1.02U PD=1.07U
M$3875 \$2104 \$1893 \$1892 VSS nfet_03v3 L=0.28U W=0.36U AS=0.1278P AD=0.0567P
+ PS=1.07U PD=0.675U
M$3876 VSS \$1864 \$2104 VSS nfet_03v3 L=0.28U W=0.36U AS=0.0567P AD=0.1584P
+ PS=0.675U PD=1.6U
M$3877 VSS \$1892 \$1893 VSS nfet_03v3 L=0.28U W=0.36U AS=0.1584P AD=0.0972P
+ PS=1.6U PD=0.9U
M$3878 \$1894 \$1892 VSS VSS nfet_03v3 L=0.28U W=0.36U AS=0.0972P AD=0.18P
+ PS=0.9U PD=1.72U
M$3879 \$1897 \$121 VSS VSS nfet_03v3 L=0.28U W=0.36U AS=0.1584P AD=0.1188P
+ PS=1.6U PD=1.02U
M$3880 \$1898 \$1863 \$1897 VSS nfet_03v3 L=0.28U W=0.36U AS=0.1188P AD=0.1278P
+ PS=1.02U PD=1.07U
M$3881 \$2110 \$1899 \$1898 VSS nfet_03v3 L=0.28U W=0.36U AS=0.1278P AD=0.0567P
+ PS=1.07U PD=0.675U
M$3882 VSS \$1864 \$2110 VSS nfet_03v3 L=0.28U W=0.36U AS=0.0567P AD=0.1584P
+ PS=0.675U PD=1.6U
M$3883 VSS \$1898 \$1899 VSS nfet_03v3 L=0.28U W=0.36U AS=0.1584P AD=0.0972P
+ PS=1.6U PD=0.9U
M$3884 \$1900 \$1898 VSS VSS nfet_03v3 L=0.28U W=0.36U AS=0.0972P AD=0.18P
+ PS=0.9U PD=1.72U
M$3885 \$1903 \$124 VSS VSS nfet_03v3 L=0.28U W=0.36U AS=0.1584P AD=0.1188P
+ PS=1.6U PD=1.02U
M$3886 \$1904 \$1863 \$1903 VSS nfet_03v3 L=0.28U W=0.36U AS=0.1188P AD=0.1278P
+ PS=1.02U PD=1.07U
M$3887 \$2118 \$1905 \$1904 VSS nfet_03v3 L=0.28U W=0.36U AS=0.1278P AD=0.0567P
+ PS=1.07U PD=0.675U
M$3888 VSS \$1864 \$2118 VSS nfet_03v3 L=0.28U W=0.36U AS=0.0567P AD=0.1584P
+ PS=0.675U PD=1.6U
M$3889 VSS \$1904 \$1905 VSS nfet_03v3 L=0.28U W=0.36U AS=0.1584P AD=0.0972P
+ PS=1.6U PD=0.9U
M$3890 \$1906 \$1904 VSS VSS nfet_03v3 L=0.28U W=0.36U AS=0.0972P AD=0.18P
+ PS=0.9U PD=1.72U
M$3891 \$1909 \$127 VSS VSS nfet_03v3 L=0.28U W=0.36U AS=0.1584P AD=0.1188P
+ PS=1.6U PD=1.02U
M$3892 \$1910 \$1863 \$1909 VSS nfet_03v3 L=0.28U W=0.36U AS=0.1188P AD=0.1278P
+ PS=1.02U PD=1.07U
M$3893 \$2128 \$1911 \$1910 VSS nfet_03v3 L=0.28U W=0.36U AS=0.1278P AD=0.0567P
+ PS=1.07U PD=0.675U
M$3894 VSS \$1864 \$2128 VSS nfet_03v3 L=0.28U W=0.36U AS=0.0567P AD=0.1584P
+ PS=0.675U PD=1.6U
M$3895 VSS \$1910 \$1911 VSS nfet_03v3 L=0.28U W=0.36U AS=0.1584P AD=0.0972P
+ PS=1.6U PD=0.9U
M$3896 \$1912 \$1910 VSS VSS nfet_03v3 L=0.28U W=0.36U AS=0.0972P AD=0.18P
+ PS=0.9U PD=1.72U
M$3897 \$1915 \$130 VSS VSS nfet_03v3 L=0.28U W=0.36U AS=0.1584P AD=0.1188P
+ PS=1.6U PD=1.02U
M$3898 \$1916 \$1863 \$1915 VSS nfet_03v3 L=0.28U W=0.36U AS=0.1188P AD=0.1278P
+ PS=1.02U PD=1.07U
M$3899 \$2134 \$1917 \$1916 VSS nfet_03v3 L=0.28U W=0.36U AS=0.1278P AD=0.0567P
+ PS=1.07U PD=0.675U
M$3900 VSS \$1864 \$2134 VSS nfet_03v3 L=0.28U W=0.36U AS=0.0567P AD=0.1584P
+ PS=0.675U PD=1.6U
M$3901 VSS \$1916 \$1917 VSS nfet_03v3 L=0.28U W=0.36U AS=0.1584P AD=0.0972P
+ PS=1.6U PD=0.9U
M$3902 \$1918 \$1916 VSS VSS nfet_03v3 L=0.28U W=0.36U AS=0.0972P AD=0.18P
+ PS=0.9U PD=1.72U
M$3903 \$1921 \$133 VSS VSS nfet_03v3 L=0.28U W=0.36U AS=0.1584P AD=0.1188P
+ PS=1.6U PD=1.02U
M$3904 \$1922 \$1863 \$1921 VSS nfet_03v3 L=0.28U W=0.36U AS=0.1188P AD=0.1278P
+ PS=1.02U PD=1.07U
M$3905 \$2142 \$1923 \$1922 VSS nfet_03v3 L=0.28U W=0.36U AS=0.1278P AD=0.0567P
+ PS=1.07U PD=0.675U
M$3906 VSS \$1864 \$2142 VSS nfet_03v3 L=0.28U W=0.36U AS=0.0567P AD=0.1584P
+ PS=0.675U PD=1.6U
M$3907 VSS \$1922 \$1923 VSS nfet_03v3 L=0.28U W=0.36U AS=0.1584P AD=0.0972P
+ PS=1.6U PD=0.9U
M$3908 \$1924 \$1922 VSS VSS nfet_03v3 L=0.28U W=0.36U AS=0.0972P AD=0.18P
+ PS=0.9U PD=1.72U
M$3909 \$1927 \$136 VSS VSS nfet_03v3 L=0.28U W=0.36U AS=0.1584P AD=0.1188P
+ PS=1.6U PD=1.02U
M$3910 \$1928 \$1863 \$1927 VSS nfet_03v3 L=0.28U W=0.36U AS=0.1188P AD=0.1278P
+ PS=1.02U PD=1.07U
M$3911 \$2150 \$1929 \$1928 VSS nfet_03v3 L=0.28U W=0.36U AS=0.1278P AD=0.0567P
+ PS=1.07U PD=0.675U
M$3912 VSS \$1864 \$2150 VSS nfet_03v3 L=0.28U W=0.36U AS=0.0567P AD=0.1584P
+ PS=0.675U PD=1.6U
M$3913 VSS \$1928 \$1929 VSS nfet_03v3 L=0.28U W=0.36U AS=0.1584P AD=0.0972P
+ PS=1.6U PD=0.9U
M$3914 \$1930 \$1928 VSS VSS nfet_03v3 L=0.28U W=0.36U AS=0.0972P AD=0.18P
+ PS=0.9U PD=1.72U
M$3915 \$1933 \$139 VSS VSS nfet_03v3 L=0.28U W=0.36U AS=0.1584P AD=0.1188P
+ PS=1.6U PD=1.02U
M$3916 \$1934 \$1863 \$1933 VSS nfet_03v3 L=0.28U W=0.36U AS=0.1188P AD=0.1278P
+ PS=1.02U PD=1.07U
M$3917 \$2158 \$1935 \$1934 VSS nfet_03v3 L=0.28U W=0.36U AS=0.1278P AD=0.0567P
+ PS=1.07U PD=0.675U
M$3918 VSS \$1864 \$2158 VSS nfet_03v3 L=0.28U W=0.36U AS=0.0567P AD=0.1584P
+ PS=0.675U PD=1.6U
M$3919 VSS \$1934 \$1935 VSS nfet_03v3 L=0.28U W=0.36U AS=0.1584P AD=0.0972P
+ PS=1.6U PD=0.9U
M$3920 \$1936 \$1934 VSS VSS nfet_03v3 L=0.28U W=0.36U AS=0.0972P AD=0.18P
+ PS=0.9U PD=1.72U
M$3921 \$1939 \$142 VSS VSS nfet_03v3 L=0.28U W=0.36U AS=0.1584P AD=0.1188P
+ PS=1.6U PD=1.02U
M$3922 \$1940 \$1863 \$1939 VSS nfet_03v3 L=0.28U W=0.36U AS=0.1188P AD=0.1278P
+ PS=1.02U PD=1.07U
M$3923 \$2153 \$1941 \$1940 VSS nfet_03v3 L=0.28U W=0.36U AS=0.1278P AD=0.0567P
+ PS=1.07U PD=0.675U
M$3924 VSS \$1864 \$2153 VSS nfet_03v3 L=0.28U W=0.36U AS=0.0567P AD=0.1584P
+ PS=0.675U PD=1.6U
M$3925 VSS \$1940 \$1941 VSS nfet_03v3 L=0.28U W=0.36U AS=0.1584P AD=0.0972P
+ PS=1.6U PD=0.9U
M$3926 \$1942 \$1940 VSS VSS nfet_03v3 L=0.28U W=0.36U AS=0.0972P AD=0.18P
+ PS=0.9U PD=1.72U
M$3927 \$1945 \$145 VSS VSS nfet_03v3 L=0.28U W=0.36U AS=0.1584P AD=0.1188P
+ PS=1.6U PD=1.02U
M$3928 \$1946 \$1863 \$1945 VSS nfet_03v3 L=0.28U W=0.36U AS=0.1188P AD=0.1278P
+ PS=1.02U PD=1.07U
M$3929 \$2127 \$1947 \$1946 VSS nfet_03v3 L=0.28U W=0.36U AS=0.1278P AD=0.0567P
+ PS=1.07U PD=0.675U
M$3930 VSS \$1864 \$2127 VSS nfet_03v3 L=0.28U W=0.36U AS=0.0567P AD=0.1584P
+ PS=0.675U PD=1.6U
M$3931 VSS \$1946 \$1947 VSS nfet_03v3 L=0.28U W=0.36U AS=0.1584P AD=0.0972P
+ PS=1.6U PD=0.9U
M$3932 \$1948 \$1946 VSS VSS nfet_03v3 L=0.28U W=0.36U AS=0.0972P AD=0.18P
+ PS=0.9U PD=1.72U
M$3933 \$1951 \$148 VSS VSS nfet_03v3 L=0.28U W=0.36U AS=0.1584P AD=0.1188P
+ PS=1.6U PD=1.02U
M$3934 \$1952 \$1863 \$1951 VSS nfet_03v3 L=0.28U W=0.36U AS=0.1188P AD=0.1278P
+ PS=1.02U PD=1.07U
M$3935 \$2103 \$1953 \$1952 VSS nfet_03v3 L=0.28U W=0.36U AS=0.1278P AD=0.0567P
+ PS=1.07U PD=0.675U
M$3936 VSS \$1864 \$2103 VSS nfet_03v3 L=0.28U W=0.36U AS=0.0567P AD=0.1584P
+ PS=0.675U PD=1.6U
M$3937 VSS \$1952 \$1953 VSS nfet_03v3 L=0.28U W=0.36U AS=0.1584P AD=0.0972P
+ PS=1.6U PD=0.9U
M$3938 \$1954 \$1952 VSS VSS nfet_03v3 L=0.28U W=0.36U AS=0.0972P AD=0.18P
+ PS=0.9U PD=1.72U
M$3939 \$1957 \$151 VSS VSS nfet_03v3 L=0.28U W=0.36U AS=0.1584P AD=0.1188P
+ PS=1.6U PD=1.02U
M$3940 \$1958 \$1863 \$1957 VSS nfet_03v3 L=0.28U W=0.36U AS=0.1188P AD=0.1278P
+ PS=1.02U PD=1.07U
M$3941 \$2079 \$1959 \$1958 VSS nfet_03v3 L=0.28U W=0.36U AS=0.1278P AD=0.0567P
+ PS=1.07U PD=0.675U
M$3942 VSS \$1864 \$2079 VSS nfet_03v3 L=0.28U W=0.36U AS=0.0567P AD=0.1584P
+ PS=0.675U PD=1.6U
M$3943 VSS \$1958 \$1959 VSS nfet_03v3 L=0.28U W=0.36U AS=0.1584P AD=0.0972P
+ PS=1.6U PD=0.9U
M$3944 \$1960 \$1958 VSS VSS nfet_03v3 L=0.28U W=0.36U AS=0.0972P AD=0.18P
+ PS=0.9U PD=1.72U
M$3945 \$2313 WE9 VSS VSS nfet_03v3 L=0.28U W=0.72U AS=0.3168P AD=0.1872P
+ PS=2.32U PD=1.24U
M$3946 \$2164 CLK \$2313 VSS nfet_03v3 L=0.28U W=0.72U AS=0.1872P AD=0.3168P
+ PS=1.24U PD=2.32U
M$3947 \$2165 \$2164 VSS VSS nfet_03v3 L=0.28U W=0.635U AS=0.2794P AD=0.1651P
+ PS=2.15U PD=1.155U
M$3948 VSS \$2164 \$2165 VSS nfet_03v3 L=0.28U W=0.635U AS=0.1651P AD=0.1693P
+ PS=1.155U PD=1.19U
M$3949 \$2166 \$2165 VSS VSS nfet_03v3 L=0.28U W=0.67U AS=0.1693P AD=0.1943P
+ PS=1.19U PD=1.25U
M$3950 VSS \$2165 \$2166 VSS nfet_03v3 L=0.28U W=0.67U AS=0.1943P AD=0.2948P
+ PS=1.25U PD=2.22U
M$3951 \$2167 \$106 VSS VSS nfet_03v3 L=0.28U W=0.36U AS=0.1584P AD=0.1188P
+ PS=1.6U PD=1.02U
M$3952 \$2168 \$2165 \$2167 VSS nfet_03v3 L=0.28U W=0.36U AS=0.1188P AD=0.1278P
+ PS=1.02U PD=1.07U
M$3953 \$2235 \$2169 \$2168 VSS nfet_03v3 L=0.28U W=0.36U AS=0.1278P AD=0.0567P
+ PS=1.07U PD=0.675U
M$3954 VSS \$2166 \$2235 VSS nfet_03v3 L=0.28U W=0.36U AS=0.0567P AD=0.1584P
+ PS=0.675U PD=1.6U
M$3955 VSS \$2168 \$2169 VSS nfet_03v3 L=0.28U W=0.36U AS=0.1584P AD=0.0972P
+ PS=1.6U PD=0.9U
M$3956 \$2170 \$2168 VSS VSS nfet_03v3 L=0.28U W=0.36U AS=0.0972P AD=0.18P
+ PS=0.9U PD=1.72U
M$3957 \$2171 \$109 VSS VSS nfet_03v3 L=0.28U W=0.36U AS=0.1584P AD=0.1188P
+ PS=1.6U PD=1.02U
M$3958 \$2172 \$2165 \$2171 VSS nfet_03v3 L=0.28U W=0.36U AS=0.1188P AD=0.1278P
+ PS=1.02U PD=1.07U
M$3959 \$2244 \$2173 \$2172 VSS nfet_03v3 L=0.28U W=0.36U AS=0.1278P AD=0.0567P
+ PS=1.07U PD=0.675U
M$3960 VSS \$2166 \$2244 VSS nfet_03v3 L=0.28U W=0.36U AS=0.0567P AD=0.1584P
+ PS=0.675U PD=1.6U
M$3961 VSS \$2172 \$2173 VSS nfet_03v3 L=0.28U W=0.36U AS=0.1584P AD=0.0972P
+ PS=1.6U PD=0.9U
M$3962 \$2174 \$2172 VSS VSS nfet_03v3 L=0.28U W=0.36U AS=0.0972P AD=0.18P
+ PS=0.9U PD=1.72U
M$3963 \$2175 \$112 VSS VSS nfet_03v3 L=0.28U W=0.36U AS=0.1584P AD=0.1188P
+ PS=1.6U PD=1.02U
M$3964 \$2176 \$2165 \$2175 VSS nfet_03v3 L=0.28U W=0.36U AS=0.1188P AD=0.1278P
+ PS=1.02U PD=1.07U
M$3965 \$2252 \$2177 \$2176 VSS nfet_03v3 L=0.28U W=0.36U AS=0.1278P AD=0.0567P
+ PS=1.07U PD=0.675U
M$3966 VSS \$2166 \$2252 VSS nfet_03v3 L=0.28U W=0.36U AS=0.0567P AD=0.1584P
+ PS=0.675U PD=1.6U
M$3967 VSS \$2176 \$2177 VSS nfet_03v3 L=0.28U W=0.36U AS=0.1584P AD=0.0972P
+ PS=1.6U PD=0.9U
M$3968 \$2178 \$2176 VSS VSS nfet_03v3 L=0.28U W=0.36U AS=0.0972P AD=0.18P
+ PS=0.9U PD=1.72U
M$3969 \$2179 \$115 VSS VSS nfet_03v3 L=0.28U W=0.36U AS=0.1584P AD=0.1188P
+ PS=1.6U PD=1.02U
M$3970 \$2180 \$2165 \$2179 VSS nfet_03v3 L=0.28U W=0.36U AS=0.1188P AD=0.1278P
+ PS=1.02U PD=1.07U
M$3971 \$2261 \$2181 \$2180 VSS nfet_03v3 L=0.28U W=0.36U AS=0.1278P AD=0.0567P
+ PS=1.07U PD=0.675U
M$3972 VSS \$2166 \$2261 VSS nfet_03v3 L=0.28U W=0.36U AS=0.0567P AD=0.1584P
+ PS=0.675U PD=1.6U
M$3973 VSS \$2180 \$2181 VSS nfet_03v3 L=0.28U W=0.36U AS=0.1584P AD=0.0972P
+ PS=1.6U PD=0.9U
M$3974 \$2182 \$2180 VSS VSS nfet_03v3 L=0.28U W=0.36U AS=0.0972P AD=0.18P
+ PS=0.9U PD=1.72U
M$3975 \$2183 \$118 VSS VSS nfet_03v3 L=0.28U W=0.36U AS=0.1584P AD=0.1188P
+ PS=1.6U PD=1.02U
M$3976 \$2184 \$2165 \$2183 VSS nfet_03v3 L=0.28U W=0.36U AS=0.1188P AD=0.1278P
+ PS=1.02U PD=1.07U
M$3977 \$2268 \$2185 \$2184 VSS nfet_03v3 L=0.28U W=0.36U AS=0.1278P AD=0.0567P
+ PS=1.07U PD=0.675U
M$3978 VSS \$2166 \$2268 VSS nfet_03v3 L=0.28U W=0.36U AS=0.0567P AD=0.1584P
+ PS=0.675U PD=1.6U
M$3979 VSS \$2184 \$2185 VSS nfet_03v3 L=0.28U W=0.36U AS=0.1584P AD=0.0972P
+ PS=1.6U PD=0.9U
M$3980 \$2186 \$2184 VSS VSS nfet_03v3 L=0.28U W=0.36U AS=0.0972P AD=0.18P
+ PS=0.9U PD=1.72U
M$3981 \$2187 \$121 VSS VSS nfet_03v3 L=0.28U W=0.36U AS=0.1584P AD=0.1188P
+ PS=1.6U PD=1.02U
M$3982 \$2188 \$2165 \$2187 VSS nfet_03v3 L=0.28U W=0.36U AS=0.1188P AD=0.1278P
+ PS=1.02U PD=1.07U
M$3983 \$2276 \$2189 \$2188 VSS nfet_03v3 L=0.28U W=0.36U AS=0.1278P AD=0.0567P
+ PS=1.07U PD=0.675U
M$3984 VSS \$2166 \$2276 VSS nfet_03v3 L=0.28U W=0.36U AS=0.0567P AD=0.1584P
+ PS=0.675U PD=1.6U
M$3985 VSS \$2188 \$2189 VSS nfet_03v3 L=0.28U W=0.36U AS=0.1584P AD=0.0972P
+ PS=1.6U PD=0.9U
M$3986 \$2190 \$2188 VSS VSS nfet_03v3 L=0.28U W=0.36U AS=0.0972P AD=0.18P
+ PS=0.9U PD=1.72U
M$3987 \$2191 \$124 VSS VSS nfet_03v3 L=0.28U W=0.36U AS=0.1584P AD=0.1188P
+ PS=1.6U PD=1.02U
M$3988 \$2192 \$2165 \$2191 VSS nfet_03v3 L=0.28U W=0.36U AS=0.1188P AD=0.1278P
+ PS=1.02U PD=1.07U
M$3989 \$2275 \$2193 \$2192 VSS nfet_03v3 L=0.28U W=0.36U AS=0.1278P AD=0.0567P
+ PS=1.07U PD=0.675U
M$3990 VSS \$2166 \$2275 VSS nfet_03v3 L=0.28U W=0.36U AS=0.0567P AD=0.1584P
+ PS=0.675U PD=1.6U
M$3991 VSS \$2192 \$2193 VSS nfet_03v3 L=0.28U W=0.36U AS=0.1584P AD=0.0972P
+ PS=1.6U PD=0.9U
M$3992 \$2194 \$2192 VSS VSS nfet_03v3 L=0.28U W=0.36U AS=0.0972P AD=0.18P
+ PS=0.9U PD=1.72U
M$3993 \$2195 \$127 VSS VSS nfet_03v3 L=0.28U W=0.36U AS=0.1584P AD=0.1188P
+ PS=1.6U PD=1.02U
M$3994 \$2196 \$2165 \$2195 VSS nfet_03v3 L=0.28U W=0.36U AS=0.1188P AD=0.1278P
+ PS=1.02U PD=1.07U
M$3995 \$2272 \$2197 \$2196 VSS nfet_03v3 L=0.28U W=0.36U AS=0.1278P AD=0.0567P
+ PS=1.07U PD=0.675U
M$3996 VSS \$2166 \$2272 VSS nfet_03v3 L=0.28U W=0.36U AS=0.0567P AD=0.1584P
+ PS=0.675U PD=1.6U
M$3997 VSS \$2196 \$2197 VSS nfet_03v3 L=0.28U W=0.36U AS=0.1584P AD=0.0972P
+ PS=1.6U PD=0.9U
M$3998 \$2198 \$2196 VSS VSS nfet_03v3 L=0.28U W=0.36U AS=0.0972P AD=0.18P
+ PS=0.9U PD=1.72U
M$3999 \$2199 \$130 VSS VSS nfet_03v3 L=0.28U W=0.36U AS=0.1584P AD=0.1188P
+ PS=1.6U PD=1.02U
M$4000 \$2200 \$2165 \$2199 VSS nfet_03v3 L=0.28U W=0.36U AS=0.1188P AD=0.1278P
+ PS=1.02U PD=1.07U
M$4001 \$2266 \$2201 \$2200 VSS nfet_03v3 L=0.28U W=0.36U AS=0.1278P AD=0.0567P
+ PS=1.07U PD=0.675U
M$4002 VSS \$2166 \$2266 VSS nfet_03v3 L=0.28U W=0.36U AS=0.0567P AD=0.1584P
+ PS=0.675U PD=1.6U
M$4003 VSS \$2200 \$2201 VSS nfet_03v3 L=0.28U W=0.36U AS=0.1584P AD=0.0972P
+ PS=1.6U PD=0.9U
M$4004 \$2202 \$2200 VSS VSS nfet_03v3 L=0.28U W=0.36U AS=0.0972P AD=0.18P
+ PS=0.9U PD=1.72U
M$4005 \$2203 \$133 VSS VSS nfet_03v3 L=0.28U W=0.36U AS=0.1584P AD=0.1188P
+ PS=1.6U PD=1.02U
M$4006 \$2204 \$2165 \$2203 VSS nfet_03v3 L=0.28U W=0.36U AS=0.1188P AD=0.1278P
+ PS=1.02U PD=1.07U
M$4007 \$2260 \$2205 \$2204 VSS nfet_03v3 L=0.28U W=0.36U AS=0.1278P AD=0.0567P
+ PS=1.07U PD=0.675U
M$4008 VSS \$2166 \$2260 VSS nfet_03v3 L=0.28U W=0.36U AS=0.0567P AD=0.1584P
+ PS=0.675U PD=1.6U
M$4009 VSS \$2204 \$2205 VSS nfet_03v3 L=0.28U W=0.36U AS=0.1584P AD=0.0972P
+ PS=1.6U PD=0.9U
M$4010 \$2206 \$2204 VSS VSS nfet_03v3 L=0.28U W=0.36U AS=0.0972P AD=0.18P
+ PS=0.9U PD=1.72U
M$4011 \$2207 \$136 VSS VSS nfet_03v3 L=0.28U W=0.36U AS=0.1584P AD=0.1188P
+ PS=1.6U PD=1.02U
M$4012 \$2208 \$2165 \$2207 VSS nfet_03v3 L=0.28U W=0.36U AS=0.1188P AD=0.1278P
+ PS=1.02U PD=1.07U
M$4013 \$2257 \$2209 \$2208 VSS nfet_03v3 L=0.28U W=0.36U AS=0.1278P AD=0.0567P
+ PS=1.07U PD=0.675U
M$4014 VSS \$2166 \$2257 VSS nfet_03v3 L=0.28U W=0.36U AS=0.0567P AD=0.1584P
+ PS=0.675U PD=1.6U
M$4015 VSS \$2208 \$2209 VSS nfet_03v3 L=0.28U W=0.36U AS=0.1584P AD=0.0972P
+ PS=1.6U PD=0.9U
M$4016 \$2210 \$2208 VSS VSS nfet_03v3 L=0.28U W=0.36U AS=0.0972P AD=0.18P
+ PS=0.9U PD=1.72U
M$4017 \$2211 \$139 VSS VSS nfet_03v3 L=0.28U W=0.36U AS=0.1584P AD=0.1188P
+ PS=1.6U PD=1.02U
M$4018 \$2212 \$2165 \$2211 VSS nfet_03v3 L=0.28U W=0.36U AS=0.1188P AD=0.1278P
+ PS=1.02U PD=1.07U
M$4019 \$2251 \$2213 \$2212 VSS nfet_03v3 L=0.28U W=0.36U AS=0.1278P AD=0.0567P
+ PS=1.07U PD=0.675U
M$4020 VSS \$2166 \$2251 VSS nfet_03v3 L=0.28U W=0.36U AS=0.0567P AD=0.1584P
+ PS=0.675U PD=1.6U
M$4021 VSS \$2212 \$2213 VSS nfet_03v3 L=0.28U W=0.36U AS=0.1584P AD=0.0972P
+ PS=1.6U PD=0.9U
M$4022 \$2214 \$2212 VSS VSS nfet_03v3 L=0.28U W=0.36U AS=0.0972P AD=0.18P
+ PS=0.9U PD=1.72U
M$4023 \$2215 \$142 VSS VSS nfet_03v3 L=0.28U W=0.36U AS=0.1584P AD=0.1188P
+ PS=1.6U PD=1.02U
M$4024 \$2216 \$2165 \$2215 VSS nfet_03v3 L=0.28U W=0.36U AS=0.1188P AD=0.1278P
+ PS=1.02U PD=1.07U
M$4025 \$2248 \$2217 \$2216 VSS nfet_03v3 L=0.28U W=0.36U AS=0.1278P AD=0.0567P
+ PS=1.07U PD=0.675U
M$4026 VSS \$2166 \$2248 VSS nfet_03v3 L=0.28U W=0.36U AS=0.0567P AD=0.1584P
+ PS=0.675U PD=1.6U
M$4027 VSS \$2216 \$2217 VSS nfet_03v3 L=0.28U W=0.36U AS=0.1584P AD=0.0972P
+ PS=1.6U PD=0.9U
M$4028 \$2218 \$2216 VSS VSS nfet_03v3 L=0.28U W=0.36U AS=0.0972P AD=0.18P
+ PS=0.9U PD=1.72U
M$4029 \$2219 \$145 VSS VSS nfet_03v3 L=0.28U W=0.36U AS=0.1584P AD=0.1188P
+ PS=1.6U PD=1.02U
M$4030 \$2220 \$2165 \$2219 VSS nfet_03v3 L=0.28U W=0.36U AS=0.1188P AD=0.1278P
+ PS=1.02U PD=1.07U
M$4031 \$2242 \$2221 \$2220 VSS nfet_03v3 L=0.28U W=0.36U AS=0.1278P AD=0.0567P
+ PS=1.07U PD=0.675U
M$4032 VSS \$2166 \$2242 VSS nfet_03v3 L=0.28U W=0.36U AS=0.0567P AD=0.1584P
+ PS=0.675U PD=1.6U
M$4033 VSS \$2220 \$2221 VSS nfet_03v3 L=0.28U W=0.36U AS=0.1584P AD=0.0972P
+ PS=1.6U PD=0.9U
M$4034 \$2222 \$2220 VSS VSS nfet_03v3 L=0.28U W=0.36U AS=0.0972P AD=0.18P
+ PS=0.9U PD=1.72U
M$4035 \$2223 \$148 VSS VSS nfet_03v3 L=0.28U W=0.36U AS=0.1584P AD=0.1188P
+ PS=1.6U PD=1.02U
M$4036 \$2224 \$2165 \$2223 VSS nfet_03v3 L=0.28U W=0.36U AS=0.1188P AD=0.1278P
+ PS=1.02U PD=1.07U
M$4037 \$2238 \$2225 \$2224 VSS nfet_03v3 L=0.28U W=0.36U AS=0.1278P AD=0.0567P
+ PS=1.07U PD=0.675U
M$4038 VSS \$2166 \$2238 VSS nfet_03v3 L=0.28U W=0.36U AS=0.0567P AD=0.1584P
+ PS=0.675U PD=1.6U
M$4039 VSS \$2224 \$2225 VSS nfet_03v3 L=0.28U W=0.36U AS=0.1584P AD=0.0972P
+ PS=1.6U PD=0.9U
M$4040 \$2226 \$2224 VSS VSS nfet_03v3 L=0.28U W=0.36U AS=0.0972P AD=0.18P
+ PS=0.9U PD=1.72U
M$4041 \$2227 \$151 VSS VSS nfet_03v3 L=0.28U W=0.36U AS=0.1584P AD=0.1188P
+ PS=1.6U PD=1.02U
M$4042 \$2228 \$2165 \$2227 VSS nfet_03v3 L=0.28U W=0.36U AS=0.1188P AD=0.1278P
+ PS=1.02U PD=1.07U
M$4043 \$2233 \$2229 \$2228 VSS nfet_03v3 L=0.28U W=0.36U AS=0.1278P AD=0.0567P
+ PS=1.07U PD=0.675U
M$4044 VSS \$2166 \$2233 VSS nfet_03v3 L=0.28U W=0.36U AS=0.0567P AD=0.1584P
+ PS=0.675U PD=1.6U
M$4045 VSS \$2228 \$2229 VSS nfet_03v3 L=0.28U W=0.36U AS=0.1584P AD=0.0972P
+ PS=1.6U PD=0.9U
M$4046 \$2230 \$2228 VSS VSS nfet_03v3 L=0.28U W=0.36U AS=0.0972P AD=0.18P
+ PS=0.9U PD=1.72U
M$4047 \$2484 RB8 VSS VSS nfet_03v3 L=0.28U W=0.36U AS=0.1656P AD=0.1944P
+ PS=1.64U PD=1.8U
M$4048 \$2281 RA9 VSS VSS nfet_03v3 L=0.28U W=0.36U AS=0.1656P AD=0.1944P
+ PS=1.64U PD=1.8U
M$4049 \$2483 RB8 \$51 VSS nfet_03v3 L=0.28U W=0.36U AS=0.1584P AD=0.1152P
+ PS=1.6U PD=1U
M$4050 \$52 RA8 \$2483 VSS nfet_03v3 L=0.28U W=0.36U AS=0.1152P AD=0.1584P
+ PS=1U PD=1.6U
M$4051 \$2170 RA9 \$51 VSS nfet_03v3 L=0.28U W=0.36U AS=0.1584P AD=0.1152P
+ PS=1.6U PD=1U
M$4052 \$52 RB9 \$2170 VSS nfet_03v3 L=0.28U W=0.36U AS=0.1152P AD=0.1584P
+ PS=1U PD=1.6U
M$4053 VSS RB9 \$2282 VSS nfet_03v3 L=0.28U W=0.36U AS=0.1854P AD=0.1584P
+ PS=1.75U PD=1.6U
M$4054 VSS RA8 \$2485 VSS nfet_03v3 L=0.28U W=0.36U AS=0.1854P AD=0.1584P
+ PS=1.75U PD=1.6U
M$4055 \$2283 RA9 VSS VSS nfet_03v3 L=0.28U W=0.36U AS=0.1656P AD=0.1944P
+ PS=1.64U PD=1.8U
M$4056 \$2490 RB8 VSS VSS nfet_03v3 L=0.28U W=0.36U AS=0.1656P AD=0.1944P
+ PS=1.64U PD=1.8U
M$4057 \$2489 RB8 \$53 VSS nfet_03v3 L=0.28U W=0.36U AS=0.1584P AD=0.1152P
+ PS=1.6U PD=1U
M$4058 \$54 RA8 \$2489 VSS nfet_03v3 L=0.28U W=0.36U AS=0.1152P AD=0.1584P
+ PS=1U PD=1.6U
M$4059 \$2174 RA9 \$53 VSS nfet_03v3 L=0.28U W=0.36U AS=0.1584P AD=0.1152P
+ PS=1.6U PD=1U
M$4060 \$54 RB9 \$2174 VSS nfet_03v3 L=0.28U W=0.36U AS=0.1152P AD=0.1584P
+ PS=1U PD=1.6U
M$4061 VSS RB9 \$2284 VSS nfet_03v3 L=0.28U W=0.36U AS=0.1854P AD=0.1584P
+ PS=1.75U PD=1.6U
M$4062 VSS RA8 \$2491 VSS nfet_03v3 L=0.28U W=0.36U AS=0.1854P AD=0.1584P
+ PS=1.75U PD=1.6U
M$4063 \$2285 RA9 VSS VSS nfet_03v3 L=0.28U W=0.36U AS=0.1656P AD=0.1944P
+ PS=1.64U PD=1.8U
M$4064 \$2496 RB8 VSS VSS nfet_03v3 L=0.28U W=0.36U AS=0.1656P AD=0.1944P
+ PS=1.64U PD=1.8U
M$4065 \$2495 RB8 \$55 VSS nfet_03v3 L=0.28U W=0.36U AS=0.1584P AD=0.1152P
+ PS=1.6U PD=1U
M$4066 \$56 RA8 \$2495 VSS nfet_03v3 L=0.28U W=0.36U AS=0.1152P AD=0.1584P
+ PS=1U PD=1.6U
M$4067 \$2178 RA9 \$55 VSS nfet_03v3 L=0.28U W=0.36U AS=0.1584P AD=0.1152P
+ PS=1.6U PD=1U
M$4068 \$56 RB9 \$2178 VSS nfet_03v3 L=0.28U W=0.36U AS=0.1152P AD=0.1584P
+ PS=1U PD=1.6U
M$4069 VSS RB9 \$2286 VSS nfet_03v3 L=0.28U W=0.36U AS=0.1854P AD=0.1584P
+ PS=1.75U PD=1.6U
M$4070 VSS RA8 \$2497 VSS nfet_03v3 L=0.28U W=0.36U AS=0.1854P AD=0.1584P
+ PS=1.75U PD=1.6U
M$4071 \$2287 RA9 VSS VSS nfet_03v3 L=0.28U W=0.36U AS=0.1656P AD=0.1944P
+ PS=1.64U PD=1.8U
M$4072 \$2502 RB8 VSS VSS nfet_03v3 L=0.28U W=0.36U AS=0.1656P AD=0.1944P
+ PS=1.64U PD=1.8U
M$4073 \$2501 RB8 \$57 VSS nfet_03v3 L=0.28U W=0.36U AS=0.1584P AD=0.1152P
+ PS=1.6U PD=1U
M$4074 \$58 RA8 \$2501 VSS nfet_03v3 L=0.28U W=0.36U AS=0.1152P AD=0.1584P
+ PS=1U PD=1.6U
M$4075 \$2182 RA9 \$57 VSS nfet_03v3 L=0.28U W=0.36U AS=0.1584P AD=0.1152P
+ PS=1.6U PD=1U
M$4076 \$58 RB9 \$2182 VSS nfet_03v3 L=0.28U W=0.36U AS=0.1152P AD=0.1584P
+ PS=1U PD=1.6U
M$4077 VSS RB9 \$2288 VSS nfet_03v3 L=0.28U W=0.36U AS=0.1854P AD=0.1584P
+ PS=1.75U PD=1.6U
M$4078 VSS RA8 \$2503 VSS nfet_03v3 L=0.28U W=0.36U AS=0.1854P AD=0.1584P
+ PS=1.75U PD=1.6U
M$4079 \$2289 RA9 VSS VSS nfet_03v3 L=0.28U W=0.36U AS=0.1656P AD=0.1944P
+ PS=1.64U PD=1.8U
M$4080 \$2508 RB8 VSS VSS nfet_03v3 L=0.28U W=0.36U AS=0.1656P AD=0.1944P
+ PS=1.64U PD=1.8U
M$4081 \$2507 RB8 \$59 VSS nfet_03v3 L=0.28U W=0.36U AS=0.1584P AD=0.1152P
+ PS=1.6U PD=1U
M$4082 \$60 RA8 \$2507 VSS nfet_03v3 L=0.28U W=0.36U AS=0.1152P AD=0.1584P
+ PS=1U PD=1.6U
M$4083 \$2186 RA9 \$59 VSS nfet_03v3 L=0.28U W=0.36U AS=0.1584P AD=0.1152P
+ PS=1.6U PD=1U
M$4084 \$60 RB9 \$2186 VSS nfet_03v3 L=0.28U W=0.36U AS=0.1152P AD=0.1584P
+ PS=1U PD=1.6U
M$4085 VSS RA8 \$2509 VSS nfet_03v3 L=0.28U W=0.36U AS=0.1854P AD=0.1584P
+ PS=1.75U PD=1.6U
M$4086 VSS RB9 \$2290 VSS nfet_03v3 L=0.28U W=0.36U AS=0.1854P AD=0.1584P
+ PS=1.75U PD=1.6U
M$4087 \$2514 RB8 VSS VSS nfet_03v3 L=0.28U W=0.36U AS=0.1656P AD=0.1944P
+ PS=1.64U PD=1.8U
M$4088 \$2291 RA9 VSS VSS nfet_03v3 L=0.28U W=0.36U AS=0.1656P AD=0.1944P
+ PS=1.64U PD=1.8U
M$4089 \$2513 RB8 \$61 VSS nfet_03v3 L=0.28U W=0.36U AS=0.1584P AD=0.1152P
+ PS=1.6U PD=1U
M$4090 \$62 RA8 \$2513 VSS nfet_03v3 L=0.28U W=0.36U AS=0.1152P AD=0.1584P
+ PS=1U PD=1.6U
M$4091 \$2190 RA9 \$61 VSS nfet_03v3 L=0.28U W=0.36U AS=0.1584P AD=0.1152P
+ PS=1.6U PD=1U
M$4092 \$62 RB9 \$2190 VSS nfet_03v3 L=0.28U W=0.36U AS=0.1152P AD=0.1584P
+ PS=1U PD=1.6U
M$4093 VSS RB9 \$2292 VSS nfet_03v3 L=0.28U W=0.36U AS=0.1854P AD=0.1584P
+ PS=1.75U PD=1.6U
M$4094 VSS RA8 \$2515 VSS nfet_03v3 L=0.28U W=0.36U AS=0.1854P AD=0.1584P
+ PS=1.75U PD=1.6U
M$4095 \$2293 RA9 VSS VSS nfet_03v3 L=0.28U W=0.36U AS=0.1656P AD=0.1944P
+ PS=1.64U PD=1.8U
M$4096 \$2520 RB8 VSS VSS nfet_03v3 L=0.28U W=0.36U AS=0.1656P AD=0.1944P
+ PS=1.64U PD=1.8U
M$4097 \$2519 RB8 \$63 VSS nfet_03v3 L=0.28U W=0.36U AS=0.1584P AD=0.1152P
+ PS=1.6U PD=1U
M$4098 \$64 RA8 \$2519 VSS nfet_03v3 L=0.28U W=0.36U AS=0.1152P AD=0.1584P
+ PS=1U PD=1.6U
M$4099 \$2194 RA9 \$63 VSS nfet_03v3 L=0.28U W=0.36U AS=0.1584P AD=0.1152P
+ PS=1.6U PD=1U
M$4100 \$64 RB9 \$2194 VSS nfet_03v3 L=0.28U W=0.36U AS=0.1152P AD=0.1584P
+ PS=1U PD=1.6U
M$4101 VSS RA8 \$2521 VSS nfet_03v3 L=0.28U W=0.36U AS=0.1854P AD=0.1584P
+ PS=1.75U PD=1.6U
M$4102 VSS RB9 \$2294 VSS nfet_03v3 L=0.28U W=0.36U AS=0.1854P AD=0.1584P
+ PS=1.75U PD=1.6U
M$4103 \$2295 RA9 VSS VSS nfet_03v3 L=0.28U W=0.36U AS=0.1656P AD=0.1944P
+ PS=1.64U PD=1.8U
M$4104 \$2526 RB8 VSS VSS nfet_03v3 L=0.28U W=0.36U AS=0.1656P AD=0.1944P
+ PS=1.64U PD=1.8U
M$4105 \$2525 RB8 \$65 VSS nfet_03v3 L=0.28U W=0.36U AS=0.1584P AD=0.1152P
+ PS=1.6U PD=1U
M$4106 \$66 RA8 \$2525 VSS nfet_03v3 L=0.28U W=0.36U AS=0.1152P AD=0.1584P
+ PS=1U PD=1.6U
M$4107 \$2198 RA9 \$65 VSS nfet_03v3 L=0.28U W=0.36U AS=0.1584P AD=0.1152P
+ PS=1.6U PD=1U
M$4108 \$66 RB9 \$2198 VSS nfet_03v3 L=0.28U W=0.36U AS=0.1152P AD=0.1584P
+ PS=1U PD=1.6U
M$4109 VSS RB9 \$2296 VSS nfet_03v3 L=0.28U W=0.36U AS=0.1854P AD=0.1584P
+ PS=1.75U PD=1.6U
M$4110 VSS RA8 \$2527 VSS nfet_03v3 L=0.28U W=0.36U AS=0.1854P AD=0.1584P
+ PS=1.75U PD=1.6U
M$4111 \$2532 RB8 VSS VSS nfet_03v3 L=0.28U W=0.36U AS=0.1656P AD=0.1944P
+ PS=1.64U PD=1.8U
M$4112 \$2297 RA9 VSS VSS nfet_03v3 L=0.28U W=0.36U AS=0.1656P AD=0.1944P
+ PS=1.64U PD=1.8U
M$4113 \$2531 RB8 \$67 VSS nfet_03v3 L=0.28U W=0.36U AS=0.1584P AD=0.1152P
+ PS=1.6U PD=1U
M$4114 \$68 RA8 \$2531 VSS nfet_03v3 L=0.28U W=0.36U AS=0.1152P AD=0.1584P
+ PS=1U PD=1.6U
M$4115 \$2202 RA9 \$67 VSS nfet_03v3 L=0.28U W=0.36U AS=0.1584P AD=0.1152P
+ PS=1.6U PD=1U
M$4116 \$68 RB9 \$2202 VSS nfet_03v3 L=0.28U W=0.36U AS=0.1152P AD=0.1584P
+ PS=1U PD=1.6U
M$4117 VSS RA8 \$2533 VSS nfet_03v3 L=0.28U W=0.36U AS=0.1854P AD=0.1584P
+ PS=1.75U PD=1.6U
M$4118 VSS RB9 \$2298 VSS nfet_03v3 L=0.28U W=0.36U AS=0.1854P AD=0.1584P
+ PS=1.75U PD=1.6U
M$4119 \$2538 RB8 VSS VSS nfet_03v3 L=0.28U W=0.36U AS=0.1656P AD=0.1944P
+ PS=1.64U PD=1.8U
M$4120 \$2299 RA9 VSS VSS nfet_03v3 L=0.28U W=0.36U AS=0.1656P AD=0.1944P
+ PS=1.64U PD=1.8U
M$4121 \$2537 RB8 \$69 VSS nfet_03v3 L=0.28U W=0.36U AS=0.1584P AD=0.1152P
+ PS=1.6U PD=1U
M$4122 \$70 RA8 \$2537 VSS nfet_03v3 L=0.28U W=0.36U AS=0.1152P AD=0.1584P
+ PS=1U PD=1.6U
M$4123 \$2206 RA9 \$69 VSS nfet_03v3 L=0.28U W=0.36U AS=0.1584P AD=0.1152P
+ PS=1.6U PD=1U
M$4124 \$70 RB9 \$2206 VSS nfet_03v3 L=0.28U W=0.36U AS=0.1152P AD=0.1584P
+ PS=1U PD=1.6U
M$4125 VSS RB9 \$2300 VSS nfet_03v3 L=0.28U W=0.36U AS=0.1854P AD=0.1584P
+ PS=1.75U PD=1.6U
M$4126 VSS RA8 \$2539 VSS nfet_03v3 L=0.28U W=0.36U AS=0.1854P AD=0.1584P
+ PS=1.75U PD=1.6U
M$4127 \$2544 RB8 VSS VSS nfet_03v3 L=0.28U W=0.36U AS=0.1656P AD=0.1944P
+ PS=1.64U PD=1.8U
M$4128 \$2301 RA9 VSS VSS nfet_03v3 L=0.28U W=0.36U AS=0.1656P AD=0.1944P
+ PS=1.64U PD=1.8U
M$4129 \$2210 RA9 \$71 VSS nfet_03v3 L=0.28U W=0.36U AS=0.1584P AD=0.1152P
+ PS=1.6U PD=1U
M$4130 \$72 RB9 \$2210 VSS nfet_03v3 L=0.28U W=0.36U AS=0.1152P AD=0.1584P
+ PS=1U PD=1.6U
M$4131 \$2543 RB8 \$71 VSS nfet_03v3 L=0.28U W=0.36U AS=0.1584P AD=0.1152P
+ PS=1.6U PD=1U
M$4132 \$72 RA8 \$2543 VSS nfet_03v3 L=0.28U W=0.36U AS=0.1152P AD=0.1584P
+ PS=1U PD=1.6U
M$4133 VSS RB9 \$2302 VSS nfet_03v3 L=0.28U W=0.36U AS=0.1854P AD=0.1584P
+ PS=1.75U PD=1.6U
M$4134 VSS RA8 \$2545 VSS nfet_03v3 L=0.28U W=0.36U AS=0.1854P AD=0.1584P
+ PS=1.75U PD=1.6U
M$4135 \$2550 RB8 VSS VSS nfet_03v3 L=0.28U W=0.36U AS=0.1656P AD=0.1944P
+ PS=1.64U PD=1.8U
M$4136 \$2303 RA9 VSS VSS nfet_03v3 L=0.28U W=0.36U AS=0.1656P AD=0.1944P
+ PS=1.64U PD=1.8U
M$4137 \$2214 RA9 \$73 VSS nfet_03v3 L=0.28U W=0.36U AS=0.1584P AD=0.1152P
+ PS=1.6U PD=1U
M$4138 \$74 RB9 \$2214 VSS nfet_03v3 L=0.28U W=0.36U AS=0.1152P AD=0.1584P
+ PS=1U PD=1.6U
M$4139 \$2549 RB8 \$73 VSS nfet_03v3 L=0.28U W=0.36U AS=0.1584P AD=0.1152P
+ PS=1.6U PD=1U
M$4140 \$74 RA8 \$2549 VSS nfet_03v3 L=0.28U W=0.36U AS=0.1152P AD=0.1584P
+ PS=1U PD=1.6U
M$4141 VSS RA8 \$2551 VSS nfet_03v3 L=0.28U W=0.36U AS=0.1854P AD=0.1584P
+ PS=1.75U PD=1.6U
M$4142 VSS RB9 \$2304 VSS nfet_03v3 L=0.28U W=0.36U AS=0.1854P AD=0.1584P
+ PS=1.75U PD=1.6U
M$4143 \$2305 RA9 VSS VSS nfet_03v3 L=0.28U W=0.36U AS=0.1656P AD=0.1944P
+ PS=1.64U PD=1.8U
M$4144 \$2556 RB8 VSS VSS nfet_03v3 L=0.28U W=0.36U AS=0.1656P AD=0.1944P
+ PS=1.64U PD=1.8U
M$4145 \$2218 RA9 \$75 VSS nfet_03v3 L=0.28U W=0.36U AS=0.1584P AD=0.1152P
+ PS=1.6U PD=1U
M$4146 \$76 RB9 \$2218 VSS nfet_03v3 L=0.28U W=0.36U AS=0.1152P AD=0.1584P
+ PS=1U PD=1.6U
M$4147 \$2555 RB8 \$75 VSS nfet_03v3 L=0.28U W=0.36U AS=0.1584P AD=0.1152P
+ PS=1.6U PD=1U
M$4148 \$76 RA8 \$2555 VSS nfet_03v3 L=0.28U W=0.36U AS=0.1152P AD=0.1584P
+ PS=1U PD=1.6U
M$4149 VSS RA8 \$2557 VSS nfet_03v3 L=0.28U W=0.36U AS=0.1854P AD=0.1584P
+ PS=1.75U PD=1.6U
M$4150 VSS RB9 \$2306 VSS nfet_03v3 L=0.28U W=0.36U AS=0.1854P AD=0.1584P
+ PS=1.75U PD=1.6U
M$4151 \$2307 RA9 VSS VSS nfet_03v3 L=0.28U W=0.36U AS=0.1656P AD=0.1944P
+ PS=1.64U PD=1.8U
M$4152 \$2562 RB8 VSS VSS nfet_03v3 L=0.28U W=0.36U AS=0.1656P AD=0.1944P
+ PS=1.64U PD=1.8U
M$4153 \$2561 RB8 \$77 VSS nfet_03v3 L=0.28U W=0.36U AS=0.1584P AD=0.1152P
+ PS=1.6U PD=1U
M$4154 \$78 RA8 \$2561 VSS nfet_03v3 L=0.28U W=0.36U AS=0.1152P AD=0.1584P
+ PS=1U PD=1.6U
M$4155 \$2222 RA9 \$77 VSS nfet_03v3 L=0.28U W=0.36U AS=0.1584P AD=0.1152P
+ PS=1.6U PD=1U
M$4156 \$78 RB9 \$2222 VSS nfet_03v3 L=0.28U W=0.36U AS=0.1152P AD=0.1584P
+ PS=1U PD=1.6U
M$4157 VSS RA8 \$2563 VSS nfet_03v3 L=0.28U W=0.36U AS=0.1854P AD=0.1584P
+ PS=1.75U PD=1.6U
M$4158 VSS RB9 \$2308 VSS nfet_03v3 L=0.28U W=0.36U AS=0.1854P AD=0.1584P
+ PS=1.75U PD=1.6U
M$4159 \$2568 RB8 VSS VSS nfet_03v3 L=0.28U W=0.36U AS=0.1656P AD=0.1944P
+ PS=1.64U PD=1.8U
M$4160 \$2309 RA9 VSS VSS nfet_03v3 L=0.28U W=0.36U AS=0.1656P AD=0.1944P
+ PS=1.64U PD=1.8U
M$4161 \$2226 RA9 \$79 VSS nfet_03v3 L=0.28U W=0.36U AS=0.1584P AD=0.1152P
+ PS=1.6U PD=1U
M$4162 \$80 RB9 \$2226 VSS nfet_03v3 L=0.28U W=0.36U AS=0.1152P AD=0.1584P
+ PS=1U PD=1.6U
M$4163 \$2567 RB8 \$79 VSS nfet_03v3 L=0.28U W=0.36U AS=0.1584P AD=0.1152P
+ PS=1.6U PD=1U
M$4164 \$80 RA8 \$2567 VSS nfet_03v3 L=0.28U W=0.36U AS=0.1152P AD=0.1584P
+ PS=1U PD=1.6U
M$4165 VSS RA8 \$2569 VSS nfet_03v3 L=0.28U W=0.36U AS=0.1854P AD=0.1584P
+ PS=1.75U PD=1.6U
M$4166 VSS RB9 \$2310 VSS nfet_03v3 L=0.28U W=0.36U AS=0.1854P AD=0.1584P
+ PS=1.75U PD=1.6U
M$4167 \$2574 RB8 VSS VSS nfet_03v3 L=0.28U W=0.36U AS=0.1656P AD=0.1944P
+ PS=1.64U PD=1.8U
M$4168 \$2311 RA9 VSS VSS nfet_03v3 L=0.28U W=0.36U AS=0.1656P AD=0.1944P
+ PS=1.64U PD=1.8U
M$4169 \$2573 RB8 \$81 VSS nfet_03v3 L=0.28U W=0.36U AS=0.1584P AD=0.1152P
+ PS=1.6U PD=1U
M$4170 \$82 RA8 \$2573 VSS nfet_03v3 L=0.28U W=0.36U AS=0.1152P AD=0.1584P
+ PS=1U PD=1.6U
M$4171 \$2230 RA9 \$81 VSS nfet_03v3 L=0.28U W=0.36U AS=0.1584P AD=0.1152P
+ PS=1.6U PD=1U
M$4172 \$82 RB9 \$2230 VSS nfet_03v3 L=0.28U W=0.36U AS=0.1152P AD=0.1584P
+ PS=1U PD=1.6U
M$4173 VSS RA8 \$2575 VSS nfet_03v3 L=0.28U W=0.36U AS=0.1854P AD=0.1584P
+ PS=1.75U PD=1.6U
M$4174 VSS RB9 \$2312 VSS nfet_03v3 L=0.28U W=0.36U AS=0.1854P AD=0.1584P
+ PS=1.75U PD=1.6U
M$4175 \$2679 WE8 VSS VSS nfet_03v3 L=0.28U W=0.72U AS=0.3168P AD=0.1872P
+ PS=2.32U PD=1.24U
M$4176 \$2474 CLK \$2679 VSS nfet_03v3 L=0.28U W=0.72U AS=0.1872P AD=0.3168P
+ PS=1.24U PD=2.32U
M$4177 \$2476 \$2474 VSS VSS nfet_03v3 L=0.28U W=0.635U AS=0.2794P AD=0.1651P
+ PS=2.15U PD=1.155U
M$4178 \$2476 \$2474 VSS VSS nfet_03v3 L=0.28U W=0.635U AS=0.1693P AD=0.1651P
+ PS=1.19U PD=1.155U
M$4179 \$2477 \$2476 VSS VSS nfet_03v3 L=0.28U W=0.67U AS=0.1693P AD=0.1943P
+ PS=1.19U PD=1.25U
M$4180 VSS \$2476 \$2477 VSS nfet_03v3 L=0.28U W=0.67U AS=0.1943P AD=0.2948P
+ PS=1.25U PD=2.22U
M$4181 \$2480 \$106 VSS VSS nfet_03v3 L=0.28U W=0.36U AS=0.1584P AD=0.1188P
+ PS=1.6U PD=1.02U
M$4182 \$2481 \$2476 \$2480 VSS nfet_03v3 L=0.28U W=0.36U AS=0.1188P AD=0.1278P
+ PS=1.02U PD=1.07U
M$4183 \$2684 \$2482 \$2481 VSS nfet_03v3 L=0.28U W=0.36U AS=0.1278P AD=0.0567P
+ PS=1.07U PD=0.675U
M$4184 VSS \$2477 \$2684 VSS nfet_03v3 L=0.28U W=0.36U AS=0.0567P AD=0.1584P
+ PS=0.675U PD=1.6U
M$4185 VSS \$2481 \$2482 VSS nfet_03v3 L=0.28U W=0.36U AS=0.1584P AD=0.0972P
+ PS=1.6U PD=0.9U
M$4186 \$2483 \$2481 VSS VSS nfet_03v3 L=0.28U W=0.36U AS=0.0972P AD=0.18P
+ PS=0.9U PD=1.72U
M$4187 \$2486 \$109 VSS VSS nfet_03v3 L=0.28U W=0.36U AS=0.1584P AD=0.1188P
+ PS=1.6U PD=1.02U
M$4188 \$2487 \$2476 \$2486 VSS nfet_03v3 L=0.28U W=0.36U AS=0.1188P AD=0.1278P
+ PS=1.02U PD=1.07U
M$4189 \$2693 \$2488 \$2487 VSS nfet_03v3 L=0.28U W=0.36U AS=0.1278P AD=0.0567P
+ PS=1.07U PD=0.675U
M$4190 VSS \$2477 \$2693 VSS nfet_03v3 L=0.28U W=0.36U AS=0.0567P AD=0.1584P
+ PS=0.675U PD=1.6U
M$4191 VSS \$2487 \$2488 VSS nfet_03v3 L=0.28U W=0.36U AS=0.1584P AD=0.0972P
+ PS=1.6U PD=0.9U
M$4192 \$2489 \$2487 VSS VSS nfet_03v3 L=0.28U W=0.36U AS=0.0972P AD=0.18P
+ PS=0.9U PD=1.72U
M$4193 \$2492 \$112 VSS VSS nfet_03v3 L=0.28U W=0.36U AS=0.1584P AD=0.1188P
+ PS=1.6U PD=1.02U
M$4194 \$2493 \$2476 \$2492 VSS nfet_03v3 L=0.28U W=0.36U AS=0.1188P AD=0.1278P
+ PS=1.02U PD=1.07U
M$4195 \$2700 \$2494 \$2493 VSS nfet_03v3 L=0.28U W=0.36U AS=0.1278P AD=0.0567P
+ PS=1.07U PD=0.675U
M$4196 VSS \$2477 \$2700 VSS nfet_03v3 L=0.28U W=0.36U AS=0.0567P AD=0.1584P
+ PS=0.675U PD=1.6U
M$4197 VSS \$2493 \$2494 VSS nfet_03v3 L=0.28U W=0.36U AS=0.1584P AD=0.0972P
+ PS=1.6U PD=0.9U
M$4198 \$2495 \$2493 VSS VSS nfet_03v3 L=0.28U W=0.36U AS=0.0972P AD=0.18P
+ PS=0.9U PD=1.72U
M$4199 \$2498 \$115 VSS VSS nfet_03v3 L=0.28U W=0.36U AS=0.1584P AD=0.1188P
+ PS=1.6U PD=1.02U
M$4200 \$2499 \$2476 \$2498 VSS nfet_03v3 L=0.28U W=0.36U AS=0.1188P AD=0.1278P
+ PS=1.02U PD=1.07U
M$4201 \$2708 \$2500 \$2499 VSS nfet_03v3 L=0.28U W=0.36U AS=0.1278P AD=0.0567P
+ PS=1.07U PD=0.675U
M$4202 VSS \$2477 \$2708 VSS nfet_03v3 L=0.28U W=0.36U AS=0.0567P AD=0.1584P
+ PS=0.675U PD=1.6U
M$4203 VSS \$2499 \$2500 VSS nfet_03v3 L=0.28U W=0.36U AS=0.1584P AD=0.0972P
+ PS=1.6U PD=0.9U
M$4204 \$2501 \$2499 VSS VSS nfet_03v3 L=0.28U W=0.36U AS=0.0972P AD=0.18P
+ PS=0.9U PD=1.72U
M$4205 \$2504 \$118 VSS VSS nfet_03v3 L=0.28U W=0.36U AS=0.1584P AD=0.1188P
+ PS=1.6U PD=1.02U
M$4206 \$2505 \$2476 \$2504 VSS nfet_03v3 L=0.28U W=0.36U AS=0.1188P AD=0.1278P
+ PS=1.02U PD=1.07U
M$4207 \$2717 \$2506 \$2505 VSS nfet_03v3 L=0.28U W=0.36U AS=0.1278P AD=0.0567P
+ PS=1.07U PD=0.675U
M$4208 VSS \$2477 \$2717 VSS nfet_03v3 L=0.28U W=0.36U AS=0.0567P AD=0.1584P
+ PS=0.675U PD=1.6U
M$4209 VSS \$2505 \$2506 VSS nfet_03v3 L=0.28U W=0.36U AS=0.1584P AD=0.0972P
+ PS=1.6U PD=0.9U
M$4210 \$2507 \$2505 VSS VSS nfet_03v3 L=0.28U W=0.36U AS=0.0972P AD=0.18P
+ PS=0.9U PD=1.72U
M$4211 \$2510 \$121 VSS VSS nfet_03v3 L=0.28U W=0.36U AS=0.1584P AD=0.1188P
+ PS=1.6U PD=1.02U
M$4212 \$2511 \$2476 \$2510 VSS nfet_03v3 L=0.28U W=0.36U AS=0.1188P AD=0.1278P
+ PS=1.02U PD=1.07U
M$4213 \$2724 \$2512 \$2511 VSS nfet_03v3 L=0.28U W=0.36U AS=0.1278P AD=0.0567P
+ PS=1.07U PD=0.675U
M$4214 VSS \$2477 \$2724 VSS nfet_03v3 L=0.28U W=0.36U AS=0.0567P AD=0.1584P
+ PS=0.675U PD=1.6U
M$4215 VSS \$2511 \$2512 VSS nfet_03v3 L=0.28U W=0.36U AS=0.1584P AD=0.0972P
+ PS=1.6U PD=0.9U
M$4216 \$2513 \$2511 VSS VSS nfet_03v3 L=0.28U W=0.36U AS=0.0972P AD=0.18P
+ PS=0.9U PD=1.72U
M$4217 \$2516 \$124 VSS VSS nfet_03v3 L=0.28U W=0.36U AS=0.1584P AD=0.1188P
+ PS=1.6U PD=1.02U
M$4218 \$2517 \$2476 \$2516 VSS nfet_03v3 L=0.28U W=0.36U AS=0.1188P AD=0.1278P
+ PS=1.02U PD=1.07U
M$4219 \$2733 \$2518 \$2517 VSS nfet_03v3 L=0.28U W=0.36U AS=0.1278P AD=0.0567P
+ PS=1.07U PD=0.675U
M$4220 VSS \$2477 \$2733 VSS nfet_03v3 L=0.28U W=0.36U AS=0.0567P AD=0.1584P
+ PS=0.675U PD=1.6U
M$4221 VSS \$2517 \$2518 VSS nfet_03v3 L=0.28U W=0.36U AS=0.1584P AD=0.0972P
+ PS=1.6U PD=0.9U
M$4222 \$2519 \$2517 VSS VSS nfet_03v3 L=0.28U W=0.36U AS=0.0972P AD=0.18P
+ PS=0.9U PD=1.72U
M$4223 \$2522 \$127 VSS VSS nfet_03v3 L=0.28U W=0.36U AS=0.1584P AD=0.1188P
+ PS=1.6U PD=1.02U
M$4224 \$2523 \$2476 \$2522 VSS nfet_03v3 L=0.28U W=0.36U AS=0.1188P AD=0.1278P
+ PS=1.02U PD=1.07U
M$4225 \$2741 \$2524 \$2523 VSS nfet_03v3 L=0.28U W=0.36U AS=0.1278P AD=0.0567P
+ PS=1.07U PD=0.675U
M$4226 VSS \$2477 \$2741 VSS nfet_03v3 L=0.28U W=0.36U AS=0.0567P AD=0.1584P
+ PS=0.675U PD=1.6U
M$4227 VSS \$2523 \$2524 VSS nfet_03v3 L=0.28U W=0.36U AS=0.1584P AD=0.0972P
+ PS=1.6U PD=0.9U
M$4228 \$2525 \$2523 VSS VSS nfet_03v3 L=0.28U W=0.36U AS=0.0972P AD=0.18P
+ PS=0.9U PD=1.72U
M$4229 \$2528 \$130 VSS VSS nfet_03v3 L=0.28U W=0.36U AS=0.1584P AD=0.1188P
+ PS=1.6U PD=1.02U
M$4230 \$2529 \$2476 \$2528 VSS nfet_03v3 L=0.28U W=0.36U AS=0.1188P AD=0.1278P
+ PS=1.02U PD=1.07U
M$4231 \$2748 \$2530 \$2529 VSS nfet_03v3 L=0.28U W=0.36U AS=0.1278P AD=0.0567P
+ PS=1.07U PD=0.675U
M$4232 VSS \$2477 \$2748 VSS nfet_03v3 L=0.28U W=0.36U AS=0.0567P AD=0.1584P
+ PS=0.675U PD=1.6U
M$4233 VSS \$2529 \$2530 VSS nfet_03v3 L=0.28U W=0.36U AS=0.1584P AD=0.0972P
+ PS=1.6U PD=0.9U
M$4234 \$2531 \$2529 VSS VSS nfet_03v3 L=0.28U W=0.36U AS=0.0972P AD=0.18P
+ PS=0.9U PD=1.72U
M$4235 \$2534 \$133 VSS VSS nfet_03v3 L=0.28U W=0.36U AS=0.1584P AD=0.1188P
+ PS=1.6U PD=1.02U
M$4236 \$2535 \$2476 \$2534 VSS nfet_03v3 L=0.28U W=0.36U AS=0.1188P AD=0.1278P
+ PS=1.02U PD=1.07U
M$4237 \$2756 \$2536 \$2535 VSS nfet_03v3 L=0.28U W=0.36U AS=0.1278P AD=0.0567P
+ PS=1.07U PD=0.675U
M$4238 VSS \$2477 \$2756 VSS nfet_03v3 L=0.28U W=0.36U AS=0.0567P AD=0.1584P
+ PS=0.675U PD=1.6U
M$4239 VSS \$2535 \$2536 VSS nfet_03v3 L=0.28U W=0.36U AS=0.1584P AD=0.0972P
+ PS=1.6U PD=0.9U
M$4240 \$2537 \$2535 VSS VSS nfet_03v3 L=0.28U W=0.36U AS=0.0972P AD=0.18P
+ PS=0.9U PD=1.72U
M$4241 \$2540 \$136 VSS VSS nfet_03v3 L=0.28U W=0.36U AS=0.1584P AD=0.1188P
+ PS=1.6U PD=1.02U
M$4242 \$2541 \$2476 \$2540 VSS nfet_03v3 L=0.28U W=0.36U AS=0.1188P AD=0.1278P
+ PS=1.02U PD=1.07U
M$4243 \$2765 \$2542 \$2541 VSS nfet_03v3 L=0.28U W=0.36U AS=0.1278P AD=0.0567P
+ PS=1.07U PD=0.675U
M$4244 VSS \$2477 \$2765 VSS nfet_03v3 L=0.28U W=0.36U AS=0.0567P AD=0.1584P
+ PS=0.675U PD=1.6U
M$4245 VSS \$2541 \$2542 VSS nfet_03v3 L=0.28U W=0.36U AS=0.1584P AD=0.0972P
+ PS=1.6U PD=0.9U
M$4246 \$2543 \$2541 VSS VSS nfet_03v3 L=0.28U W=0.36U AS=0.0972P AD=0.18P
+ PS=0.9U PD=1.72U
M$4247 \$2546 \$139 VSS VSS nfet_03v3 L=0.28U W=0.36U AS=0.1584P AD=0.1188P
+ PS=1.6U PD=1.02U
M$4248 \$2547 \$2476 \$2546 VSS nfet_03v3 L=0.28U W=0.36U AS=0.1188P AD=0.1278P
+ PS=1.02U PD=1.07U
M$4249 \$2772 \$2548 \$2547 VSS nfet_03v3 L=0.28U W=0.36U AS=0.1278P AD=0.0567P
+ PS=1.07U PD=0.675U
M$4250 VSS \$2477 \$2772 VSS nfet_03v3 L=0.28U W=0.36U AS=0.0567P AD=0.1584P
+ PS=0.675U PD=1.6U
M$4251 VSS \$2547 \$2548 VSS nfet_03v3 L=0.28U W=0.36U AS=0.1584P AD=0.0972P
+ PS=1.6U PD=0.9U
M$4252 \$2549 \$2547 VSS VSS nfet_03v3 L=0.28U W=0.36U AS=0.0972P AD=0.18P
+ PS=0.9U PD=1.72U
M$4253 \$2552 \$142 VSS VSS nfet_03v3 L=0.28U W=0.36U AS=0.1584P AD=0.1188P
+ PS=1.6U PD=1.02U
M$4254 \$2553 \$2476 \$2552 VSS nfet_03v3 L=0.28U W=0.36U AS=0.1188P AD=0.1278P
+ PS=1.02U PD=1.07U
M$4255 \$2764 \$2554 \$2553 VSS nfet_03v3 L=0.28U W=0.36U AS=0.1278P AD=0.0567P
+ PS=1.07U PD=0.675U
M$4256 VSS \$2477 \$2764 VSS nfet_03v3 L=0.28U W=0.36U AS=0.0567P AD=0.1584P
+ PS=0.675U PD=1.6U
M$4257 VSS \$2553 \$2554 VSS nfet_03v3 L=0.28U W=0.36U AS=0.1584P AD=0.0972P
+ PS=1.6U PD=0.9U
M$4258 \$2555 \$2553 VSS VSS nfet_03v3 L=0.28U W=0.36U AS=0.0972P AD=0.18P
+ PS=0.9U PD=1.72U
M$4259 \$2558 \$145 VSS VSS nfet_03v3 L=0.28U W=0.36U AS=0.1584P AD=0.1188P
+ PS=1.6U PD=1.02U
M$4260 \$2559 \$2476 \$2558 VSS nfet_03v3 L=0.28U W=0.36U AS=0.1188P AD=0.1278P
+ PS=1.02U PD=1.07U
M$4261 \$2740 \$2560 \$2559 VSS nfet_03v3 L=0.28U W=0.36U AS=0.1278P AD=0.0567P
+ PS=1.07U PD=0.675U
M$4262 VSS \$2477 \$2740 VSS nfet_03v3 L=0.28U W=0.36U AS=0.0567P AD=0.1584P
+ PS=0.675U PD=1.6U
M$4263 VSS \$2559 \$2560 VSS nfet_03v3 L=0.28U W=0.36U AS=0.1584P AD=0.0972P
+ PS=1.6U PD=0.9U
M$4264 \$2561 \$2559 VSS VSS nfet_03v3 L=0.28U W=0.36U AS=0.0972P AD=0.18P
+ PS=0.9U PD=1.72U
M$4265 \$2564 \$148 VSS VSS nfet_03v3 L=0.28U W=0.36U AS=0.1584P AD=0.1188P
+ PS=1.6U PD=1.02U
M$4266 \$2565 \$2476 \$2564 VSS nfet_03v3 L=0.28U W=0.36U AS=0.1188P AD=0.1278P
+ PS=1.02U PD=1.07U
M$4267 \$2716 \$2566 \$2565 VSS nfet_03v3 L=0.28U W=0.36U AS=0.1278P AD=0.0567P
+ PS=1.07U PD=0.675U
M$4268 VSS \$2477 \$2716 VSS nfet_03v3 L=0.28U W=0.36U AS=0.0567P AD=0.1584P
+ PS=0.675U PD=1.6U
M$4269 VSS \$2565 \$2566 VSS nfet_03v3 L=0.28U W=0.36U AS=0.1584P AD=0.0972P
+ PS=1.6U PD=0.9U
M$4270 \$2567 \$2565 VSS VSS nfet_03v3 L=0.28U W=0.36U AS=0.0972P AD=0.18P
+ PS=0.9U PD=1.72U
M$4271 \$2570 \$151 VSS VSS nfet_03v3 L=0.28U W=0.36U AS=0.1584P AD=0.1188P
+ PS=1.6U PD=1.02U
M$4272 \$2571 \$2476 \$2570 VSS nfet_03v3 L=0.28U W=0.36U AS=0.1188P AD=0.1278P
+ PS=1.02U PD=1.07U
M$4273 \$2692 \$2572 \$2571 VSS nfet_03v3 L=0.28U W=0.36U AS=0.1278P AD=0.0567P
+ PS=1.07U PD=0.675U
M$4274 VSS \$2477 \$2692 VSS nfet_03v3 L=0.28U W=0.36U AS=0.0567P AD=0.1584P
+ PS=0.675U PD=1.6U
M$4275 VSS \$2571 \$2572 VSS nfet_03v3 L=0.28U W=0.36U AS=0.1584P AD=0.0972P
+ PS=1.6U PD=0.9U
M$4276 \$2573 \$2571 VSS VSS nfet_03v3 L=0.28U W=0.36U AS=0.0972P AD=0.18P
+ PS=0.9U PD=1.72U
M$4277 \$2932 WE7 VSS VSS nfet_03v3 L=0.28U W=0.72U AS=0.3168P AD=0.1872P
+ PS=2.32U PD=1.24U
M$4278 \$2777 CLK \$2932 VSS nfet_03v3 L=0.28U W=0.72U AS=0.1872P AD=0.3168P
+ PS=1.24U PD=2.32U
M$4279 \$2778 \$2777 VSS VSS nfet_03v3 L=0.28U W=0.635U AS=0.2794P AD=0.1651P
+ PS=2.15U PD=1.155U
M$4280 VSS \$2777 \$2778 VSS nfet_03v3 L=0.28U W=0.635U AS=0.1651P AD=0.1693P
+ PS=1.155U PD=1.19U
M$4281 \$2779 \$2778 VSS VSS nfet_03v3 L=0.28U W=0.67U AS=0.1693P AD=0.1943P
+ PS=1.19U PD=1.25U
M$4282 VSS \$2778 \$2779 VSS nfet_03v3 L=0.28U W=0.67U AS=0.1943P AD=0.2948P
+ PS=1.25U PD=2.22U
M$4283 \$2780 \$106 VSS VSS nfet_03v3 L=0.28U W=0.36U AS=0.1584P AD=0.1188P
+ PS=1.6U PD=1.02U
M$4284 \$2781 \$2778 \$2780 VSS nfet_03v3 L=0.28U W=0.36U AS=0.1188P AD=0.1278P
+ PS=1.02U PD=1.07U
M$4285 \$2849 \$2782 \$2781 VSS nfet_03v3 L=0.28U W=0.36U AS=0.1278P AD=0.0567P
+ PS=1.07U PD=0.675U
M$4286 VSS \$2779 \$2849 VSS nfet_03v3 L=0.28U W=0.36U AS=0.0567P AD=0.1584P
+ PS=0.675U PD=1.6U
M$4287 VSS \$2781 \$2782 VSS nfet_03v3 L=0.28U W=0.36U AS=0.1584P AD=0.0972P
+ PS=1.6U PD=0.9U
M$4288 \$2783 \$2781 VSS VSS nfet_03v3 L=0.28U W=0.36U AS=0.0972P AD=0.18P
+ PS=0.9U PD=1.72U
M$4289 \$2784 \$109 VSS VSS nfet_03v3 L=0.28U W=0.36U AS=0.1584P AD=0.1188P
+ PS=1.6U PD=1.02U
M$4290 \$2785 \$2778 \$2784 VSS nfet_03v3 L=0.28U W=0.36U AS=0.1188P AD=0.1278P
+ PS=1.02U PD=1.07U
M$4291 \$2858 \$2786 \$2785 VSS nfet_03v3 L=0.28U W=0.36U AS=0.1278P AD=0.0567P
+ PS=1.07U PD=0.675U
M$4292 VSS \$2779 \$2858 VSS nfet_03v3 L=0.28U W=0.36U AS=0.0567P AD=0.1584P
+ PS=0.675U PD=1.6U
M$4293 VSS \$2785 \$2786 VSS nfet_03v3 L=0.28U W=0.36U AS=0.1584P AD=0.0972P
+ PS=1.6U PD=0.9U
M$4294 \$2787 \$2785 VSS VSS nfet_03v3 L=0.28U W=0.36U AS=0.0972P AD=0.18P
+ PS=0.9U PD=1.72U
M$4295 \$2788 \$112 VSS VSS nfet_03v3 L=0.28U W=0.36U AS=0.1584P AD=0.1188P
+ PS=1.6U PD=1.02U
M$4296 \$2789 \$2778 \$2788 VSS nfet_03v3 L=0.28U W=0.36U AS=0.1188P AD=0.1278P
+ PS=1.02U PD=1.07U
M$4297 \$2867 \$2790 \$2789 VSS nfet_03v3 L=0.28U W=0.36U AS=0.1278P AD=0.0567P
+ PS=1.07U PD=0.675U
M$4298 VSS \$2779 \$2867 VSS nfet_03v3 L=0.28U W=0.36U AS=0.0567P AD=0.1584P
+ PS=0.675U PD=1.6U
M$4299 VSS \$2789 \$2790 VSS nfet_03v3 L=0.28U W=0.36U AS=0.1584P AD=0.0972P
+ PS=1.6U PD=0.9U
M$4300 \$2791 \$2789 VSS VSS nfet_03v3 L=0.28U W=0.36U AS=0.0972P AD=0.18P
+ PS=0.9U PD=1.72U
M$4301 \$2792 \$115 VSS VSS nfet_03v3 L=0.28U W=0.36U AS=0.1584P AD=0.1188P
+ PS=1.6U PD=1.02U
M$4302 \$2793 \$2778 \$2792 VSS nfet_03v3 L=0.28U W=0.36U AS=0.1188P AD=0.1278P
+ PS=1.02U PD=1.07U
M$4303 \$2876 \$2794 \$2793 VSS nfet_03v3 L=0.28U W=0.36U AS=0.1278P AD=0.0567P
+ PS=1.07U PD=0.675U
M$4304 VSS \$2779 \$2876 VSS nfet_03v3 L=0.28U W=0.36U AS=0.0567P AD=0.1584P
+ PS=0.675U PD=1.6U
M$4305 VSS \$2793 \$2794 VSS nfet_03v3 L=0.28U W=0.36U AS=0.1584P AD=0.0972P
+ PS=1.6U PD=0.9U
M$4306 \$2795 \$2793 VSS VSS nfet_03v3 L=0.28U W=0.36U AS=0.0972P AD=0.18P
+ PS=0.9U PD=1.72U
M$4307 \$2796 \$118 VSS VSS nfet_03v3 L=0.28U W=0.36U AS=0.1584P AD=0.1188P
+ PS=1.6U PD=1.02U
M$4308 \$2797 \$2778 \$2796 VSS nfet_03v3 L=0.28U W=0.36U AS=0.1188P AD=0.1278P
+ PS=1.02U PD=1.07U
M$4309 \$2885 \$2798 \$2797 VSS nfet_03v3 L=0.28U W=0.36U AS=0.1278P AD=0.0567P
+ PS=1.07U PD=0.675U
M$4310 VSS \$2779 \$2885 VSS nfet_03v3 L=0.28U W=0.36U AS=0.0567P AD=0.1584P
+ PS=0.675U PD=1.6U
M$4311 VSS \$2797 \$2798 VSS nfet_03v3 L=0.28U W=0.36U AS=0.1584P AD=0.0972P
+ PS=1.6U PD=0.9U
M$4312 \$2799 \$2797 VSS VSS nfet_03v3 L=0.28U W=0.36U AS=0.0972P AD=0.18P
+ PS=0.9U PD=1.72U
M$4313 \$2800 \$121 VSS VSS nfet_03v3 L=0.28U W=0.36U AS=0.1584P AD=0.1188P
+ PS=1.6U PD=1.02U
M$4314 \$2801 \$2778 \$2800 VSS nfet_03v3 L=0.28U W=0.36U AS=0.1188P AD=0.1278P
+ PS=1.02U PD=1.07U
M$4315 \$2893 \$2802 \$2801 VSS nfet_03v3 L=0.28U W=0.36U AS=0.1278P AD=0.0567P
+ PS=1.07U PD=0.675U
M$4316 VSS \$2779 \$2893 VSS nfet_03v3 L=0.28U W=0.36U AS=0.0567P AD=0.1584P
+ PS=0.675U PD=1.6U
M$4317 VSS \$2801 \$2802 VSS nfet_03v3 L=0.28U W=0.36U AS=0.1584P AD=0.0972P
+ PS=1.6U PD=0.9U
M$4318 \$2803 \$2801 VSS VSS nfet_03v3 L=0.28U W=0.36U AS=0.0972P AD=0.18P
+ PS=0.9U PD=1.72U
M$4319 \$2804 \$124 VSS VSS nfet_03v3 L=0.28U W=0.36U AS=0.1584P AD=0.1188P
+ PS=1.6U PD=1.02U
M$4320 \$2805 \$2778 \$2804 VSS nfet_03v3 L=0.28U W=0.36U AS=0.1188P AD=0.1278P
+ PS=1.02U PD=1.07U
M$4321 \$2896 \$2806 \$2805 VSS nfet_03v3 L=0.28U W=0.36U AS=0.1278P AD=0.0567P
+ PS=1.07U PD=0.675U
M$4322 VSS \$2779 \$2896 VSS nfet_03v3 L=0.28U W=0.36U AS=0.0567P AD=0.1584P
+ PS=0.675U PD=1.6U
M$4323 VSS \$2805 \$2806 VSS nfet_03v3 L=0.28U W=0.36U AS=0.1584P AD=0.0972P
+ PS=1.6U PD=0.9U
M$4324 \$2807 \$2805 VSS VSS nfet_03v3 L=0.28U W=0.36U AS=0.0972P AD=0.18P
+ PS=0.9U PD=1.72U
M$4325 \$2808 \$127 VSS VSS nfet_03v3 L=0.28U W=0.36U AS=0.1584P AD=0.1188P
+ PS=1.6U PD=1.02U
M$4326 \$2809 \$2778 \$2808 VSS nfet_03v3 L=0.28U W=0.36U AS=0.1188P AD=0.1278P
+ PS=1.02U PD=1.07U
M$4327 \$2890 \$2810 \$2809 VSS nfet_03v3 L=0.28U W=0.36U AS=0.1278P AD=0.0567P
+ PS=1.07U PD=0.675U
M$4328 VSS \$2779 \$2890 VSS nfet_03v3 L=0.28U W=0.36U AS=0.0567P AD=0.1584P
+ PS=0.675U PD=1.6U
M$4329 VSS \$2809 \$2810 VSS nfet_03v3 L=0.28U W=0.36U AS=0.1584P AD=0.0972P
+ PS=1.6U PD=0.9U
M$4330 \$2811 \$2809 VSS VSS nfet_03v3 L=0.28U W=0.36U AS=0.0972P AD=0.18P
+ PS=0.9U PD=1.72U
M$4331 \$2812 \$130 VSS VSS nfet_03v3 L=0.28U W=0.36U AS=0.1584P AD=0.1188P
+ PS=1.6U PD=1.02U
M$4332 \$2813 \$2778 \$2812 VSS nfet_03v3 L=0.28U W=0.36U AS=0.1188P AD=0.1278P
+ PS=1.02U PD=1.07U
M$4333 \$2884 \$2814 \$2813 VSS nfet_03v3 L=0.28U W=0.36U AS=0.1278P AD=0.0567P
+ PS=1.07U PD=0.675U
M$4334 VSS \$2779 \$2884 VSS nfet_03v3 L=0.28U W=0.36U AS=0.0567P AD=0.1584P
+ PS=0.675U PD=1.6U
M$4335 VSS \$2813 \$2814 VSS nfet_03v3 L=0.28U W=0.36U AS=0.1584P AD=0.0972P
+ PS=1.6U PD=0.9U
M$4336 \$2815 \$2813 VSS VSS nfet_03v3 L=0.28U W=0.36U AS=0.0972P AD=0.18P
+ PS=0.9U PD=1.72U
M$4337 \$2816 \$133 VSS VSS nfet_03v3 L=0.28U W=0.36U AS=0.1584P AD=0.1188P
+ PS=1.6U PD=1.02U
M$4338 \$2817 \$2778 \$2816 VSS nfet_03v3 L=0.28U W=0.36U AS=0.1188P AD=0.1278P
+ PS=1.02U PD=1.07U
M$4339 \$2880 \$2818 \$2817 VSS nfet_03v3 L=0.28U W=0.36U AS=0.1278P AD=0.0567P
+ PS=1.07U PD=0.675U
M$4340 VSS \$2779 \$2880 VSS nfet_03v3 L=0.28U W=0.36U AS=0.0567P AD=0.1584P
+ PS=0.675U PD=1.6U
M$4341 VSS \$2817 \$2818 VSS nfet_03v3 L=0.28U W=0.36U AS=0.1584P AD=0.0972P
+ PS=1.6U PD=0.9U
M$4342 \$2819 \$2817 VSS VSS nfet_03v3 L=0.28U W=0.36U AS=0.0972P AD=0.18P
+ PS=0.9U PD=1.72U
M$4343 \$2820 \$136 VSS VSS nfet_03v3 L=0.28U W=0.36U AS=0.1584P AD=0.1188P
+ PS=1.6U PD=1.02U
M$4344 \$2821 \$2778 \$2820 VSS nfet_03v3 L=0.28U W=0.36U AS=0.1188P AD=0.1278P
+ PS=1.02U PD=1.07U
M$4345 \$2873 \$2822 \$2821 VSS nfet_03v3 L=0.28U W=0.36U AS=0.1278P AD=0.0567P
+ PS=1.07U PD=0.675U
M$4346 VSS \$2779 \$2873 VSS nfet_03v3 L=0.28U W=0.36U AS=0.0567P AD=0.1584P
+ PS=0.675U PD=1.6U
M$4347 VSS \$2821 \$2822 VSS nfet_03v3 L=0.28U W=0.36U AS=0.1584P AD=0.0972P
+ PS=1.6U PD=0.9U
M$4348 \$2823 \$2821 VSS VSS nfet_03v3 L=0.28U W=0.36U AS=0.0972P AD=0.18P
+ PS=0.9U PD=1.72U
M$4349 \$2824 \$139 VSS VSS nfet_03v3 L=0.28U W=0.36U AS=0.1584P AD=0.1188P
+ PS=1.6U PD=1.02U
M$4350 \$2825 \$2778 \$2824 VSS nfet_03v3 L=0.28U W=0.36U AS=0.1188P AD=0.1278P
+ PS=1.02U PD=1.07U
M$4351 \$2869 \$2826 \$2825 VSS nfet_03v3 L=0.28U W=0.36U AS=0.1278P AD=0.0567P
+ PS=1.07U PD=0.675U
M$4352 VSS \$2779 \$2869 VSS nfet_03v3 L=0.28U W=0.36U AS=0.0567P AD=0.1584P
+ PS=0.675U PD=1.6U
M$4353 VSS \$2825 \$2826 VSS nfet_03v3 L=0.28U W=0.36U AS=0.1584P AD=0.0972P
+ PS=1.6U PD=0.9U
M$4354 \$2827 \$2825 VSS VSS nfet_03v3 L=0.28U W=0.36U AS=0.0972P AD=0.18P
+ PS=0.9U PD=1.72U
M$4355 \$2828 \$142 VSS VSS nfet_03v3 L=0.28U W=0.36U AS=0.1584P AD=0.1188P
+ PS=1.6U PD=1.02U
M$4356 \$2829 \$2778 \$2828 VSS nfet_03v3 L=0.28U W=0.36U AS=0.1188P AD=0.1278P
+ PS=1.02U PD=1.07U
M$4357 \$2864 \$2830 \$2829 VSS nfet_03v3 L=0.28U W=0.36U AS=0.1278P AD=0.0567P
+ PS=1.07U PD=0.675U
M$4358 VSS \$2779 \$2864 VSS nfet_03v3 L=0.28U W=0.36U AS=0.0567P AD=0.1584P
+ PS=0.675U PD=1.6U
M$4359 VSS \$2829 \$2830 VSS nfet_03v3 L=0.28U W=0.36U AS=0.1584P AD=0.0972P
+ PS=1.6U PD=0.9U
M$4360 \$2831 \$2829 VSS VSS nfet_03v3 L=0.28U W=0.36U AS=0.0972P AD=0.18P
+ PS=0.9U PD=1.72U
M$4361 \$2832 \$145 VSS VSS nfet_03v3 L=0.28U W=0.36U AS=0.1584P AD=0.1188P
+ PS=1.6U PD=1.02U
M$4362 \$2833 \$2778 \$2832 VSS nfet_03v3 L=0.28U W=0.36U AS=0.1188P AD=0.1278P
+ PS=1.02U PD=1.07U
M$4363 \$2857 \$2834 \$2833 VSS nfet_03v3 L=0.28U W=0.36U AS=0.1278P AD=0.0567P
+ PS=1.07U PD=0.675U
M$4364 VSS \$2779 \$2857 VSS nfet_03v3 L=0.28U W=0.36U AS=0.0567P AD=0.1584P
+ PS=0.675U PD=1.6U
M$4365 VSS \$2833 \$2834 VSS nfet_03v3 L=0.28U W=0.36U AS=0.1584P AD=0.0972P
+ PS=1.6U PD=0.9U
M$4366 \$2835 \$2833 VSS VSS nfet_03v3 L=0.28U W=0.36U AS=0.0972P AD=0.18P
+ PS=0.9U PD=1.72U
M$4367 \$2836 \$148 VSS VSS nfet_03v3 L=0.28U W=0.36U AS=0.1584P AD=0.1188P
+ PS=1.6U PD=1.02U
M$4368 \$2837 \$2778 \$2836 VSS nfet_03v3 L=0.28U W=0.36U AS=0.1188P AD=0.1278P
+ PS=1.02U PD=1.07U
M$4369 \$2853 \$2838 \$2837 VSS nfet_03v3 L=0.28U W=0.36U AS=0.1278P AD=0.0567P
+ PS=1.07U PD=0.675U
M$4370 VSS \$2779 \$2853 VSS nfet_03v3 L=0.28U W=0.36U AS=0.0567P AD=0.1584P
+ PS=0.675U PD=1.6U
M$4371 VSS \$2837 \$2838 VSS nfet_03v3 L=0.28U W=0.36U AS=0.1584P AD=0.0972P
+ PS=1.6U PD=0.9U
M$4372 \$2839 \$2837 VSS VSS nfet_03v3 L=0.28U W=0.36U AS=0.0972P AD=0.18P
+ PS=0.9U PD=1.72U
M$4373 \$2840 \$151 VSS VSS nfet_03v3 L=0.28U W=0.36U AS=0.1584P AD=0.1188P
+ PS=1.6U PD=1.02U
M$4374 \$2841 \$2778 \$2840 VSS nfet_03v3 L=0.28U W=0.36U AS=0.1188P AD=0.1278P
+ PS=1.02U PD=1.07U
M$4375 \$2846 \$2842 \$2841 VSS nfet_03v3 L=0.28U W=0.36U AS=0.1278P AD=0.0567P
+ PS=1.07U PD=0.675U
M$4376 VSS \$2779 \$2846 VSS nfet_03v3 L=0.28U W=0.36U AS=0.0567P AD=0.1584P
+ PS=0.675U PD=1.6U
M$4377 VSS \$2841 \$2842 VSS nfet_03v3 L=0.28U W=0.36U AS=0.1584P AD=0.0972P
+ PS=1.6U PD=0.9U
M$4378 \$2843 \$2841 VSS VSS nfet_03v3 L=0.28U W=0.36U AS=0.0972P AD=0.18P
+ PS=0.9U PD=1.72U
M$4379 \$3103 RB6 VSS VSS nfet_03v3 L=0.28U W=0.36U AS=0.1656P AD=0.1944P
+ PS=1.64U PD=1.8U
M$4380 \$2900 RA7 VSS VSS nfet_03v3 L=0.28U W=0.36U AS=0.1656P AD=0.1944P
+ PS=1.64U PD=1.8U
M$4381 \$3102 RB6 \$51 VSS nfet_03v3 L=0.28U W=0.36U AS=0.1584P AD=0.1152P
+ PS=1.6U PD=1U
M$4382 \$52 RA6 \$3102 VSS nfet_03v3 L=0.28U W=0.36U AS=0.1152P AD=0.1584P
+ PS=1U PD=1.6U
M$4383 \$2783 RA7 \$51 VSS nfet_03v3 L=0.28U W=0.36U AS=0.1584P AD=0.1152P
+ PS=1.6U PD=1U
M$4384 \$52 RB7 \$2783 VSS nfet_03v3 L=0.28U W=0.36U AS=0.1152P AD=0.1584P
+ PS=1U PD=1.6U
M$4385 VSS RB7 \$2901 VSS nfet_03v3 L=0.28U W=0.36U AS=0.1854P AD=0.1584P
+ PS=1.75U PD=1.6U
M$4386 VSS RA6 \$3104 VSS nfet_03v3 L=0.28U W=0.36U AS=0.1854P AD=0.1584P
+ PS=1.75U PD=1.6U
M$4387 \$3109 RB6 VSS VSS nfet_03v3 L=0.28U W=0.36U AS=0.1656P AD=0.1944P
+ PS=1.64U PD=1.8U
M$4388 \$2902 RA7 VSS VSS nfet_03v3 L=0.28U W=0.36U AS=0.1656P AD=0.1944P
+ PS=1.64U PD=1.8U
M$4389 \$3108 RB6 \$53 VSS nfet_03v3 L=0.28U W=0.36U AS=0.1584P AD=0.1152P
+ PS=1.6U PD=1U
M$4390 \$54 RA6 \$3108 VSS nfet_03v3 L=0.28U W=0.36U AS=0.1152P AD=0.1584P
+ PS=1U PD=1.6U
M$4391 \$2787 RA7 \$53 VSS nfet_03v3 L=0.28U W=0.36U AS=0.1584P AD=0.1152P
+ PS=1.6U PD=1U
M$4392 \$54 RB7 \$2787 VSS nfet_03v3 L=0.28U W=0.36U AS=0.1152P AD=0.1584P
+ PS=1U PD=1.6U
M$4393 VSS RA6 \$3110 VSS nfet_03v3 L=0.28U W=0.36U AS=0.1854P AD=0.1584P
+ PS=1.75U PD=1.6U
M$4394 VSS RB7 \$2903 VSS nfet_03v3 L=0.28U W=0.36U AS=0.1854P AD=0.1584P
+ PS=1.75U PD=1.6U
M$4395 \$3115 RB6 VSS VSS nfet_03v3 L=0.28U W=0.36U AS=0.1656P AD=0.1944P
+ PS=1.64U PD=1.8U
M$4396 \$2904 RA7 VSS VSS nfet_03v3 L=0.28U W=0.36U AS=0.1656P AD=0.1944P
+ PS=1.64U PD=1.8U
M$4397 \$2791 RA7 \$55 VSS nfet_03v3 L=0.28U W=0.36U AS=0.1584P AD=0.1152P
+ PS=1.6U PD=1U
M$4398 \$56 RB7 \$2791 VSS nfet_03v3 L=0.28U W=0.36U AS=0.1152P AD=0.1584P
+ PS=1U PD=1.6U
M$4399 \$3114 RB6 \$55 VSS nfet_03v3 L=0.28U W=0.36U AS=0.1584P AD=0.1152P
+ PS=1.6U PD=1U
M$4400 \$56 RA6 \$3114 VSS nfet_03v3 L=0.28U W=0.36U AS=0.1152P AD=0.1584P
+ PS=1U PD=1.6U
M$4401 VSS RA6 \$3116 VSS nfet_03v3 L=0.28U W=0.36U AS=0.1854P AD=0.1584P
+ PS=1.75U PD=1.6U
M$4402 VSS RB7 \$2905 VSS nfet_03v3 L=0.28U W=0.36U AS=0.1854P AD=0.1584P
+ PS=1.75U PD=1.6U
M$4403 \$2906 RA7 VSS VSS nfet_03v3 L=0.28U W=0.36U AS=0.1656P AD=0.1944P
+ PS=1.64U PD=1.8U
M$4404 \$3121 RB6 VSS VSS nfet_03v3 L=0.28U W=0.36U AS=0.1656P AD=0.1944P
+ PS=1.64U PD=1.8U
M$4405 \$3120 RB6 \$57 VSS nfet_03v3 L=0.28U W=0.36U AS=0.1584P AD=0.1152P
+ PS=1.6U PD=1U
M$4406 \$58 RA6 \$3120 VSS nfet_03v3 L=0.28U W=0.36U AS=0.1152P AD=0.1584P
+ PS=1U PD=1.6U
M$4407 \$2795 RA7 \$57 VSS nfet_03v3 L=0.28U W=0.36U AS=0.1584P AD=0.1152P
+ PS=1.6U PD=1U
M$4408 \$58 RB7 \$2795 VSS nfet_03v3 L=0.28U W=0.36U AS=0.1152P AD=0.1584P
+ PS=1U PD=1.6U
M$4409 VSS RA6 \$3122 VSS nfet_03v3 L=0.28U W=0.36U AS=0.1854P AD=0.1584P
+ PS=1.75U PD=1.6U
M$4410 VSS RB7 \$2907 VSS nfet_03v3 L=0.28U W=0.36U AS=0.1854P AD=0.1584P
+ PS=1.75U PD=1.6U
M$4411 \$2908 RA7 VSS VSS nfet_03v3 L=0.28U W=0.36U AS=0.1656P AD=0.1944P
+ PS=1.64U PD=1.8U
M$4412 \$3127 RB6 VSS VSS nfet_03v3 L=0.28U W=0.36U AS=0.1656P AD=0.1944P
+ PS=1.64U PD=1.8U
M$4413 \$2799 RA7 \$59 VSS nfet_03v3 L=0.28U W=0.36U AS=0.1584P AD=0.1152P
+ PS=1.6U PD=1U
M$4414 \$60 RB7 \$2799 VSS nfet_03v3 L=0.28U W=0.36U AS=0.1152P AD=0.1584P
+ PS=1U PD=1.6U
M$4415 \$3126 RB6 \$59 VSS nfet_03v3 L=0.28U W=0.36U AS=0.1584P AD=0.1152P
+ PS=1.6U PD=1U
M$4416 \$60 RA6 \$3126 VSS nfet_03v3 L=0.28U W=0.36U AS=0.1152P AD=0.1584P
+ PS=1U PD=1.6U
M$4417 VSS RB7 \$2909 VSS nfet_03v3 L=0.28U W=0.36U AS=0.1854P AD=0.1584P
+ PS=1.75U PD=1.6U
M$4418 VSS RA6 \$3128 VSS nfet_03v3 L=0.28U W=0.36U AS=0.1854P AD=0.1584P
+ PS=1.75U PD=1.6U
M$4419 \$2910 RA7 VSS VSS nfet_03v3 L=0.28U W=0.36U AS=0.1656P AD=0.1944P
+ PS=1.64U PD=1.8U
M$4420 \$3133 RB6 VSS VSS nfet_03v3 L=0.28U W=0.36U AS=0.1656P AD=0.1944P
+ PS=1.64U PD=1.8U
M$4421 \$3132 RB6 \$61 VSS nfet_03v3 L=0.28U W=0.36U AS=0.1584P AD=0.1152P
+ PS=1.6U PD=1U
M$4422 \$62 RA6 \$3132 VSS nfet_03v3 L=0.28U W=0.36U AS=0.1152P AD=0.1584P
+ PS=1U PD=1.6U
M$4423 \$2803 RA7 \$61 VSS nfet_03v3 L=0.28U W=0.36U AS=0.1584P AD=0.1152P
+ PS=1.6U PD=1U
M$4424 \$62 RB7 \$2803 VSS nfet_03v3 L=0.28U W=0.36U AS=0.1152P AD=0.1584P
+ PS=1U PD=1.6U
M$4425 VSS RA6 \$3134 VSS nfet_03v3 L=0.28U W=0.36U AS=0.1854P AD=0.1584P
+ PS=1.75U PD=1.6U
M$4426 VSS RB7 \$2911 VSS nfet_03v3 L=0.28U W=0.36U AS=0.1854P AD=0.1584P
+ PS=1.75U PD=1.6U
M$4427 \$3139 RB6 VSS VSS nfet_03v3 L=0.28U W=0.36U AS=0.1656P AD=0.1944P
+ PS=1.64U PD=1.8U
M$4428 \$2912 RA7 VSS VSS nfet_03v3 L=0.28U W=0.36U AS=0.1656P AD=0.1944P
+ PS=1.64U PD=1.8U
M$4429 \$3138 RB6 \$63 VSS nfet_03v3 L=0.28U W=0.36U AS=0.1584P AD=0.1152P
+ PS=1.6U PD=1U
M$4430 \$64 RA6 \$3138 VSS nfet_03v3 L=0.28U W=0.36U AS=0.1152P AD=0.1584P
+ PS=1U PD=1.6U
M$4431 \$2807 RA7 \$63 VSS nfet_03v3 L=0.28U W=0.36U AS=0.1584P AD=0.1152P
+ PS=1.6U PD=1U
M$4432 \$64 RB7 \$2807 VSS nfet_03v3 L=0.28U W=0.36U AS=0.1152P AD=0.1584P
+ PS=1U PD=1.6U
M$4433 VSS RB7 \$2913 VSS nfet_03v3 L=0.28U W=0.36U AS=0.1854P AD=0.1584P
+ PS=1.75U PD=1.6U
M$4434 VSS RA6 \$3140 VSS nfet_03v3 L=0.28U W=0.36U AS=0.1854P AD=0.1584P
+ PS=1.75U PD=1.6U
M$4435 \$3145 RB6 VSS VSS nfet_03v3 L=0.28U W=0.36U AS=0.1656P AD=0.1944P
+ PS=1.64U PD=1.8U
M$4436 \$2914 RA7 VSS VSS nfet_03v3 L=0.28U W=0.36U AS=0.1656P AD=0.1944P
+ PS=1.64U PD=1.8U
M$4437 \$3144 RB6 \$65 VSS nfet_03v3 L=0.28U W=0.36U AS=0.1584P AD=0.1152P
+ PS=1.6U PD=1U
M$4438 \$66 RA6 \$3144 VSS nfet_03v3 L=0.28U W=0.36U AS=0.1152P AD=0.1584P
+ PS=1U PD=1.6U
M$4439 \$2811 RA7 \$65 VSS nfet_03v3 L=0.28U W=0.36U AS=0.1584P AD=0.1152P
+ PS=1.6U PD=1U
M$4440 \$66 RB7 \$2811 VSS nfet_03v3 L=0.28U W=0.36U AS=0.1152P AD=0.1584P
+ PS=1U PD=1.6U
M$4441 VSS RB7 \$2915 VSS nfet_03v3 L=0.28U W=0.36U AS=0.1854P AD=0.1584P
+ PS=1.75U PD=1.6U
M$4442 VSS RA6 \$3146 VSS nfet_03v3 L=0.28U W=0.36U AS=0.1854P AD=0.1584P
+ PS=1.75U PD=1.6U
M$4443 \$2916 RA7 VSS VSS nfet_03v3 L=0.28U W=0.36U AS=0.1656P AD=0.1944P
+ PS=1.64U PD=1.8U
M$4444 \$3151 RB6 VSS VSS nfet_03v3 L=0.28U W=0.36U AS=0.1656P AD=0.1944P
+ PS=1.64U PD=1.8U
M$4445 \$2815 RA7 \$67 VSS nfet_03v3 L=0.28U W=0.36U AS=0.1584P AD=0.1152P
+ PS=1.6U PD=1U
M$4446 \$68 RB7 \$2815 VSS nfet_03v3 L=0.28U W=0.36U AS=0.1152P AD=0.1584P
+ PS=1U PD=1.6U
M$4447 \$3150 RB6 \$67 VSS nfet_03v3 L=0.28U W=0.36U AS=0.1584P AD=0.1152P
+ PS=1.6U PD=1U
M$4448 \$68 RA6 \$3150 VSS nfet_03v3 L=0.28U W=0.36U AS=0.1152P AD=0.1584P
+ PS=1U PD=1.6U
M$4449 VSS RB7 \$2917 VSS nfet_03v3 L=0.28U W=0.36U AS=0.1854P AD=0.1584P
+ PS=1.75U PD=1.6U
M$4450 VSS RA6 \$3152 VSS nfet_03v3 L=0.28U W=0.36U AS=0.1854P AD=0.1584P
+ PS=1.75U PD=1.6U
M$4451 \$3157 RB6 VSS VSS nfet_03v3 L=0.28U W=0.36U AS=0.1656P AD=0.1944P
+ PS=1.64U PD=1.8U
M$4452 \$2918 RA7 VSS VSS nfet_03v3 L=0.28U W=0.36U AS=0.1656P AD=0.1944P
+ PS=1.64U PD=1.8U
M$4453 \$2819 RA7 \$69 VSS nfet_03v3 L=0.28U W=0.36U AS=0.1584P AD=0.1152P
+ PS=1.6U PD=1U
M$4454 \$70 RB7 \$2819 VSS nfet_03v3 L=0.28U W=0.36U AS=0.1152P AD=0.1584P
+ PS=1U PD=1.6U
M$4455 \$3156 RB6 \$69 VSS nfet_03v3 L=0.28U W=0.36U AS=0.1584P AD=0.1152P
+ PS=1.6U PD=1U
M$4456 \$70 RA6 \$3156 VSS nfet_03v3 L=0.28U W=0.36U AS=0.1152P AD=0.1584P
+ PS=1U PD=1.6U
M$4457 VSS RB7 \$2919 VSS nfet_03v3 L=0.28U W=0.36U AS=0.1854P AD=0.1584P
+ PS=1.75U PD=1.6U
M$4458 VSS RA6 \$3158 VSS nfet_03v3 L=0.28U W=0.36U AS=0.1854P AD=0.1584P
+ PS=1.75U PD=1.6U
M$4459 \$3163 RB6 VSS VSS nfet_03v3 L=0.28U W=0.36U AS=0.1656P AD=0.1944P
+ PS=1.64U PD=1.8U
M$4460 \$2920 RA7 VSS VSS nfet_03v3 L=0.28U W=0.36U AS=0.1656P AD=0.1944P
+ PS=1.64U PD=1.8U
M$4461 \$3162 RB6 \$71 VSS nfet_03v3 L=0.28U W=0.36U AS=0.1584P AD=0.1152P
+ PS=1.6U PD=1U
M$4462 \$72 RA6 \$3162 VSS nfet_03v3 L=0.28U W=0.36U AS=0.1152P AD=0.1584P
+ PS=1U PD=1.6U
M$4463 \$2823 RA7 \$71 VSS nfet_03v3 L=0.28U W=0.36U AS=0.1584P AD=0.1152P
+ PS=1.6U PD=1U
M$4464 \$72 RB7 \$2823 VSS nfet_03v3 L=0.28U W=0.36U AS=0.1152P AD=0.1584P
+ PS=1U PD=1.6U
M$4465 VSS RA6 \$3164 VSS nfet_03v3 L=0.28U W=0.36U AS=0.1854P AD=0.1584P
+ PS=1.75U PD=1.6U
M$4466 VSS RB7 \$2921 VSS nfet_03v3 L=0.28U W=0.36U AS=0.1854P AD=0.1584P
+ PS=1.75U PD=1.6U
M$4467 \$3169 RB6 VSS VSS nfet_03v3 L=0.28U W=0.36U AS=0.1656P AD=0.1944P
+ PS=1.64U PD=1.8U
M$4468 \$2922 RA7 VSS VSS nfet_03v3 L=0.28U W=0.36U AS=0.1656P AD=0.1944P
+ PS=1.64U PD=1.8U
M$4469 \$3168 RB6 \$73 VSS nfet_03v3 L=0.28U W=0.36U AS=0.1584P AD=0.1152P
+ PS=1.6U PD=1U
M$4470 \$74 RA6 \$3168 VSS nfet_03v3 L=0.28U W=0.36U AS=0.1152P AD=0.1584P
+ PS=1U PD=1.6U
M$4471 \$2827 RA7 \$73 VSS nfet_03v3 L=0.28U W=0.36U AS=0.1584P AD=0.1152P
+ PS=1.6U PD=1U
M$4472 \$74 RB7 \$2827 VSS nfet_03v3 L=0.28U W=0.36U AS=0.1152P AD=0.1584P
+ PS=1U PD=1.6U
M$4473 VSS RA6 \$3170 VSS nfet_03v3 L=0.28U W=0.36U AS=0.1854P AD=0.1584P
+ PS=1.75U PD=1.6U
M$4474 VSS RB7 \$2923 VSS nfet_03v3 L=0.28U W=0.36U AS=0.1854P AD=0.1584P
+ PS=1.75U PD=1.6U
M$4475 \$3175 RB6 VSS VSS nfet_03v3 L=0.28U W=0.36U AS=0.1656P AD=0.1944P
+ PS=1.64U PD=1.8U
M$4476 \$2924 RA7 VSS VSS nfet_03v3 L=0.28U W=0.36U AS=0.1656P AD=0.1944P
+ PS=1.64U PD=1.8U
M$4477 \$3174 RB6 \$75 VSS nfet_03v3 L=0.28U W=0.36U AS=0.1584P AD=0.1152P
+ PS=1.6U PD=1U
M$4478 \$76 RA6 \$3174 VSS nfet_03v3 L=0.28U W=0.36U AS=0.1152P AD=0.1584P
+ PS=1U PD=1.6U
M$4479 \$2831 RA7 \$75 VSS nfet_03v3 L=0.28U W=0.36U AS=0.1584P AD=0.1152P
+ PS=1.6U PD=1U
M$4480 \$76 RB7 \$2831 VSS nfet_03v3 L=0.28U W=0.36U AS=0.1152P AD=0.1584P
+ PS=1U PD=1.6U
M$4481 VSS RA6 \$3176 VSS nfet_03v3 L=0.28U W=0.36U AS=0.1854P AD=0.1584P
+ PS=1.75U PD=1.6U
M$4482 VSS RB7 \$2925 VSS nfet_03v3 L=0.28U W=0.36U AS=0.1854P AD=0.1584P
+ PS=1.75U PD=1.6U
M$4483 \$2926 RA7 VSS VSS nfet_03v3 L=0.28U W=0.36U AS=0.1656P AD=0.1944P
+ PS=1.64U PD=1.8U
M$4484 \$3181 RB6 VSS VSS nfet_03v3 L=0.28U W=0.36U AS=0.1656P AD=0.1944P
+ PS=1.64U PD=1.8U
M$4485 \$2835 RA7 \$77 VSS nfet_03v3 L=0.28U W=0.36U AS=0.1584P AD=0.1152P
+ PS=1.6U PD=1U
M$4486 \$78 RB7 \$2835 VSS nfet_03v3 L=0.28U W=0.36U AS=0.1152P AD=0.1584P
+ PS=1U PD=1.6U
M$4487 \$3180 RB6 \$77 VSS nfet_03v3 L=0.28U W=0.36U AS=0.1584P AD=0.1152P
+ PS=1.6U PD=1U
M$4488 \$78 RA6 \$3180 VSS nfet_03v3 L=0.28U W=0.36U AS=0.1152P AD=0.1584P
+ PS=1U PD=1.6U
M$4489 VSS RB7 \$2927 VSS nfet_03v3 L=0.28U W=0.36U AS=0.1854P AD=0.1584P
+ PS=1.75U PD=1.6U
M$4490 VSS RA6 \$3182 VSS nfet_03v3 L=0.28U W=0.36U AS=0.1854P AD=0.1584P
+ PS=1.75U PD=1.6U
M$4491 \$2928 RA7 VSS VSS nfet_03v3 L=0.28U W=0.36U AS=0.1656P AD=0.1944P
+ PS=1.64U PD=1.8U
M$4492 \$3187 RB6 VSS VSS nfet_03v3 L=0.28U W=0.36U AS=0.1656P AD=0.1944P
+ PS=1.64U PD=1.8U
M$4493 \$2839 RA7 \$79 VSS nfet_03v3 L=0.28U W=0.36U AS=0.1584P AD=0.1152P
+ PS=1.6U PD=1U
M$4494 \$80 RB7 \$2839 VSS nfet_03v3 L=0.28U W=0.36U AS=0.1152P AD=0.1584P
+ PS=1U PD=1.6U
M$4495 \$3186 RB6 \$79 VSS nfet_03v3 L=0.28U W=0.36U AS=0.1584P AD=0.1152P
+ PS=1.6U PD=1U
M$4496 \$80 RA6 \$3186 VSS nfet_03v3 L=0.28U W=0.36U AS=0.1152P AD=0.1584P
+ PS=1U PD=1.6U
M$4497 VSS RB7 \$2929 VSS nfet_03v3 L=0.28U W=0.36U AS=0.1854P AD=0.1584P
+ PS=1.75U PD=1.6U
M$4498 VSS RA6 \$3188 VSS nfet_03v3 L=0.28U W=0.36U AS=0.1854P AD=0.1584P
+ PS=1.75U PD=1.6U
M$4499 \$2930 RA7 VSS VSS nfet_03v3 L=0.28U W=0.36U AS=0.1656P AD=0.1944P
+ PS=1.64U PD=1.8U
M$4500 \$3193 RB6 VSS VSS nfet_03v3 L=0.28U W=0.36U AS=0.1656P AD=0.1944P
+ PS=1.64U PD=1.8U
M$4501 \$3192 RB6 \$81 VSS nfet_03v3 L=0.28U W=0.36U AS=0.1584P AD=0.1152P
+ PS=1.6U PD=1U
M$4502 \$82 RA6 \$3192 VSS nfet_03v3 L=0.28U W=0.36U AS=0.1152P AD=0.1584P
+ PS=1U PD=1.6U
M$4503 \$2843 RA7 \$81 VSS nfet_03v3 L=0.28U W=0.36U AS=0.1584P AD=0.1152P
+ PS=1.6U PD=1U
M$4504 \$82 RB7 \$2843 VSS nfet_03v3 L=0.28U W=0.36U AS=0.1152P AD=0.1584P
+ PS=1U PD=1.6U
M$4505 VSS RB7 \$2931 VSS nfet_03v3 L=0.28U W=0.36U AS=0.1854P AD=0.1584P
+ PS=1.75U PD=1.6U
M$4506 VSS RA6 \$3194 VSS nfet_03v3 L=0.28U W=0.36U AS=0.1854P AD=0.1584P
+ PS=1.75U PD=1.6U
M$4507 \$3298 WE6 VSS VSS nfet_03v3 L=0.28U W=0.72U AS=0.3168P AD=0.1872P
+ PS=2.32U PD=1.24U
M$4508 \$3093 CLK \$3298 VSS nfet_03v3 L=0.28U W=0.72U AS=0.1872P AD=0.3168P
+ PS=1.24U PD=2.32U
M$4509 \$3095 \$3093 VSS VSS nfet_03v3 L=0.28U W=0.635U AS=0.2794P AD=0.1651P
+ PS=2.15U PD=1.155U
M$4510 \$3095 \$3093 VSS VSS nfet_03v3 L=0.28U W=0.635U AS=0.1693P AD=0.1651P
+ PS=1.19U PD=1.155U
M$4511 \$3096 \$3095 VSS VSS nfet_03v3 L=0.28U W=0.67U AS=0.1693P AD=0.1943P
+ PS=1.19U PD=1.25U
M$4512 VSS \$3095 \$3096 VSS nfet_03v3 L=0.28U W=0.67U AS=0.1943P AD=0.2948P
+ PS=1.25U PD=2.22U
M$4513 \$3099 \$106 VSS VSS nfet_03v3 L=0.28U W=0.36U AS=0.1584P AD=0.1188P
+ PS=1.6U PD=1.02U
M$4514 \$3100 \$3095 \$3099 VSS nfet_03v3 L=0.28U W=0.36U AS=0.1188P AD=0.1278P
+ PS=1.02U PD=1.07U
M$4515 \$3303 \$3101 \$3100 VSS nfet_03v3 L=0.28U W=0.36U AS=0.1278P AD=0.0567P
+ PS=1.07U PD=0.675U
M$4516 VSS \$3096 \$3303 VSS nfet_03v3 L=0.28U W=0.36U AS=0.0567P AD=0.1584P
+ PS=0.675U PD=1.6U
M$4517 VSS \$3100 \$3101 VSS nfet_03v3 L=0.28U W=0.36U AS=0.1584P AD=0.0972P
+ PS=1.6U PD=0.9U
M$4518 \$3102 \$3100 VSS VSS nfet_03v3 L=0.28U W=0.36U AS=0.0972P AD=0.18P
+ PS=0.9U PD=1.72U
M$4519 \$3105 \$109 VSS VSS nfet_03v3 L=0.28U W=0.36U AS=0.1584P AD=0.1188P
+ PS=1.6U PD=1.02U
M$4520 \$3106 \$3095 \$3105 VSS nfet_03v3 L=0.28U W=0.36U AS=0.1188P AD=0.1278P
+ PS=1.02U PD=1.07U
M$4521 \$3312 \$3107 \$3106 VSS nfet_03v3 L=0.28U W=0.36U AS=0.1278P AD=0.0567P
+ PS=1.07U PD=0.675U
M$4522 VSS \$3096 \$3312 VSS nfet_03v3 L=0.28U W=0.36U AS=0.0567P AD=0.1584P
+ PS=0.675U PD=1.6U
M$4523 VSS \$3106 \$3107 VSS nfet_03v3 L=0.28U W=0.36U AS=0.1584P AD=0.0972P
+ PS=1.6U PD=0.9U
M$4524 \$3108 \$3106 VSS VSS nfet_03v3 L=0.28U W=0.36U AS=0.0972P AD=0.18P
+ PS=0.9U PD=1.72U
M$4525 \$3111 \$112 VSS VSS nfet_03v3 L=0.28U W=0.36U AS=0.1584P AD=0.1188P
+ PS=1.6U PD=1.02U
M$4526 \$3112 \$3095 \$3111 VSS nfet_03v3 L=0.28U W=0.36U AS=0.1188P AD=0.1278P
+ PS=1.02U PD=1.07U
M$4527 \$3318 \$3113 \$3112 VSS nfet_03v3 L=0.28U W=0.36U AS=0.1278P AD=0.0567P
+ PS=1.07U PD=0.675U
M$4528 VSS \$3096 \$3318 VSS nfet_03v3 L=0.28U W=0.36U AS=0.0567P AD=0.1584P
+ PS=0.675U PD=1.6U
M$4529 VSS \$3112 \$3113 VSS nfet_03v3 L=0.28U W=0.36U AS=0.1584P AD=0.0972P
+ PS=1.6U PD=0.9U
M$4530 \$3114 \$3112 VSS VSS nfet_03v3 L=0.28U W=0.36U AS=0.0972P AD=0.18P
+ PS=0.9U PD=1.72U
M$4531 \$3117 \$115 VSS VSS nfet_03v3 L=0.28U W=0.36U AS=0.1584P AD=0.1188P
+ PS=1.6U PD=1.02U
M$4532 \$3118 \$3095 \$3117 VSS nfet_03v3 L=0.28U W=0.36U AS=0.1188P AD=0.1278P
+ PS=1.02U PD=1.07U
M$4533 \$3326 \$3119 \$3118 VSS nfet_03v3 L=0.28U W=0.36U AS=0.1278P AD=0.0567P
+ PS=1.07U PD=0.675U
M$4534 VSS \$3096 \$3326 VSS nfet_03v3 L=0.28U W=0.36U AS=0.0567P AD=0.1584P
+ PS=0.675U PD=1.6U
M$4535 VSS \$3118 \$3119 VSS nfet_03v3 L=0.28U W=0.36U AS=0.1584P AD=0.0972P
+ PS=1.6U PD=0.9U
M$4536 \$3120 \$3118 VSS VSS nfet_03v3 L=0.28U W=0.36U AS=0.0972P AD=0.18P
+ PS=0.9U PD=1.72U
M$4537 \$3123 \$118 VSS VSS nfet_03v3 L=0.28U W=0.36U AS=0.1584P AD=0.1188P
+ PS=1.6U PD=1.02U
M$4538 \$3124 \$3095 \$3123 VSS nfet_03v3 L=0.28U W=0.36U AS=0.1188P AD=0.1278P
+ PS=1.02U PD=1.07U
M$4539 \$3336 \$3125 \$3124 VSS nfet_03v3 L=0.28U W=0.36U AS=0.1278P AD=0.0567P
+ PS=1.07U PD=0.675U
M$4540 VSS \$3096 \$3336 VSS nfet_03v3 L=0.28U W=0.36U AS=0.0567P AD=0.1584P
+ PS=0.675U PD=1.6U
M$4541 VSS \$3124 \$3125 VSS nfet_03v3 L=0.28U W=0.36U AS=0.1584P AD=0.0972P
+ PS=1.6U PD=0.9U
M$4542 \$3126 \$3124 VSS VSS nfet_03v3 L=0.28U W=0.36U AS=0.0972P AD=0.18P
+ PS=0.9U PD=1.72U
M$4543 \$3129 \$121 VSS VSS nfet_03v3 L=0.28U W=0.36U AS=0.1584P AD=0.1188P
+ PS=1.6U PD=1.02U
M$4544 \$3130 \$3095 \$3129 VSS nfet_03v3 L=0.28U W=0.36U AS=0.1188P AD=0.1278P
+ PS=1.02U PD=1.07U
M$4545 \$3342 \$3131 \$3130 VSS nfet_03v3 L=0.28U W=0.36U AS=0.1278P AD=0.0567P
+ PS=1.07U PD=0.675U
M$4546 VSS \$3096 \$3342 VSS nfet_03v3 L=0.28U W=0.36U AS=0.0567P AD=0.1584P
+ PS=0.675U PD=1.6U
M$4547 VSS \$3130 \$3131 VSS nfet_03v3 L=0.28U W=0.36U AS=0.1584P AD=0.0972P
+ PS=1.6U PD=0.9U
M$4548 \$3132 \$3130 VSS VSS nfet_03v3 L=0.28U W=0.36U AS=0.0972P AD=0.18P
+ PS=0.9U PD=1.72U
M$4549 \$3135 \$124 VSS VSS nfet_03v3 L=0.28U W=0.36U AS=0.1584P AD=0.1188P
+ PS=1.6U PD=1.02U
M$4550 \$3136 \$3095 \$3135 VSS nfet_03v3 L=0.28U W=0.36U AS=0.1188P AD=0.1278P
+ PS=1.02U PD=1.07U
M$4551 \$3350 \$3137 \$3136 VSS nfet_03v3 L=0.28U W=0.36U AS=0.1278P AD=0.0567P
+ PS=1.07U PD=0.675U
M$4552 VSS \$3096 \$3350 VSS nfet_03v3 L=0.28U W=0.36U AS=0.0567P AD=0.1584P
+ PS=0.675U PD=1.6U
M$4553 VSS \$3136 \$3137 VSS nfet_03v3 L=0.28U W=0.36U AS=0.1584P AD=0.0972P
+ PS=1.6U PD=0.9U
M$4554 \$3138 \$3136 VSS VSS nfet_03v3 L=0.28U W=0.36U AS=0.0972P AD=0.18P
+ PS=0.9U PD=1.72U
M$4555 \$3141 \$127 VSS VSS nfet_03v3 L=0.28U W=0.36U AS=0.1584P AD=0.1188P
+ PS=1.6U PD=1.02U
M$4556 \$3142 \$3095 \$3141 VSS nfet_03v3 L=0.28U W=0.36U AS=0.1188P AD=0.1278P
+ PS=1.02U PD=1.07U
M$4557 \$3360 \$3143 \$3142 VSS nfet_03v3 L=0.28U W=0.36U AS=0.1278P AD=0.0567P
+ PS=1.07U PD=0.675U
M$4558 VSS \$3096 \$3360 VSS nfet_03v3 L=0.28U W=0.36U AS=0.0567P AD=0.1584P
+ PS=0.675U PD=1.6U
M$4559 VSS \$3142 \$3143 VSS nfet_03v3 L=0.28U W=0.36U AS=0.1584P AD=0.0972P
+ PS=1.6U PD=0.9U
M$4560 \$3144 \$3142 VSS VSS nfet_03v3 L=0.28U W=0.36U AS=0.0972P AD=0.18P
+ PS=0.9U PD=1.72U
M$4561 \$3147 \$130 VSS VSS nfet_03v3 L=0.28U W=0.36U AS=0.1584P AD=0.1188P
+ PS=1.6U PD=1.02U
M$4562 \$3148 \$3095 \$3147 VSS nfet_03v3 L=0.28U W=0.36U AS=0.1188P AD=0.1278P
+ PS=1.02U PD=1.07U
M$4563 \$3366 \$3149 \$3148 VSS nfet_03v3 L=0.28U W=0.36U AS=0.1278P AD=0.0567P
+ PS=1.07U PD=0.675U
M$4564 VSS \$3096 \$3366 VSS nfet_03v3 L=0.28U W=0.36U AS=0.0567P AD=0.1584P
+ PS=0.675U PD=1.6U
M$4565 VSS \$3148 \$3149 VSS nfet_03v3 L=0.28U W=0.36U AS=0.1584P AD=0.0972P
+ PS=1.6U PD=0.9U
M$4566 \$3150 \$3148 VSS VSS nfet_03v3 L=0.28U W=0.36U AS=0.0972P AD=0.18P
+ PS=0.9U PD=1.72U
M$4567 \$3153 \$133 VSS VSS nfet_03v3 L=0.28U W=0.36U AS=0.1584P AD=0.1188P
+ PS=1.6U PD=1.02U
M$4568 \$3154 \$3095 \$3153 VSS nfet_03v3 L=0.28U W=0.36U AS=0.1188P AD=0.1278P
+ PS=1.02U PD=1.07U
M$4569 \$3374 \$3155 \$3154 VSS nfet_03v3 L=0.28U W=0.36U AS=0.1278P AD=0.0567P
+ PS=1.07U PD=0.675U
M$4570 VSS \$3096 \$3374 VSS nfet_03v3 L=0.28U W=0.36U AS=0.0567P AD=0.1584P
+ PS=0.675U PD=1.6U
M$4571 VSS \$3154 \$3155 VSS nfet_03v3 L=0.28U W=0.36U AS=0.1584P AD=0.0972P
+ PS=1.6U PD=0.9U
M$4572 \$3156 \$3154 VSS VSS nfet_03v3 L=0.28U W=0.36U AS=0.0972P AD=0.18P
+ PS=0.9U PD=1.72U
M$4573 \$3159 \$136 VSS VSS nfet_03v3 L=0.28U W=0.36U AS=0.1584P AD=0.1188P
+ PS=1.6U PD=1.02U
M$4574 \$3160 \$3095 \$3159 VSS nfet_03v3 L=0.28U W=0.36U AS=0.1188P AD=0.1278P
+ PS=1.02U PD=1.07U
M$4575 \$3382 \$3161 \$3160 VSS nfet_03v3 L=0.28U W=0.36U AS=0.1278P AD=0.0567P
+ PS=1.07U PD=0.675U
M$4576 VSS \$3096 \$3382 VSS nfet_03v3 L=0.28U W=0.36U AS=0.0567P AD=0.1584P
+ PS=0.675U PD=1.6U
M$4577 VSS \$3160 \$3161 VSS nfet_03v3 L=0.28U W=0.36U AS=0.1584P AD=0.0972P
+ PS=1.6U PD=0.9U
M$4578 \$3162 \$3160 VSS VSS nfet_03v3 L=0.28U W=0.36U AS=0.0972P AD=0.18P
+ PS=0.9U PD=1.72U
M$4579 \$3165 \$139 VSS VSS nfet_03v3 L=0.28U W=0.36U AS=0.1584P AD=0.1188P
+ PS=1.6U PD=1.02U
M$4580 \$3166 \$3095 \$3165 VSS nfet_03v3 L=0.28U W=0.36U AS=0.1188P AD=0.1278P
+ PS=1.02U PD=1.07U
M$4581 \$3390 \$3167 \$3166 VSS nfet_03v3 L=0.28U W=0.36U AS=0.1278P AD=0.0567P
+ PS=1.07U PD=0.675U
M$4582 VSS \$3096 \$3390 VSS nfet_03v3 L=0.28U W=0.36U AS=0.0567P AD=0.1584P
+ PS=0.675U PD=1.6U
M$4583 VSS \$3166 \$3167 VSS nfet_03v3 L=0.28U W=0.36U AS=0.1584P AD=0.0972P
+ PS=1.6U PD=0.9U
M$4584 \$3168 \$3166 VSS VSS nfet_03v3 L=0.28U W=0.36U AS=0.0972P AD=0.18P
+ PS=0.9U PD=1.72U
M$4585 \$3171 \$142 VSS VSS nfet_03v3 L=0.28U W=0.36U AS=0.1584P AD=0.1188P
+ PS=1.6U PD=1.02U
M$4586 \$3172 \$3095 \$3171 VSS nfet_03v3 L=0.28U W=0.36U AS=0.1188P AD=0.1278P
+ PS=1.02U PD=1.07U
M$4587 \$3385 \$3173 \$3172 VSS nfet_03v3 L=0.28U W=0.36U AS=0.1278P AD=0.0567P
+ PS=1.07U PD=0.675U
M$4588 VSS \$3096 \$3385 VSS nfet_03v3 L=0.28U W=0.36U AS=0.0567P AD=0.1584P
+ PS=0.675U PD=1.6U
M$4589 VSS \$3172 \$3173 VSS nfet_03v3 L=0.28U W=0.36U AS=0.1584P AD=0.0972P
+ PS=1.6U PD=0.9U
M$4590 \$3174 \$3172 VSS VSS nfet_03v3 L=0.28U W=0.36U AS=0.0972P AD=0.18P
+ PS=0.9U PD=1.72U
M$4591 \$3177 \$145 VSS VSS nfet_03v3 L=0.28U W=0.36U AS=0.1584P AD=0.1188P
+ PS=1.6U PD=1.02U
M$4592 \$3178 \$3095 \$3177 VSS nfet_03v3 L=0.28U W=0.36U AS=0.1188P AD=0.1278P
+ PS=1.02U PD=1.07U
M$4593 \$3359 \$3179 \$3178 VSS nfet_03v3 L=0.28U W=0.36U AS=0.1278P AD=0.0567P
+ PS=1.07U PD=0.675U
M$4594 VSS \$3096 \$3359 VSS nfet_03v3 L=0.28U W=0.36U AS=0.0567P AD=0.1584P
+ PS=0.675U PD=1.6U
M$4595 VSS \$3178 \$3179 VSS nfet_03v3 L=0.28U W=0.36U AS=0.1584P AD=0.0972P
+ PS=1.6U PD=0.9U
M$4596 \$3180 \$3178 VSS VSS nfet_03v3 L=0.28U W=0.36U AS=0.0972P AD=0.18P
+ PS=0.9U PD=1.72U
M$4597 \$3183 \$148 VSS VSS nfet_03v3 L=0.28U W=0.36U AS=0.1584P AD=0.1188P
+ PS=1.6U PD=1.02U
M$4598 \$3184 \$3095 \$3183 VSS nfet_03v3 L=0.28U W=0.36U AS=0.1188P AD=0.1278P
+ PS=1.02U PD=1.07U
M$4599 \$3335 \$3185 \$3184 VSS nfet_03v3 L=0.28U W=0.36U AS=0.1278P AD=0.0567P
+ PS=1.07U PD=0.675U
M$4600 VSS \$3096 \$3335 VSS nfet_03v3 L=0.28U W=0.36U AS=0.0567P AD=0.1584P
+ PS=0.675U PD=1.6U
M$4601 VSS \$3184 \$3185 VSS nfet_03v3 L=0.28U W=0.36U AS=0.1584P AD=0.0972P
+ PS=1.6U PD=0.9U
M$4602 \$3186 \$3184 VSS VSS nfet_03v3 L=0.28U W=0.36U AS=0.0972P AD=0.18P
+ PS=0.9U PD=1.72U
M$4603 \$3189 \$151 VSS VSS nfet_03v3 L=0.28U W=0.36U AS=0.1584P AD=0.1188P
+ PS=1.6U PD=1.02U
M$4604 \$3190 \$3095 \$3189 VSS nfet_03v3 L=0.28U W=0.36U AS=0.1188P AD=0.1278P
+ PS=1.02U PD=1.07U
M$4605 \$3311 \$3191 \$3190 VSS nfet_03v3 L=0.28U W=0.36U AS=0.1278P AD=0.0567P
+ PS=1.07U PD=0.675U
M$4606 VSS \$3096 \$3311 VSS nfet_03v3 L=0.28U W=0.36U AS=0.0567P AD=0.1584P
+ PS=0.675U PD=1.6U
M$4607 VSS \$3190 \$3191 VSS nfet_03v3 L=0.28U W=0.36U AS=0.1584P AD=0.0972P
+ PS=1.6U PD=0.9U
M$4608 \$3192 \$3190 VSS VSS nfet_03v3 L=0.28U W=0.36U AS=0.0972P AD=0.18P
+ PS=0.9U PD=1.72U
M$4609 \$3545 WE5 VSS VSS nfet_03v3 L=0.28U W=0.72U AS=0.3168P AD=0.1872P
+ PS=2.32U PD=1.24U
M$4610 \$3396 CLK \$3545 VSS nfet_03v3 L=0.28U W=0.72U AS=0.1872P AD=0.3168P
+ PS=1.24U PD=2.32U
M$4611 \$3397 \$3396 VSS VSS nfet_03v3 L=0.28U W=0.635U AS=0.2794P AD=0.1651P
+ PS=2.15U PD=1.155U
M$4612 VSS \$3396 \$3397 VSS nfet_03v3 L=0.28U W=0.635U AS=0.1651P AD=0.1693P
+ PS=1.155U PD=1.19U
M$4613 \$3398 \$3397 VSS VSS nfet_03v3 L=0.28U W=0.67U AS=0.1693P AD=0.1943P
+ PS=1.19U PD=1.25U
M$4614 VSS \$3397 \$3398 VSS nfet_03v3 L=0.28U W=0.67U AS=0.1943P AD=0.2948P
+ PS=1.25U PD=2.22U
M$4615 \$3399 \$106 VSS VSS nfet_03v3 L=0.28U W=0.36U AS=0.1584P AD=0.1188P
+ PS=1.6U PD=1.02U
M$4616 \$3400 \$3397 \$3399 VSS nfet_03v3 L=0.28U W=0.36U AS=0.1188P AD=0.1278P
+ PS=1.02U PD=1.07U
M$4617 \$3467 \$3401 \$3400 VSS nfet_03v3 L=0.28U W=0.36U AS=0.1278P AD=0.0567P
+ PS=1.07U PD=0.675U
M$4618 VSS \$3398 \$3467 VSS nfet_03v3 L=0.28U W=0.36U AS=0.0567P AD=0.1584P
+ PS=0.675U PD=1.6U
M$4619 VSS \$3400 \$3401 VSS nfet_03v3 L=0.28U W=0.36U AS=0.1584P AD=0.0972P
+ PS=1.6U PD=0.9U
M$4620 \$3402 \$3400 VSS VSS nfet_03v3 L=0.28U W=0.36U AS=0.0972P AD=0.18P
+ PS=0.9U PD=1.72U
M$4621 \$3403 \$109 VSS VSS nfet_03v3 L=0.28U W=0.36U AS=0.1584P AD=0.1188P
+ PS=1.6U PD=1.02U
M$4622 \$3404 \$3397 \$3403 VSS nfet_03v3 L=0.28U W=0.36U AS=0.1188P AD=0.1278P
+ PS=1.02U PD=1.07U
M$4623 \$3476 \$3405 \$3404 VSS nfet_03v3 L=0.28U W=0.36U AS=0.1278P AD=0.0567P
+ PS=1.07U PD=0.675U
M$4624 VSS \$3398 \$3476 VSS nfet_03v3 L=0.28U W=0.36U AS=0.0567P AD=0.1584P
+ PS=0.675U PD=1.6U
M$4625 VSS \$3404 \$3405 VSS nfet_03v3 L=0.28U W=0.36U AS=0.1584P AD=0.0972P
+ PS=1.6U PD=0.9U
M$4626 \$3406 \$3404 VSS VSS nfet_03v3 L=0.28U W=0.36U AS=0.0972P AD=0.18P
+ PS=0.9U PD=1.72U
M$4627 \$3407 \$112 VSS VSS nfet_03v3 L=0.28U W=0.36U AS=0.1584P AD=0.1188P
+ PS=1.6U PD=1.02U
M$4628 \$3408 \$3397 \$3407 VSS nfet_03v3 L=0.28U W=0.36U AS=0.1188P AD=0.1278P
+ PS=1.02U PD=1.07U
M$4629 \$3484 \$3409 \$3408 VSS nfet_03v3 L=0.28U W=0.36U AS=0.1278P AD=0.0567P
+ PS=1.07U PD=0.675U
M$4630 VSS \$3398 \$3484 VSS nfet_03v3 L=0.28U W=0.36U AS=0.0567P AD=0.1584P
+ PS=0.675U PD=1.6U
M$4631 VSS \$3408 \$3409 VSS nfet_03v3 L=0.28U W=0.36U AS=0.1584P AD=0.0972P
+ PS=1.6U PD=0.9U
M$4632 \$3410 \$3408 VSS VSS nfet_03v3 L=0.28U W=0.36U AS=0.0972P AD=0.18P
+ PS=0.9U PD=1.72U
M$4633 \$3411 \$115 VSS VSS nfet_03v3 L=0.28U W=0.36U AS=0.1584P AD=0.1188P
+ PS=1.6U PD=1.02U
M$4634 \$3412 \$3397 \$3411 VSS nfet_03v3 L=0.28U W=0.36U AS=0.1188P AD=0.1278P
+ PS=1.02U PD=1.07U
M$4635 \$3493 \$3413 \$3412 VSS nfet_03v3 L=0.28U W=0.36U AS=0.1278P AD=0.0567P
+ PS=1.07U PD=0.675U
M$4636 VSS \$3398 \$3493 VSS nfet_03v3 L=0.28U W=0.36U AS=0.0567P AD=0.1584P
+ PS=0.675U PD=1.6U
M$4637 VSS \$3412 \$3413 VSS nfet_03v3 L=0.28U W=0.36U AS=0.1584P AD=0.0972P
+ PS=1.6U PD=0.9U
M$4638 \$3414 \$3412 VSS VSS nfet_03v3 L=0.28U W=0.36U AS=0.0972P AD=0.18P
+ PS=0.9U PD=1.72U
M$4639 \$3415 \$118 VSS VSS nfet_03v3 L=0.28U W=0.36U AS=0.1584P AD=0.1188P
+ PS=1.6U PD=1.02U
M$4640 \$3416 \$3397 \$3415 VSS nfet_03v3 L=0.28U W=0.36U AS=0.1188P AD=0.1278P
+ PS=1.02U PD=1.07U
M$4641 \$3500 \$3417 \$3416 VSS nfet_03v3 L=0.28U W=0.36U AS=0.1278P AD=0.0567P
+ PS=1.07U PD=0.675U
M$4642 VSS \$3398 \$3500 VSS nfet_03v3 L=0.28U W=0.36U AS=0.0567P AD=0.1584P
+ PS=0.675U PD=1.6U
M$4643 VSS \$3416 \$3417 VSS nfet_03v3 L=0.28U W=0.36U AS=0.1584P AD=0.0972P
+ PS=1.6U PD=0.9U
M$4644 \$3418 \$3416 VSS VSS nfet_03v3 L=0.28U W=0.36U AS=0.0972P AD=0.18P
+ PS=0.9U PD=1.72U
M$4645 \$3419 \$121 VSS VSS nfet_03v3 L=0.28U W=0.36U AS=0.1584P AD=0.1188P
+ PS=1.6U PD=1.02U
M$4646 \$3420 \$3397 \$3419 VSS nfet_03v3 L=0.28U W=0.36U AS=0.1188P AD=0.1278P
+ PS=1.02U PD=1.07U
M$4647 \$3508 \$3421 \$3420 VSS nfet_03v3 L=0.28U W=0.36U AS=0.1278P AD=0.0567P
+ PS=1.07U PD=0.675U
M$4648 VSS \$3398 \$3508 VSS nfet_03v3 L=0.28U W=0.36U AS=0.0567P AD=0.1584P
+ PS=0.675U PD=1.6U
M$4649 VSS \$3420 \$3421 VSS nfet_03v3 L=0.28U W=0.36U AS=0.1584P AD=0.0972P
+ PS=1.6U PD=0.9U
M$4650 \$3422 \$3420 VSS VSS nfet_03v3 L=0.28U W=0.36U AS=0.0972P AD=0.18P
+ PS=0.9U PD=1.72U
M$4651 \$3423 \$124 VSS VSS nfet_03v3 L=0.28U W=0.36U AS=0.1584P AD=0.1188P
+ PS=1.6U PD=1.02U
M$4652 \$3424 \$3397 \$3423 VSS nfet_03v3 L=0.28U W=0.36U AS=0.1188P AD=0.1278P
+ PS=1.02U PD=1.07U
M$4653 \$3507 \$3425 \$3424 VSS nfet_03v3 L=0.28U W=0.36U AS=0.1278P AD=0.0567P
+ PS=1.07U PD=0.675U
M$4654 VSS \$3398 \$3507 VSS nfet_03v3 L=0.28U W=0.36U AS=0.0567P AD=0.1584P
+ PS=0.675U PD=1.6U
M$4655 VSS \$3424 \$3425 VSS nfet_03v3 L=0.28U W=0.36U AS=0.1584P AD=0.0972P
+ PS=1.6U PD=0.9U
M$4656 \$3426 \$3424 VSS VSS nfet_03v3 L=0.28U W=0.36U AS=0.0972P AD=0.18P
+ PS=0.9U PD=1.72U
M$4657 \$3427 \$127 VSS VSS nfet_03v3 L=0.28U W=0.36U AS=0.1584P AD=0.1188P
+ PS=1.6U PD=1.02U
M$4658 \$3428 \$3397 \$3427 VSS nfet_03v3 L=0.28U W=0.36U AS=0.1188P AD=0.1278P
+ PS=1.02U PD=1.07U
M$4659 \$3504 \$3429 \$3428 VSS nfet_03v3 L=0.28U W=0.36U AS=0.1278P AD=0.0567P
+ PS=1.07U PD=0.675U
M$4660 VSS \$3398 \$3504 VSS nfet_03v3 L=0.28U W=0.36U AS=0.0567P AD=0.1584P
+ PS=0.675U PD=1.6U
M$4661 VSS \$3428 \$3429 VSS nfet_03v3 L=0.28U W=0.36U AS=0.1584P AD=0.0972P
+ PS=1.6U PD=0.9U
M$4662 \$3430 \$3428 VSS VSS nfet_03v3 L=0.28U W=0.36U AS=0.0972P AD=0.18P
+ PS=0.9U PD=1.72U
M$4663 \$3431 \$130 VSS VSS nfet_03v3 L=0.28U W=0.36U AS=0.1584P AD=0.1188P
+ PS=1.6U PD=1.02U
M$4664 \$3432 \$3397 \$3431 VSS nfet_03v3 L=0.28U W=0.36U AS=0.1188P AD=0.1278P
+ PS=1.02U PD=1.07U
M$4665 \$3498 \$3433 \$3432 VSS nfet_03v3 L=0.28U W=0.36U AS=0.1278P AD=0.0567P
+ PS=1.07U PD=0.675U
M$4666 VSS \$3398 \$3498 VSS nfet_03v3 L=0.28U W=0.36U AS=0.0567P AD=0.1584P
+ PS=0.675U PD=1.6U
M$4667 VSS \$3432 \$3433 VSS nfet_03v3 L=0.28U W=0.36U AS=0.1584P AD=0.0972P
+ PS=1.6U PD=0.9U
M$4668 \$3434 \$3432 VSS VSS nfet_03v3 L=0.28U W=0.36U AS=0.0972P AD=0.18P
+ PS=0.9U PD=1.72U
M$4669 \$3435 \$133 VSS VSS nfet_03v3 L=0.28U W=0.36U AS=0.1584P AD=0.1188P
+ PS=1.6U PD=1.02U
M$4670 \$3436 \$3397 \$3435 VSS nfet_03v3 L=0.28U W=0.36U AS=0.1188P AD=0.1278P
+ PS=1.02U PD=1.07U
M$4671 \$3492 \$3437 \$3436 VSS nfet_03v3 L=0.28U W=0.36U AS=0.1278P AD=0.0567P
+ PS=1.07U PD=0.675U
M$4672 VSS \$3398 \$3492 VSS nfet_03v3 L=0.28U W=0.36U AS=0.0567P AD=0.1584P
+ PS=0.675U PD=1.6U
M$4673 VSS \$3436 \$3437 VSS nfet_03v3 L=0.28U W=0.36U AS=0.1584P AD=0.0972P
+ PS=1.6U PD=0.9U
M$4674 \$3438 \$3436 VSS VSS nfet_03v3 L=0.28U W=0.36U AS=0.0972P AD=0.18P
+ PS=0.9U PD=1.72U
M$4675 \$3439 \$136 VSS VSS nfet_03v3 L=0.28U W=0.36U AS=0.1584P AD=0.1188P
+ PS=1.6U PD=1.02U
M$4676 \$3440 \$3397 \$3439 VSS nfet_03v3 L=0.28U W=0.36U AS=0.1188P AD=0.1278P
+ PS=1.02U PD=1.07U
M$4677 \$3489 \$3441 \$3440 VSS nfet_03v3 L=0.28U W=0.36U AS=0.1278P AD=0.0567P
+ PS=1.07U PD=0.675U
M$4678 VSS \$3398 \$3489 VSS nfet_03v3 L=0.28U W=0.36U AS=0.0567P AD=0.1584P
+ PS=0.675U PD=1.6U
M$4679 VSS \$3440 \$3441 VSS nfet_03v3 L=0.28U W=0.36U AS=0.1584P AD=0.0972P
+ PS=1.6U PD=0.9U
M$4680 \$3442 \$3440 VSS VSS nfet_03v3 L=0.28U W=0.36U AS=0.0972P AD=0.18P
+ PS=0.9U PD=1.72U
M$4681 \$3443 \$139 VSS VSS nfet_03v3 L=0.28U W=0.36U AS=0.1584P AD=0.1188P
+ PS=1.6U PD=1.02U
M$4682 \$3444 \$3397 \$3443 VSS nfet_03v3 L=0.28U W=0.36U AS=0.1188P AD=0.1278P
+ PS=1.02U PD=1.07U
M$4683 \$3483 \$3445 \$3444 VSS nfet_03v3 L=0.28U W=0.36U AS=0.1278P AD=0.0567P
+ PS=1.07U PD=0.675U
M$4684 VSS \$3398 \$3483 VSS nfet_03v3 L=0.28U W=0.36U AS=0.0567P AD=0.1584P
+ PS=0.675U PD=1.6U
M$4685 VSS \$3444 \$3445 VSS nfet_03v3 L=0.28U W=0.36U AS=0.1584P AD=0.0972P
+ PS=1.6U PD=0.9U
M$4686 \$3446 \$3444 VSS VSS nfet_03v3 L=0.28U W=0.36U AS=0.0972P AD=0.18P
+ PS=0.9U PD=1.72U
M$4687 \$3447 \$142 VSS VSS nfet_03v3 L=0.28U W=0.36U AS=0.1584P AD=0.1188P
+ PS=1.6U PD=1.02U
M$4688 \$3448 \$3397 \$3447 VSS nfet_03v3 L=0.28U W=0.36U AS=0.1188P AD=0.1278P
+ PS=1.02U PD=1.07U
M$4689 \$3480 \$3449 \$3448 VSS nfet_03v3 L=0.28U W=0.36U AS=0.1278P AD=0.0567P
+ PS=1.07U PD=0.675U
M$4690 VSS \$3398 \$3480 VSS nfet_03v3 L=0.28U W=0.36U AS=0.0567P AD=0.1584P
+ PS=0.675U PD=1.6U
M$4691 VSS \$3448 \$3449 VSS nfet_03v3 L=0.28U W=0.36U AS=0.1584P AD=0.0972P
+ PS=1.6U PD=0.9U
M$4692 \$3450 \$3448 VSS VSS nfet_03v3 L=0.28U W=0.36U AS=0.0972P AD=0.18P
+ PS=0.9U PD=1.72U
M$4693 \$3451 \$145 VSS VSS nfet_03v3 L=0.28U W=0.36U AS=0.1584P AD=0.1188P
+ PS=1.6U PD=1.02U
M$4694 \$3452 \$3397 \$3451 VSS nfet_03v3 L=0.28U W=0.36U AS=0.1188P AD=0.1278P
+ PS=1.02U PD=1.07U
M$4695 \$3474 \$3453 \$3452 VSS nfet_03v3 L=0.28U W=0.36U AS=0.1278P AD=0.0567P
+ PS=1.07U PD=0.675U
M$4696 VSS \$3398 \$3474 VSS nfet_03v3 L=0.28U W=0.36U AS=0.0567P AD=0.1584P
+ PS=0.675U PD=1.6U
M$4697 VSS \$3452 \$3453 VSS nfet_03v3 L=0.28U W=0.36U AS=0.1584P AD=0.0972P
+ PS=1.6U PD=0.9U
M$4698 \$3454 \$3452 VSS VSS nfet_03v3 L=0.28U W=0.36U AS=0.0972P AD=0.18P
+ PS=0.9U PD=1.72U
M$4699 \$3455 \$148 VSS VSS nfet_03v3 L=0.28U W=0.36U AS=0.1584P AD=0.1188P
+ PS=1.6U PD=1.02U
M$4700 \$3456 \$3397 \$3455 VSS nfet_03v3 L=0.28U W=0.36U AS=0.1188P AD=0.1278P
+ PS=1.02U PD=1.07U
M$4701 \$3470 \$3457 \$3456 VSS nfet_03v3 L=0.28U W=0.36U AS=0.1278P AD=0.0567P
+ PS=1.07U PD=0.675U
M$4702 VSS \$3398 \$3470 VSS nfet_03v3 L=0.28U W=0.36U AS=0.0567P AD=0.1584P
+ PS=0.675U PD=1.6U
M$4703 VSS \$3456 \$3457 VSS nfet_03v3 L=0.28U W=0.36U AS=0.1584P AD=0.0972P
+ PS=1.6U PD=0.9U
M$4704 \$3458 \$3456 VSS VSS nfet_03v3 L=0.28U W=0.36U AS=0.0972P AD=0.18P
+ PS=0.9U PD=1.72U
M$4705 \$3459 \$151 VSS VSS nfet_03v3 L=0.28U W=0.36U AS=0.1584P AD=0.1188P
+ PS=1.6U PD=1.02U
M$4706 \$3460 \$3397 \$3459 VSS nfet_03v3 L=0.28U W=0.36U AS=0.1188P AD=0.1278P
+ PS=1.02U PD=1.07U
M$4707 \$3465 \$3461 \$3460 VSS nfet_03v3 L=0.28U W=0.36U AS=0.1278P AD=0.0567P
+ PS=1.07U PD=0.675U
M$4708 VSS \$3398 \$3465 VSS nfet_03v3 L=0.28U W=0.36U AS=0.0567P AD=0.1584P
+ PS=0.675U PD=1.6U
M$4709 VSS \$3460 \$3461 VSS nfet_03v3 L=0.28U W=0.36U AS=0.1584P AD=0.0972P
+ PS=1.6U PD=0.9U
M$4710 \$3462 \$3460 VSS VSS nfet_03v3 L=0.28U W=0.36U AS=0.0972P AD=0.18P
+ PS=0.9U PD=1.72U
M$4711 \$3513 RA5 VSS VSS nfet_03v3 L=0.28U W=0.36U AS=0.1656P AD=0.1944P
+ PS=1.64U PD=1.8U
M$4712 \$3716 RB4 VSS VSS nfet_03v3 L=0.28U W=0.36U AS=0.1656P AD=0.1944P
+ PS=1.64U PD=1.8U
M$4713 \$3715 RB4 \$51 VSS nfet_03v3 L=0.28U W=0.36U AS=0.1584P AD=0.1152P
+ PS=1.6U PD=1U
M$4714 \$52 RA4 \$3715 VSS nfet_03v3 L=0.28U W=0.36U AS=0.1152P AD=0.1584P
+ PS=1U PD=1.6U
M$4715 \$3402 RA5 \$51 VSS nfet_03v3 L=0.28U W=0.36U AS=0.1584P AD=0.1152P
+ PS=1.6U PD=1U
M$4716 \$52 RB5 \$3402 VSS nfet_03v3 L=0.28U W=0.36U AS=0.1152P AD=0.1584P
+ PS=1U PD=1.6U
M$4717 VSS RA4 \$3717 VSS nfet_03v3 L=0.28U W=0.36U AS=0.1854P AD=0.1584P
+ PS=1.75U PD=1.6U
M$4718 VSS RB5 \$3514 VSS nfet_03v3 L=0.28U W=0.36U AS=0.1854P AD=0.1584P
+ PS=1.75U PD=1.6U
M$4719 \$3722 RB4 VSS VSS nfet_03v3 L=0.28U W=0.36U AS=0.1656P AD=0.1944P
+ PS=1.64U PD=1.8U
M$4720 \$3515 RA5 VSS VSS nfet_03v3 L=0.28U W=0.36U AS=0.1656P AD=0.1944P
+ PS=1.64U PD=1.8U
M$4721 \$3406 RA5 \$53 VSS nfet_03v3 L=0.28U W=0.36U AS=0.1584P AD=0.1152P
+ PS=1.6U PD=1U
M$4722 \$54 RB5 \$3406 VSS nfet_03v3 L=0.28U W=0.36U AS=0.1152P AD=0.1584P
+ PS=1U PD=1.6U
M$4723 \$3721 RB4 \$53 VSS nfet_03v3 L=0.28U W=0.36U AS=0.1584P AD=0.1152P
+ PS=1.6U PD=1U
M$4724 \$54 RA4 \$3721 VSS nfet_03v3 L=0.28U W=0.36U AS=0.1152P AD=0.1584P
+ PS=1U PD=1.6U
M$4725 VSS RB5 \$3516 VSS nfet_03v3 L=0.28U W=0.36U AS=0.1854P AD=0.1584P
+ PS=1.75U PD=1.6U
M$4726 VSS RA4 \$3723 VSS nfet_03v3 L=0.28U W=0.36U AS=0.1854P AD=0.1584P
+ PS=1.75U PD=1.6U
M$4727 \$3728 RB4 VSS VSS nfet_03v3 L=0.28U W=0.36U AS=0.1656P AD=0.1944P
+ PS=1.64U PD=1.8U
M$4728 \$3517 RA5 VSS VSS nfet_03v3 L=0.28U W=0.36U AS=0.1656P AD=0.1944P
+ PS=1.64U PD=1.8U
M$4729 \$3410 RA5 \$55 VSS nfet_03v3 L=0.28U W=0.36U AS=0.1584P AD=0.1152P
+ PS=1.6U PD=1U
M$4730 \$56 RB5 \$3410 VSS nfet_03v3 L=0.28U W=0.36U AS=0.1152P AD=0.1584P
+ PS=1U PD=1.6U
M$4731 \$3727 RB4 \$55 VSS nfet_03v3 L=0.28U W=0.36U AS=0.1584P AD=0.1152P
+ PS=1.6U PD=1U
M$4732 \$56 RA4 \$3727 VSS nfet_03v3 L=0.28U W=0.36U AS=0.1152P AD=0.1584P
+ PS=1U PD=1.6U
M$4733 VSS RB5 \$3518 VSS nfet_03v3 L=0.28U W=0.36U AS=0.1854P AD=0.1584P
+ PS=1.75U PD=1.6U
M$4734 VSS RA4 \$3729 VSS nfet_03v3 L=0.28U W=0.36U AS=0.1854P AD=0.1584P
+ PS=1.75U PD=1.6U
M$4735 \$3734 RB4 VSS VSS nfet_03v3 L=0.28U W=0.36U AS=0.1656P AD=0.1944P
+ PS=1.64U PD=1.8U
M$4736 \$3519 RA5 VSS VSS nfet_03v3 L=0.28U W=0.36U AS=0.1656P AD=0.1944P
+ PS=1.64U PD=1.8U
M$4737 \$3733 RB4 \$57 VSS nfet_03v3 L=0.28U W=0.36U AS=0.1584P AD=0.1152P
+ PS=1.6U PD=1U
M$4738 \$58 RA4 \$3733 VSS nfet_03v3 L=0.28U W=0.36U AS=0.1152P AD=0.1584P
+ PS=1U PD=1.6U
M$4739 \$3414 RA5 \$57 VSS nfet_03v3 L=0.28U W=0.36U AS=0.1584P AD=0.1152P
+ PS=1.6U PD=1U
M$4740 \$58 RB5 \$3414 VSS nfet_03v3 L=0.28U W=0.36U AS=0.1152P AD=0.1584P
+ PS=1U PD=1.6U
M$4741 VSS RA4 \$3735 VSS nfet_03v3 L=0.28U W=0.36U AS=0.1854P AD=0.1584P
+ PS=1.75U PD=1.6U
M$4742 VSS RB5 \$3520 VSS nfet_03v3 L=0.28U W=0.36U AS=0.1854P AD=0.1584P
+ PS=1.75U PD=1.6U
M$4743 \$3740 RB4 VSS VSS nfet_03v3 L=0.28U W=0.36U AS=0.1656P AD=0.1944P
+ PS=1.64U PD=1.8U
M$4744 \$3521 RA5 VSS VSS nfet_03v3 L=0.28U W=0.36U AS=0.1656P AD=0.1944P
+ PS=1.64U PD=1.8U
M$4745 \$3739 RB4 \$59 VSS nfet_03v3 L=0.28U W=0.36U AS=0.1584P AD=0.1152P
+ PS=1.6U PD=1U
M$4746 \$60 RA4 \$3739 VSS nfet_03v3 L=0.28U W=0.36U AS=0.1152P AD=0.1584P
+ PS=1U PD=1.6U
M$4747 \$3418 RA5 \$59 VSS nfet_03v3 L=0.28U W=0.36U AS=0.1584P AD=0.1152P
+ PS=1.6U PD=1U
M$4748 \$60 RB5 \$3418 VSS nfet_03v3 L=0.28U W=0.36U AS=0.1152P AD=0.1584P
+ PS=1U PD=1.6U
M$4749 VSS RB5 \$3522 VSS nfet_03v3 L=0.28U W=0.36U AS=0.1854P AD=0.1584P
+ PS=1.75U PD=1.6U
M$4750 VSS RA4 \$3741 VSS nfet_03v3 L=0.28U W=0.36U AS=0.1854P AD=0.1584P
+ PS=1.75U PD=1.6U
M$4751 \$3523 RA5 VSS VSS nfet_03v3 L=0.28U W=0.36U AS=0.1656P AD=0.1944P
+ PS=1.64U PD=1.8U
M$4752 \$3746 RB4 VSS VSS nfet_03v3 L=0.28U W=0.36U AS=0.1656P AD=0.1944P
+ PS=1.64U PD=1.8U
M$4753 \$3745 RB4 \$61 VSS nfet_03v3 L=0.28U W=0.36U AS=0.1584P AD=0.1152P
+ PS=1.6U PD=1U
M$4754 \$62 RA4 \$3745 VSS nfet_03v3 L=0.28U W=0.36U AS=0.1152P AD=0.1584P
+ PS=1U PD=1.6U
M$4755 \$3422 RA5 \$61 VSS nfet_03v3 L=0.28U W=0.36U AS=0.1584P AD=0.1152P
+ PS=1.6U PD=1U
M$4756 \$62 RB5 \$3422 VSS nfet_03v3 L=0.28U W=0.36U AS=0.1152P AD=0.1584P
+ PS=1U PD=1.6U
M$4757 VSS RB5 \$3524 VSS nfet_03v3 L=0.28U W=0.36U AS=0.1854P AD=0.1584P
+ PS=1.75U PD=1.6U
M$4758 VSS RA4 \$3747 VSS nfet_03v3 L=0.28U W=0.36U AS=0.1854P AD=0.1584P
+ PS=1.75U PD=1.6U
M$4759 \$3525 RA5 VSS VSS nfet_03v3 L=0.28U W=0.36U AS=0.1656P AD=0.1944P
+ PS=1.64U PD=1.8U
M$4760 \$3752 RB4 VSS VSS nfet_03v3 L=0.28U W=0.36U AS=0.1656P AD=0.1944P
+ PS=1.64U PD=1.8U
M$4761 \$3426 RA5 \$63 VSS nfet_03v3 L=0.28U W=0.36U AS=0.1584P AD=0.1152P
+ PS=1.6U PD=1U
M$4762 \$64 RB5 \$3426 VSS nfet_03v3 L=0.28U W=0.36U AS=0.1152P AD=0.1584P
+ PS=1U PD=1.6U
M$4763 \$3751 RB4 \$63 VSS nfet_03v3 L=0.28U W=0.36U AS=0.1584P AD=0.1152P
+ PS=1.6U PD=1U
M$4764 \$64 RA4 \$3751 VSS nfet_03v3 L=0.28U W=0.36U AS=0.1152P AD=0.1584P
+ PS=1U PD=1.6U
M$4765 VSS RB5 \$3526 VSS nfet_03v3 L=0.28U W=0.36U AS=0.1854P AD=0.1584P
+ PS=1.75U PD=1.6U
M$4766 VSS RA4 \$3753 VSS nfet_03v3 L=0.28U W=0.36U AS=0.1854P AD=0.1584P
+ PS=1.75U PD=1.6U
M$4767 \$3527 RA5 VSS VSS nfet_03v3 L=0.28U W=0.36U AS=0.1656P AD=0.1944P
+ PS=1.64U PD=1.8U
M$4768 \$3758 RB4 VSS VSS nfet_03v3 L=0.28U W=0.36U AS=0.1656P AD=0.1944P
+ PS=1.64U PD=1.8U
M$4769 \$3757 RB4 \$65 VSS nfet_03v3 L=0.28U W=0.36U AS=0.1584P AD=0.1152P
+ PS=1.6U PD=1U
M$4770 \$66 RA4 \$3757 VSS nfet_03v3 L=0.28U W=0.36U AS=0.1152P AD=0.1584P
+ PS=1U PD=1.6U
M$4771 \$3430 RA5 \$65 VSS nfet_03v3 L=0.28U W=0.36U AS=0.1584P AD=0.1152P
+ PS=1.6U PD=1U
M$4772 \$66 RB5 \$3430 VSS nfet_03v3 L=0.28U W=0.36U AS=0.1152P AD=0.1584P
+ PS=1U PD=1.6U
M$4773 VSS RB5 \$3528 VSS nfet_03v3 L=0.28U W=0.36U AS=0.1854P AD=0.1584P
+ PS=1.75U PD=1.6U
M$4774 VSS RA4 \$3759 VSS nfet_03v3 L=0.28U W=0.36U AS=0.1854P AD=0.1584P
+ PS=1.75U PD=1.6U
M$4775 \$3529 RA5 VSS VSS nfet_03v3 L=0.28U W=0.36U AS=0.1656P AD=0.1944P
+ PS=1.64U PD=1.8U
M$4776 \$3764 RB4 VSS VSS nfet_03v3 L=0.28U W=0.36U AS=0.1656P AD=0.1944P
+ PS=1.64U PD=1.8U
M$4777 \$3434 RA5 \$67 VSS nfet_03v3 L=0.28U W=0.36U AS=0.1584P AD=0.1152P
+ PS=1.6U PD=1U
M$4778 \$68 RB5 \$3434 VSS nfet_03v3 L=0.28U W=0.36U AS=0.1152P AD=0.1584P
+ PS=1U PD=1.6U
M$4779 \$3763 RB4 \$67 VSS nfet_03v3 L=0.28U W=0.36U AS=0.1584P AD=0.1152P
+ PS=1.6U PD=1U
M$4780 \$68 RA4 \$3763 VSS nfet_03v3 L=0.28U W=0.36U AS=0.1152P AD=0.1584P
+ PS=1U PD=1.6U
M$4781 VSS RB5 \$3530 VSS nfet_03v3 L=0.28U W=0.36U AS=0.1854P AD=0.1584P
+ PS=1.75U PD=1.6U
M$4782 VSS RA4 \$3765 VSS nfet_03v3 L=0.28U W=0.36U AS=0.1854P AD=0.1584P
+ PS=1.75U PD=1.6U
M$4783 \$3770 RB4 VSS VSS nfet_03v3 L=0.28U W=0.36U AS=0.1656P AD=0.1944P
+ PS=1.64U PD=1.8U
M$4784 \$3531 RA5 VSS VSS nfet_03v3 L=0.28U W=0.36U AS=0.1656P AD=0.1944P
+ PS=1.64U PD=1.8U
M$4785 \$3438 RA5 \$69 VSS nfet_03v3 L=0.28U W=0.36U AS=0.1584P AD=0.1152P
+ PS=1.6U PD=1U
M$4786 \$70 RB5 \$3438 VSS nfet_03v3 L=0.28U W=0.36U AS=0.1152P AD=0.1584P
+ PS=1U PD=1.6U
M$4787 \$3769 RB4 \$69 VSS nfet_03v3 L=0.28U W=0.36U AS=0.1584P AD=0.1152P
+ PS=1.6U PD=1U
M$4788 \$70 RA4 \$3769 VSS nfet_03v3 L=0.28U W=0.36U AS=0.1152P AD=0.1584P
+ PS=1U PD=1.6U
M$4789 VSS RB5 \$3532 VSS nfet_03v3 L=0.28U W=0.36U AS=0.1854P AD=0.1584P
+ PS=1.75U PD=1.6U
M$4790 VSS RA4 \$3771 VSS nfet_03v3 L=0.28U W=0.36U AS=0.1854P AD=0.1584P
+ PS=1.75U PD=1.6U
M$4791 \$3776 RB4 VSS VSS nfet_03v3 L=0.28U W=0.36U AS=0.1656P AD=0.1944P
+ PS=1.64U PD=1.8U
M$4792 \$3533 RA5 VSS VSS nfet_03v3 L=0.28U W=0.36U AS=0.1656P AD=0.1944P
+ PS=1.64U PD=1.8U
M$4793 \$3442 RA5 \$71 VSS nfet_03v3 L=0.28U W=0.36U AS=0.1584P AD=0.1152P
+ PS=1.6U PD=1U
M$4794 \$72 RB5 \$3442 VSS nfet_03v3 L=0.28U W=0.36U AS=0.1152P AD=0.1584P
+ PS=1U PD=1.6U
M$4795 \$3775 RB4 \$71 VSS nfet_03v3 L=0.28U W=0.36U AS=0.1584P AD=0.1152P
+ PS=1.6U PD=1U
M$4796 \$72 RA4 \$3775 VSS nfet_03v3 L=0.28U W=0.36U AS=0.1152P AD=0.1584P
+ PS=1U PD=1.6U
M$4797 VSS RB5 \$3534 VSS nfet_03v3 L=0.28U W=0.36U AS=0.1854P AD=0.1584P
+ PS=1.75U PD=1.6U
M$4798 VSS RA4 \$3777 VSS nfet_03v3 L=0.28U W=0.36U AS=0.1854P AD=0.1584P
+ PS=1.75U PD=1.6U
M$4799 \$3782 RB4 VSS VSS nfet_03v3 L=0.28U W=0.36U AS=0.1656P AD=0.1944P
+ PS=1.64U PD=1.8U
M$4800 \$3535 RA5 VSS VSS nfet_03v3 L=0.28U W=0.36U AS=0.1656P AD=0.1944P
+ PS=1.64U PD=1.8U
M$4801 \$3446 RA5 \$73 VSS nfet_03v3 L=0.28U W=0.36U AS=0.1584P AD=0.1152P
+ PS=1.6U PD=1U
M$4802 \$74 RB5 \$3446 VSS nfet_03v3 L=0.28U W=0.36U AS=0.1152P AD=0.1584P
+ PS=1U PD=1.6U
M$4803 \$3781 RB4 \$73 VSS nfet_03v3 L=0.28U W=0.36U AS=0.1584P AD=0.1152P
+ PS=1.6U PD=1U
M$4804 \$74 RA4 \$3781 VSS nfet_03v3 L=0.28U W=0.36U AS=0.1152P AD=0.1584P
+ PS=1U PD=1.6U
M$4805 VSS RA4 \$3783 VSS nfet_03v3 L=0.28U W=0.36U AS=0.1854P AD=0.1584P
+ PS=1.75U PD=1.6U
M$4806 VSS RB5 \$3536 VSS nfet_03v3 L=0.28U W=0.36U AS=0.1854P AD=0.1584P
+ PS=1.75U PD=1.6U
M$4807 \$3788 RB4 VSS VSS nfet_03v3 L=0.28U W=0.36U AS=0.1656P AD=0.1944P
+ PS=1.64U PD=1.8U
M$4808 \$3537 RA5 VSS VSS nfet_03v3 L=0.28U W=0.36U AS=0.1656P AD=0.1944P
+ PS=1.64U PD=1.8U
M$4809 \$3787 RB4 \$75 VSS nfet_03v3 L=0.28U W=0.36U AS=0.1584P AD=0.1152P
+ PS=1.6U PD=1U
M$4810 \$76 RA4 \$3787 VSS nfet_03v3 L=0.28U W=0.36U AS=0.1152P AD=0.1584P
+ PS=1U PD=1.6U
M$4811 \$3450 RA5 \$75 VSS nfet_03v3 L=0.28U W=0.36U AS=0.1584P AD=0.1152P
+ PS=1.6U PD=1U
M$4812 \$76 RB5 \$3450 VSS nfet_03v3 L=0.28U W=0.36U AS=0.1152P AD=0.1584P
+ PS=1U PD=1.6U
M$4813 VSS RA4 \$3789 VSS nfet_03v3 L=0.28U W=0.36U AS=0.1854P AD=0.1584P
+ PS=1.75U PD=1.6U
M$4814 VSS RB5 \$3538 VSS nfet_03v3 L=0.28U W=0.36U AS=0.1854P AD=0.1584P
+ PS=1.75U PD=1.6U
M$4815 \$3539 RA5 VSS VSS nfet_03v3 L=0.28U W=0.36U AS=0.1656P AD=0.1944P
+ PS=1.64U PD=1.8U
M$4816 \$3794 RB4 VSS VSS nfet_03v3 L=0.28U W=0.36U AS=0.1656P AD=0.1944P
+ PS=1.64U PD=1.8U
M$4817 \$3793 RB4 \$77 VSS nfet_03v3 L=0.28U W=0.36U AS=0.1584P AD=0.1152P
+ PS=1.6U PD=1U
M$4818 \$78 RA4 \$3793 VSS nfet_03v3 L=0.28U W=0.36U AS=0.1152P AD=0.1584P
+ PS=1U PD=1.6U
M$4819 \$3454 RA5 \$77 VSS nfet_03v3 L=0.28U W=0.36U AS=0.1584P AD=0.1152P
+ PS=1.6U PD=1U
M$4820 \$78 RB5 \$3454 VSS nfet_03v3 L=0.28U W=0.36U AS=0.1152P AD=0.1584P
+ PS=1U PD=1.6U
M$4821 VSS RA4 \$3795 VSS nfet_03v3 L=0.28U W=0.36U AS=0.1854P AD=0.1584P
+ PS=1.75U PD=1.6U
M$4822 VSS RB5 \$3540 VSS nfet_03v3 L=0.28U W=0.36U AS=0.1854P AD=0.1584P
+ PS=1.75U PD=1.6U
M$4823 \$3800 RB4 VSS VSS nfet_03v3 L=0.28U W=0.36U AS=0.1656P AD=0.1944P
+ PS=1.64U PD=1.8U
M$4824 \$3541 RA5 VSS VSS nfet_03v3 L=0.28U W=0.36U AS=0.1656P AD=0.1944P
+ PS=1.64U PD=1.8U
M$4825 \$3799 RB4 \$79 VSS nfet_03v3 L=0.28U W=0.36U AS=0.1584P AD=0.1152P
+ PS=1.6U PD=1U
M$4826 \$80 RA4 \$3799 VSS nfet_03v3 L=0.28U W=0.36U AS=0.1152P AD=0.1584P
+ PS=1U PD=1.6U
M$4827 \$3458 RA5 \$79 VSS nfet_03v3 L=0.28U W=0.36U AS=0.1584P AD=0.1152P
+ PS=1.6U PD=1U
M$4828 \$80 RB5 \$3458 VSS nfet_03v3 L=0.28U W=0.36U AS=0.1152P AD=0.1584P
+ PS=1U PD=1.6U
M$4829 VSS RB5 \$3542 VSS nfet_03v3 L=0.28U W=0.36U AS=0.1854P AD=0.1584P
+ PS=1.75U PD=1.6U
M$4830 VSS RA4 \$3801 VSS nfet_03v3 L=0.28U W=0.36U AS=0.1854P AD=0.1584P
+ PS=1.75U PD=1.6U
M$4831 \$3543 RA5 VSS VSS nfet_03v3 L=0.28U W=0.36U AS=0.1656P AD=0.1944P
+ PS=1.64U PD=1.8U
M$4832 \$3806 RB4 VSS VSS nfet_03v3 L=0.28U W=0.36U AS=0.1656P AD=0.1944P
+ PS=1.64U PD=1.8U
M$4833 \$3805 RB4 \$81 VSS nfet_03v3 L=0.28U W=0.36U AS=0.1584P AD=0.1152P
+ PS=1.6U PD=1U
M$4834 \$82 RA4 \$3805 VSS nfet_03v3 L=0.28U W=0.36U AS=0.1152P AD=0.1584P
+ PS=1U PD=1.6U
M$4835 \$3462 RA5 \$81 VSS nfet_03v3 L=0.28U W=0.36U AS=0.1584P AD=0.1152P
+ PS=1.6U PD=1U
M$4836 \$82 RB5 \$3462 VSS nfet_03v3 L=0.28U W=0.36U AS=0.1152P AD=0.1584P
+ PS=1U PD=1.6U
M$4837 VSS RA4 \$3807 VSS nfet_03v3 L=0.28U W=0.36U AS=0.1854P AD=0.1584P
+ PS=1.75U PD=1.6U
M$4838 VSS RB5 \$3544 VSS nfet_03v3 L=0.28U W=0.36U AS=0.1854P AD=0.1584P
+ PS=1.75U PD=1.6U
M$4839 \$3911 WE4 VSS VSS nfet_03v3 L=0.28U W=0.72U AS=0.3168P AD=0.1872P
+ PS=2.32U PD=1.24U
M$4840 \$3706 CLK \$3911 VSS nfet_03v3 L=0.28U W=0.72U AS=0.1872P AD=0.3168P
+ PS=1.24U PD=2.32U
M$4841 \$3708 \$3706 VSS VSS nfet_03v3 L=0.28U W=0.635U AS=0.2794P AD=0.1651P
+ PS=2.15U PD=1.155U
M$4842 \$3708 \$3706 VSS VSS nfet_03v3 L=0.28U W=0.635U AS=0.1693P AD=0.1651P
+ PS=1.19U PD=1.155U
M$4843 \$3709 \$3708 VSS VSS nfet_03v3 L=0.28U W=0.67U AS=0.1693P AD=0.1943P
+ PS=1.19U PD=1.25U
M$4844 VSS \$3708 \$3709 VSS nfet_03v3 L=0.28U W=0.67U AS=0.1943P AD=0.2948P
+ PS=1.25U PD=2.22U
M$4845 \$3712 \$106 VSS VSS nfet_03v3 L=0.28U W=0.36U AS=0.1584P AD=0.1188P
+ PS=1.6U PD=1.02U
M$4846 \$3713 \$3708 \$3712 VSS nfet_03v3 L=0.28U W=0.36U AS=0.1188P AD=0.1278P
+ PS=1.02U PD=1.07U
M$4847 \$3916 \$3714 \$3713 VSS nfet_03v3 L=0.28U W=0.36U AS=0.1278P AD=0.0567P
+ PS=1.07U PD=0.675U
M$4848 VSS \$3709 \$3916 VSS nfet_03v3 L=0.28U W=0.36U AS=0.0567P AD=0.1584P
+ PS=0.675U PD=1.6U
M$4849 VSS \$3713 \$3714 VSS nfet_03v3 L=0.28U W=0.36U AS=0.1584P AD=0.0972P
+ PS=1.6U PD=0.9U
M$4850 \$3715 \$3713 VSS VSS nfet_03v3 L=0.28U W=0.36U AS=0.0972P AD=0.18P
+ PS=0.9U PD=1.72U
M$4851 \$3718 \$109 VSS VSS nfet_03v3 L=0.28U W=0.36U AS=0.1584P AD=0.1188P
+ PS=1.6U PD=1.02U
M$4852 \$3719 \$3708 \$3718 VSS nfet_03v3 L=0.28U W=0.36U AS=0.1188P AD=0.1278P
+ PS=1.02U PD=1.07U
M$4853 \$3925 \$3720 \$3719 VSS nfet_03v3 L=0.28U W=0.36U AS=0.1278P AD=0.0567P
+ PS=1.07U PD=0.675U
M$4854 VSS \$3709 \$3925 VSS nfet_03v3 L=0.28U W=0.36U AS=0.0567P AD=0.1584P
+ PS=0.675U PD=1.6U
M$4855 VSS \$3719 \$3720 VSS nfet_03v3 L=0.28U W=0.36U AS=0.1584P AD=0.0972P
+ PS=1.6U PD=0.9U
M$4856 \$3721 \$3719 VSS VSS nfet_03v3 L=0.28U W=0.36U AS=0.0972P AD=0.18P
+ PS=0.9U PD=1.72U
M$4857 \$3724 \$112 VSS VSS nfet_03v3 L=0.28U W=0.36U AS=0.1584P AD=0.1188P
+ PS=1.6U PD=1.02U
M$4858 \$3725 \$3708 \$3724 VSS nfet_03v3 L=0.28U W=0.36U AS=0.1188P AD=0.1278P
+ PS=1.02U PD=1.07U
M$4859 \$3932 \$3726 \$3725 VSS nfet_03v3 L=0.28U W=0.36U AS=0.1278P AD=0.0567P
+ PS=1.07U PD=0.675U
M$4860 VSS \$3709 \$3932 VSS nfet_03v3 L=0.28U W=0.36U AS=0.0567P AD=0.1584P
+ PS=0.675U PD=1.6U
M$4861 VSS \$3725 \$3726 VSS nfet_03v3 L=0.28U W=0.36U AS=0.1584P AD=0.0972P
+ PS=1.6U PD=0.9U
M$4862 \$3727 \$3725 VSS VSS nfet_03v3 L=0.28U W=0.36U AS=0.0972P AD=0.18P
+ PS=0.9U PD=1.72U
M$4863 \$3730 \$115 VSS VSS nfet_03v3 L=0.28U W=0.36U AS=0.1584P AD=0.1188P
+ PS=1.6U PD=1.02U
M$4864 \$3731 \$3708 \$3730 VSS nfet_03v3 L=0.28U W=0.36U AS=0.1188P AD=0.1278P
+ PS=1.02U PD=1.07U
M$4865 \$3940 \$3732 \$3731 VSS nfet_03v3 L=0.28U W=0.36U AS=0.1278P AD=0.0567P
+ PS=1.07U PD=0.675U
M$4866 VSS \$3709 \$3940 VSS nfet_03v3 L=0.28U W=0.36U AS=0.0567P AD=0.1584P
+ PS=0.675U PD=1.6U
M$4867 VSS \$3731 \$3732 VSS nfet_03v3 L=0.28U W=0.36U AS=0.1584P AD=0.0972P
+ PS=1.6U PD=0.9U
M$4868 \$3733 \$3731 VSS VSS nfet_03v3 L=0.28U W=0.36U AS=0.0972P AD=0.18P
+ PS=0.9U PD=1.72U
M$4869 \$3736 \$118 VSS VSS nfet_03v3 L=0.28U W=0.36U AS=0.1584P AD=0.1188P
+ PS=1.6U PD=1.02U
M$4870 \$3737 \$3708 \$3736 VSS nfet_03v3 L=0.28U W=0.36U AS=0.1188P AD=0.1278P
+ PS=1.02U PD=1.07U
M$4871 \$3949 \$3738 \$3737 VSS nfet_03v3 L=0.28U W=0.36U AS=0.1278P AD=0.0567P
+ PS=1.07U PD=0.675U
M$4872 VSS \$3709 \$3949 VSS nfet_03v3 L=0.28U W=0.36U AS=0.0567P AD=0.1584P
+ PS=0.675U PD=1.6U
M$4873 VSS \$3737 \$3738 VSS nfet_03v3 L=0.28U W=0.36U AS=0.1584P AD=0.0972P
+ PS=1.6U PD=0.9U
M$4874 \$3739 \$3737 VSS VSS nfet_03v3 L=0.28U W=0.36U AS=0.0972P AD=0.18P
+ PS=0.9U PD=1.72U
M$4875 \$3742 \$121 VSS VSS nfet_03v3 L=0.28U W=0.36U AS=0.1584P AD=0.1188P
+ PS=1.6U PD=1.02U
M$4876 \$3743 \$3708 \$3742 VSS nfet_03v3 L=0.28U W=0.36U AS=0.1188P AD=0.1278P
+ PS=1.02U PD=1.07U
M$4877 \$3955 \$3744 \$3743 VSS nfet_03v3 L=0.28U W=0.36U AS=0.1278P AD=0.0567P
+ PS=1.07U PD=0.675U
M$4878 VSS \$3709 \$3955 VSS nfet_03v3 L=0.28U W=0.36U AS=0.0567P AD=0.1584P
+ PS=0.675U PD=1.6U
M$4879 VSS \$3743 \$3744 VSS nfet_03v3 L=0.28U W=0.36U AS=0.1584P AD=0.0972P
+ PS=1.6U PD=0.9U
M$4880 \$3745 \$3743 VSS VSS nfet_03v3 L=0.28U W=0.36U AS=0.0972P AD=0.18P
+ PS=0.9U PD=1.72U
M$4881 \$3748 \$124 VSS VSS nfet_03v3 L=0.28U W=0.36U AS=0.1584P AD=0.1188P
+ PS=1.6U PD=1.02U
M$4882 \$3749 \$3708 \$3748 VSS nfet_03v3 L=0.28U W=0.36U AS=0.1188P AD=0.1278P
+ PS=1.02U PD=1.07U
M$4883 \$3964 \$3750 \$3749 VSS nfet_03v3 L=0.28U W=0.36U AS=0.1278P AD=0.0567P
+ PS=1.07U PD=0.675U
M$4884 VSS \$3709 \$3964 VSS nfet_03v3 L=0.28U W=0.36U AS=0.0567P AD=0.1584P
+ PS=0.675U PD=1.6U
M$4885 VSS \$3749 \$3750 VSS nfet_03v3 L=0.28U W=0.36U AS=0.1584P AD=0.0972P
+ PS=1.6U PD=0.9U
M$4886 \$3751 \$3749 VSS VSS nfet_03v3 L=0.28U W=0.36U AS=0.0972P AD=0.18P
+ PS=0.9U PD=1.72U
M$4887 \$3754 \$127 VSS VSS nfet_03v3 L=0.28U W=0.36U AS=0.1584P AD=0.1188P
+ PS=1.6U PD=1.02U
M$4888 \$3755 \$3708 \$3754 VSS nfet_03v3 L=0.28U W=0.36U AS=0.1188P AD=0.1278P
+ PS=1.02U PD=1.07U
M$4889 \$3973 \$3756 \$3755 VSS nfet_03v3 L=0.28U W=0.36U AS=0.1278P AD=0.0567P
+ PS=1.07U PD=0.675U
M$4890 VSS \$3709 \$3973 VSS nfet_03v3 L=0.28U W=0.36U AS=0.0567P AD=0.1584P
+ PS=0.675U PD=1.6U
M$4891 VSS \$3755 \$3756 VSS nfet_03v3 L=0.28U W=0.36U AS=0.1584P AD=0.0972P
+ PS=1.6U PD=0.9U
M$4892 \$3757 \$3755 VSS VSS nfet_03v3 L=0.28U W=0.36U AS=0.0972P AD=0.18P
+ PS=0.9U PD=1.72U
M$4893 \$3760 \$130 VSS VSS nfet_03v3 L=0.28U W=0.36U AS=0.1584P AD=0.1188P
+ PS=1.6U PD=1.02U
M$4894 \$3761 \$3708 \$3760 VSS nfet_03v3 L=0.28U W=0.36U AS=0.1188P AD=0.1278P
+ PS=1.02U PD=1.07U
M$4895 \$3979 \$3762 \$3761 VSS nfet_03v3 L=0.28U W=0.36U AS=0.1278P AD=0.0567P
+ PS=1.07U PD=0.675U
M$4896 VSS \$3709 \$3979 VSS nfet_03v3 L=0.28U W=0.36U AS=0.0567P AD=0.1584P
+ PS=0.675U PD=1.6U
M$4897 VSS \$3761 \$3762 VSS nfet_03v3 L=0.28U W=0.36U AS=0.1584P AD=0.0972P
+ PS=1.6U PD=0.9U
M$4898 \$3763 \$3761 VSS VSS nfet_03v3 L=0.28U W=0.36U AS=0.0972P AD=0.18P
+ PS=0.9U PD=1.72U
M$4899 \$3766 \$133 VSS VSS nfet_03v3 L=0.28U W=0.36U AS=0.1584P AD=0.1188P
+ PS=1.6U PD=1.02U
M$4900 \$3767 \$3708 \$3766 VSS nfet_03v3 L=0.28U W=0.36U AS=0.1188P AD=0.1278P
+ PS=1.02U PD=1.07U
M$4901 \$3987 \$3768 \$3767 VSS nfet_03v3 L=0.28U W=0.36U AS=0.1278P AD=0.0567P
+ PS=1.07U PD=0.675U
M$4902 VSS \$3709 \$3987 VSS nfet_03v3 L=0.28U W=0.36U AS=0.0567P AD=0.1584P
+ PS=0.675U PD=1.6U
M$4903 VSS \$3767 \$3768 VSS nfet_03v3 L=0.28U W=0.36U AS=0.1584P AD=0.0972P
+ PS=1.6U PD=0.9U
M$4904 \$3769 \$3767 VSS VSS nfet_03v3 L=0.28U W=0.36U AS=0.0972P AD=0.18P
+ PS=0.9U PD=1.72U
M$4905 \$3772 \$136 VSS VSS nfet_03v3 L=0.28U W=0.36U AS=0.1584P AD=0.1188P
+ PS=1.6U PD=1.02U
M$4906 \$3773 \$3708 \$3772 VSS nfet_03v3 L=0.28U W=0.36U AS=0.1188P AD=0.1278P
+ PS=1.02U PD=1.07U
M$4907 \$3995 \$3774 \$3773 VSS nfet_03v3 L=0.28U W=0.36U AS=0.1278P AD=0.0567P
+ PS=1.07U PD=0.675U
M$4908 VSS \$3709 \$3995 VSS nfet_03v3 L=0.28U W=0.36U AS=0.0567P AD=0.1584P
+ PS=0.675U PD=1.6U
M$4909 VSS \$3773 \$3774 VSS nfet_03v3 L=0.28U W=0.36U AS=0.1584P AD=0.0972P
+ PS=1.6U PD=0.9U
M$4910 \$3775 \$3773 VSS VSS nfet_03v3 L=0.28U W=0.36U AS=0.0972P AD=0.18P
+ PS=0.9U PD=1.72U
M$4911 \$3778 \$139 VSS VSS nfet_03v3 L=0.28U W=0.36U AS=0.1584P AD=0.1188P
+ PS=1.6U PD=1.02U
M$4912 \$3779 \$3708 \$3778 VSS nfet_03v3 L=0.28U W=0.36U AS=0.1188P AD=0.1278P
+ PS=1.02U PD=1.07U
M$4913 \$4003 \$3780 \$3779 VSS nfet_03v3 L=0.28U W=0.36U AS=0.1278P AD=0.0567P
+ PS=1.07U PD=0.675U
M$4914 VSS \$3709 \$4003 VSS nfet_03v3 L=0.28U W=0.36U AS=0.0567P AD=0.1584P
+ PS=0.675U PD=1.6U
M$4915 VSS \$3779 \$3780 VSS nfet_03v3 L=0.28U W=0.36U AS=0.1584P AD=0.0972P
+ PS=1.6U PD=0.9U
M$4916 \$3781 \$3779 VSS VSS nfet_03v3 L=0.28U W=0.36U AS=0.0972P AD=0.18P
+ PS=0.9U PD=1.72U
M$4917 \$3784 \$142 VSS VSS nfet_03v3 L=0.28U W=0.36U AS=0.1584P AD=0.1188P
+ PS=1.6U PD=1.02U
M$4918 \$3785 \$3708 \$3784 VSS nfet_03v3 L=0.28U W=0.36U AS=0.1188P AD=0.1278P
+ PS=1.02U PD=1.07U
M$4919 \$3998 \$3786 \$3785 VSS nfet_03v3 L=0.28U W=0.36U AS=0.1278P AD=0.0567P
+ PS=1.07U PD=0.675U
M$4920 VSS \$3709 \$3998 VSS nfet_03v3 L=0.28U W=0.36U AS=0.0567P AD=0.1584P
+ PS=0.675U PD=1.6U
M$4921 VSS \$3785 \$3786 VSS nfet_03v3 L=0.28U W=0.36U AS=0.1584P AD=0.0972P
+ PS=1.6U PD=0.9U
M$4922 \$3787 \$3785 VSS VSS nfet_03v3 L=0.28U W=0.36U AS=0.0972P AD=0.18P
+ PS=0.9U PD=1.72U
M$4923 \$3790 \$145 VSS VSS nfet_03v3 L=0.28U W=0.36U AS=0.1584P AD=0.1188P
+ PS=1.6U PD=1.02U
M$4924 \$3791 \$3708 \$3790 VSS nfet_03v3 L=0.28U W=0.36U AS=0.1188P AD=0.1278P
+ PS=1.02U PD=1.07U
M$4925 \$3972 \$3792 \$3791 VSS nfet_03v3 L=0.28U W=0.36U AS=0.1278P AD=0.0567P
+ PS=1.07U PD=0.675U
M$4926 VSS \$3709 \$3972 VSS nfet_03v3 L=0.28U W=0.36U AS=0.0567P AD=0.1584P
+ PS=0.675U PD=1.6U
M$4927 VSS \$3791 \$3792 VSS nfet_03v3 L=0.28U W=0.36U AS=0.1584P AD=0.0972P
+ PS=1.6U PD=0.9U
M$4928 \$3793 \$3791 VSS VSS nfet_03v3 L=0.28U W=0.36U AS=0.0972P AD=0.18P
+ PS=0.9U PD=1.72U
M$4929 \$3796 \$148 VSS VSS nfet_03v3 L=0.28U W=0.36U AS=0.1584P AD=0.1188P
+ PS=1.6U PD=1.02U
M$4930 \$3797 \$3708 \$3796 VSS nfet_03v3 L=0.28U W=0.36U AS=0.1188P AD=0.1278P
+ PS=1.02U PD=1.07U
M$4931 \$3948 \$3798 \$3797 VSS nfet_03v3 L=0.28U W=0.36U AS=0.1278P AD=0.0567P
+ PS=1.07U PD=0.675U
M$4932 VSS \$3709 \$3948 VSS nfet_03v3 L=0.28U W=0.36U AS=0.0567P AD=0.1584P
+ PS=0.675U PD=1.6U
M$4933 VSS \$3797 \$3798 VSS nfet_03v3 L=0.28U W=0.36U AS=0.1584P AD=0.0972P
+ PS=1.6U PD=0.9U
M$4934 \$3799 \$3797 VSS VSS nfet_03v3 L=0.28U W=0.36U AS=0.0972P AD=0.18P
+ PS=0.9U PD=1.72U
M$4935 \$3802 \$151 VSS VSS nfet_03v3 L=0.28U W=0.36U AS=0.1584P AD=0.1188P
+ PS=1.6U PD=1.02U
M$4936 \$3803 \$3708 \$3802 VSS nfet_03v3 L=0.28U W=0.36U AS=0.1188P AD=0.1278P
+ PS=1.02U PD=1.07U
M$4937 \$3924 \$3804 \$3803 VSS nfet_03v3 L=0.28U W=0.36U AS=0.1278P AD=0.0567P
+ PS=1.07U PD=0.675U
M$4938 VSS \$3709 \$3924 VSS nfet_03v3 L=0.28U W=0.36U AS=0.0567P AD=0.1584P
+ PS=0.675U PD=1.6U
M$4939 VSS \$3803 \$3804 VSS nfet_03v3 L=0.28U W=0.36U AS=0.1584P AD=0.0972P
+ PS=1.6U PD=0.9U
M$4940 \$3805 \$3803 VSS VSS nfet_03v3 L=0.28U W=0.36U AS=0.0972P AD=0.18P
+ PS=0.9U PD=1.72U
M$4941 \$4158 WE3 VSS VSS nfet_03v3 L=0.28U W=0.72U AS=0.3168P AD=0.1872P
+ PS=2.32U PD=1.24U
M$4942 \$4009 CLK \$4158 VSS nfet_03v3 L=0.28U W=0.72U AS=0.1872P AD=0.3168P
+ PS=1.24U PD=2.32U
M$4943 \$4010 \$4009 VSS VSS nfet_03v3 L=0.28U W=0.635U AS=0.2794P AD=0.1651P
+ PS=2.15U PD=1.155U
M$4944 VSS \$4009 \$4010 VSS nfet_03v3 L=0.28U W=0.635U AS=0.1651P AD=0.1693P
+ PS=1.155U PD=1.19U
M$4945 \$4011 \$4010 VSS VSS nfet_03v3 L=0.28U W=0.67U AS=0.1693P AD=0.1943P
+ PS=1.19U PD=1.25U
M$4946 VSS \$4010 \$4011 VSS nfet_03v3 L=0.28U W=0.67U AS=0.1943P AD=0.2948P
+ PS=1.25U PD=2.22U
M$4947 \$4012 \$106 VSS VSS nfet_03v3 L=0.28U W=0.36U AS=0.1584P AD=0.1188P
+ PS=1.6U PD=1.02U
M$4948 \$4013 \$4010 \$4012 VSS nfet_03v3 L=0.28U W=0.36U AS=0.1188P AD=0.1278P
+ PS=1.02U PD=1.07U
M$4949 \$4080 \$4014 \$4013 VSS nfet_03v3 L=0.28U W=0.36U AS=0.1278P AD=0.0567P
+ PS=1.07U PD=0.675U
M$4950 VSS \$4011 \$4080 VSS nfet_03v3 L=0.28U W=0.36U AS=0.0567P AD=0.1584P
+ PS=0.675U PD=1.6U
M$4951 VSS \$4013 \$4014 VSS nfet_03v3 L=0.28U W=0.36U AS=0.1584P AD=0.0972P
+ PS=1.6U PD=0.9U
M$4952 \$4015 \$4013 VSS VSS nfet_03v3 L=0.28U W=0.36U AS=0.0972P AD=0.18P
+ PS=0.9U PD=1.72U
M$4953 \$4016 \$109 VSS VSS nfet_03v3 L=0.28U W=0.36U AS=0.1584P AD=0.1188P
+ PS=1.6U PD=1.02U
M$4954 \$4017 \$4010 \$4016 VSS nfet_03v3 L=0.28U W=0.36U AS=0.1188P AD=0.1278P
+ PS=1.02U PD=1.07U
M$4955 \$4089 \$4018 \$4017 VSS nfet_03v3 L=0.28U W=0.36U AS=0.1278P AD=0.0567P
+ PS=1.07U PD=0.675U
M$4956 VSS \$4011 \$4089 VSS nfet_03v3 L=0.28U W=0.36U AS=0.0567P AD=0.1584P
+ PS=0.675U PD=1.6U
M$4957 VSS \$4017 \$4018 VSS nfet_03v3 L=0.28U W=0.36U AS=0.1584P AD=0.0972P
+ PS=1.6U PD=0.9U
M$4958 \$4019 \$4017 VSS VSS nfet_03v3 L=0.28U W=0.36U AS=0.0972P AD=0.18P
+ PS=0.9U PD=1.72U
M$4959 \$4020 \$112 VSS VSS nfet_03v3 L=0.28U W=0.36U AS=0.1584P AD=0.1188P
+ PS=1.6U PD=1.02U
M$4960 \$4021 \$4010 \$4020 VSS nfet_03v3 L=0.28U W=0.36U AS=0.1188P AD=0.1278P
+ PS=1.02U PD=1.07U
M$4961 \$4097 \$4022 \$4021 VSS nfet_03v3 L=0.28U W=0.36U AS=0.1278P AD=0.0567P
+ PS=1.07U PD=0.675U
M$4962 VSS \$4011 \$4097 VSS nfet_03v3 L=0.28U W=0.36U AS=0.0567P AD=0.1584P
+ PS=0.675U PD=1.6U
M$4963 VSS \$4021 \$4022 VSS nfet_03v3 L=0.28U W=0.36U AS=0.1584P AD=0.0972P
+ PS=1.6U PD=0.9U
M$4964 \$4023 \$4021 VSS VSS nfet_03v3 L=0.28U W=0.36U AS=0.0972P AD=0.18P
+ PS=0.9U PD=1.72U
M$4965 \$4024 \$115 VSS VSS nfet_03v3 L=0.28U W=0.36U AS=0.1584P AD=0.1188P
+ PS=1.6U PD=1.02U
M$4966 \$4025 \$4010 \$4024 VSS nfet_03v3 L=0.28U W=0.36U AS=0.1188P AD=0.1278P
+ PS=1.02U PD=1.07U
M$4967 \$4106 \$4026 \$4025 VSS nfet_03v3 L=0.28U W=0.36U AS=0.1278P AD=0.0567P
+ PS=1.07U PD=0.675U
M$4968 VSS \$4011 \$4106 VSS nfet_03v3 L=0.28U W=0.36U AS=0.0567P AD=0.1584P
+ PS=0.675U PD=1.6U
M$4969 VSS \$4025 \$4026 VSS nfet_03v3 L=0.28U W=0.36U AS=0.1584P AD=0.0972P
+ PS=1.6U PD=0.9U
M$4970 \$4027 \$4025 VSS VSS nfet_03v3 L=0.28U W=0.36U AS=0.0972P AD=0.18P
+ PS=0.9U PD=1.72U
M$4971 \$4028 \$118 VSS VSS nfet_03v3 L=0.28U W=0.36U AS=0.1584P AD=0.1188P
+ PS=1.6U PD=1.02U
M$4972 \$4029 \$4010 \$4028 VSS nfet_03v3 L=0.28U W=0.36U AS=0.1188P AD=0.1278P
+ PS=1.02U PD=1.07U
M$4973 \$4113 \$4030 \$4029 VSS nfet_03v3 L=0.28U W=0.36U AS=0.1278P AD=0.0567P
+ PS=1.07U PD=0.675U
M$4974 VSS \$4011 \$4113 VSS nfet_03v3 L=0.28U W=0.36U AS=0.0567P AD=0.1584P
+ PS=0.675U PD=1.6U
M$4975 VSS \$4029 \$4030 VSS nfet_03v3 L=0.28U W=0.36U AS=0.1584P AD=0.0972P
+ PS=1.6U PD=0.9U
M$4976 \$4031 \$4029 VSS VSS nfet_03v3 L=0.28U W=0.36U AS=0.0972P AD=0.18P
+ PS=0.9U PD=1.72U
M$4977 \$4032 \$121 VSS VSS nfet_03v3 L=0.28U W=0.36U AS=0.1584P AD=0.1188P
+ PS=1.6U PD=1.02U
M$4978 \$4033 \$4010 \$4032 VSS nfet_03v3 L=0.28U W=0.36U AS=0.1188P AD=0.1278P
+ PS=1.02U PD=1.07U
M$4979 \$4121 \$4034 \$4033 VSS nfet_03v3 L=0.28U W=0.36U AS=0.1278P AD=0.0567P
+ PS=1.07U PD=0.675U
M$4980 VSS \$4011 \$4121 VSS nfet_03v3 L=0.28U W=0.36U AS=0.0567P AD=0.1584P
+ PS=0.675U PD=1.6U
M$4981 VSS \$4033 \$4034 VSS nfet_03v3 L=0.28U W=0.36U AS=0.1584P AD=0.0972P
+ PS=1.6U PD=0.9U
M$4982 \$4035 \$4033 VSS VSS nfet_03v3 L=0.28U W=0.36U AS=0.0972P AD=0.18P
+ PS=0.9U PD=1.72U
M$4983 \$4036 \$124 VSS VSS nfet_03v3 L=0.28U W=0.36U AS=0.1584P AD=0.1188P
+ PS=1.6U PD=1.02U
M$4984 \$4037 \$4010 \$4036 VSS nfet_03v3 L=0.28U W=0.36U AS=0.1188P AD=0.1278P
+ PS=1.02U PD=1.07U
M$4985 \$4120 \$4038 \$4037 VSS nfet_03v3 L=0.28U W=0.36U AS=0.1278P AD=0.0567P
+ PS=1.07U PD=0.675U
M$4986 VSS \$4011 \$4120 VSS nfet_03v3 L=0.28U W=0.36U AS=0.0567P AD=0.1584P
+ PS=0.675U PD=1.6U
M$4987 VSS \$4037 \$4038 VSS nfet_03v3 L=0.28U W=0.36U AS=0.1584P AD=0.0972P
+ PS=1.6U PD=0.9U
M$4988 \$4039 \$4037 VSS VSS nfet_03v3 L=0.28U W=0.36U AS=0.0972P AD=0.18P
+ PS=0.9U PD=1.72U
M$4989 \$4040 \$127 VSS VSS nfet_03v3 L=0.28U W=0.36U AS=0.1584P AD=0.1188P
+ PS=1.6U PD=1.02U
M$4990 \$4041 \$4010 \$4040 VSS nfet_03v3 L=0.28U W=0.36U AS=0.1188P AD=0.1278P
+ PS=1.02U PD=1.07U
M$4991 \$4117 \$4042 \$4041 VSS nfet_03v3 L=0.28U W=0.36U AS=0.1278P AD=0.0567P
+ PS=1.07U PD=0.675U
M$4992 VSS \$4011 \$4117 VSS nfet_03v3 L=0.28U W=0.36U AS=0.0567P AD=0.1584P
+ PS=0.675U PD=1.6U
M$4993 VSS \$4041 \$4042 VSS nfet_03v3 L=0.28U W=0.36U AS=0.1584P AD=0.0972P
+ PS=1.6U PD=0.9U
M$4994 \$4043 \$4041 VSS VSS nfet_03v3 L=0.28U W=0.36U AS=0.0972P AD=0.18P
+ PS=0.9U PD=1.72U
M$4995 \$4044 \$130 VSS VSS nfet_03v3 L=0.28U W=0.36U AS=0.1584P AD=0.1188P
+ PS=1.6U PD=1.02U
M$4996 \$4045 \$4010 \$4044 VSS nfet_03v3 L=0.28U W=0.36U AS=0.1188P AD=0.1278P
+ PS=1.02U PD=1.07U
M$4997 \$4111 \$4046 \$4045 VSS nfet_03v3 L=0.28U W=0.36U AS=0.1278P AD=0.0567P
+ PS=1.07U PD=0.675U
M$4998 VSS \$4011 \$4111 VSS nfet_03v3 L=0.28U W=0.36U AS=0.0567P AD=0.1584P
+ PS=0.675U PD=1.6U
M$4999 VSS \$4045 \$4046 VSS nfet_03v3 L=0.28U W=0.36U AS=0.1584P AD=0.0972P
+ PS=1.6U PD=0.9U
M$5000 \$4047 \$4045 VSS VSS nfet_03v3 L=0.28U W=0.36U AS=0.0972P AD=0.18P
+ PS=0.9U PD=1.72U
M$5001 \$4048 \$133 VSS VSS nfet_03v3 L=0.28U W=0.36U AS=0.1584P AD=0.1188P
+ PS=1.6U PD=1.02U
M$5002 \$4049 \$4010 \$4048 VSS nfet_03v3 L=0.28U W=0.36U AS=0.1188P AD=0.1278P
+ PS=1.02U PD=1.07U
M$5003 \$4105 \$4050 \$4049 VSS nfet_03v3 L=0.28U W=0.36U AS=0.1278P AD=0.0567P
+ PS=1.07U PD=0.675U
M$5004 VSS \$4011 \$4105 VSS nfet_03v3 L=0.28U W=0.36U AS=0.0567P AD=0.1584P
+ PS=0.675U PD=1.6U
M$5005 VSS \$4049 \$4050 VSS nfet_03v3 L=0.28U W=0.36U AS=0.1584P AD=0.0972P
+ PS=1.6U PD=0.9U
M$5006 \$4051 \$4049 VSS VSS nfet_03v3 L=0.28U W=0.36U AS=0.0972P AD=0.18P
+ PS=0.9U PD=1.72U
M$5007 \$4052 \$136 VSS VSS nfet_03v3 L=0.28U W=0.36U AS=0.1584P AD=0.1188P
+ PS=1.6U PD=1.02U
M$5008 \$4053 \$4010 \$4052 VSS nfet_03v3 L=0.28U W=0.36U AS=0.1188P AD=0.1278P
+ PS=1.02U PD=1.07U
M$5009 \$4102 \$4054 \$4053 VSS nfet_03v3 L=0.28U W=0.36U AS=0.1278P AD=0.0567P
+ PS=1.07U PD=0.675U
M$5010 VSS \$4011 \$4102 VSS nfet_03v3 L=0.28U W=0.36U AS=0.0567P AD=0.1584P
+ PS=0.675U PD=1.6U
M$5011 VSS \$4053 \$4054 VSS nfet_03v3 L=0.28U W=0.36U AS=0.1584P AD=0.0972P
+ PS=1.6U PD=0.9U
M$5012 \$4055 \$4053 VSS VSS nfet_03v3 L=0.28U W=0.36U AS=0.0972P AD=0.18P
+ PS=0.9U PD=1.72U
M$5013 \$4056 \$139 VSS VSS nfet_03v3 L=0.28U W=0.36U AS=0.1584P AD=0.1188P
+ PS=1.6U PD=1.02U
M$5014 \$4057 \$4010 \$4056 VSS nfet_03v3 L=0.28U W=0.36U AS=0.1188P AD=0.1278P
+ PS=1.02U PD=1.07U
M$5015 \$4096 \$4058 \$4057 VSS nfet_03v3 L=0.28U W=0.36U AS=0.1278P AD=0.0567P
+ PS=1.07U PD=0.675U
M$5016 VSS \$4011 \$4096 VSS nfet_03v3 L=0.28U W=0.36U AS=0.0567P AD=0.1584P
+ PS=0.675U PD=1.6U
M$5017 VSS \$4057 \$4058 VSS nfet_03v3 L=0.28U W=0.36U AS=0.1584P AD=0.0972P
+ PS=1.6U PD=0.9U
M$5018 \$4059 \$4057 VSS VSS nfet_03v3 L=0.28U W=0.36U AS=0.0972P AD=0.18P
+ PS=0.9U PD=1.72U
M$5019 \$4060 \$142 VSS VSS nfet_03v3 L=0.28U W=0.36U AS=0.1584P AD=0.1188P
+ PS=1.6U PD=1.02U
M$5020 \$4061 \$4010 \$4060 VSS nfet_03v3 L=0.28U W=0.36U AS=0.1188P AD=0.1278P
+ PS=1.02U PD=1.07U
M$5021 \$4093 \$4062 \$4061 VSS nfet_03v3 L=0.28U W=0.36U AS=0.1278P AD=0.0567P
+ PS=1.07U PD=0.675U
M$5022 VSS \$4011 \$4093 VSS nfet_03v3 L=0.28U W=0.36U AS=0.0567P AD=0.1584P
+ PS=0.675U PD=1.6U
M$5023 VSS \$4061 \$4062 VSS nfet_03v3 L=0.28U W=0.36U AS=0.1584P AD=0.0972P
+ PS=1.6U PD=0.9U
M$5024 \$4063 \$4061 VSS VSS nfet_03v3 L=0.28U W=0.36U AS=0.0972P AD=0.18P
+ PS=0.9U PD=1.72U
M$5025 \$4064 \$145 VSS VSS nfet_03v3 L=0.28U W=0.36U AS=0.1584P AD=0.1188P
+ PS=1.6U PD=1.02U
M$5026 \$4065 \$4010 \$4064 VSS nfet_03v3 L=0.28U W=0.36U AS=0.1188P AD=0.1278P
+ PS=1.02U PD=1.07U
M$5027 \$4087 \$4066 \$4065 VSS nfet_03v3 L=0.28U W=0.36U AS=0.1278P AD=0.0567P
+ PS=1.07U PD=0.675U
M$5028 VSS \$4011 \$4087 VSS nfet_03v3 L=0.28U W=0.36U AS=0.0567P AD=0.1584P
+ PS=0.675U PD=1.6U
M$5029 VSS \$4065 \$4066 VSS nfet_03v3 L=0.28U W=0.36U AS=0.1584P AD=0.0972P
+ PS=1.6U PD=0.9U
M$5030 \$4067 \$4065 VSS VSS nfet_03v3 L=0.28U W=0.36U AS=0.0972P AD=0.18P
+ PS=0.9U PD=1.72U
M$5031 \$4068 \$148 VSS VSS nfet_03v3 L=0.28U W=0.36U AS=0.1584P AD=0.1188P
+ PS=1.6U PD=1.02U
M$5032 \$4069 \$4010 \$4068 VSS nfet_03v3 L=0.28U W=0.36U AS=0.1188P AD=0.1278P
+ PS=1.02U PD=1.07U
M$5033 \$4083 \$4070 \$4069 VSS nfet_03v3 L=0.28U W=0.36U AS=0.1278P AD=0.0567P
+ PS=1.07U PD=0.675U
M$5034 VSS \$4011 \$4083 VSS nfet_03v3 L=0.28U W=0.36U AS=0.0567P AD=0.1584P
+ PS=0.675U PD=1.6U
M$5035 VSS \$4069 \$4070 VSS nfet_03v3 L=0.28U W=0.36U AS=0.1584P AD=0.0972P
+ PS=1.6U PD=0.9U
M$5036 \$4071 \$4069 VSS VSS nfet_03v3 L=0.28U W=0.36U AS=0.0972P AD=0.18P
+ PS=0.9U PD=1.72U
M$5037 \$4072 \$151 VSS VSS nfet_03v3 L=0.28U W=0.36U AS=0.1584P AD=0.1188P
+ PS=1.6U PD=1.02U
M$5038 \$4073 \$4010 \$4072 VSS nfet_03v3 L=0.28U W=0.36U AS=0.1188P AD=0.1278P
+ PS=1.02U PD=1.07U
M$5039 \$4078 \$4074 \$4073 VSS nfet_03v3 L=0.28U W=0.36U AS=0.1278P AD=0.0567P
+ PS=1.07U PD=0.675U
M$5040 VSS \$4011 \$4078 VSS nfet_03v3 L=0.28U W=0.36U AS=0.0567P AD=0.1584P
+ PS=0.675U PD=1.6U
M$5041 VSS \$4073 \$4074 VSS nfet_03v3 L=0.28U W=0.36U AS=0.1584P AD=0.0972P
+ PS=1.6U PD=0.9U
M$5042 \$4075 \$4073 VSS VSS nfet_03v3 L=0.28U W=0.36U AS=0.0972P AD=0.18P
+ PS=0.9U PD=1.72U
M$5043 \$4126 RA3 VSS VSS nfet_03v3 L=0.28U W=0.36U AS=0.1656P AD=0.1944P
+ PS=1.64U PD=1.8U
M$5044 \$4329 RB2 VSS VSS nfet_03v3 L=0.28U W=0.36U AS=0.1656P AD=0.1944P
+ PS=1.64U PD=1.8U
M$5045 \$4328 RB2 \$51 VSS nfet_03v3 L=0.28U W=0.36U AS=0.1584P AD=0.1152P
+ PS=1.6U PD=1U
M$5046 \$52 RA2 \$4328 VSS nfet_03v3 L=0.28U W=0.36U AS=0.1152P AD=0.1584P
+ PS=1U PD=1.6U
M$5047 \$4015 RA3 \$51 VSS nfet_03v3 L=0.28U W=0.36U AS=0.1584P AD=0.1152P
+ PS=1.6U PD=1U
M$5048 \$52 RB3 \$4015 VSS nfet_03v3 L=0.28U W=0.36U AS=0.1152P AD=0.1584P
+ PS=1U PD=1.6U
M$5049 VSS RA2 \$4330 VSS nfet_03v3 L=0.28U W=0.36U AS=0.1854P AD=0.1584P
+ PS=1.75U PD=1.6U
M$5050 VSS RB3 \$4127 VSS nfet_03v3 L=0.28U W=0.36U AS=0.1854P AD=0.1584P
+ PS=1.75U PD=1.6U
M$5051 \$4128 RA3 VSS VSS nfet_03v3 L=0.28U W=0.36U AS=0.1656P AD=0.1944P
+ PS=1.64U PD=1.8U
M$5052 \$4335 RB2 VSS VSS nfet_03v3 L=0.28U W=0.36U AS=0.1656P AD=0.1944P
+ PS=1.64U PD=1.8U
M$5053 \$4334 RB2 \$53 VSS nfet_03v3 L=0.28U W=0.36U AS=0.1584P AD=0.1152P
+ PS=1.6U PD=1U
M$5054 \$54 RA2 \$4334 VSS nfet_03v3 L=0.28U W=0.36U AS=0.1152P AD=0.1584P
+ PS=1U PD=1.6U
M$5055 \$4019 RA3 \$53 VSS nfet_03v3 L=0.28U W=0.36U AS=0.1584P AD=0.1152P
+ PS=1.6U PD=1U
M$5056 \$54 RB3 \$4019 VSS nfet_03v3 L=0.28U W=0.36U AS=0.1152P AD=0.1584P
+ PS=1U PD=1.6U
M$5057 VSS RB3 \$4129 VSS nfet_03v3 L=0.28U W=0.36U AS=0.1854P AD=0.1584P
+ PS=1.75U PD=1.6U
M$5058 VSS RA2 \$4336 VSS nfet_03v3 L=0.28U W=0.36U AS=0.1854P AD=0.1584P
+ PS=1.75U PD=1.6U
M$5059 \$4130 RA3 VSS VSS nfet_03v3 L=0.28U W=0.36U AS=0.1656P AD=0.1944P
+ PS=1.64U PD=1.8U
M$5060 \$4341 RB2 VSS VSS nfet_03v3 L=0.28U W=0.36U AS=0.1656P AD=0.1944P
+ PS=1.64U PD=1.8U
M$5061 \$4023 RA3 \$55 VSS nfet_03v3 L=0.28U W=0.36U AS=0.1584P AD=0.1152P
+ PS=1.6U PD=1U
M$5062 \$56 RB3 \$4023 VSS nfet_03v3 L=0.28U W=0.36U AS=0.1152P AD=0.1584P
+ PS=1U PD=1.6U
M$5063 \$4340 RB2 \$55 VSS nfet_03v3 L=0.28U W=0.36U AS=0.1584P AD=0.1152P
+ PS=1.6U PD=1U
M$5064 \$56 RA2 \$4340 VSS nfet_03v3 L=0.28U W=0.36U AS=0.1152P AD=0.1584P
+ PS=1U PD=1.6U
M$5065 VSS RA2 \$4342 VSS nfet_03v3 L=0.28U W=0.36U AS=0.1854P AD=0.1584P
+ PS=1.75U PD=1.6U
M$5066 VSS RB3 \$4131 VSS nfet_03v3 L=0.28U W=0.36U AS=0.1854P AD=0.1584P
+ PS=1.75U PD=1.6U
M$5067 \$4132 RA3 VSS VSS nfet_03v3 L=0.28U W=0.36U AS=0.1656P AD=0.1944P
+ PS=1.64U PD=1.8U
M$5068 \$4347 RB2 VSS VSS nfet_03v3 L=0.28U W=0.36U AS=0.1656P AD=0.1944P
+ PS=1.64U PD=1.8U
M$5069 \$4027 RA3 \$57 VSS nfet_03v3 L=0.28U W=0.36U AS=0.1584P AD=0.1152P
+ PS=1.6U PD=1U
M$5070 \$58 RB3 \$4027 VSS nfet_03v3 L=0.28U W=0.36U AS=0.1152P AD=0.1584P
+ PS=1U PD=1.6U
M$5071 \$4346 RB2 \$57 VSS nfet_03v3 L=0.28U W=0.36U AS=0.1584P AD=0.1152P
+ PS=1.6U PD=1U
M$5072 \$58 RA2 \$4346 VSS nfet_03v3 L=0.28U W=0.36U AS=0.1152P AD=0.1584P
+ PS=1U PD=1.6U
M$5073 VSS RA2 \$4348 VSS nfet_03v3 L=0.28U W=0.36U AS=0.1854P AD=0.1584P
+ PS=1.75U PD=1.6U
M$5074 VSS RB3 \$4133 VSS nfet_03v3 L=0.28U W=0.36U AS=0.1854P AD=0.1584P
+ PS=1.75U PD=1.6U
M$5075 \$4353 RB2 VSS VSS nfet_03v3 L=0.28U W=0.36U AS=0.1656P AD=0.1944P
+ PS=1.64U PD=1.8U
M$5076 \$4134 RA3 VSS VSS nfet_03v3 L=0.28U W=0.36U AS=0.1656P AD=0.1944P
+ PS=1.64U PD=1.8U
M$5077 \$4352 RB2 \$59 VSS nfet_03v3 L=0.28U W=0.36U AS=0.1584P AD=0.1152P
+ PS=1.6U PD=1U
M$5078 \$60 RA2 \$4352 VSS nfet_03v3 L=0.28U W=0.36U AS=0.1152P AD=0.1584P
+ PS=1U PD=1.6U
M$5079 \$4031 RA3 \$59 VSS nfet_03v3 L=0.28U W=0.36U AS=0.1584P AD=0.1152P
+ PS=1.6U PD=1U
M$5080 \$60 RB3 \$4031 VSS nfet_03v3 L=0.28U W=0.36U AS=0.1152P AD=0.1584P
+ PS=1U PD=1.6U
M$5081 VSS RB3 \$4135 VSS nfet_03v3 L=0.28U W=0.36U AS=0.1854P AD=0.1584P
+ PS=1.75U PD=1.6U
M$5082 VSS RA2 \$4354 VSS nfet_03v3 L=0.28U W=0.36U AS=0.1854P AD=0.1584P
+ PS=1.75U PD=1.6U
M$5083 \$4136 RA3 VSS VSS nfet_03v3 L=0.28U W=0.36U AS=0.1656P AD=0.1944P
+ PS=1.64U PD=1.8U
M$5084 \$4359 RB2 VSS VSS nfet_03v3 L=0.28U W=0.36U AS=0.1656P AD=0.1944P
+ PS=1.64U PD=1.8U
M$5085 \$4358 RB2 \$61 VSS nfet_03v3 L=0.28U W=0.36U AS=0.1584P AD=0.1152P
+ PS=1.6U PD=1U
M$5086 \$62 RA2 \$4358 VSS nfet_03v3 L=0.28U W=0.36U AS=0.1152P AD=0.1584P
+ PS=1U PD=1.6U
M$5087 \$4035 RA3 \$61 VSS nfet_03v3 L=0.28U W=0.36U AS=0.1584P AD=0.1152P
+ PS=1.6U PD=1U
M$5088 \$62 RB3 \$4035 VSS nfet_03v3 L=0.28U W=0.36U AS=0.1152P AD=0.1584P
+ PS=1U PD=1.6U
M$5089 VSS RB3 \$4137 VSS nfet_03v3 L=0.28U W=0.36U AS=0.1854P AD=0.1584P
+ PS=1.75U PD=1.6U
M$5090 VSS RA2 \$4360 VSS nfet_03v3 L=0.28U W=0.36U AS=0.1854P AD=0.1584P
+ PS=1.75U PD=1.6U
M$5091 \$4365 RB2 VSS VSS nfet_03v3 L=0.28U W=0.36U AS=0.1656P AD=0.1944P
+ PS=1.64U PD=1.8U
M$5092 \$4138 RA3 VSS VSS nfet_03v3 L=0.28U W=0.36U AS=0.1656P AD=0.1944P
+ PS=1.64U PD=1.8U
M$5093 \$4039 RA3 \$63 VSS nfet_03v3 L=0.28U W=0.36U AS=0.1584P AD=0.1152P
+ PS=1.6U PD=1U
M$5094 \$64 RB3 \$4039 VSS nfet_03v3 L=0.28U W=0.36U AS=0.1152P AD=0.1584P
+ PS=1U PD=1.6U
M$5095 \$4364 RB2 \$63 VSS nfet_03v3 L=0.28U W=0.36U AS=0.1584P AD=0.1152P
+ PS=1.6U PD=1U
M$5096 \$64 RA2 \$4364 VSS nfet_03v3 L=0.28U W=0.36U AS=0.1152P AD=0.1584P
+ PS=1U PD=1.6U
M$5097 VSS RB3 \$4139 VSS nfet_03v3 L=0.28U W=0.36U AS=0.1854P AD=0.1584P
+ PS=1.75U PD=1.6U
M$5098 VSS RA2 \$4366 VSS nfet_03v3 L=0.28U W=0.36U AS=0.1854P AD=0.1584P
+ PS=1.75U PD=1.6U
M$5099 \$4371 RB2 VSS VSS nfet_03v3 L=0.28U W=0.36U AS=0.1656P AD=0.1944P
+ PS=1.64U PD=1.8U
M$5100 \$4140 RA3 VSS VSS nfet_03v3 L=0.28U W=0.36U AS=0.1656P AD=0.1944P
+ PS=1.64U PD=1.8U
M$5101 \$4043 RA3 \$65 VSS nfet_03v3 L=0.28U W=0.36U AS=0.1584P AD=0.1152P
+ PS=1.6U PD=1U
M$5102 \$66 RB3 \$4043 VSS nfet_03v3 L=0.28U W=0.36U AS=0.1152P AD=0.1584P
+ PS=1U PD=1.6U
M$5103 \$4370 RB2 \$65 VSS nfet_03v3 L=0.28U W=0.36U AS=0.1584P AD=0.1152P
+ PS=1.6U PD=1U
M$5104 \$66 RA2 \$4370 VSS nfet_03v3 L=0.28U W=0.36U AS=0.1152P AD=0.1584P
+ PS=1U PD=1.6U
M$5105 VSS RB3 \$4141 VSS nfet_03v3 L=0.28U W=0.36U AS=0.1854P AD=0.1584P
+ PS=1.75U PD=1.6U
M$5106 VSS RA2 \$4372 VSS nfet_03v3 L=0.28U W=0.36U AS=0.1854P AD=0.1584P
+ PS=1.75U PD=1.6U
M$5107 \$4142 RA3 VSS VSS nfet_03v3 L=0.28U W=0.36U AS=0.1656P AD=0.1944P
+ PS=1.64U PD=1.8U
M$5108 \$4377 RB2 VSS VSS nfet_03v3 L=0.28U W=0.36U AS=0.1656P AD=0.1944P
+ PS=1.64U PD=1.8U
M$5109 \$4376 RB2 \$67 VSS nfet_03v3 L=0.28U W=0.36U AS=0.1584P AD=0.1152P
+ PS=1.6U PD=1U
M$5110 \$68 RA2 \$4376 VSS nfet_03v3 L=0.28U W=0.36U AS=0.1152P AD=0.1584P
+ PS=1U PD=1.6U
M$5111 \$4047 RA3 \$67 VSS nfet_03v3 L=0.28U W=0.36U AS=0.1584P AD=0.1152P
+ PS=1.6U PD=1U
M$5112 \$68 RB3 \$4047 VSS nfet_03v3 L=0.28U W=0.36U AS=0.1152P AD=0.1584P
+ PS=1U PD=1.6U
M$5113 VSS RA2 \$4378 VSS nfet_03v3 L=0.28U W=0.36U AS=0.1854P AD=0.1584P
+ PS=1.75U PD=1.6U
M$5114 VSS RB3 \$4143 VSS nfet_03v3 L=0.28U W=0.36U AS=0.1854P AD=0.1584P
+ PS=1.75U PD=1.6U
M$5115 \$4144 RA3 VSS VSS nfet_03v3 L=0.28U W=0.36U AS=0.1656P AD=0.1944P
+ PS=1.64U PD=1.8U
M$5116 \$4383 RB2 VSS VSS nfet_03v3 L=0.28U W=0.36U AS=0.1656P AD=0.1944P
+ PS=1.64U PD=1.8U
M$5117 \$4051 RA3 \$69 VSS nfet_03v3 L=0.28U W=0.36U AS=0.1584P AD=0.1152P
+ PS=1.6U PD=1U
M$5118 \$70 RB3 \$4051 VSS nfet_03v3 L=0.28U W=0.36U AS=0.1152P AD=0.1584P
+ PS=1U PD=1.6U
M$5119 \$4382 RB2 \$69 VSS nfet_03v3 L=0.28U W=0.36U AS=0.1584P AD=0.1152P
+ PS=1.6U PD=1U
M$5120 \$70 RA2 \$4382 VSS nfet_03v3 L=0.28U W=0.36U AS=0.1152P AD=0.1584P
+ PS=1U PD=1.6U
M$5121 VSS RB3 \$4145 VSS nfet_03v3 L=0.28U W=0.36U AS=0.1854P AD=0.1584P
+ PS=1.75U PD=1.6U
M$5122 VSS RA2 \$4384 VSS nfet_03v3 L=0.28U W=0.36U AS=0.1854P AD=0.1584P
+ PS=1.75U PD=1.6U
M$5123 \$4389 RB2 VSS VSS nfet_03v3 L=0.28U W=0.36U AS=0.1656P AD=0.1944P
+ PS=1.64U PD=1.8U
M$5124 \$4146 RA3 VSS VSS nfet_03v3 L=0.28U W=0.36U AS=0.1656P AD=0.1944P
+ PS=1.64U PD=1.8U
M$5125 \$4388 RB2 \$71 VSS nfet_03v3 L=0.28U W=0.36U AS=0.1584P AD=0.1152P
+ PS=1.6U PD=1U
M$5126 \$72 RA2 \$4388 VSS nfet_03v3 L=0.28U W=0.36U AS=0.1152P AD=0.1584P
+ PS=1U PD=1.6U
M$5127 \$4055 RA3 \$71 VSS nfet_03v3 L=0.28U W=0.36U AS=0.1584P AD=0.1152P
+ PS=1.6U PD=1U
M$5128 \$72 RB3 \$4055 VSS nfet_03v3 L=0.28U W=0.36U AS=0.1152P AD=0.1584P
+ PS=1U PD=1.6U
M$5129 VSS RB3 \$4147 VSS nfet_03v3 L=0.28U W=0.36U AS=0.1854P AD=0.1584P
+ PS=1.75U PD=1.6U
M$5130 VSS RA2 \$4390 VSS nfet_03v3 L=0.28U W=0.36U AS=0.1854P AD=0.1584P
+ PS=1.75U PD=1.6U
M$5131 \$4395 RB2 VSS VSS nfet_03v3 L=0.28U W=0.36U AS=0.1656P AD=0.1944P
+ PS=1.64U PD=1.8U
M$5132 \$4148 RA3 VSS VSS nfet_03v3 L=0.28U W=0.36U AS=0.1656P AD=0.1944P
+ PS=1.64U PD=1.8U
M$5133 \$4059 RA3 \$73 VSS nfet_03v3 L=0.28U W=0.36U AS=0.1584P AD=0.1152P
+ PS=1.6U PD=1U
M$5134 \$74 RB3 \$4059 VSS nfet_03v3 L=0.28U W=0.36U AS=0.1152P AD=0.1584P
+ PS=1U PD=1.6U
M$5135 \$4394 RB2 \$73 VSS nfet_03v3 L=0.28U W=0.36U AS=0.1584P AD=0.1152P
+ PS=1.6U PD=1U
M$5136 \$74 RA2 \$4394 VSS nfet_03v3 L=0.28U W=0.36U AS=0.1152P AD=0.1584P
+ PS=1U PD=1.6U
M$5137 VSS RB3 \$4149 VSS nfet_03v3 L=0.28U W=0.36U AS=0.1854P AD=0.1584P
+ PS=1.75U PD=1.6U
M$5138 VSS RA2 \$4396 VSS nfet_03v3 L=0.28U W=0.36U AS=0.1854P AD=0.1584P
+ PS=1.75U PD=1.6U
M$5139 \$4150 RA3 VSS VSS nfet_03v3 L=0.28U W=0.36U AS=0.1656P AD=0.1944P
+ PS=1.64U PD=1.8U
M$5140 \$4401 RB2 VSS VSS nfet_03v3 L=0.28U W=0.36U AS=0.1656P AD=0.1944P
+ PS=1.64U PD=1.8U
M$5141 \$4400 RB2 \$75 VSS nfet_03v3 L=0.28U W=0.36U AS=0.1584P AD=0.1152P
+ PS=1.6U PD=1U
M$5142 \$76 RA2 \$4400 VSS nfet_03v3 L=0.28U W=0.36U AS=0.1152P AD=0.1584P
+ PS=1U PD=1.6U
M$5143 \$4063 RA3 \$75 VSS nfet_03v3 L=0.28U W=0.36U AS=0.1584P AD=0.1152P
+ PS=1.6U PD=1U
M$5144 \$76 RB3 \$4063 VSS nfet_03v3 L=0.28U W=0.36U AS=0.1152P AD=0.1584P
+ PS=1U PD=1.6U
M$5145 VSS RA2 \$4402 VSS nfet_03v3 L=0.28U W=0.36U AS=0.1854P AD=0.1584P
+ PS=1.75U PD=1.6U
M$5146 VSS RB3 \$4151 VSS nfet_03v3 L=0.28U W=0.36U AS=0.1854P AD=0.1584P
+ PS=1.75U PD=1.6U
M$5147 \$4407 RB2 VSS VSS nfet_03v3 L=0.28U W=0.36U AS=0.1656P AD=0.1944P
+ PS=1.64U PD=1.8U
M$5148 \$4152 RA3 VSS VSS nfet_03v3 L=0.28U W=0.36U AS=0.1656P AD=0.1944P
+ PS=1.64U PD=1.8U
M$5149 \$4406 RB2 \$77 VSS nfet_03v3 L=0.28U W=0.36U AS=0.1584P AD=0.1152P
+ PS=1.6U PD=1U
M$5150 \$78 RA2 \$4406 VSS nfet_03v3 L=0.28U W=0.36U AS=0.1152P AD=0.1584P
+ PS=1U PD=1.6U
M$5151 \$4067 RA3 \$77 VSS nfet_03v3 L=0.28U W=0.36U AS=0.1584P AD=0.1152P
+ PS=1.6U PD=1U
M$5152 \$78 RB3 \$4067 VSS nfet_03v3 L=0.28U W=0.36U AS=0.1152P AD=0.1584P
+ PS=1U PD=1.6U
M$5153 VSS RB3 \$4153 VSS nfet_03v3 L=0.28U W=0.36U AS=0.1854P AD=0.1584P
+ PS=1.75U PD=1.6U
M$5154 VSS RA2 \$4408 VSS nfet_03v3 L=0.28U W=0.36U AS=0.1854P AD=0.1584P
+ PS=1.75U PD=1.6U
M$5155 \$4413 RB2 VSS VSS nfet_03v3 L=0.28U W=0.36U AS=0.1656P AD=0.1944P
+ PS=1.64U PD=1.8U
M$5156 \$4154 RA3 VSS VSS nfet_03v3 L=0.28U W=0.36U AS=0.1656P AD=0.1944P
+ PS=1.64U PD=1.8U
M$5157 \$4071 RA3 \$79 VSS nfet_03v3 L=0.28U W=0.36U AS=0.1584P AD=0.1152P
+ PS=1.6U PD=1U
M$5158 \$80 RB3 \$4071 VSS nfet_03v3 L=0.28U W=0.36U AS=0.1152P AD=0.1584P
+ PS=1U PD=1.6U
M$5159 \$4412 RB2 \$79 VSS nfet_03v3 L=0.28U W=0.36U AS=0.1584P AD=0.1152P
+ PS=1.6U PD=1U
M$5160 \$80 RA2 \$4412 VSS nfet_03v3 L=0.28U W=0.36U AS=0.1152P AD=0.1584P
+ PS=1U PD=1.6U
M$5161 VSS RA2 \$4414 VSS nfet_03v3 L=0.28U W=0.36U AS=0.1854P AD=0.1584P
+ PS=1.75U PD=1.6U
M$5162 VSS RB3 \$4155 VSS nfet_03v3 L=0.28U W=0.36U AS=0.1854P AD=0.1584P
+ PS=1.75U PD=1.6U
M$5163 \$4156 RA3 VSS VSS nfet_03v3 L=0.28U W=0.36U AS=0.1656P AD=0.1944P
+ PS=1.64U PD=1.8U
M$5164 \$4419 RB2 VSS VSS nfet_03v3 L=0.28U W=0.36U AS=0.1656P AD=0.1944P
+ PS=1.64U PD=1.8U
M$5165 \$4075 RA3 \$81 VSS nfet_03v3 L=0.28U W=0.36U AS=0.1584P AD=0.1152P
+ PS=1.6U PD=1U
M$5166 \$82 RB3 \$4075 VSS nfet_03v3 L=0.28U W=0.36U AS=0.1152P AD=0.1584P
+ PS=1U PD=1.6U
M$5167 \$4418 RB2 \$81 VSS nfet_03v3 L=0.28U W=0.36U AS=0.1584P AD=0.1152P
+ PS=1.6U PD=1U
M$5168 \$82 RA2 \$4418 VSS nfet_03v3 L=0.28U W=0.36U AS=0.1152P AD=0.1584P
+ PS=1U PD=1.6U
M$5169 VSS RB3 \$4157 VSS nfet_03v3 L=0.28U W=0.36U AS=0.1854P AD=0.1584P
+ PS=1.75U PD=1.6U
M$5170 VSS RA2 \$4420 VSS nfet_03v3 L=0.28U W=0.36U AS=0.1854P AD=0.1584P
+ PS=1.75U PD=1.6U
M$5171 \$4524 WE2 VSS VSS nfet_03v3 L=0.28U W=0.72U AS=0.3168P AD=0.1872P
+ PS=2.32U PD=1.24U
M$5172 \$4319 CLK \$4524 VSS nfet_03v3 L=0.28U W=0.72U AS=0.1872P AD=0.3168P
+ PS=1.24U PD=2.32U
M$5173 \$4321 \$4319 VSS VSS nfet_03v3 L=0.28U W=0.635U AS=0.2794P AD=0.1651P
+ PS=2.15U PD=1.155U
M$5174 \$4321 \$4319 VSS VSS nfet_03v3 L=0.28U W=0.635U AS=0.1693P AD=0.1651P
+ PS=1.19U PD=1.155U
M$5175 \$4322 \$4321 VSS VSS nfet_03v3 L=0.28U W=0.67U AS=0.1693P AD=0.1943P
+ PS=1.19U PD=1.25U
M$5176 VSS \$4321 \$4322 VSS nfet_03v3 L=0.28U W=0.67U AS=0.1943P AD=0.2948P
+ PS=1.25U PD=2.22U
M$5177 \$4325 \$106 VSS VSS nfet_03v3 L=0.28U W=0.36U AS=0.1584P AD=0.1188P
+ PS=1.6U PD=1.02U
M$5178 \$4326 \$4321 \$4325 VSS nfet_03v3 L=0.28U W=0.36U AS=0.1188P AD=0.1278P
+ PS=1.02U PD=1.07U
M$5179 \$4529 \$4327 \$4326 VSS nfet_03v3 L=0.28U W=0.36U AS=0.1278P AD=0.0567P
+ PS=1.07U PD=0.675U
M$5180 VSS \$4322 \$4529 VSS nfet_03v3 L=0.28U W=0.36U AS=0.0567P AD=0.1584P
+ PS=0.675U PD=1.6U
M$5181 VSS \$4326 \$4327 VSS nfet_03v3 L=0.28U W=0.36U AS=0.1584P AD=0.0972P
+ PS=1.6U PD=0.9U
M$5182 \$4328 \$4326 VSS VSS nfet_03v3 L=0.28U W=0.36U AS=0.0972P AD=0.18P
+ PS=0.9U PD=1.72U
M$5183 \$4331 \$109 VSS VSS nfet_03v3 L=0.28U W=0.36U AS=0.1584P AD=0.1188P
+ PS=1.6U PD=1.02U
M$5184 \$4332 \$4321 \$4331 VSS nfet_03v3 L=0.28U W=0.36U AS=0.1188P AD=0.1278P
+ PS=1.02U PD=1.07U
M$5185 \$4538 \$4333 \$4332 VSS nfet_03v3 L=0.28U W=0.36U AS=0.1278P AD=0.0567P
+ PS=1.07U PD=0.675U
M$5186 VSS \$4322 \$4538 VSS nfet_03v3 L=0.28U W=0.36U AS=0.0567P AD=0.1584P
+ PS=0.675U PD=1.6U
M$5187 VSS \$4332 \$4333 VSS nfet_03v3 L=0.28U W=0.36U AS=0.1584P AD=0.0972P
+ PS=1.6U PD=0.9U
M$5188 \$4334 \$4332 VSS VSS nfet_03v3 L=0.28U W=0.36U AS=0.0972P AD=0.18P
+ PS=0.9U PD=1.72U
M$5189 \$4337 \$112 VSS VSS nfet_03v3 L=0.28U W=0.36U AS=0.1584P AD=0.1188P
+ PS=1.6U PD=1.02U
M$5190 \$4338 \$4321 \$4337 VSS nfet_03v3 L=0.28U W=0.36U AS=0.1188P AD=0.1278P
+ PS=1.02U PD=1.07U
M$5191 \$4545 \$4339 \$4338 VSS nfet_03v3 L=0.28U W=0.36U AS=0.1278P AD=0.0567P
+ PS=1.07U PD=0.675U
M$5192 VSS \$4322 \$4545 VSS nfet_03v3 L=0.28U W=0.36U AS=0.0567P AD=0.1584P
+ PS=0.675U PD=1.6U
M$5193 VSS \$4338 \$4339 VSS nfet_03v3 L=0.28U W=0.36U AS=0.1584P AD=0.0972P
+ PS=1.6U PD=0.9U
M$5194 \$4340 \$4338 VSS VSS nfet_03v3 L=0.28U W=0.36U AS=0.0972P AD=0.18P
+ PS=0.9U PD=1.72U
M$5195 \$4343 \$115 VSS VSS nfet_03v3 L=0.28U W=0.36U AS=0.1584P AD=0.1188P
+ PS=1.6U PD=1.02U
M$5196 \$4344 \$4321 \$4343 VSS nfet_03v3 L=0.28U W=0.36U AS=0.1188P AD=0.1278P
+ PS=1.02U PD=1.07U
M$5197 \$4553 \$4345 \$4344 VSS nfet_03v3 L=0.28U W=0.36U AS=0.1278P AD=0.0567P
+ PS=1.07U PD=0.675U
M$5198 VSS \$4322 \$4553 VSS nfet_03v3 L=0.28U W=0.36U AS=0.0567P AD=0.1584P
+ PS=0.675U PD=1.6U
M$5199 VSS \$4344 \$4345 VSS nfet_03v3 L=0.28U W=0.36U AS=0.1584P AD=0.0972P
+ PS=1.6U PD=0.9U
M$5200 \$4346 \$4344 VSS VSS nfet_03v3 L=0.28U W=0.36U AS=0.0972P AD=0.18P
+ PS=0.9U PD=1.72U
M$5201 \$4349 \$118 VSS VSS nfet_03v3 L=0.28U W=0.36U AS=0.1584P AD=0.1188P
+ PS=1.6U PD=1.02U
M$5202 \$4350 \$4321 \$4349 VSS nfet_03v3 L=0.28U W=0.36U AS=0.1188P AD=0.1278P
+ PS=1.02U PD=1.07U
M$5203 \$4562 \$4351 \$4350 VSS nfet_03v3 L=0.28U W=0.36U AS=0.1278P AD=0.0567P
+ PS=1.07U PD=0.675U
M$5204 VSS \$4322 \$4562 VSS nfet_03v3 L=0.28U W=0.36U AS=0.0567P AD=0.1584P
+ PS=0.675U PD=1.6U
M$5205 VSS \$4350 \$4351 VSS nfet_03v3 L=0.28U W=0.36U AS=0.1584P AD=0.0972P
+ PS=1.6U PD=0.9U
M$5206 \$4352 \$4350 VSS VSS nfet_03v3 L=0.28U W=0.36U AS=0.0972P AD=0.18P
+ PS=0.9U PD=1.72U
M$5207 \$4355 \$121 VSS VSS nfet_03v3 L=0.28U W=0.36U AS=0.1584P AD=0.1188P
+ PS=1.6U PD=1.02U
M$5208 \$4356 \$4321 \$4355 VSS nfet_03v3 L=0.28U W=0.36U AS=0.1188P AD=0.1278P
+ PS=1.02U PD=1.07U
M$5209 \$4569 \$4357 \$4356 VSS nfet_03v3 L=0.28U W=0.36U AS=0.1278P AD=0.0567P
+ PS=1.07U PD=0.675U
M$5210 VSS \$4322 \$4569 VSS nfet_03v3 L=0.28U W=0.36U AS=0.0567P AD=0.1584P
+ PS=0.675U PD=1.6U
M$5211 VSS \$4356 \$4357 VSS nfet_03v3 L=0.28U W=0.36U AS=0.1584P AD=0.0972P
+ PS=1.6U PD=0.9U
M$5212 \$4358 \$4356 VSS VSS nfet_03v3 L=0.28U W=0.36U AS=0.0972P AD=0.18P
+ PS=0.9U PD=1.72U
M$5213 \$4361 \$124 VSS VSS nfet_03v3 L=0.28U W=0.36U AS=0.1584P AD=0.1188P
+ PS=1.6U PD=1.02U
M$5214 \$4362 \$4321 \$4361 VSS nfet_03v3 L=0.28U W=0.36U AS=0.1188P AD=0.1278P
+ PS=1.02U PD=1.07U
M$5215 \$4577 \$4363 \$4362 VSS nfet_03v3 L=0.28U W=0.36U AS=0.1278P AD=0.0567P
+ PS=1.07U PD=0.675U
M$5216 VSS \$4322 \$4577 VSS nfet_03v3 L=0.28U W=0.36U AS=0.0567P AD=0.1584P
+ PS=0.675U PD=1.6U
M$5217 VSS \$4362 \$4363 VSS nfet_03v3 L=0.28U W=0.36U AS=0.1584P AD=0.0972P
+ PS=1.6U PD=0.9U
M$5218 \$4364 \$4362 VSS VSS nfet_03v3 L=0.28U W=0.36U AS=0.0972P AD=0.18P
+ PS=0.9U PD=1.72U
M$5219 \$4367 \$127 VSS VSS nfet_03v3 L=0.28U W=0.36U AS=0.1584P AD=0.1188P
+ PS=1.6U PD=1.02U
M$5220 \$4368 \$4321 \$4367 VSS nfet_03v3 L=0.28U W=0.36U AS=0.1188P AD=0.1278P
+ PS=1.02U PD=1.07U
M$5221 \$4586 \$4369 \$4368 VSS nfet_03v3 L=0.28U W=0.36U AS=0.1278P AD=0.0567P
+ PS=1.07U PD=0.675U
M$5222 VSS \$4322 \$4586 VSS nfet_03v3 L=0.28U W=0.36U AS=0.0567P AD=0.1584P
+ PS=0.675U PD=1.6U
M$5223 VSS \$4368 \$4369 VSS nfet_03v3 L=0.28U W=0.36U AS=0.1584P AD=0.0972P
+ PS=1.6U PD=0.9U
M$5224 \$4370 \$4368 VSS VSS nfet_03v3 L=0.28U W=0.36U AS=0.0972P AD=0.18P
+ PS=0.9U PD=1.72U
M$5225 \$4373 \$130 VSS VSS nfet_03v3 L=0.28U W=0.36U AS=0.1584P AD=0.1188P
+ PS=1.6U PD=1.02U
M$5226 \$4374 \$4321 \$4373 VSS nfet_03v3 L=0.28U W=0.36U AS=0.1188P AD=0.1278P
+ PS=1.02U PD=1.07U
M$5227 \$4593 \$4375 \$4374 VSS nfet_03v3 L=0.28U W=0.36U AS=0.1278P AD=0.0567P
+ PS=1.07U PD=0.675U
M$5228 VSS \$4322 \$4593 VSS nfet_03v3 L=0.28U W=0.36U AS=0.0567P AD=0.1584P
+ PS=0.675U PD=1.6U
M$5229 VSS \$4374 \$4375 VSS nfet_03v3 L=0.28U W=0.36U AS=0.1584P AD=0.0972P
+ PS=1.6U PD=0.9U
M$5230 \$4376 \$4374 VSS VSS nfet_03v3 L=0.28U W=0.36U AS=0.0972P AD=0.18P
+ PS=0.9U PD=1.72U
M$5231 \$4379 \$133 VSS VSS nfet_03v3 L=0.28U W=0.36U AS=0.1584P AD=0.1188P
+ PS=1.6U PD=1.02U
M$5232 \$4380 \$4321 \$4379 VSS nfet_03v3 L=0.28U W=0.36U AS=0.1188P AD=0.1278P
+ PS=1.02U PD=1.07U
M$5233 \$4601 \$4381 \$4380 VSS nfet_03v3 L=0.28U W=0.36U AS=0.1278P AD=0.0567P
+ PS=1.07U PD=0.675U
M$5234 VSS \$4322 \$4601 VSS nfet_03v3 L=0.28U W=0.36U AS=0.0567P AD=0.1584P
+ PS=0.675U PD=1.6U
M$5235 VSS \$4380 \$4381 VSS nfet_03v3 L=0.28U W=0.36U AS=0.1584P AD=0.0972P
+ PS=1.6U PD=0.9U
M$5236 \$4382 \$4380 VSS VSS nfet_03v3 L=0.28U W=0.36U AS=0.0972P AD=0.18P
+ PS=0.9U PD=1.72U
M$5237 \$4385 \$136 VSS VSS nfet_03v3 L=0.28U W=0.36U AS=0.1584P AD=0.1188P
+ PS=1.6U PD=1.02U
M$5238 \$4386 \$4321 \$4385 VSS nfet_03v3 L=0.28U W=0.36U AS=0.1188P AD=0.1278P
+ PS=1.02U PD=1.07U
M$5239 \$4610 \$4387 \$4386 VSS nfet_03v3 L=0.28U W=0.36U AS=0.1278P AD=0.0567P
+ PS=1.07U PD=0.675U
M$5240 VSS \$4322 \$4610 VSS nfet_03v3 L=0.28U W=0.36U AS=0.0567P AD=0.1584P
+ PS=0.675U PD=1.6U
M$5241 VSS \$4386 \$4387 VSS nfet_03v3 L=0.28U W=0.36U AS=0.1584P AD=0.0972P
+ PS=1.6U PD=0.9U
M$5242 \$4388 \$4386 VSS VSS nfet_03v3 L=0.28U W=0.36U AS=0.0972P AD=0.18P
+ PS=0.9U PD=1.72U
M$5243 \$4391 \$139 VSS VSS nfet_03v3 L=0.28U W=0.36U AS=0.1584P AD=0.1188P
+ PS=1.6U PD=1.02U
M$5244 \$4392 \$4321 \$4391 VSS nfet_03v3 L=0.28U W=0.36U AS=0.1188P AD=0.1278P
+ PS=1.02U PD=1.07U
M$5245 \$4617 \$4393 \$4392 VSS nfet_03v3 L=0.28U W=0.36U AS=0.1278P AD=0.0567P
+ PS=1.07U PD=0.675U
M$5246 VSS \$4322 \$4617 VSS nfet_03v3 L=0.28U W=0.36U AS=0.0567P AD=0.1584P
+ PS=0.675U PD=1.6U
M$5247 VSS \$4392 \$4393 VSS nfet_03v3 L=0.28U W=0.36U AS=0.1584P AD=0.0972P
+ PS=1.6U PD=0.9U
M$5248 \$4394 \$4392 VSS VSS nfet_03v3 L=0.28U W=0.36U AS=0.0972P AD=0.18P
+ PS=0.9U PD=1.72U
M$5249 \$4397 \$142 VSS VSS nfet_03v3 L=0.28U W=0.36U AS=0.1584P AD=0.1188P
+ PS=1.6U PD=1.02U
M$5250 \$4398 \$4321 \$4397 VSS nfet_03v3 L=0.28U W=0.36U AS=0.1188P AD=0.1278P
+ PS=1.02U PD=1.07U
M$5251 \$4609 \$4399 \$4398 VSS nfet_03v3 L=0.28U W=0.36U AS=0.1278P AD=0.0567P
+ PS=1.07U PD=0.675U
M$5252 VSS \$4322 \$4609 VSS nfet_03v3 L=0.28U W=0.36U AS=0.0567P AD=0.1584P
+ PS=0.675U PD=1.6U
M$5253 VSS \$4398 \$4399 VSS nfet_03v3 L=0.28U W=0.36U AS=0.1584P AD=0.0972P
+ PS=1.6U PD=0.9U
M$5254 \$4400 \$4398 VSS VSS nfet_03v3 L=0.28U W=0.36U AS=0.0972P AD=0.18P
+ PS=0.9U PD=1.72U
M$5255 \$4403 \$145 VSS VSS nfet_03v3 L=0.28U W=0.36U AS=0.1584P AD=0.1188P
+ PS=1.6U PD=1.02U
M$5256 \$4404 \$4321 \$4403 VSS nfet_03v3 L=0.28U W=0.36U AS=0.1188P AD=0.1278P
+ PS=1.02U PD=1.07U
M$5257 \$4585 \$4405 \$4404 VSS nfet_03v3 L=0.28U W=0.36U AS=0.1278P AD=0.0567P
+ PS=1.07U PD=0.675U
M$5258 VSS \$4322 \$4585 VSS nfet_03v3 L=0.28U W=0.36U AS=0.0567P AD=0.1584P
+ PS=0.675U PD=1.6U
M$5259 VSS \$4404 \$4405 VSS nfet_03v3 L=0.28U W=0.36U AS=0.1584P AD=0.0972P
+ PS=1.6U PD=0.9U
M$5260 \$4406 \$4404 VSS VSS nfet_03v3 L=0.28U W=0.36U AS=0.0972P AD=0.18P
+ PS=0.9U PD=1.72U
M$5261 \$4409 \$148 VSS VSS nfet_03v3 L=0.28U W=0.36U AS=0.1584P AD=0.1188P
+ PS=1.6U PD=1.02U
M$5262 \$4410 \$4321 \$4409 VSS nfet_03v3 L=0.28U W=0.36U AS=0.1188P AD=0.1278P
+ PS=1.02U PD=1.07U
M$5263 \$4561 \$4411 \$4410 VSS nfet_03v3 L=0.28U W=0.36U AS=0.1278P AD=0.0567P
+ PS=1.07U PD=0.675U
M$5264 VSS \$4322 \$4561 VSS nfet_03v3 L=0.28U W=0.36U AS=0.0567P AD=0.1584P
+ PS=0.675U PD=1.6U
M$5265 VSS \$4410 \$4411 VSS nfet_03v3 L=0.28U W=0.36U AS=0.1584P AD=0.0972P
+ PS=1.6U PD=0.9U
M$5266 \$4412 \$4410 VSS VSS nfet_03v3 L=0.28U W=0.36U AS=0.0972P AD=0.18P
+ PS=0.9U PD=1.72U
M$5267 \$4415 \$151 VSS VSS nfet_03v3 L=0.28U W=0.36U AS=0.1584P AD=0.1188P
+ PS=1.6U PD=1.02U
M$5268 \$4416 \$4321 \$4415 VSS nfet_03v3 L=0.28U W=0.36U AS=0.1188P AD=0.1278P
+ PS=1.02U PD=1.07U
M$5269 \$4537 \$4417 \$4416 VSS nfet_03v3 L=0.28U W=0.36U AS=0.1278P AD=0.0567P
+ PS=1.07U PD=0.675U
M$5270 VSS \$4322 \$4537 VSS nfet_03v3 L=0.28U W=0.36U AS=0.0567P AD=0.1584P
+ PS=0.675U PD=1.6U
M$5271 VSS \$4416 \$4417 VSS nfet_03v3 L=0.28U W=0.36U AS=0.1584P AD=0.0972P
+ PS=1.6U PD=0.9U
M$5272 \$4418 \$4416 VSS VSS nfet_03v3 L=0.28U W=0.36U AS=0.0972P AD=0.18P
+ PS=0.9U PD=1.72U
M$5273 \$4777 WE1 VSS VSS nfet_03v3 L=0.28U W=0.72U AS=0.3168P AD=0.1872P
+ PS=2.32U PD=1.24U
M$5274 \$4622 CLK \$4777 VSS nfet_03v3 L=0.28U W=0.72U AS=0.1872P AD=0.3168P
+ PS=1.24U PD=2.32U
M$5275 \$4623 \$4622 VSS VSS nfet_03v3 L=0.28U W=0.635U AS=0.2794P AD=0.1651P
+ PS=2.15U PD=1.155U
M$5276 VSS \$4622 \$4623 VSS nfet_03v3 L=0.28U W=0.635U AS=0.1651P AD=0.1693P
+ PS=1.155U PD=1.19U
M$5277 \$4624 \$4623 VSS VSS nfet_03v3 L=0.28U W=0.67U AS=0.1693P AD=0.1943P
+ PS=1.19U PD=1.25U
M$5278 VSS \$4623 \$4624 VSS nfet_03v3 L=0.28U W=0.67U AS=0.1943P AD=0.2948P
+ PS=1.25U PD=2.22U
M$5279 \$4625 \$106 VSS VSS nfet_03v3 L=0.28U W=0.36U AS=0.1584P AD=0.1188P
+ PS=1.6U PD=1.02U
M$5280 \$4626 \$4623 \$4625 VSS nfet_03v3 L=0.28U W=0.36U AS=0.1188P AD=0.1278P
+ PS=1.02U PD=1.07U
M$5281 \$4694 \$4627 \$4626 VSS nfet_03v3 L=0.28U W=0.36U AS=0.1278P AD=0.0567P
+ PS=1.07U PD=0.675U
M$5282 VSS \$4624 \$4694 VSS nfet_03v3 L=0.28U W=0.36U AS=0.0567P AD=0.1584P
+ PS=0.675U PD=1.6U
M$5283 VSS \$4626 \$4627 VSS nfet_03v3 L=0.28U W=0.36U AS=0.1584P AD=0.0972P
+ PS=1.6U PD=0.9U
M$5284 \$4628 \$4626 VSS VSS nfet_03v3 L=0.28U W=0.36U AS=0.0972P AD=0.18P
+ PS=0.9U PD=1.72U
M$5285 \$4629 \$109 VSS VSS nfet_03v3 L=0.28U W=0.36U AS=0.1584P AD=0.1188P
+ PS=1.6U PD=1.02U
M$5286 \$4630 \$4623 \$4629 VSS nfet_03v3 L=0.28U W=0.36U AS=0.1188P AD=0.1278P
+ PS=1.02U PD=1.07U
M$5287 \$4704 \$4631 \$4630 VSS nfet_03v3 L=0.28U W=0.36U AS=0.1278P AD=0.0567P
+ PS=1.07U PD=0.675U
M$5288 VSS \$4624 \$4704 VSS nfet_03v3 L=0.28U W=0.36U AS=0.0567P AD=0.1584P
+ PS=0.675U PD=1.6U
M$5289 VSS \$4630 \$4631 VSS nfet_03v3 L=0.28U W=0.36U AS=0.1584P AD=0.0972P
+ PS=1.6U PD=0.9U
M$5290 \$4632 \$4630 VSS VSS nfet_03v3 L=0.28U W=0.36U AS=0.0972P AD=0.18P
+ PS=0.9U PD=1.72U
M$5291 \$4633 \$112 VSS VSS nfet_03v3 L=0.28U W=0.36U AS=0.1584P AD=0.1188P
+ PS=1.6U PD=1.02U
M$5292 \$4634 \$4623 \$4633 VSS nfet_03v3 L=0.28U W=0.36U AS=0.1188P AD=0.1278P
+ PS=1.02U PD=1.07U
M$5293 \$4712 \$4635 \$4634 VSS nfet_03v3 L=0.28U W=0.36U AS=0.1278P AD=0.0567P
+ PS=1.07U PD=0.675U
M$5294 VSS \$4624 \$4712 VSS nfet_03v3 L=0.28U W=0.36U AS=0.0567P AD=0.1584P
+ PS=0.675U PD=1.6U
M$5295 VSS \$4634 \$4635 VSS nfet_03v3 L=0.28U W=0.36U AS=0.1584P AD=0.0972P
+ PS=1.6U PD=0.9U
M$5296 \$4636 \$4634 VSS VSS nfet_03v3 L=0.28U W=0.36U AS=0.0972P AD=0.18P
+ PS=0.9U PD=1.72U
M$5297 \$4637 \$115 VSS VSS nfet_03v3 L=0.28U W=0.36U AS=0.1584P AD=0.1188P
+ PS=1.6U PD=1.02U
M$5298 \$4638 \$4623 \$4637 VSS nfet_03v3 L=0.28U W=0.36U AS=0.1188P AD=0.1278P
+ PS=1.02U PD=1.07U
M$5299 \$4721 \$4639 \$4638 VSS nfet_03v3 L=0.28U W=0.36U AS=0.1278P AD=0.0567P
+ PS=1.07U PD=0.675U
M$5300 VSS \$4624 \$4721 VSS nfet_03v3 L=0.28U W=0.36U AS=0.0567P AD=0.1584P
+ PS=0.675U PD=1.6U
M$5301 VSS \$4638 \$4639 VSS nfet_03v3 L=0.28U W=0.36U AS=0.1584P AD=0.0972P
+ PS=1.6U PD=0.9U
M$5302 \$4640 \$4638 VSS VSS nfet_03v3 L=0.28U W=0.36U AS=0.0972P AD=0.18P
+ PS=0.9U PD=1.72U
M$5303 \$4641 \$118 VSS VSS nfet_03v3 L=0.28U W=0.36U AS=0.1584P AD=0.1188P
+ PS=1.6U PD=1.02U
M$5304 \$4642 \$4623 \$4641 VSS nfet_03v3 L=0.28U W=0.36U AS=0.1188P AD=0.1278P
+ PS=1.02U PD=1.07U
M$5305 \$4730 \$4643 \$4642 VSS nfet_03v3 L=0.28U W=0.36U AS=0.1278P AD=0.0567P
+ PS=1.07U PD=0.675U
M$5306 VSS \$4624 \$4730 VSS nfet_03v3 L=0.28U W=0.36U AS=0.0567P AD=0.1584P
+ PS=0.675U PD=1.6U
M$5307 VSS \$4642 \$4643 VSS nfet_03v3 L=0.28U W=0.36U AS=0.1584P AD=0.0972P
+ PS=1.6U PD=0.9U
M$5308 \$4644 \$4642 VSS VSS nfet_03v3 L=0.28U W=0.36U AS=0.0972P AD=0.18P
+ PS=0.9U PD=1.72U
M$5309 \$4645 \$121 VSS VSS nfet_03v3 L=0.28U W=0.36U AS=0.1584P AD=0.1188P
+ PS=1.6U PD=1.02U
M$5310 \$4646 \$4623 \$4645 VSS nfet_03v3 L=0.28U W=0.36U AS=0.1188P AD=0.1278P
+ PS=1.02U PD=1.07U
M$5311 \$4738 \$4647 \$4646 VSS nfet_03v3 L=0.28U W=0.36U AS=0.1278P AD=0.0567P
+ PS=1.07U PD=0.675U
M$5312 VSS \$4624 \$4738 VSS nfet_03v3 L=0.28U W=0.36U AS=0.0567P AD=0.1584P
+ PS=0.675U PD=1.6U
M$5313 VSS \$4646 \$4647 VSS nfet_03v3 L=0.28U W=0.36U AS=0.1584P AD=0.0972P
+ PS=1.6U PD=0.9U
M$5314 \$4648 \$4646 VSS VSS nfet_03v3 L=0.28U W=0.36U AS=0.0972P AD=0.18P
+ PS=0.9U PD=1.72U
M$5315 \$4649 \$124 VSS VSS nfet_03v3 L=0.28U W=0.36U AS=0.1584P AD=0.1188P
+ PS=1.6U PD=1.02U
M$5316 \$4650 \$4623 \$4649 VSS nfet_03v3 L=0.28U W=0.36U AS=0.1188P AD=0.1278P
+ PS=1.02U PD=1.07U
M$5317 \$4741 \$4651 \$4650 VSS nfet_03v3 L=0.28U W=0.36U AS=0.1278P AD=0.0567P
+ PS=1.07U PD=0.675U
M$5318 VSS \$4624 \$4741 VSS nfet_03v3 L=0.28U W=0.36U AS=0.0567P AD=0.1584P
+ PS=0.675U PD=1.6U
M$5319 VSS \$4650 \$4651 VSS nfet_03v3 L=0.28U W=0.36U AS=0.1584P AD=0.0972P
+ PS=1.6U PD=0.9U
M$5320 \$4652 \$4650 VSS VSS nfet_03v3 L=0.28U W=0.36U AS=0.0972P AD=0.18P
+ PS=0.9U PD=1.72U
M$5321 \$4653 \$127 VSS VSS nfet_03v3 L=0.28U W=0.36U AS=0.1584P AD=0.1188P
+ PS=1.6U PD=1.02U
M$5322 \$4654 \$4623 \$4653 VSS nfet_03v3 L=0.28U W=0.36U AS=0.1188P AD=0.1278P
+ PS=1.02U PD=1.07U
M$5323 \$4735 \$4655 \$4654 VSS nfet_03v3 L=0.28U W=0.36U AS=0.1278P AD=0.0567P
+ PS=1.07U PD=0.675U
M$5324 VSS \$4624 \$4735 VSS nfet_03v3 L=0.28U W=0.36U AS=0.0567P AD=0.1584P
+ PS=0.675U PD=1.6U
M$5325 VSS \$4654 \$4655 VSS nfet_03v3 L=0.28U W=0.36U AS=0.1584P AD=0.0972P
+ PS=1.6U PD=0.9U
M$5326 \$4656 \$4654 VSS VSS nfet_03v3 L=0.28U W=0.36U AS=0.0972P AD=0.18P
+ PS=0.9U PD=1.72U
M$5327 \$4657 \$130 VSS VSS nfet_03v3 L=0.28U W=0.36U AS=0.1584P AD=0.1188P
+ PS=1.6U PD=1.02U
M$5328 \$4658 \$4623 \$4657 VSS nfet_03v3 L=0.28U W=0.36U AS=0.1188P AD=0.1278P
+ PS=1.02U PD=1.07U
M$5329 \$4729 \$4659 \$4658 VSS nfet_03v3 L=0.28U W=0.36U AS=0.1278P AD=0.0567P
+ PS=1.07U PD=0.675U
M$5330 VSS \$4624 \$4729 VSS nfet_03v3 L=0.28U W=0.36U AS=0.0567P AD=0.1584P
+ PS=0.675U PD=1.6U
M$5331 VSS \$4658 \$4659 VSS nfet_03v3 L=0.28U W=0.36U AS=0.1584P AD=0.0972P
+ PS=1.6U PD=0.9U
M$5332 \$4660 \$4658 VSS VSS nfet_03v3 L=0.28U W=0.36U AS=0.0972P AD=0.18P
+ PS=0.9U PD=1.72U
M$5333 \$4661 \$133 VSS VSS nfet_03v3 L=0.28U W=0.36U AS=0.1584P AD=0.1188P
+ PS=1.6U PD=1.02U
M$5334 \$4662 \$4623 \$4661 VSS nfet_03v3 L=0.28U W=0.36U AS=0.1188P AD=0.1278P
+ PS=1.02U PD=1.07U
M$5335 \$4725 \$4663 \$4662 VSS nfet_03v3 L=0.28U W=0.36U AS=0.1278P AD=0.0567P
+ PS=1.07U PD=0.675U
M$5336 VSS \$4624 \$4725 VSS nfet_03v3 L=0.28U W=0.36U AS=0.0567P AD=0.1584P
+ PS=0.675U PD=1.6U
M$5337 VSS \$4662 \$4663 VSS nfet_03v3 L=0.28U W=0.36U AS=0.1584P AD=0.0972P
+ PS=1.6U PD=0.9U
M$5338 \$4664 \$4662 VSS VSS nfet_03v3 L=0.28U W=0.36U AS=0.0972P AD=0.18P
+ PS=0.9U PD=1.72U
M$5339 \$4665 \$136 VSS VSS nfet_03v3 L=0.28U W=0.36U AS=0.1584P AD=0.1188P
+ PS=1.6U PD=1.02U
M$5340 \$4666 \$4623 \$4665 VSS nfet_03v3 L=0.28U W=0.36U AS=0.1188P AD=0.1278P
+ PS=1.02U PD=1.07U
M$5341 \$4718 \$4667 \$4666 VSS nfet_03v3 L=0.28U W=0.36U AS=0.1278P AD=0.0567P
+ PS=1.07U PD=0.675U
M$5342 VSS \$4624 \$4718 VSS nfet_03v3 L=0.28U W=0.36U AS=0.0567P AD=0.1584P
+ PS=0.675U PD=1.6U
M$5343 VSS \$4666 \$4667 VSS nfet_03v3 L=0.28U W=0.36U AS=0.1584P AD=0.0972P
+ PS=1.6U PD=0.9U
M$5344 \$4668 \$4666 VSS VSS nfet_03v3 L=0.28U W=0.36U AS=0.0972P AD=0.18P
+ PS=0.9U PD=1.72U
M$5345 \$4669 \$139 VSS VSS nfet_03v3 L=0.28U W=0.36U AS=0.1584P AD=0.1188P
+ PS=1.6U PD=1.02U
M$5346 \$4670 \$4623 \$4669 VSS nfet_03v3 L=0.28U W=0.36U AS=0.1188P AD=0.1278P
+ PS=1.02U PD=1.07U
M$5347 \$4714 \$4671 \$4670 VSS nfet_03v3 L=0.28U W=0.36U AS=0.1278P AD=0.0567P
+ PS=1.07U PD=0.675U
M$5348 VSS \$4624 \$4714 VSS nfet_03v3 L=0.28U W=0.36U AS=0.0567P AD=0.1584P
+ PS=0.675U PD=1.6U
M$5349 VSS \$4670 \$4671 VSS nfet_03v3 L=0.28U W=0.36U AS=0.1584P AD=0.0972P
+ PS=1.6U PD=0.9U
M$5350 \$4672 \$4670 VSS VSS nfet_03v3 L=0.28U W=0.36U AS=0.0972P AD=0.18P
+ PS=0.9U PD=1.72U
M$5351 \$4673 \$142 VSS VSS nfet_03v3 L=0.28U W=0.36U AS=0.1584P AD=0.1188P
+ PS=1.6U PD=1.02U
M$5352 \$4674 \$4623 \$4673 VSS nfet_03v3 L=0.28U W=0.36U AS=0.1188P AD=0.1278P
+ PS=1.02U PD=1.07U
M$5353 \$4709 \$4675 \$4674 VSS nfet_03v3 L=0.28U W=0.36U AS=0.1278P AD=0.0567P
+ PS=1.07U PD=0.675U
M$5354 VSS \$4624 \$4709 VSS nfet_03v3 L=0.28U W=0.36U AS=0.0567P AD=0.1584P
+ PS=0.675U PD=1.6U
M$5355 VSS \$4674 \$4675 VSS nfet_03v3 L=0.28U W=0.36U AS=0.1584P AD=0.0972P
+ PS=1.6U PD=0.9U
M$5356 \$4676 \$4674 VSS VSS nfet_03v3 L=0.28U W=0.36U AS=0.0972P AD=0.18P
+ PS=0.9U PD=1.72U
M$5357 \$4677 \$145 VSS VSS nfet_03v3 L=0.28U W=0.36U AS=0.1584P AD=0.1188P
+ PS=1.6U PD=1.02U
M$5358 \$4678 \$4623 \$4677 VSS nfet_03v3 L=0.28U W=0.36U AS=0.1188P AD=0.1278P
+ PS=1.02U PD=1.07U
M$5359 \$4702 \$4679 \$4678 VSS nfet_03v3 L=0.28U W=0.36U AS=0.1278P AD=0.0567P
+ PS=1.07U PD=0.675U
M$5360 VSS \$4624 \$4702 VSS nfet_03v3 L=0.28U W=0.36U AS=0.0567P AD=0.1584P
+ PS=0.675U PD=1.6U
M$5361 VSS \$4678 \$4679 VSS nfet_03v3 L=0.28U W=0.36U AS=0.1584P AD=0.0972P
+ PS=1.6U PD=0.9U
M$5362 \$4680 \$4678 VSS VSS nfet_03v3 L=0.28U W=0.36U AS=0.0972P AD=0.18P
+ PS=0.9U PD=1.72U
M$5363 \$4681 \$148 VSS VSS nfet_03v3 L=0.28U W=0.36U AS=0.1584P AD=0.1188P
+ PS=1.6U PD=1.02U
M$5364 \$4682 \$4623 \$4681 VSS nfet_03v3 L=0.28U W=0.36U AS=0.1188P AD=0.1278P
+ PS=1.02U PD=1.07U
M$5365 \$4698 \$4683 \$4682 VSS nfet_03v3 L=0.28U W=0.36U AS=0.1278P AD=0.0567P
+ PS=1.07U PD=0.675U
M$5366 VSS \$4624 \$4698 VSS nfet_03v3 L=0.28U W=0.36U AS=0.0567P AD=0.1584P
+ PS=0.675U PD=1.6U
M$5367 VSS \$4682 \$4683 VSS nfet_03v3 L=0.28U W=0.36U AS=0.1584P AD=0.0972P
+ PS=1.6U PD=0.9U
M$5368 \$4684 \$4682 VSS VSS nfet_03v3 L=0.28U W=0.36U AS=0.0972P AD=0.18P
+ PS=0.9U PD=1.72U
M$5369 \$4685 \$151 VSS VSS nfet_03v3 L=0.28U W=0.36U AS=0.1584P AD=0.1188P
+ PS=1.6U PD=1.02U
M$5370 \$4686 \$4623 \$4685 VSS nfet_03v3 L=0.28U W=0.36U AS=0.1188P AD=0.1278P
+ PS=1.02U PD=1.07U
M$5371 \$4691 \$4687 \$4686 VSS nfet_03v3 L=0.28U W=0.36U AS=0.1278P AD=0.0567P
+ PS=1.07U PD=0.675U
M$5372 VSS \$4624 \$4691 VSS nfet_03v3 L=0.28U W=0.36U AS=0.0567P AD=0.1584P
+ PS=0.675U PD=1.6U
M$5373 VSS \$4686 \$4687 VSS nfet_03v3 L=0.28U W=0.36U AS=0.1584P AD=0.0972P
+ PS=1.6U PD=0.9U
M$5374 \$4688 \$4686 VSS VSS nfet_03v3 L=0.28U W=0.36U AS=0.0972P AD=0.18P
+ PS=0.9U PD=1.72U
M$5375 \$4948 RB0 VSS VSS nfet_03v3 L=0.28U W=0.36U AS=0.1656P AD=0.1944P
+ PS=1.64U PD=1.8U
M$5376 \$4745 RA1 VSS VSS nfet_03v3 L=0.28U W=0.36U AS=0.1656P AD=0.1944P
+ PS=1.64U PD=1.8U
M$5377 \$4947 RB0 \$51 VSS nfet_03v3 L=0.28U W=0.36U AS=0.1584P AD=0.1152P
+ PS=1.6U PD=1U
M$5378 \$52 RA0 \$4947 VSS nfet_03v3 L=0.28U W=0.36U AS=0.1152P AD=0.1584P
+ PS=1U PD=1.6U
M$5379 \$4628 RA1 \$51 VSS nfet_03v3 L=0.28U W=0.36U AS=0.1584P AD=0.1152P
+ PS=1.6U PD=1U
M$5380 \$52 RB1 \$4628 VSS nfet_03v3 L=0.28U W=0.36U AS=0.1152P AD=0.1584P
+ PS=1U PD=1.6U
M$5381 VSS RA0 \$4949 VSS nfet_03v3 L=0.28U W=0.36U AS=0.1854P AD=0.1584P
+ PS=1.75U PD=1.6U
M$5382 VSS RB1 \$4746 VSS nfet_03v3 L=0.28U W=0.36U AS=0.1854P AD=0.1584P
+ PS=1.75U PD=1.6U
M$5383 \$4954 RB0 VSS VSS nfet_03v3 L=0.28U W=0.36U AS=0.1656P AD=0.1944P
+ PS=1.64U PD=1.8U
M$5384 \$4747 RA1 VSS VSS nfet_03v3 L=0.28U W=0.36U AS=0.1656P AD=0.1944P
+ PS=1.64U PD=1.8U
M$5385 \$4632 RA1 \$53 VSS nfet_03v3 L=0.28U W=0.36U AS=0.1584P AD=0.1152P
+ PS=1.6U PD=1U
M$5386 \$54 RB1 \$4632 VSS nfet_03v3 L=0.28U W=0.36U AS=0.1152P AD=0.1584P
+ PS=1U PD=1.6U
M$5387 \$4953 RB0 \$53 VSS nfet_03v3 L=0.28U W=0.36U AS=0.1584P AD=0.1152P
+ PS=1.6U PD=1U
M$5388 \$54 RA0 \$4953 VSS nfet_03v3 L=0.28U W=0.36U AS=0.1152P AD=0.1584P
+ PS=1U PD=1.6U
M$5389 VSS RB1 \$4748 VSS nfet_03v3 L=0.28U W=0.36U AS=0.1854P AD=0.1584P
+ PS=1.75U PD=1.6U
M$5390 VSS RA0 \$4955 VSS nfet_03v3 L=0.28U W=0.36U AS=0.1854P AD=0.1584P
+ PS=1.75U PD=1.6U
M$5391 \$4960 RB0 VSS VSS nfet_03v3 L=0.28U W=0.36U AS=0.1656P AD=0.1944P
+ PS=1.64U PD=1.8U
M$5392 \$4749 RA1 VSS VSS nfet_03v3 L=0.28U W=0.36U AS=0.1656P AD=0.1944P
+ PS=1.64U PD=1.8U
M$5393 \$4636 RA1 \$55 VSS nfet_03v3 L=0.28U W=0.36U AS=0.1584P AD=0.1152P
+ PS=1.6U PD=1U
M$5394 \$56 RB1 \$4636 VSS nfet_03v3 L=0.28U W=0.36U AS=0.1152P AD=0.1584P
+ PS=1U PD=1.6U
M$5395 \$4959 RB0 \$55 VSS nfet_03v3 L=0.28U W=0.36U AS=0.1584P AD=0.1152P
+ PS=1.6U PD=1U
M$5396 \$56 RA0 \$4959 VSS nfet_03v3 L=0.28U W=0.36U AS=0.1152P AD=0.1584P
+ PS=1U PD=1.6U
M$5397 VSS RB1 \$4750 VSS nfet_03v3 L=0.28U W=0.36U AS=0.1854P AD=0.1584P
+ PS=1.75U PD=1.6U
M$5398 VSS RA0 \$4961 VSS nfet_03v3 L=0.28U W=0.36U AS=0.1854P AD=0.1584P
+ PS=1.75U PD=1.6U
M$5399 \$4966 RB0 VSS VSS nfet_03v3 L=0.28U W=0.36U AS=0.1656P AD=0.1944P
+ PS=1.64U PD=1.8U
M$5400 \$4751 RA1 VSS VSS nfet_03v3 L=0.28U W=0.36U AS=0.1656P AD=0.1944P
+ PS=1.64U PD=1.8U
M$5401 \$4965 RB0 \$57 VSS nfet_03v3 L=0.28U W=0.36U AS=0.1584P AD=0.1152P
+ PS=1.6U PD=1U
M$5402 \$58 RA0 \$4965 VSS nfet_03v3 L=0.28U W=0.36U AS=0.1152P AD=0.1584P
+ PS=1U PD=1.6U
M$5403 \$4640 RA1 \$57 VSS nfet_03v3 L=0.28U W=0.36U AS=0.1584P AD=0.1152P
+ PS=1.6U PD=1U
M$5404 \$58 RB1 \$4640 VSS nfet_03v3 L=0.28U W=0.36U AS=0.1152P AD=0.1584P
+ PS=1U PD=1.6U
M$5405 VSS RB1 \$4752 VSS nfet_03v3 L=0.28U W=0.36U AS=0.1854P AD=0.1584P
+ PS=1.75U PD=1.6U
M$5406 VSS RA0 \$4967 VSS nfet_03v3 L=0.28U W=0.36U AS=0.1854P AD=0.1584P
+ PS=1.75U PD=1.6U
M$5407 \$4753 RA1 VSS VSS nfet_03v3 L=0.28U W=0.36U AS=0.1656P AD=0.1944P
+ PS=1.64U PD=1.8U
M$5408 \$4972 RB0 VSS VSS nfet_03v3 L=0.28U W=0.36U AS=0.1656P AD=0.1944P
+ PS=1.64U PD=1.8U
M$5409 \$4971 RB0 \$59 VSS nfet_03v3 L=0.28U W=0.36U AS=0.1584P AD=0.1152P
+ PS=1.6U PD=1U
M$5410 \$60 RA0 \$4971 VSS nfet_03v3 L=0.28U W=0.36U AS=0.1152P AD=0.1584P
+ PS=1U PD=1.6U
M$5411 \$4644 RA1 \$59 VSS nfet_03v3 L=0.28U W=0.36U AS=0.1584P AD=0.1152P
+ PS=1.6U PD=1U
M$5412 \$60 RB1 \$4644 VSS nfet_03v3 L=0.28U W=0.36U AS=0.1152P AD=0.1584P
+ PS=1U PD=1.6U
M$5413 VSS RB1 \$4754 VSS nfet_03v3 L=0.28U W=0.36U AS=0.1854P AD=0.1584P
+ PS=1.75U PD=1.6U
M$5414 VSS RA0 \$4973 VSS nfet_03v3 L=0.28U W=0.36U AS=0.1854P AD=0.1584P
+ PS=1.75U PD=1.6U
M$5415 \$4978 RB0 VSS VSS nfet_03v3 L=0.28U W=0.36U AS=0.1656P AD=0.1944P
+ PS=1.64U PD=1.8U
M$5416 \$4755 RA1 VSS VSS nfet_03v3 L=0.28U W=0.36U AS=0.1656P AD=0.1944P
+ PS=1.64U PD=1.8U
M$5417 \$4977 RB0 \$61 VSS nfet_03v3 L=0.28U W=0.36U AS=0.1584P AD=0.1152P
+ PS=1.6U PD=1U
M$5418 \$62 RA0 \$4977 VSS nfet_03v3 L=0.28U W=0.36U AS=0.1152P AD=0.1584P
+ PS=1U PD=1.6U
M$5419 \$4648 RA1 \$61 VSS nfet_03v3 L=0.28U W=0.36U AS=0.1584P AD=0.1152P
+ PS=1.6U PD=1U
M$5420 \$62 RB1 \$4648 VSS nfet_03v3 L=0.28U W=0.36U AS=0.1152P AD=0.1584P
+ PS=1U PD=1.6U
M$5421 VSS RB1 \$4756 VSS nfet_03v3 L=0.28U W=0.36U AS=0.1854P AD=0.1584P
+ PS=1.75U PD=1.6U
M$5422 VSS RA0 \$4979 VSS nfet_03v3 L=0.28U W=0.36U AS=0.1854P AD=0.1584P
+ PS=1.75U PD=1.6U
M$5423 \$4757 RA1 VSS VSS nfet_03v3 L=0.28U W=0.36U AS=0.1656P AD=0.1944P
+ PS=1.64U PD=1.8U
M$5424 \$4984 RB0 VSS VSS nfet_03v3 L=0.28U W=0.36U AS=0.1656P AD=0.1944P
+ PS=1.64U PD=1.8U
M$5425 \$4983 RB0 \$63 VSS nfet_03v3 L=0.28U W=0.36U AS=0.1584P AD=0.1152P
+ PS=1.6U PD=1U
M$5426 \$64 RA0 \$4983 VSS nfet_03v3 L=0.28U W=0.36U AS=0.1152P AD=0.1584P
+ PS=1U PD=1.6U
M$5427 \$4652 RA1 \$63 VSS nfet_03v3 L=0.28U W=0.36U AS=0.1584P AD=0.1152P
+ PS=1.6U PD=1U
M$5428 \$64 RB1 \$4652 VSS nfet_03v3 L=0.28U W=0.36U AS=0.1152P AD=0.1584P
+ PS=1U PD=1.6U
M$5429 VSS RA0 \$4985 VSS nfet_03v3 L=0.28U W=0.36U AS=0.1854P AD=0.1584P
+ PS=1.75U PD=1.6U
M$5430 VSS RB1 \$4758 VSS nfet_03v3 L=0.28U W=0.36U AS=0.1854P AD=0.1584P
+ PS=1.75U PD=1.6U
M$5431 \$4759 RA1 VSS VSS nfet_03v3 L=0.28U W=0.36U AS=0.1656P AD=0.1944P
+ PS=1.64U PD=1.8U
M$5432 \$4990 RB0 VSS VSS nfet_03v3 L=0.28U W=0.36U AS=0.1656P AD=0.1944P
+ PS=1.64U PD=1.8U
M$5433 \$4989 RB0 \$65 VSS nfet_03v3 L=0.28U W=0.36U AS=0.1584P AD=0.1152P
+ PS=1.6U PD=1U
M$5434 \$66 RA0 \$4989 VSS nfet_03v3 L=0.28U W=0.36U AS=0.1152P AD=0.1584P
+ PS=1U PD=1.6U
M$5435 \$4656 RA1 \$65 VSS nfet_03v3 L=0.28U W=0.36U AS=0.1584P AD=0.1152P
+ PS=1.6U PD=1U
M$5436 \$66 RB1 \$4656 VSS nfet_03v3 L=0.28U W=0.36U AS=0.1152P AD=0.1584P
+ PS=1U PD=1.6U
M$5437 VSS RB1 \$4760 VSS nfet_03v3 L=0.28U W=0.36U AS=0.1854P AD=0.1584P
+ PS=1.75U PD=1.6U
M$5438 VSS RA0 \$4991 VSS nfet_03v3 L=0.28U W=0.36U AS=0.1854P AD=0.1584P
+ PS=1.75U PD=1.6U
M$5439 \$4996 RB0 VSS VSS nfet_03v3 L=0.28U W=0.36U AS=0.1656P AD=0.1944P
+ PS=1.64U PD=1.8U
M$5440 \$4761 RA1 VSS VSS nfet_03v3 L=0.28U W=0.36U AS=0.1656P AD=0.1944P
+ PS=1.64U PD=1.8U
M$5441 \$4995 RB0 \$67 VSS nfet_03v3 L=0.28U W=0.36U AS=0.1584P AD=0.1152P
+ PS=1.6U PD=1U
M$5442 \$68 RA0 \$4995 VSS nfet_03v3 L=0.28U W=0.36U AS=0.1152P AD=0.1584P
+ PS=1U PD=1.6U
M$5443 \$4660 RA1 \$67 VSS nfet_03v3 L=0.28U W=0.36U AS=0.1584P AD=0.1152P
+ PS=1.6U PD=1U
M$5444 \$68 RB1 \$4660 VSS nfet_03v3 L=0.28U W=0.36U AS=0.1152P AD=0.1584P
+ PS=1U PD=1.6U
M$5445 VSS RB1 \$4762 VSS nfet_03v3 L=0.28U W=0.36U AS=0.1854P AD=0.1584P
+ PS=1.75U PD=1.6U
M$5446 VSS RA0 \$4997 VSS nfet_03v3 L=0.28U W=0.36U AS=0.1854P AD=0.1584P
+ PS=1.75U PD=1.6U
M$5447 \$5002 RB0 VSS VSS nfet_03v3 L=0.28U W=0.36U AS=0.1656P AD=0.1944P
+ PS=1.64U PD=1.8U
M$5448 \$4763 RA1 VSS VSS nfet_03v3 L=0.28U W=0.36U AS=0.1656P AD=0.1944P
+ PS=1.64U PD=1.8U
M$5449 \$5001 RB0 \$69 VSS nfet_03v3 L=0.28U W=0.36U AS=0.1584P AD=0.1152P
+ PS=1.6U PD=1U
M$5450 \$70 RA0 \$5001 VSS nfet_03v3 L=0.28U W=0.36U AS=0.1152P AD=0.1584P
+ PS=1U PD=1.6U
M$5451 \$4664 RA1 \$69 VSS nfet_03v3 L=0.28U W=0.36U AS=0.1584P AD=0.1152P
+ PS=1.6U PD=1U
M$5452 \$70 RB1 \$4664 VSS nfet_03v3 L=0.28U W=0.36U AS=0.1152P AD=0.1584P
+ PS=1U PD=1.6U
M$5453 VSS RA0 \$5003 VSS nfet_03v3 L=0.28U W=0.36U AS=0.1854P AD=0.1584P
+ PS=1.75U PD=1.6U
M$5454 VSS RB1 \$4764 VSS nfet_03v3 L=0.28U W=0.36U AS=0.1854P AD=0.1584P
+ PS=1.75U PD=1.6U
M$5455 \$5008 RB0 VSS VSS nfet_03v3 L=0.28U W=0.36U AS=0.1656P AD=0.1944P
+ PS=1.64U PD=1.8U
M$5456 \$4765 RA1 VSS VSS nfet_03v3 L=0.28U W=0.36U AS=0.1656P AD=0.1944P
+ PS=1.64U PD=1.8U
M$5457 \$4668 RA1 \$71 VSS nfet_03v3 L=0.28U W=0.36U AS=0.1584P AD=0.1152P
+ PS=1.6U PD=1U
M$5458 \$72 RB1 \$4668 VSS nfet_03v3 L=0.28U W=0.36U AS=0.1152P AD=0.1584P
+ PS=1U PD=1.6U
M$5459 \$5007 RB0 \$71 VSS nfet_03v3 L=0.28U W=0.36U AS=0.1584P AD=0.1152P
+ PS=1.6U PD=1U
M$5460 \$72 RA0 \$5007 VSS nfet_03v3 L=0.28U W=0.36U AS=0.1152P AD=0.1584P
+ PS=1U PD=1.6U
M$5461 VSS RB1 \$4766 VSS nfet_03v3 L=0.28U W=0.36U AS=0.1854P AD=0.1584P
+ PS=1.75U PD=1.6U
M$5462 VSS RA0 \$5009 VSS nfet_03v3 L=0.28U W=0.36U AS=0.1854P AD=0.1584P
+ PS=1.75U PD=1.6U
M$5463 \$4767 RA1 VSS VSS nfet_03v3 L=0.28U W=0.36U AS=0.1656P AD=0.1944P
+ PS=1.64U PD=1.8U
M$5464 \$5014 RB0 VSS VSS nfet_03v3 L=0.28U W=0.36U AS=0.1656P AD=0.1944P
+ PS=1.64U PD=1.8U
M$5465 \$4672 RA1 \$73 VSS nfet_03v3 L=0.28U W=0.36U AS=0.1584P AD=0.1152P
+ PS=1.6U PD=1U
M$5466 \$74 RB1 \$4672 VSS nfet_03v3 L=0.28U W=0.36U AS=0.1152P AD=0.1584P
+ PS=1U PD=1.6U
M$5467 \$5013 RB0 \$73 VSS nfet_03v3 L=0.28U W=0.36U AS=0.1584P AD=0.1152P
+ PS=1.6U PD=1U
M$5468 \$74 RA0 \$5013 VSS nfet_03v3 L=0.28U W=0.36U AS=0.1152P AD=0.1584P
+ PS=1U PD=1.6U
M$5469 VSS RB1 \$4768 VSS nfet_03v3 L=0.28U W=0.36U AS=0.1854P AD=0.1584P
+ PS=1.75U PD=1.6U
M$5470 VSS RA0 \$5015 VSS nfet_03v3 L=0.28U W=0.36U AS=0.1854P AD=0.1584P
+ PS=1.75U PD=1.6U
M$5471 \$5020 RB0 VSS VSS nfet_03v3 L=0.28U W=0.36U AS=0.1656P AD=0.1944P
+ PS=1.64U PD=1.8U
M$5472 \$4769 RA1 VSS VSS nfet_03v3 L=0.28U W=0.36U AS=0.1656P AD=0.1944P
+ PS=1.64U PD=1.8U
M$5473 \$4676 RA1 \$75 VSS nfet_03v3 L=0.28U W=0.36U AS=0.1584P AD=0.1152P
+ PS=1.6U PD=1U
M$5474 \$76 RB1 \$4676 VSS nfet_03v3 L=0.28U W=0.36U AS=0.1152P AD=0.1584P
+ PS=1U PD=1.6U
M$5475 \$5019 RB0 \$75 VSS nfet_03v3 L=0.28U W=0.36U AS=0.1584P AD=0.1152P
+ PS=1.6U PD=1U
M$5476 \$76 RA0 \$5019 VSS nfet_03v3 L=0.28U W=0.36U AS=0.1152P AD=0.1584P
+ PS=1U PD=1.6U
M$5477 VSS RB1 \$4770 VSS nfet_03v3 L=0.28U W=0.36U AS=0.1854P AD=0.1584P
+ PS=1.75U PD=1.6U
M$5478 VSS RA0 \$5021 VSS nfet_03v3 L=0.28U W=0.36U AS=0.1854P AD=0.1584P
+ PS=1.75U PD=1.6U
M$5479 \$5026 RB0 VSS VSS nfet_03v3 L=0.28U W=0.36U AS=0.1656P AD=0.1944P
+ PS=1.64U PD=1.8U
M$5480 \$4771 RA1 VSS VSS nfet_03v3 L=0.28U W=0.36U AS=0.1656P AD=0.1944P
+ PS=1.64U PD=1.8U
M$5481 \$5025 RB0 \$77 VSS nfet_03v3 L=0.28U W=0.36U AS=0.1584P AD=0.1152P
+ PS=1.6U PD=1U
M$5482 \$78 RA0 \$5025 VSS nfet_03v3 L=0.28U W=0.36U AS=0.1152P AD=0.1584P
+ PS=1U PD=1.6U
M$5483 \$4680 RA1 \$77 VSS nfet_03v3 L=0.28U W=0.36U AS=0.1584P AD=0.1152P
+ PS=1.6U PD=1U
M$5484 \$78 RB1 \$4680 VSS nfet_03v3 L=0.28U W=0.36U AS=0.1152P AD=0.1584P
+ PS=1U PD=1.6U
M$5485 VSS RA0 \$5027 VSS nfet_03v3 L=0.28U W=0.36U AS=0.1854P AD=0.1584P
+ PS=1.75U PD=1.6U
M$5486 VSS RB1 \$4772 VSS nfet_03v3 L=0.28U W=0.36U AS=0.1854P AD=0.1584P
+ PS=1.75U PD=1.6U
M$5487 \$5032 RB0 VSS VSS nfet_03v3 L=0.28U W=0.36U AS=0.1656P AD=0.1944P
+ PS=1.64U PD=1.8U
M$5488 \$4773 RA1 VSS VSS nfet_03v3 L=0.28U W=0.36U AS=0.1656P AD=0.1944P
+ PS=1.64U PD=1.8U
M$5489 \$5031 RB0 \$79 VSS nfet_03v3 L=0.28U W=0.36U AS=0.1584P AD=0.1152P
+ PS=1.6U PD=1U
M$5490 \$80 RA0 \$5031 VSS nfet_03v3 L=0.28U W=0.36U AS=0.1152P AD=0.1584P
+ PS=1U PD=1.6U
M$5491 \$4684 RA1 \$79 VSS nfet_03v3 L=0.28U W=0.36U AS=0.1584P AD=0.1152P
+ PS=1.6U PD=1U
M$5492 \$80 RB1 \$4684 VSS nfet_03v3 L=0.28U W=0.36U AS=0.1152P AD=0.1584P
+ PS=1U PD=1.6U
M$5493 VSS RA0 \$5033 VSS nfet_03v3 L=0.28U W=0.36U AS=0.1854P AD=0.1584P
+ PS=1.75U PD=1.6U
M$5494 VSS RB1 \$4774 VSS nfet_03v3 L=0.28U W=0.36U AS=0.1854P AD=0.1584P
+ PS=1.75U PD=1.6U
M$5495 \$4775 RA1 VSS VSS nfet_03v3 L=0.28U W=0.36U AS=0.1656P AD=0.1944P
+ PS=1.64U PD=1.8U
M$5496 \$5038 RB0 VSS VSS nfet_03v3 L=0.28U W=0.36U AS=0.1656P AD=0.1944P
+ PS=1.64U PD=1.8U
M$5497 \$5037 RB0 \$81 VSS nfet_03v3 L=0.28U W=0.36U AS=0.1584P AD=0.1152P
+ PS=1.6U PD=1U
M$5498 \$82 RA0 \$5037 VSS nfet_03v3 L=0.28U W=0.36U AS=0.1152P AD=0.1584P
+ PS=1U PD=1.6U
M$5499 \$4688 RA1 \$81 VSS nfet_03v3 L=0.28U W=0.36U AS=0.1584P AD=0.1152P
+ PS=1.6U PD=1U
M$5500 \$82 RB1 \$4688 VSS nfet_03v3 L=0.28U W=0.36U AS=0.1152P AD=0.1584P
+ PS=1U PD=1.6U
M$5501 VSS RB1 \$4776 VSS nfet_03v3 L=0.28U W=0.36U AS=0.1854P AD=0.1584P
+ PS=1.75U PD=1.6U
M$5502 VSS RA0 \$5039 VSS nfet_03v3 L=0.28U W=0.36U AS=0.1854P AD=0.1584P
+ PS=1.75U PD=1.6U
M$5503 \$5142 WE0 VSS VSS nfet_03v3 L=0.28U W=0.72U AS=0.3168P AD=0.1872P
+ PS=2.32U PD=1.24U
M$5504 \$4938 CLK \$5142 VSS nfet_03v3 L=0.28U W=0.72U AS=0.1872P AD=0.3168P
+ PS=1.24U PD=2.32U
M$5505 \$4940 \$4938 VSS VSS nfet_03v3 L=0.28U W=0.635U AS=0.2794P AD=0.1651P
+ PS=2.15U PD=1.155U
M$5506 \$4940 \$4938 VSS VSS nfet_03v3 L=0.28U W=0.635U AS=0.1693P AD=0.1651P
+ PS=1.19U PD=1.155U
M$5507 \$4941 \$4940 VSS VSS nfet_03v3 L=0.28U W=0.67U AS=0.1693P AD=0.1943P
+ PS=1.19U PD=1.25U
M$5508 VSS \$4940 \$4941 VSS nfet_03v3 L=0.28U W=0.67U AS=0.1943P AD=0.2948P
+ PS=1.25U PD=2.22U
M$5509 \$4944 \$106 VSS VSS nfet_03v3 L=0.28U W=0.36U AS=0.1584P AD=0.1188P
+ PS=1.6U PD=1.02U
M$5510 \$4945 \$4940 \$4944 VSS nfet_03v3 L=0.28U W=0.36U AS=0.1188P AD=0.1278P
+ PS=1.02U PD=1.07U
M$5511 \$5145 \$4946 \$4945 VSS nfet_03v3 L=0.28U W=0.36U AS=0.1278P AD=0.0567P
+ PS=1.07U PD=0.675U
M$5512 VSS \$4941 \$5145 VSS nfet_03v3 L=0.28U W=0.36U AS=0.0567P AD=0.1584P
+ PS=0.675U PD=1.6U
M$5513 VSS \$4945 \$4946 VSS nfet_03v3 L=0.28U W=0.36U AS=0.1584P AD=0.0972P
+ PS=1.6U PD=0.9U
M$5514 \$4947 \$4945 VSS VSS nfet_03v3 L=0.28U W=0.36U AS=0.0972P AD=0.18P
+ PS=0.9U PD=1.72U
M$5515 \$4950 \$109 VSS VSS nfet_03v3 L=0.28U W=0.36U AS=0.1584P AD=0.1188P
+ PS=1.6U PD=1.02U
M$5516 \$4951 \$4940 \$4950 VSS nfet_03v3 L=0.28U W=0.36U AS=0.1188P AD=0.1278P
+ PS=1.02U PD=1.07U
M$5517 \$5151 \$4952 \$4951 VSS nfet_03v3 L=0.28U W=0.36U AS=0.1278P AD=0.0567P
+ PS=1.07U PD=0.675U
M$5518 VSS \$4941 \$5151 VSS nfet_03v3 L=0.28U W=0.36U AS=0.0567P AD=0.1584P
+ PS=0.675U PD=1.6U
M$5519 VSS \$4951 \$4952 VSS nfet_03v3 L=0.28U W=0.36U AS=0.1584P AD=0.0972P
+ PS=1.6U PD=0.9U
M$5520 \$4953 \$4951 VSS VSS nfet_03v3 L=0.28U W=0.36U AS=0.0972P AD=0.18P
+ PS=0.9U PD=1.72U
M$5521 \$4956 \$112 VSS VSS nfet_03v3 L=0.28U W=0.36U AS=0.1584P AD=0.1188P
+ PS=1.6U PD=1.02U
M$5522 \$4957 \$4940 \$4956 VSS nfet_03v3 L=0.28U W=0.36U AS=0.1188P AD=0.1278P
+ PS=1.02U PD=1.07U
M$5523 \$5157 \$4958 \$4957 VSS nfet_03v3 L=0.28U W=0.36U AS=0.1278P AD=0.0567P
+ PS=1.07U PD=0.675U
M$5524 VSS \$4941 \$5157 VSS nfet_03v3 L=0.28U W=0.36U AS=0.0567P AD=0.1584P
+ PS=0.675U PD=1.6U
M$5525 VSS \$4957 \$4958 VSS nfet_03v3 L=0.28U W=0.36U AS=0.1584P AD=0.0972P
+ PS=1.6U PD=0.9U
M$5526 \$4959 \$4957 VSS VSS nfet_03v3 L=0.28U W=0.36U AS=0.0972P AD=0.18P
+ PS=0.9U PD=1.72U
M$5527 \$4962 \$115 VSS VSS nfet_03v3 L=0.28U W=0.36U AS=0.1584P AD=0.1188P
+ PS=1.6U PD=1.02U
M$5528 \$4963 \$4940 \$4962 VSS nfet_03v3 L=0.28U W=0.36U AS=0.1188P AD=0.1278P
+ PS=1.02U PD=1.07U
M$5529 \$5163 \$4964 \$4963 VSS nfet_03v3 L=0.28U W=0.36U AS=0.1278P AD=0.0567P
+ PS=1.07U PD=0.675U
M$5530 VSS \$4941 \$5163 VSS nfet_03v3 L=0.28U W=0.36U AS=0.0567P AD=0.1584P
+ PS=0.675U PD=1.6U
M$5531 VSS \$4963 \$4964 VSS nfet_03v3 L=0.28U W=0.36U AS=0.1584P AD=0.0972P
+ PS=1.6U PD=0.9U
M$5532 \$4965 \$4963 VSS VSS nfet_03v3 L=0.28U W=0.36U AS=0.0972P AD=0.18P
+ PS=0.9U PD=1.72U
M$5533 \$4968 \$118 VSS VSS nfet_03v3 L=0.28U W=0.36U AS=0.1584P AD=0.1188P
+ PS=1.6U PD=1.02U
M$5534 \$4969 \$4940 \$4968 VSS nfet_03v3 L=0.28U W=0.36U AS=0.1188P AD=0.1278P
+ PS=1.02U PD=1.07U
M$5535 \$5169 \$4970 \$4969 VSS nfet_03v3 L=0.28U W=0.36U AS=0.1278P AD=0.0567P
+ PS=1.07U PD=0.675U
M$5536 VSS \$4941 \$5169 VSS nfet_03v3 L=0.28U W=0.36U AS=0.0567P AD=0.1584P
+ PS=0.675U PD=1.6U
M$5537 VSS \$4969 \$4970 VSS nfet_03v3 L=0.28U W=0.36U AS=0.1584P AD=0.0972P
+ PS=1.6U PD=0.9U
M$5538 \$4971 \$4969 VSS VSS nfet_03v3 L=0.28U W=0.36U AS=0.0972P AD=0.18P
+ PS=0.9U PD=1.72U
M$5539 \$4974 \$121 VSS VSS nfet_03v3 L=0.28U W=0.36U AS=0.1584P AD=0.1188P
+ PS=1.6U PD=1.02U
M$5540 \$4975 \$4940 \$4974 VSS nfet_03v3 L=0.28U W=0.36U AS=0.1188P AD=0.1278P
+ PS=1.02U PD=1.07U
M$5541 \$5175 \$4976 \$4975 VSS nfet_03v3 L=0.28U W=0.36U AS=0.1278P AD=0.0567P
+ PS=1.07U PD=0.675U
M$5542 VSS \$4941 \$5175 VSS nfet_03v3 L=0.28U W=0.36U AS=0.0567P AD=0.1584P
+ PS=0.675U PD=1.6U
M$5543 VSS \$4975 \$4976 VSS nfet_03v3 L=0.28U W=0.36U AS=0.1584P AD=0.0972P
+ PS=1.6U PD=0.9U
M$5544 \$4977 \$4975 VSS VSS nfet_03v3 L=0.28U W=0.36U AS=0.0972P AD=0.18P
+ PS=0.9U PD=1.72U
M$5545 \$4980 \$124 VSS VSS nfet_03v3 L=0.28U W=0.36U AS=0.1584P AD=0.1188P
+ PS=1.6U PD=1.02U
M$5546 \$4981 \$4940 \$4980 VSS nfet_03v3 L=0.28U W=0.36U AS=0.1188P AD=0.1278P
+ PS=1.02U PD=1.07U
M$5547 \$5181 \$4982 \$4981 VSS nfet_03v3 L=0.28U W=0.36U AS=0.1278P AD=0.0567P
+ PS=1.07U PD=0.675U
M$5548 VSS \$4941 \$5181 VSS nfet_03v3 L=0.28U W=0.36U AS=0.0567P AD=0.1584P
+ PS=0.675U PD=1.6U
M$5549 VSS \$4981 \$4982 VSS nfet_03v3 L=0.28U W=0.36U AS=0.1584P AD=0.0972P
+ PS=1.6U PD=0.9U
M$5550 \$4983 \$4981 VSS VSS nfet_03v3 L=0.28U W=0.36U AS=0.0972P AD=0.18P
+ PS=0.9U PD=1.72U
M$5551 \$4986 \$127 VSS VSS nfet_03v3 L=0.28U W=0.36U AS=0.1584P AD=0.1188P
+ PS=1.6U PD=1.02U
M$5552 \$4987 \$4940 \$4986 VSS nfet_03v3 L=0.28U W=0.36U AS=0.1188P AD=0.1278P
+ PS=1.02U PD=1.07U
M$5553 \$5187 \$4988 \$4987 VSS nfet_03v3 L=0.28U W=0.36U AS=0.1278P AD=0.0567P
+ PS=1.07U PD=0.675U
M$5554 VSS \$4941 \$5187 VSS nfet_03v3 L=0.28U W=0.36U AS=0.0567P AD=0.1584P
+ PS=0.675U PD=1.6U
M$5555 VSS \$4987 \$4988 VSS nfet_03v3 L=0.28U W=0.36U AS=0.1584P AD=0.0972P
+ PS=1.6U PD=0.9U
M$5556 \$4989 \$4987 VSS VSS nfet_03v3 L=0.28U W=0.36U AS=0.0972P AD=0.18P
+ PS=0.9U PD=1.72U
M$5557 \$4992 \$130 VSS VSS nfet_03v3 L=0.28U W=0.36U AS=0.1584P AD=0.1188P
+ PS=1.6U PD=1.02U
M$5558 \$4993 \$4940 \$4992 VSS nfet_03v3 L=0.28U W=0.36U AS=0.1188P AD=0.1278P
+ PS=1.02U PD=1.07U
M$5559 \$5193 \$4994 \$4993 VSS nfet_03v3 L=0.28U W=0.36U AS=0.1278P AD=0.0567P
+ PS=1.07U PD=0.675U
M$5560 VSS \$4941 \$5193 VSS nfet_03v3 L=0.28U W=0.36U AS=0.0567P AD=0.1584P
+ PS=0.675U PD=1.6U
M$5561 VSS \$4993 \$4994 VSS nfet_03v3 L=0.28U W=0.36U AS=0.1584P AD=0.0972P
+ PS=1.6U PD=0.9U
M$5562 \$4995 \$4993 VSS VSS nfet_03v3 L=0.28U W=0.36U AS=0.0972P AD=0.18P
+ PS=0.9U PD=1.72U
M$5563 \$4998 \$133 VSS VSS nfet_03v3 L=0.28U W=0.36U AS=0.1584P AD=0.1188P
+ PS=1.6U PD=1.02U
M$5564 \$4999 \$4940 \$4998 VSS nfet_03v3 L=0.28U W=0.36U AS=0.1188P AD=0.1278P
+ PS=1.02U PD=1.07U
M$5565 \$5199 \$5000 \$4999 VSS nfet_03v3 L=0.28U W=0.36U AS=0.1278P AD=0.0567P
+ PS=1.07U PD=0.675U
M$5566 VSS \$4941 \$5199 VSS nfet_03v3 L=0.28U W=0.36U AS=0.0567P AD=0.1584P
+ PS=0.675U PD=1.6U
M$5567 VSS \$4999 \$5000 VSS nfet_03v3 L=0.28U W=0.36U AS=0.1584P AD=0.0972P
+ PS=1.6U PD=0.9U
M$5568 \$5001 \$4999 VSS VSS nfet_03v3 L=0.28U W=0.36U AS=0.0972P AD=0.18P
+ PS=0.9U PD=1.72U
M$5569 \$5004 \$136 VSS VSS nfet_03v3 L=0.28U W=0.36U AS=0.1584P AD=0.1188P
+ PS=1.6U PD=1.02U
M$5570 \$5005 \$4940 \$5004 VSS nfet_03v3 L=0.28U W=0.36U AS=0.1188P AD=0.1278P
+ PS=1.02U PD=1.07U
M$5571 \$5205 \$5006 \$5005 VSS nfet_03v3 L=0.28U W=0.36U AS=0.1278P AD=0.0567P
+ PS=1.07U PD=0.675U
M$5572 VSS \$4941 \$5205 VSS nfet_03v3 L=0.28U W=0.36U AS=0.0567P AD=0.1584P
+ PS=0.675U PD=1.6U
M$5573 VSS \$5005 \$5006 VSS nfet_03v3 L=0.28U W=0.36U AS=0.1584P AD=0.0972P
+ PS=1.6U PD=0.9U
M$5574 \$5007 \$5005 VSS VSS nfet_03v3 L=0.28U W=0.36U AS=0.0972P AD=0.18P
+ PS=0.9U PD=1.72U
M$5575 \$5010 \$139 VSS VSS nfet_03v3 L=0.28U W=0.36U AS=0.1584P AD=0.1188P
+ PS=1.6U PD=1.02U
M$5576 \$5011 \$4940 \$5010 VSS nfet_03v3 L=0.28U W=0.36U AS=0.1188P AD=0.1278P
+ PS=1.02U PD=1.07U
M$5577 \$5211 \$5012 \$5011 VSS nfet_03v3 L=0.28U W=0.36U AS=0.1278P AD=0.0567P
+ PS=1.07U PD=0.675U
M$5578 VSS \$4941 \$5211 VSS nfet_03v3 L=0.28U W=0.36U AS=0.0567P AD=0.1584P
+ PS=0.675U PD=1.6U
M$5579 VSS \$5011 \$5012 VSS nfet_03v3 L=0.28U W=0.36U AS=0.1584P AD=0.0972P
+ PS=1.6U PD=0.9U
M$5580 \$5013 \$5011 VSS VSS nfet_03v3 L=0.28U W=0.36U AS=0.0972P AD=0.18P
+ PS=0.9U PD=1.72U
M$5581 \$5016 \$142 VSS VSS nfet_03v3 L=0.28U W=0.36U AS=0.1584P AD=0.1188P
+ PS=1.6U PD=1.02U
M$5582 \$5017 \$4940 \$5016 VSS nfet_03v3 L=0.28U W=0.36U AS=0.1188P AD=0.1278P
+ PS=1.02U PD=1.07U
M$5583 \$5217 \$5018 \$5017 VSS nfet_03v3 L=0.28U W=0.36U AS=0.1278P AD=0.0567P
+ PS=1.07U PD=0.675U
M$5584 VSS \$4941 \$5217 VSS nfet_03v3 L=0.28U W=0.36U AS=0.0567P AD=0.1584P
+ PS=0.675U PD=1.6U
M$5585 VSS \$5017 \$5018 VSS nfet_03v3 L=0.28U W=0.36U AS=0.1584P AD=0.0972P
+ PS=1.6U PD=0.9U
M$5586 \$5019 \$5017 VSS VSS nfet_03v3 L=0.28U W=0.36U AS=0.0972P AD=0.18P
+ PS=0.9U PD=1.72U
M$5587 \$5022 \$145 VSS VSS nfet_03v3 L=0.28U W=0.36U AS=0.1584P AD=0.1188P
+ PS=1.6U PD=1.02U
M$5588 \$5023 \$4940 \$5022 VSS nfet_03v3 L=0.28U W=0.36U AS=0.1188P AD=0.1278P
+ PS=1.02U PD=1.07U
M$5589 \$5223 \$5024 \$5023 VSS nfet_03v3 L=0.28U W=0.36U AS=0.1278P AD=0.0567P
+ PS=1.07U PD=0.675U
M$5590 VSS \$4941 \$5223 VSS nfet_03v3 L=0.28U W=0.36U AS=0.0567P AD=0.1584P
+ PS=0.675U PD=1.6U
M$5591 VSS \$5023 \$5024 VSS nfet_03v3 L=0.28U W=0.36U AS=0.1584P AD=0.0972P
+ PS=1.6U PD=0.9U
M$5592 \$5025 \$5023 VSS VSS nfet_03v3 L=0.28U W=0.36U AS=0.0972P AD=0.18P
+ PS=0.9U PD=1.72U
M$5593 \$5028 \$148 VSS VSS nfet_03v3 L=0.28U W=0.36U AS=0.1584P AD=0.1188P
+ PS=1.6U PD=1.02U
M$5594 \$5029 \$4940 \$5028 VSS nfet_03v3 L=0.28U W=0.36U AS=0.1188P AD=0.1278P
+ PS=1.02U PD=1.07U
M$5595 \$5229 \$5030 \$5029 VSS nfet_03v3 L=0.28U W=0.36U AS=0.1278P AD=0.0567P
+ PS=1.07U PD=0.675U
M$5596 VSS \$4941 \$5229 VSS nfet_03v3 L=0.28U W=0.36U AS=0.0567P AD=0.1584P
+ PS=0.675U PD=1.6U
M$5597 VSS \$5029 \$5030 VSS nfet_03v3 L=0.28U W=0.36U AS=0.1584P AD=0.0972P
+ PS=1.6U PD=0.9U
M$5598 \$5031 \$5029 VSS VSS nfet_03v3 L=0.28U W=0.36U AS=0.0972P AD=0.18P
+ PS=0.9U PD=1.72U
M$5599 \$5034 \$151 VSS VSS nfet_03v3 L=0.28U W=0.36U AS=0.1584P AD=0.1188P
+ PS=1.6U PD=1.02U
M$5600 \$5035 \$4940 \$5034 VSS nfet_03v3 L=0.28U W=0.36U AS=0.1188P AD=0.1278P
+ PS=1.02U PD=1.07U
M$5601 \$5235 \$5036 \$5035 VSS nfet_03v3 L=0.28U W=0.36U AS=0.1278P AD=0.0567P
+ PS=1.07U PD=0.675U
M$5602 VSS \$4941 \$5235 VSS nfet_03v3 L=0.28U W=0.36U AS=0.0567P AD=0.1584P
+ PS=0.675U PD=1.6U
M$5603 VSS \$5035 \$5036 VSS nfet_03v3 L=0.28U W=0.36U AS=0.1584P AD=0.0972P
+ PS=1.6U PD=0.9U
M$5604 \$5037 \$5035 VSS VSS nfet_03v3 L=0.28U W=0.36U AS=0.0972P AD=0.18P
+ PS=0.9U PD=1.72U
.ENDS rf
