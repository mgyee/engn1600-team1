* Extracted by KLayout with GF180MCU LVS runset on : 26/02/2026 04:21

.SUBCKT rf VSS QB VDD QA QAb QBb WEMb D|Q WEM D WECLK WECLKb CLK RB RA WE
M$1 VDD QAb QA VDD pfet_03v3 L=0.28U W=11.52U AS=6.5664P AD=3.9744P PS=41.28U
+ PD=22.56U
M$2 QB QBb VDD VDD pfet_03v3 L=0.28U W=11.52U AS=3.9744P AD=6.5664P PS=22.56U
+ PD=41.28U
M$33 WEMb \$256 VDD VDD pfet_03v3 L=0.28U W=2.52U AS=0.882P AD=0.882P PS=5.18U
+ PD=5.18U
M$35 D|Q \$203 VDD VDD pfet_03v3 L=0.28U W=2.48U AS=0.868P AD=0.868P PS=5.12U
+ PD=5.12U
M$37 \$107 \$203 VDD VDD pfet_03v3 L=0.28U W=0.36U AS=0.1584P AD=0.1584P
+ PS=1.6U PD=1.6U
M$38 \$157 WEM VDD VDD pfet_03v3 L=0.28U W=0.36U AS=0.1584P AD=0.0567P PS=1.6U
+ PD=0.675U
M$39 \$203 \$107 \$157 VDD pfet_03v3 L=0.28U W=0.36U AS=0.0567P AD=0.1278P
+ PS=0.675U PD=1.07U
M$40 \$109 WEMb \$203 VDD pfet_03v3 L=0.28U W=0.36U AS=0.1278P AD=0.2097P
+ PS=1.07U PD=1.38U
M$41 VDD D \$109 VDD pfet_03v3 L=0.28U W=0.72U AS=0.2097P AD=0.3168P PS=1.38U
+ PD=2.32U
M$42 D|Q \$205 VDD VDD pfet_03v3 L=0.28U W=2.48U AS=0.868P AD=0.868P PS=5.12U
+ PD=5.12U
M$44 \$111 \$205 VDD VDD pfet_03v3 L=0.28U W=0.36U AS=0.1584P AD=0.1584P
+ PS=1.6U PD=1.6U
M$45 \$162 WEM VDD VDD pfet_03v3 L=0.28U W=0.36U AS=0.1584P AD=0.0567P PS=1.6U
+ PD=0.675U
M$46 \$205 \$111 \$162 VDD pfet_03v3 L=0.28U W=0.36U AS=0.0567P AD=0.1278P
+ PS=0.675U PD=1.07U
M$47 \$112 WEMb \$205 VDD pfet_03v3 L=0.28U W=0.36U AS=0.1278P AD=0.2097P
+ PS=1.07U PD=1.38U
M$48 VDD D \$112 VDD pfet_03v3 L=0.28U W=0.72U AS=0.2097P AD=0.3168P PS=1.38U
+ PD=2.32U
M$49 D|Q \$207 VDD VDD pfet_03v3 L=0.28U W=2.48U AS=0.868P AD=0.868P PS=5.12U
+ PD=5.12U
M$51 \$114 \$207 VDD VDD pfet_03v3 L=0.28U W=0.36U AS=0.1584P AD=0.1584P
+ PS=1.6U PD=1.6U
M$52 \$168 WEM VDD VDD pfet_03v3 L=0.28U W=0.36U AS=0.1584P AD=0.0567P PS=1.6U
+ PD=0.675U
M$53 \$207 \$114 \$168 VDD pfet_03v3 L=0.28U W=0.36U AS=0.0567P AD=0.1278P
+ PS=0.675U PD=1.07U
M$54 \$115 WEMb \$207 VDD pfet_03v3 L=0.28U W=0.36U AS=0.1278P AD=0.2097P
+ PS=1.07U PD=1.38U
M$55 VDD D \$115 VDD pfet_03v3 L=0.28U W=0.72U AS=0.2097P AD=0.3168P PS=1.38U
+ PD=2.32U
M$56 D|Q \$209 VDD VDD pfet_03v3 L=0.28U W=2.48U AS=0.868P AD=0.868P PS=5.12U
+ PD=5.12U
M$58 \$117 \$209 VDD VDD pfet_03v3 L=0.28U W=0.36U AS=0.1584P AD=0.1584P
+ PS=1.6U PD=1.6U
M$59 \$172 WEM VDD VDD pfet_03v3 L=0.28U W=0.36U AS=0.1584P AD=0.0567P PS=1.6U
+ PD=0.675U
M$60 \$209 \$117 \$172 VDD pfet_03v3 L=0.28U W=0.36U AS=0.0567P AD=0.1278P
+ PS=0.675U PD=1.07U
M$61 \$118 WEMb \$209 VDD pfet_03v3 L=0.28U W=0.36U AS=0.1278P AD=0.2097P
+ PS=1.07U PD=1.38U
M$62 VDD D \$118 VDD pfet_03v3 L=0.28U W=0.72U AS=0.2097P AD=0.3168P PS=1.38U
+ PD=2.32U
M$63 D|Q \$211 VDD VDD pfet_03v3 L=0.28U W=2.48U AS=0.868P AD=0.868P PS=5.12U
+ PD=5.12U
M$65 \$120 \$211 VDD VDD pfet_03v3 L=0.28U W=0.36U AS=0.1584P AD=0.1584P
+ PS=1.6U PD=1.6U
M$66 \$177 WEM VDD VDD pfet_03v3 L=0.28U W=0.36U AS=0.1584P AD=0.0567P PS=1.6U
+ PD=0.675U
M$67 \$211 \$120 \$177 VDD pfet_03v3 L=0.28U W=0.36U AS=0.0567P AD=0.1278P
+ PS=0.675U PD=1.07U
M$68 \$121 WEMb \$211 VDD pfet_03v3 L=0.28U W=0.36U AS=0.1278P AD=0.2097P
+ PS=1.07U PD=1.38U
M$69 VDD D \$121 VDD pfet_03v3 L=0.28U W=0.72U AS=0.2097P AD=0.3168P PS=1.38U
+ PD=2.32U
M$70 D|Q \$213 VDD VDD pfet_03v3 L=0.28U W=2.48U AS=0.868P AD=0.868P PS=5.12U
+ PD=5.12U
M$72 \$123 \$213 VDD VDD pfet_03v3 L=0.28U W=0.36U AS=0.1584P AD=0.1584P
+ PS=1.6U PD=1.6U
M$73 \$182 WEM VDD VDD pfet_03v3 L=0.28U W=0.36U AS=0.1584P AD=0.0567P PS=1.6U
+ PD=0.675U
M$74 \$213 \$123 \$182 VDD pfet_03v3 L=0.28U W=0.36U AS=0.0567P AD=0.1278P
+ PS=0.675U PD=1.07U
M$75 \$124 WEMb \$213 VDD pfet_03v3 L=0.28U W=0.36U AS=0.1278P AD=0.2097P
+ PS=1.07U PD=1.38U
M$76 VDD D \$124 VDD pfet_03v3 L=0.28U W=0.72U AS=0.2097P AD=0.3168P PS=1.38U
+ PD=2.32U
M$77 D|Q \$215 VDD VDD pfet_03v3 L=0.28U W=2.48U AS=0.868P AD=0.868P PS=5.12U
+ PD=5.12U
M$79 \$126 \$215 VDD VDD pfet_03v3 L=0.28U W=0.36U AS=0.1584P AD=0.1584P
+ PS=1.6U PD=1.6U
M$80 \$186 WEM VDD VDD pfet_03v3 L=0.28U W=0.36U AS=0.1584P AD=0.0567P PS=1.6U
+ PD=0.675U
M$81 \$215 \$126 \$186 VDD pfet_03v3 L=0.28U W=0.36U AS=0.0567P AD=0.1278P
+ PS=0.675U PD=1.07U
M$82 \$127 WEMb \$215 VDD pfet_03v3 L=0.28U W=0.36U AS=0.1278P AD=0.2097P
+ PS=1.07U PD=1.38U
M$83 VDD D \$127 VDD pfet_03v3 L=0.28U W=0.72U AS=0.2097P AD=0.3168P PS=1.38U
+ PD=2.32U
M$84 D|Q \$217 VDD VDD pfet_03v3 L=0.28U W=2.48U AS=0.868P AD=0.868P PS=5.12U
+ PD=5.12U
M$86 \$129 \$217 VDD VDD pfet_03v3 L=0.28U W=0.36U AS=0.1584P AD=0.1584P
+ PS=1.6U PD=1.6U
M$87 \$192 WEM VDD VDD pfet_03v3 L=0.28U W=0.36U AS=0.1584P AD=0.0567P PS=1.6U
+ PD=0.675U
M$88 \$217 \$129 \$192 VDD pfet_03v3 L=0.28U W=0.36U AS=0.0567P AD=0.1278P
+ PS=0.675U PD=1.07U
M$89 \$130 WEMb \$217 VDD pfet_03v3 L=0.28U W=0.36U AS=0.1278P AD=0.2097P
+ PS=1.07U PD=1.38U
M$90 VDD D \$130 VDD pfet_03v3 L=0.28U W=0.72U AS=0.2097P AD=0.3168P PS=1.38U
+ PD=2.32U
M$91 D|Q \$219 VDD VDD pfet_03v3 L=0.28U W=2.48U AS=0.868P AD=0.868P PS=5.12U
+ PD=5.12U
M$93 \$132 \$219 VDD VDD pfet_03v3 L=0.28U W=0.36U AS=0.1584P AD=0.1584P
+ PS=1.6U PD=1.6U
M$94 \$197 WEM VDD VDD pfet_03v3 L=0.28U W=0.36U AS=0.1584P AD=0.0567P PS=1.6U
+ PD=0.675U
M$95 \$219 \$132 \$197 VDD pfet_03v3 L=0.28U W=0.36U AS=0.0567P AD=0.1278P
+ PS=0.675U PD=1.07U
M$96 \$133 WEMb \$219 VDD pfet_03v3 L=0.28U W=0.36U AS=0.1278P AD=0.2097P
+ PS=1.07U PD=1.38U
M$97 VDD D \$133 VDD pfet_03v3 L=0.28U W=0.72U AS=0.2097P AD=0.3168P PS=1.38U
+ PD=2.32U
M$98 D|Q \$221 VDD VDD pfet_03v3 L=0.28U W=2.48U AS=0.868P AD=0.868P PS=5.12U
+ PD=5.12U
M$100 \$135 \$221 VDD VDD pfet_03v3 L=0.28U W=0.36U AS=0.1584P AD=0.1584P
+ PS=1.6U PD=1.6U
M$101 \$202 WEM VDD VDD pfet_03v3 L=0.28U W=0.36U AS=0.1584P AD=0.0567P PS=1.6U
+ PD=0.675U
M$102 \$221 \$135 \$202 VDD pfet_03v3 L=0.28U W=0.36U AS=0.0567P AD=0.1278P
+ PS=0.675U PD=1.07U
M$103 \$136 WEMb \$221 VDD pfet_03v3 L=0.28U W=0.36U AS=0.1278P AD=0.2097P
+ PS=1.07U PD=1.38U
M$104 VDD D \$136 VDD pfet_03v3 L=0.28U W=0.72U AS=0.2097P AD=0.3168P PS=1.38U
+ PD=2.32U
M$105 D|Q \$223 VDD VDD pfet_03v3 L=0.28U W=2.48U AS=0.868P AD=0.868P PS=5.12U
+ PD=5.12U
M$107 \$138 \$223 VDD VDD pfet_03v3 L=0.28U W=0.36U AS=0.1584P AD=0.1584P
+ PS=1.6U PD=1.6U
M$108 \$196 WEM VDD VDD pfet_03v3 L=0.28U W=0.36U AS=0.1584P AD=0.0567P PS=1.6U
+ PD=0.675U
M$109 \$223 \$138 \$196 VDD pfet_03v3 L=0.28U W=0.36U AS=0.0567P AD=0.1278P
+ PS=0.675U PD=1.07U
M$110 \$139 WEMb \$223 VDD pfet_03v3 L=0.28U W=0.36U AS=0.1278P AD=0.2097P
+ PS=1.07U PD=1.38U
M$111 VDD D \$139 VDD pfet_03v3 L=0.28U W=0.72U AS=0.2097P AD=0.3168P PS=1.38U
+ PD=2.32U
M$112 D|Q \$225 VDD VDD pfet_03v3 L=0.28U W=2.48U AS=0.868P AD=0.868P PS=5.12U
+ PD=5.12U
M$114 \$141 \$225 VDD VDD pfet_03v3 L=0.28U W=0.36U AS=0.1584P AD=0.1584P
+ PS=1.6U PD=1.6U
M$115 \$189 WEM VDD VDD pfet_03v3 L=0.28U W=0.36U AS=0.1584P AD=0.0567P PS=1.6U
+ PD=0.675U
M$116 \$225 \$141 \$189 VDD pfet_03v3 L=0.28U W=0.36U AS=0.0567P AD=0.1278P
+ PS=0.675U PD=1.07U
M$117 \$142 WEMb \$225 VDD pfet_03v3 L=0.28U W=0.36U AS=0.1278P AD=0.2097P
+ PS=1.07U PD=1.38U
M$118 VDD D \$142 VDD pfet_03v3 L=0.28U W=0.72U AS=0.2097P AD=0.3168P PS=1.38U
+ PD=2.32U
M$119 D|Q \$227 VDD VDD pfet_03v3 L=0.28U W=2.48U AS=0.868P AD=0.868P PS=5.12U
+ PD=5.12U
M$121 \$144 \$227 VDD VDD pfet_03v3 L=0.28U W=0.36U AS=0.1584P AD=0.1584P
+ PS=1.6U PD=1.6U
M$122 \$180 WEM VDD VDD pfet_03v3 L=0.28U W=0.36U AS=0.1584P AD=0.0567P PS=1.6U
+ PD=0.675U
M$123 \$227 \$144 \$180 VDD pfet_03v3 L=0.28U W=0.36U AS=0.0567P AD=0.1278P
+ PS=0.675U PD=1.07U
M$124 \$145 WEMb \$227 VDD pfet_03v3 L=0.28U W=0.36U AS=0.1278P AD=0.2097P
+ PS=1.07U PD=1.38U
M$125 VDD D \$145 VDD pfet_03v3 L=0.28U W=0.72U AS=0.2097P AD=0.3168P PS=1.38U
+ PD=2.32U
M$126 D|Q \$229 VDD VDD pfet_03v3 L=0.28U W=2.48U AS=0.868P AD=0.868P PS=5.12U
+ PD=5.12U
M$128 \$147 \$229 VDD VDD pfet_03v3 L=0.28U W=0.36U AS=0.1584P AD=0.1584P
+ PS=1.6U PD=1.6U
M$129 \$173 WEM VDD VDD pfet_03v3 L=0.28U W=0.36U AS=0.1584P AD=0.0567P PS=1.6U
+ PD=0.675U
M$130 \$229 \$147 \$173 VDD pfet_03v3 L=0.28U W=0.36U AS=0.0567P AD=0.1278P
+ PS=0.675U PD=1.07U
M$131 \$148 WEMb \$229 VDD pfet_03v3 L=0.28U W=0.36U AS=0.1278P AD=0.2097P
+ PS=1.07U PD=1.38U
M$132 VDD D \$148 VDD pfet_03v3 L=0.28U W=0.72U AS=0.2097P AD=0.3168P PS=1.38U
+ PD=2.32U
M$133 D|Q \$231 VDD VDD pfet_03v3 L=0.28U W=2.48U AS=0.868P AD=0.868P PS=5.12U
+ PD=5.12U
M$135 \$150 \$231 VDD VDD pfet_03v3 L=0.28U W=0.36U AS=0.1584P AD=0.1584P
+ PS=1.6U PD=1.6U
M$136 \$165 WEM VDD VDD pfet_03v3 L=0.28U W=0.36U AS=0.1584P AD=0.0567P PS=1.6U
+ PD=0.675U
M$137 \$231 \$150 \$165 VDD pfet_03v3 L=0.28U W=0.36U AS=0.0567P AD=0.1278P
+ PS=0.675U PD=1.07U
M$138 \$151 WEMb \$231 VDD pfet_03v3 L=0.28U W=0.36U AS=0.1278P AD=0.2097P
+ PS=1.07U PD=1.38U
M$139 VDD D \$151 VDD pfet_03v3 L=0.28U W=0.72U AS=0.2097P AD=0.3168P PS=1.38U
+ PD=2.32U
M$140 D|Q \$233 VDD VDD pfet_03v3 L=0.28U W=2.48U AS=0.868P AD=0.868P PS=5.12U
+ PD=5.12U
M$142 \$153 \$233 VDD VDD pfet_03v3 L=0.28U W=0.36U AS=0.1584P AD=0.1584P
+ PS=1.6U PD=1.6U
M$143 \$158 WEM VDD VDD pfet_03v3 L=0.28U W=0.36U AS=0.1584P AD=0.0567P PS=1.6U
+ PD=0.675U
M$144 \$233 \$153 \$158 VDD pfet_03v3 L=0.28U W=0.36U AS=0.0567P AD=0.1278P
+ PS=0.675U PD=1.07U
M$145 \$154 WEMb \$233 VDD pfet_03v3 L=0.28U W=0.36U AS=0.1278P AD=0.2097P
+ PS=1.07U PD=1.38U
M$146 VDD D \$154 VDD pfet_03v3 L=0.28U W=0.72U AS=0.2097P AD=0.3168P PS=1.38U
+ PD=2.32U
M$147 \$337 WE VDD VDD pfet_03v3 L=0.28U W=0.72U AS=0.3168P AD=0.1872P PS=2.32U
+ PD=1.24U
M$148 VDD CLK \$337 VDD pfet_03v3 L=0.28U W=0.72U AS=0.1872P AD=0.3168P
+ PS=1.24U PD=2.32U
M$149 WECLK \$337 VDD VDD pfet_03v3 L=0.28U W=2.54U AS=0.8974P AD=0.6604P
+ PS=5.28U PD=3.58U
M$151 WECLKb WECLK VDD VDD pfet_03v3 L=0.28U W=42.88U AS=11.6352P AD=15.6512P
+ PS=60.48U PD=87.68U
M$153 \$340 D|Q VDD VDD pfet_03v3 L=0.28U W=0.72U AS=0.3168P AD=0.2097P
+ PS=2.32U PD=1.38U
M$154 \$341 WECLKb \$340 VDD pfet_03v3 L=0.28U W=0.36U AS=0.2097P AD=0.1278P
+ PS=1.38U PD=1.07U
M$155 \$562 \$342 \$341 VDD pfet_03v3 L=0.28U W=0.36U AS=0.1278P AD=0.0567P
+ PS=1.07U PD=0.675U
M$156 VDD WECLK \$562 VDD pfet_03v3 L=0.28U W=0.36U AS=0.0567P AD=0.1584P
+ PS=0.675U PD=1.6U
M$157 \$342 \$341 VDD VDD pfet_03v3 L=0.28U W=0.36U AS=0.1764P AD=0.1584P
+ PS=1.26U PD=1.6U
M$158 \$321 \$341 VDD VDD pfet_03v3 L=0.28U W=0.72U AS=0.1764P AD=0.36P
+ PS=1.26U PD=2.44U
M$159 \$439 RA VDD VDD pfet_03v3 L=0.28U W=0.72U AS=0.3312P AD=0.3888P PS=2.36U
+ PD=2.52U
M$160 \$321 \$439 QAb VDD pfet_03v3 L=0.28U W=0.36U AS=0.1584P AD=0.1152P
+ PS=1.6U PD=1U
M$161 QBb \$440 \$321 VDD pfet_03v3 L=0.28U W=0.36U AS=0.1152P AD=0.1584P PS=1U
+ PD=1.6U
M$162 VDD RB \$440 VDD pfet_03v3 L=0.28U W=0.72U AS=0.3708P AD=0.3168P PS=2.47U
+ PD=2.32U
M$163 \$343 D|Q VDD VDD pfet_03v3 L=0.28U W=0.72U AS=0.3168P AD=0.2097P
+ PS=2.32U PD=1.38U
M$164 \$344 WECLKb \$343 VDD pfet_03v3 L=0.28U W=0.36U AS=0.2097P AD=0.1278P
+ PS=1.38U PD=1.07U
M$165 \$572 \$345 \$344 VDD pfet_03v3 L=0.28U W=0.36U AS=0.1278P AD=0.0567P
+ PS=1.07U PD=0.675U
M$166 VDD WECLK \$572 VDD pfet_03v3 L=0.28U W=0.36U AS=0.0567P AD=0.1584P
+ PS=0.675U PD=1.6U
M$167 \$345 \$344 VDD VDD pfet_03v3 L=0.28U W=0.36U AS=0.1764P AD=0.1584P
+ PS=1.26U PD=1.6U
M$168 \$322 \$344 VDD VDD pfet_03v3 L=0.28U W=0.72U AS=0.1764P AD=0.36P
+ PS=1.26U PD=2.44U
M$169 \$441 RA VDD VDD pfet_03v3 L=0.28U W=0.72U AS=0.3312P AD=0.3888P PS=2.36U
+ PD=2.52U
M$170 \$322 \$441 QAb VDD pfet_03v3 L=0.28U W=0.36U AS=0.1584P AD=0.1152P
+ PS=1.6U PD=1U
M$171 QBb \$442 \$322 VDD pfet_03v3 L=0.28U W=0.36U AS=0.1152P AD=0.1584P PS=1U
+ PD=1.6U
M$172 VDD RB \$442 VDD pfet_03v3 L=0.28U W=0.72U AS=0.3708P AD=0.3168P PS=2.47U
+ PD=2.32U
M$173 \$346 D|Q VDD VDD pfet_03v3 L=0.28U W=0.72U AS=0.3168P AD=0.2097P
+ PS=2.32U PD=1.38U
M$174 \$347 WECLKb \$346 VDD pfet_03v3 L=0.28U W=0.36U AS=0.2097P AD=0.1278P
+ PS=1.38U PD=1.07U
M$175 \$579 \$348 \$347 VDD pfet_03v3 L=0.28U W=0.36U AS=0.1278P AD=0.0567P
+ PS=1.07U PD=0.675U
M$176 VDD WECLK \$579 VDD pfet_03v3 L=0.28U W=0.36U AS=0.0567P AD=0.1584P
+ PS=0.675U PD=1.6U
M$177 \$348 \$347 VDD VDD pfet_03v3 L=0.28U W=0.36U AS=0.1764P AD=0.1584P
+ PS=1.26U PD=1.6U
M$178 \$323 \$347 VDD VDD pfet_03v3 L=0.28U W=0.72U AS=0.1764P AD=0.36P
+ PS=1.26U PD=2.44U
M$179 \$443 RA VDD VDD pfet_03v3 L=0.28U W=0.72U AS=0.3312P AD=0.3888P PS=2.36U
+ PD=2.52U
M$180 \$323 \$443 QAb VDD pfet_03v3 L=0.28U W=0.36U AS=0.1584P AD=0.1152P
+ PS=1.6U PD=1U
M$181 QBb \$444 \$323 VDD pfet_03v3 L=0.28U W=0.36U AS=0.1152P AD=0.1584P PS=1U
+ PD=1.6U
M$182 VDD RB \$444 VDD pfet_03v3 L=0.28U W=0.72U AS=0.3708P AD=0.3168P PS=2.47U
+ PD=2.32U
M$183 \$349 D|Q VDD VDD pfet_03v3 L=0.28U W=0.72U AS=0.3168P AD=0.2097P
+ PS=2.32U PD=1.38U
M$184 \$350 WECLKb \$349 VDD pfet_03v3 L=0.28U W=0.36U AS=0.2097P AD=0.1278P
+ PS=1.38U PD=1.07U
M$185 \$588 \$351 \$350 VDD pfet_03v3 L=0.28U W=0.36U AS=0.1278P AD=0.0567P
+ PS=1.07U PD=0.675U
M$186 VDD WECLK \$588 VDD pfet_03v3 L=0.28U W=0.36U AS=0.0567P AD=0.1584P
+ PS=0.675U PD=1.6U
M$187 \$351 \$350 VDD VDD pfet_03v3 L=0.28U W=0.36U AS=0.1764P AD=0.1584P
+ PS=1.26U PD=1.6U
M$188 \$324 \$350 VDD VDD pfet_03v3 L=0.28U W=0.72U AS=0.1764P AD=0.36P
+ PS=1.26U PD=2.44U
M$189 \$445 RA VDD VDD pfet_03v3 L=0.28U W=0.72U AS=0.3312P AD=0.3888P PS=2.36U
+ PD=2.52U
M$190 \$324 \$445 QAb VDD pfet_03v3 L=0.28U W=0.36U AS=0.1584P AD=0.1152P
+ PS=1.6U PD=1U
M$191 QBb \$446 \$324 VDD pfet_03v3 L=0.28U W=0.36U AS=0.1152P AD=0.1584P PS=1U
+ PD=1.6U
M$192 VDD RB \$446 VDD pfet_03v3 L=0.28U W=0.72U AS=0.3708P AD=0.3168P PS=2.47U
+ PD=2.32U
M$193 \$352 D|Q VDD VDD pfet_03v3 L=0.28U W=0.72U AS=0.3168P AD=0.2097P
+ PS=2.32U PD=1.38U
M$194 \$353 WECLKb \$352 VDD pfet_03v3 L=0.28U W=0.36U AS=0.2097P AD=0.1278P
+ PS=1.38U PD=1.07U
M$195 \$599 \$354 \$353 VDD pfet_03v3 L=0.28U W=0.36U AS=0.1278P AD=0.0567P
+ PS=1.07U PD=0.675U
M$196 VDD WECLK \$599 VDD pfet_03v3 L=0.28U W=0.36U AS=0.0567P AD=0.1584P
+ PS=0.675U PD=1.6U
M$197 \$354 \$353 VDD VDD pfet_03v3 L=0.28U W=0.36U AS=0.1764P AD=0.1584P
+ PS=1.26U PD=1.6U
M$198 \$325 \$353 VDD VDD pfet_03v3 L=0.28U W=0.72U AS=0.1764P AD=0.36P
+ PS=1.26U PD=2.44U
M$199 \$447 RA VDD VDD pfet_03v3 L=0.28U W=0.72U AS=0.3312P AD=0.3888P PS=2.36U
+ PD=2.52U
M$200 \$325 \$447 QAb VDD pfet_03v3 L=0.28U W=0.36U AS=0.1584P AD=0.1152P
+ PS=1.6U PD=1U
M$201 QBb \$448 \$325 VDD pfet_03v3 L=0.28U W=0.36U AS=0.1152P AD=0.1584P PS=1U
+ PD=1.6U
M$202 VDD RB \$448 VDD pfet_03v3 L=0.28U W=0.72U AS=0.3708P AD=0.3168P PS=2.47U
+ PD=2.32U
M$203 \$355 D|Q VDD VDD pfet_03v3 L=0.28U W=0.72U AS=0.3168P AD=0.2097P
+ PS=2.32U PD=1.38U
M$204 \$356 WECLKb \$355 VDD pfet_03v3 L=0.28U W=0.36U AS=0.2097P AD=0.1278P
+ PS=1.38U PD=1.07U
M$205 \$607 \$357 \$356 VDD pfet_03v3 L=0.28U W=0.36U AS=0.1278P AD=0.0567P
+ PS=1.07U PD=0.675U
M$206 VDD WECLK \$607 VDD pfet_03v3 L=0.28U W=0.36U AS=0.0567P AD=0.1584P
+ PS=0.675U PD=1.6U
M$207 \$357 \$356 VDD VDD pfet_03v3 L=0.28U W=0.36U AS=0.1764P AD=0.1584P
+ PS=1.26U PD=1.6U
M$208 \$326 \$356 VDD VDD pfet_03v3 L=0.28U W=0.72U AS=0.1764P AD=0.36P
+ PS=1.26U PD=2.44U
M$209 \$449 RA VDD VDD pfet_03v3 L=0.28U W=0.72U AS=0.3312P AD=0.3888P PS=2.36U
+ PD=2.52U
M$210 \$326 \$449 QAb VDD pfet_03v3 L=0.28U W=0.36U AS=0.1584P AD=0.1152P
+ PS=1.6U PD=1U
M$211 QBb \$450 \$326 VDD pfet_03v3 L=0.28U W=0.36U AS=0.1152P AD=0.1584P PS=1U
+ PD=1.6U
M$212 VDD RB \$450 VDD pfet_03v3 L=0.28U W=0.72U AS=0.3708P AD=0.3168P PS=2.47U
+ PD=2.32U
M$213 \$358 D|Q VDD VDD pfet_03v3 L=0.28U W=0.72U AS=0.3168P AD=0.2097P
+ PS=2.32U PD=1.38U
M$214 \$359 WECLKb \$358 VDD pfet_03v3 L=0.28U W=0.36U AS=0.2097P AD=0.1278P
+ PS=1.38U PD=1.07U
M$215 \$615 \$360 \$359 VDD pfet_03v3 L=0.28U W=0.36U AS=0.1278P AD=0.0567P
+ PS=1.07U PD=0.675U
M$216 VDD WECLK \$615 VDD pfet_03v3 L=0.28U W=0.36U AS=0.0567P AD=0.1584P
+ PS=0.675U PD=1.6U
M$217 \$360 \$359 VDD VDD pfet_03v3 L=0.28U W=0.36U AS=0.1764P AD=0.1584P
+ PS=1.26U PD=1.6U
M$218 \$327 \$359 VDD VDD pfet_03v3 L=0.28U W=0.72U AS=0.1764P AD=0.36P
+ PS=1.26U PD=2.44U
M$219 \$451 RA VDD VDD pfet_03v3 L=0.28U W=0.72U AS=0.3312P AD=0.3888P PS=2.36U
+ PD=2.52U
M$220 \$327 \$451 QAb VDD pfet_03v3 L=0.28U W=0.36U AS=0.1584P AD=0.1152P
+ PS=1.6U PD=1U
M$221 QBb \$452 \$327 VDD pfet_03v3 L=0.28U W=0.36U AS=0.1152P AD=0.1584P PS=1U
+ PD=1.6U
M$222 VDD RB \$452 VDD pfet_03v3 L=0.28U W=0.72U AS=0.3708P AD=0.3168P PS=2.47U
+ PD=2.32U
M$223 \$361 D|Q VDD VDD pfet_03v3 L=0.28U W=0.72U AS=0.3168P AD=0.2097P
+ PS=2.32U PD=1.38U
M$224 \$362 WECLKb \$361 VDD pfet_03v3 L=0.28U W=0.36U AS=0.2097P AD=0.1278P
+ PS=1.38U PD=1.07U
M$225 \$624 \$363 \$362 VDD pfet_03v3 L=0.28U W=0.36U AS=0.1278P AD=0.0567P
+ PS=1.07U PD=0.675U
M$226 VDD WECLK \$624 VDD pfet_03v3 L=0.28U W=0.36U AS=0.0567P AD=0.1584P
+ PS=0.675U PD=1.6U
M$227 \$363 \$362 VDD VDD pfet_03v3 L=0.28U W=0.36U AS=0.1764P AD=0.1584P
+ PS=1.26U PD=1.6U
M$228 \$328 \$362 VDD VDD pfet_03v3 L=0.28U W=0.72U AS=0.1764P AD=0.36P
+ PS=1.26U PD=2.44U
M$229 \$453 RA VDD VDD pfet_03v3 L=0.28U W=0.72U AS=0.3312P AD=0.3888P PS=2.36U
+ PD=2.52U
M$230 \$328 \$453 QAb VDD pfet_03v3 L=0.28U W=0.36U AS=0.1584P AD=0.1152P
+ PS=1.6U PD=1U
M$231 QBb \$454 \$328 VDD pfet_03v3 L=0.28U W=0.36U AS=0.1152P AD=0.1584P PS=1U
+ PD=1.6U
M$232 VDD RB \$454 VDD pfet_03v3 L=0.28U W=0.72U AS=0.3708P AD=0.3168P PS=2.47U
+ PD=2.32U
M$233 \$364 D|Q VDD VDD pfet_03v3 L=0.28U W=0.72U AS=0.3168P AD=0.2097P
+ PS=2.32U PD=1.38U
M$234 \$365 WECLKb \$364 VDD pfet_03v3 L=0.28U W=0.36U AS=0.2097P AD=0.1278P
+ PS=1.38U PD=1.07U
M$235 \$633 \$366 \$365 VDD pfet_03v3 L=0.28U W=0.36U AS=0.1278P AD=0.0567P
+ PS=1.07U PD=0.675U
M$236 VDD WECLK \$633 VDD pfet_03v3 L=0.28U W=0.36U AS=0.0567P AD=0.1584P
+ PS=0.675U PD=1.6U
M$237 \$366 \$365 VDD VDD pfet_03v3 L=0.28U W=0.36U AS=0.1764P AD=0.1584P
+ PS=1.26U PD=1.6U
M$238 \$329 \$365 VDD VDD pfet_03v3 L=0.28U W=0.72U AS=0.1764P AD=0.36P
+ PS=1.26U PD=2.44U
M$239 \$455 RA VDD VDD pfet_03v3 L=0.28U W=0.72U AS=0.3312P AD=0.3888P PS=2.36U
+ PD=2.52U
M$240 \$329 \$455 QAb VDD pfet_03v3 L=0.28U W=0.36U AS=0.1584P AD=0.1152P
+ PS=1.6U PD=1U
M$241 QBb \$456 \$329 VDD pfet_03v3 L=0.28U W=0.36U AS=0.1152P AD=0.1584P PS=1U
+ PD=1.6U
M$242 VDD RB \$456 VDD pfet_03v3 L=0.28U W=0.72U AS=0.3708P AD=0.3168P PS=2.47U
+ PD=2.32U
M$243 \$367 D|Q VDD VDD pfet_03v3 L=0.28U W=0.72U AS=0.3168P AD=0.2097P
+ PS=2.32U PD=1.38U
M$244 \$368 WECLKb \$367 VDD pfet_03v3 L=0.28U W=0.36U AS=0.2097P AD=0.1278P
+ PS=1.38U PD=1.07U
M$245 \$642 \$369 \$368 VDD pfet_03v3 L=0.28U W=0.36U AS=0.1278P AD=0.0567P
+ PS=1.07U PD=0.675U
M$246 VDD WECLK \$642 VDD pfet_03v3 L=0.28U W=0.36U AS=0.0567P AD=0.1584P
+ PS=0.675U PD=1.6U
M$247 \$369 \$368 VDD VDD pfet_03v3 L=0.28U W=0.36U AS=0.1764P AD=0.1584P
+ PS=1.26U PD=1.6U
M$248 \$330 \$368 VDD VDD pfet_03v3 L=0.28U W=0.72U AS=0.1764P AD=0.36P
+ PS=1.26U PD=2.44U
M$249 \$457 RA VDD VDD pfet_03v3 L=0.28U W=0.72U AS=0.3312P AD=0.3888P PS=2.36U
+ PD=2.52U
M$250 \$330 \$457 QAb VDD pfet_03v3 L=0.28U W=0.36U AS=0.1584P AD=0.1152P
+ PS=1.6U PD=1U
M$251 QBb \$458 \$330 VDD pfet_03v3 L=0.28U W=0.36U AS=0.1152P AD=0.1584P PS=1U
+ PD=1.6U
M$252 VDD RB \$458 VDD pfet_03v3 L=0.28U W=0.72U AS=0.3708P AD=0.3168P PS=2.47U
+ PD=2.32U
M$253 \$370 D|Q VDD VDD pfet_03v3 L=0.28U W=0.72U AS=0.3168P AD=0.2097P
+ PS=2.32U PD=1.38U
M$254 \$371 WECLKb \$370 VDD pfet_03v3 L=0.28U W=0.36U AS=0.2097P AD=0.1278P
+ PS=1.38U PD=1.07U
M$255 \$651 \$372 \$371 VDD pfet_03v3 L=0.28U W=0.36U AS=0.1278P AD=0.0567P
+ PS=1.07U PD=0.675U
M$256 VDD WECLK \$651 VDD pfet_03v3 L=0.28U W=0.36U AS=0.0567P AD=0.1584P
+ PS=0.675U PD=1.6U
M$257 \$372 \$371 VDD VDD pfet_03v3 L=0.28U W=0.36U AS=0.1764P AD=0.1584P
+ PS=1.26U PD=1.6U
M$258 \$331 \$371 VDD VDD pfet_03v3 L=0.28U W=0.72U AS=0.1764P AD=0.36P
+ PS=1.26U PD=2.44U
M$259 \$459 RA VDD VDD pfet_03v3 L=0.28U W=0.72U AS=0.3312P AD=0.3888P PS=2.36U
+ PD=2.52U
M$260 \$331 \$459 QAb VDD pfet_03v3 L=0.28U W=0.36U AS=0.1584P AD=0.1152P
+ PS=1.6U PD=1U
M$261 QBb \$460 \$331 VDD pfet_03v3 L=0.28U W=0.36U AS=0.1152P AD=0.1584P PS=1U
+ PD=1.6U
M$262 VDD RB \$460 VDD pfet_03v3 L=0.28U W=0.72U AS=0.3708P AD=0.3168P PS=2.47U
+ PD=2.32U
M$263 \$373 D|Q VDD VDD pfet_03v3 L=0.28U W=0.72U AS=0.3168P AD=0.2097P
+ PS=2.32U PD=1.38U
M$264 \$374 WECLKb \$373 VDD pfet_03v3 L=0.28U W=0.36U AS=0.2097P AD=0.1278P
+ PS=1.38U PD=1.07U
M$265 \$658 \$375 \$374 VDD pfet_03v3 L=0.28U W=0.36U AS=0.1278P AD=0.0567P
+ PS=1.07U PD=0.675U
M$266 VDD WECLK \$658 VDD pfet_03v3 L=0.28U W=0.36U AS=0.0567P AD=0.1584P
+ PS=0.675U PD=1.6U
M$267 \$375 \$374 VDD VDD pfet_03v3 L=0.28U W=0.36U AS=0.1764P AD=0.1584P
+ PS=1.26U PD=1.6U
M$268 \$332 \$374 VDD VDD pfet_03v3 L=0.28U W=0.72U AS=0.1764P AD=0.36P
+ PS=1.26U PD=2.44U
M$269 \$461 RA VDD VDD pfet_03v3 L=0.28U W=0.72U AS=0.3312P AD=0.3888P PS=2.36U
+ PD=2.52U
M$270 \$332 \$461 QAb VDD pfet_03v3 L=0.28U W=0.36U AS=0.1584P AD=0.1152P
+ PS=1.6U PD=1U
M$271 QBb \$462 \$332 VDD pfet_03v3 L=0.28U W=0.36U AS=0.1152P AD=0.1584P PS=1U
+ PD=1.6U
M$272 VDD RB \$462 VDD pfet_03v3 L=0.28U W=0.72U AS=0.3708P AD=0.3168P PS=2.47U
+ PD=2.32U
M$273 \$376 D|Q VDD VDD pfet_03v3 L=0.28U W=0.72U AS=0.3168P AD=0.2097P
+ PS=2.32U PD=1.38U
M$274 \$377 WECLKb \$376 VDD pfet_03v3 L=0.28U W=0.36U AS=0.2097P AD=0.1278P
+ PS=1.38U PD=1.07U
M$275 \$646 \$378 \$377 VDD pfet_03v3 L=0.28U W=0.36U AS=0.1278P AD=0.0567P
+ PS=1.07U PD=0.675U
M$276 VDD WECLK \$646 VDD pfet_03v3 L=0.28U W=0.36U AS=0.0567P AD=0.1584P
+ PS=0.675U PD=1.6U
M$277 \$378 \$377 VDD VDD pfet_03v3 L=0.28U W=0.36U AS=0.1764P AD=0.1584P
+ PS=1.26U PD=1.6U
M$278 \$333 \$377 VDD VDD pfet_03v3 L=0.28U W=0.72U AS=0.1764P AD=0.36P
+ PS=1.26U PD=2.44U
M$279 \$463 RA VDD VDD pfet_03v3 L=0.28U W=0.72U AS=0.3312P AD=0.3888P PS=2.36U
+ PD=2.52U
M$280 \$333 \$463 QAb VDD pfet_03v3 L=0.28U W=0.36U AS=0.1584P AD=0.1152P
+ PS=1.6U PD=1U
M$281 QBb \$464 \$333 VDD pfet_03v3 L=0.28U W=0.36U AS=0.1152P AD=0.1584P PS=1U
+ PD=1.6U
M$282 VDD RB \$464 VDD pfet_03v3 L=0.28U W=0.72U AS=0.3708P AD=0.3168P PS=2.47U
+ PD=2.32U
M$283 \$379 D|Q VDD VDD pfet_03v3 L=0.28U W=0.72U AS=0.3168P AD=0.2097P
+ PS=2.32U PD=1.38U
M$284 \$380 WECLKb \$379 VDD pfet_03v3 L=0.28U W=0.36U AS=0.2097P AD=0.1278P
+ PS=1.38U PD=1.07U
M$285 \$620 \$381 \$380 VDD pfet_03v3 L=0.28U W=0.36U AS=0.1278P AD=0.0567P
+ PS=1.07U PD=0.675U
M$286 VDD WECLK \$620 VDD pfet_03v3 L=0.28U W=0.36U AS=0.0567P AD=0.1584P
+ PS=0.675U PD=1.6U
M$287 \$381 \$380 VDD VDD pfet_03v3 L=0.28U W=0.36U AS=0.1764P AD=0.1584P
+ PS=1.26U PD=1.6U
M$288 \$334 \$380 VDD VDD pfet_03v3 L=0.28U W=0.72U AS=0.1764P AD=0.36P
+ PS=1.26U PD=2.44U
M$289 \$465 RA VDD VDD pfet_03v3 L=0.28U W=0.72U AS=0.3312P AD=0.3888P PS=2.36U
+ PD=2.52U
M$290 \$334 \$465 QAb VDD pfet_03v3 L=0.28U W=0.36U AS=0.1584P AD=0.1152P
+ PS=1.6U PD=1U
M$291 QBb \$466 \$334 VDD pfet_03v3 L=0.28U W=0.36U AS=0.1152P AD=0.1584P PS=1U
+ PD=1.6U
M$292 VDD RB \$466 VDD pfet_03v3 L=0.28U W=0.72U AS=0.3708P AD=0.3168P PS=2.47U
+ PD=2.32U
M$293 \$382 D|Q VDD VDD pfet_03v3 L=0.28U W=0.72U AS=0.3168P AD=0.2097P
+ PS=2.32U PD=1.38U
M$294 \$383 WECLKb \$382 VDD pfet_03v3 L=0.28U W=0.36U AS=0.2097P AD=0.1278P
+ PS=1.38U PD=1.07U
M$295 \$600 \$384 \$383 VDD pfet_03v3 L=0.28U W=0.36U AS=0.1278P AD=0.0567P
+ PS=1.07U PD=0.675U
M$296 VDD WECLK \$600 VDD pfet_03v3 L=0.28U W=0.36U AS=0.0567P AD=0.1584P
+ PS=0.675U PD=1.6U
M$297 \$384 \$383 VDD VDD pfet_03v3 L=0.28U W=0.36U AS=0.1764P AD=0.1584P
+ PS=1.26U PD=1.6U
M$298 \$335 \$383 VDD VDD pfet_03v3 L=0.28U W=0.72U AS=0.1764P AD=0.36P
+ PS=1.26U PD=2.44U
M$299 \$467 RA VDD VDD pfet_03v3 L=0.28U W=0.72U AS=0.3312P AD=0.3888P PS=2.36U
+ PD=2.52U
M$300 \$335 \$467 QAb VDD pfet_03v3 L=0.28U W=0.36U AS=0.1584P AD=0.1152P
+ PS=1.6U PD=1U
M$301 QBb \$468 \$335 VDD pfet_03v3 L=0.28U W=0.36U AS=0.1152P AD=0.1584P PS=1U
+ PD=1.6U
M$302 VDD RB \$468 VDD pfet_03v3 L=0.28U W=0.72U AS=0.3708P AD=0.3168P PS=2.47U
+ PD=2.32U
M$303 \$385 D|Q VDD VDD pfet_03v3 L=0.28U W=0.72U AS=0.3168P AD=0.2097P
+ PS=2.32U PD=1.38U
M$304 \$386 WECLKb \$385 VDD pfet_03v3 L=0.28U W=0.36U AS=0.2097P AD=0.1278P
+ PS=1.38U PD=1.07U
M$305 \$571 \$387 \$386 VDD pfet_03v3 L=0.28U W=0.36U AS=0.1278P AD=0.0567P
+ PS=1.07U PD=0.675U
M$306 VDD WECLK \$571 VDD pfet_03v3 L=0.28U W=0.36U AS=0.0567P AD=0.1584P
+ PS=0.675U PD=1.6U
M$307 \$387 \$386 VDD VDD pfet_03v3 L=0.28U W=0.36U AS=0.1764P AD=0.1584P
+ PS=1.26U PD=1.6U
M$308 \$336 \$386 VDD VDD pfet_03v3 L=0.28U W=0.72U AS=0.1764P AD=0.36P
+ PS=1.26U PD=2.44U
M$309 \$469 RA VDD VDD pfet_03v3 L=0.28U W=0.72U AS=0.3312P AD=0.3888P PS=2.36U
+ PD=2.52U
M$310 \$336 \$469 QAb VDD pfet_03v3 L=0.28U W=0.36U AS=0.1584P AD=0.1152P
+ PS=1.6U PD=1U
M$311 QBb \$470 \$336 VDD pfet_03v3 L=0.28U W=0.36U AS=0.1152P AD=0.1584P PS=1U
+ PD=1.6U
M$312 VDD RB \$470 VDD pfet_03v3 L=0.28U W=0.72U AS=0.3708P AD=0.3168P PS=2.47U
+ PD=2.32U
M$313 \$663 WE VDD VDD pfet_03v3 L=0.28U W=0.72U AS=0.3168P AD=0.1872P PS=2.32U
+ PD=1.24U
M$314 VDD CLK \$663 VDD pfet_03v3 L=0.28U W=0.72U AS=0.1872P AD=0.3168P
+ PS=1.24U PD=2.32U
M$315 WECLK \$663 VDD VDD pfet_03v3 L=0.28U W=2.54U AS=0.889P AD=0.6688P
+ PS=5.21U PD=3.65U
M$319 \$669 WECLKb \$668 VDD pfet_03v3 L=0.28U W=0.36U AS=0.2097P AD=0.1278P
+ PS=1.38U PD=1.07U
M$320 \$771 \$670 \$669 VDD pfet_03v3 L=0.28U W=0.36U AS=0.1278P AD=0.0567P
+ PS=1.07U PD=0.675U
M$321 VDD WECLK \$771 VDD pfet_03v3 L=0.28U W=0.36U AS=0.0567P AD=0.1584P
+ PS=0.675U PD=1.6U
M$322 \$668 D|Q VDD VDD pfet_03v3 L=0.28U W=0.72U AS=0.3168P AD=0.2097P
+ PS=2.32U PD=1.38U
M$323 VDD \$669 \$670 VDD pfet_03v3 L=0.28U W=0.36U AS=0.1584P AD=0.1764P
+ PS=1.6U PD=1.26U
M$324 \$671 \$669 VDD VDD pfet_03v3 L=0.28U W=0.72U AS=0.1764P AD=0.36P
+ PS=1.26U PD=2.44U
M$325 \$672 RA VDD VDD pfet_03v3 L=0.28U W=0.72U AS=0.3312P AD=0.3888P PS=2.36U
+ PD=2.52U
M$326 \$671 \$672 QAb VDD pfet_03v3 L=0.28U W=0.36U AS=0.1584P AD=0.1152P
+ PS=1.6U PD=1U
M$327 QBb \$673 \$671 VDD pfet_03v3 L=0.28U W=0.36U AS=0.1152P AD=0.1584P PS=1U
+ PD=1.6U
M$328 VDD RB \$673 VDD pfet_03v3 L=0.28U W=0.72U AS=0.3708P AD=0.3168P PS=2.47U
+ PD=2.32U
M$329 \$676 WECLKb \$675 VDD pfet_03v3 L=0.28U W=0.36U AS=0.2097P AD=0.1278P
+ PS=1.38U PD=1.07U
M$330 \$780 \$677 \$676 VDD pfet_03v3 L=0.28U W=0.36U AS=0.1278P AD=0.0567P
+ PS=1.07U PD=0.675U
M$331 VDD WECLK \$780 VDD pfet_03v3 L=0.28U W=0.36U AS=0.0567P AD=0.1584P
+ PS=0.675U PD=1.6U
M$332 \$675 D|Q VDD VDD pfet_03v3 L=0.28U W=0.72U AS=0.3168P AD=0.2097P
+ PS=2.32U PD=1.38U
M$333 VDD \$676 \$677 VDD pfet_03v3 L=0.28U W=0.36U AS=0.1584P AD=0.1764P
+ PS=1.6U PD=1.26U
M$334 \$678 \$676 VDD VDD pfet_03v3 L=0.28U W=0.72U AS=0.1764P AD=0.36P
+ PS=1.26U PD=2.44U
M$335 \$679 RA VDD VDD pfet_03v3 L=0.28U W=0.72U AS=0.3312P AD=0.3888P PS=2.36U
+ PD=2.52U
M$336 \$678 \$679 QAb VDD pfet_03v3 L=0.28U W=0.36U AS=0.1584P AD=0.1152P
+ PS=1.6U PD=1U
M$337 QBb \$680 \$678 VDD pfet_03v3 L=0.28U W=0.36U AS=0.1152P AD=0.1584P PS=1U
+ PD=1.6U
M$338 VDD RB \$680 VDD pfet_03v3 L=0.28U W=0.72U AS=0.3708P AD=0.3168P PS=2.47U
+ PD=2.32U
M$339 \$682 WECLKb \$681 VDD pfet_03v3 L=0.28U W=0.36U AS=0.2097P AD=0.1278P
+ PS=1.38U PD=1.07U
M$340 \$790 \$683 \$682 VDD pfet_03v3 L=0.28U W=0.36U AS=0.1278P AD=0.0567P
+ PS=1.07U PD=0.675U
M$341 VDD WECLK \$790 VDD pfet_03v3 L=0.28U W=0.36U AS=0.0567P AD=0.1584P
+ PS=0.675U PD=1.6U
M$342 \$681 D|Q VDD VDD pfet_03v3 L=0.28U W=0.72U AS=0.3168P AD=0.2097P
+ PS=2.32U PD=1.38U
M$343 VDD \$682 \$683 VDD pfet_03v3 L=0.28U W=0.36U AS=0.1584P AD=0.1764P
+ PS=1.6U PD=1.26U
M$344 \$684 \$682 VDD VDD pfet_03v3 L=0.28U W=0.72U AS=0.1764P AD=0.36P
+ PS=1.26U PD=2.44U
M$345 \$685 RA VDD VDD pfet_03v3 L=0.28U W=0.72U AS=0.3312P AD=0.3888P PS=2.36U
+ PD=2.52U
M$346 \$684 \$685 QAb VDD pfet_03v3 L=0.28U W=0.36U AS=0.1584P AD=0.1152P
+ PS=1.6U PD=1U
M$347 QBb \$686 \$684 VDD pfet_03v3 L=0.28U W=0.36U AS=0.1152P AD=0.1584P PS=1U
+ PD=1.6U
M$348 VDD RB \$686 VDD pfet_03v3 L=0.28U W=0.72U AS=0.3708P AD=0.3168P PS=2.47U
+ PD=2.32U
M$349 \$688 WECLKb \$687 VDD pfet_03v3 L=0.28U W=0.36U AS=0.2097P AD=0.1278P
+ PS=1.38U PD=1.07U
M$350 \$801 \$689 \$688 VDD pfet_03v3 L=0.28U W=0.36U AS=0.1278P AD=0.0567P
+ PS=1.07U PD=0.675U
M$351 VDD WECLK \$801 VDD pfet_03v3 L=0.28U W=0.36U AS=0.0567P AD=0.1584P
+ PS=0.675U PD=1.6U
M$352 \$687 D|Q VDD VDD pfet_03v3 L=0.28U W=0.72U AS=0.3168P AD=0.2097P
+ PS=2.32U PD=1.38U
M$353 VDD \$688 \$689 VDD pfet_03v3 L=0.28U W=0.36U AS=0.1584P AD=0.1764P
+ PS=1.6U PD=1.26U
M$354 \$690 \$688 VDD VDD pfet_03v3 L=0.28U W=0.72U AS=0.1764P AD=0.36P
+ PS=1.26U PD=2.44U
M$355 \$691 RA VDD VDD pfet_03v3 L=0.28U W=0.72U AS=0.3312P AD=0.3888P PS=2.36U
+ PD=2.52U
M$356 \$690 \$691 QAb VDD pfet_03v3 L=0.28U W=0.36U AS=0.1584P AD=0.1152P
+ PS=1.6U PD=1U
M$357 QBb \$692 \$690 VDD pfet_03v3 L=0.28U W=0.36U AS=0.1152P AD=0.1584P PS=1U
+ PD=1.6U
M$358 VDD RB \$692 VDD pfet_03v3 L=0.28U W=0.72U AS=0.3708P AD=0.3168P PS=2.47U
+ PD=2.32U
M$359 \$694 WECLKb \$693 VDD pfet_03v3 L=0.28U W=0.36U AS=0.2097P AD=0.1278P
+ PS=1.38U PD=1.07U
M$360 \$813 \$695 \$694 VDD pfet_03v3 L=0.28U W=0.36U AS=0.1278P AD=0.0567P
+ PS=1.07U PD=0.675U
M$361 VDD WECLK \$813 VDD pfet_03v3 L=0.28U W=0.36U AS=0.0567P AD=0.1584P
+ PS=0.675U PD=1.6U
M$362 \$693 D|Q VDD VDD pfet_03v3 L=0.28U W=0.72U AS=0.3168P AD=0.2097P
+ PS=2.32U PD=1.38U
M$363 VDD \$694 \$695 VDD pfet_03v3 L=0.28U W=0.36U AS=0.1584P AD=0.1764P
+ PS=1.6U PD=1.26U
M$364 \$696 \$694 VDD VDD pfet_03v3 L=0.28U W=0.72U AS=0.1764P AD=0.36P
+ PS=1.26U PD=2.44U
M$365 \$697 RA VDD VDD pfet_03v3 L=0.28U W=0.72U AS=0.3312P AD=0.3888P PS=2.36U
+ PD=2.52U
M$366 \$696 \$697 QAb VDD pfet_03v3 L=0.28U W=0.36U AS=0.1584P AD=0.1152P
+ PS=1.6U PD=1U
M$367 QBb \$698 \$696 VDD pfet_03v3 L=0.28U W=0.36U AS=0.1152P AD=0.1584P PS=1U
+ PD=1.6U
M$368 VDD RB \$698 VDD pfet_03v3 L=0.28U W=0.72U AS=0.3708P AD=0.3168P PS=2.47U
+ PD=2.32U
M$369 \$700 WECLKb \$699 VDD pfet_03v3 L=0.28U W=0.36U AS=0.2097P AD=0.1278P
+ PS=1.38U PD=1.07U
M$370 \$822 \$701 \$700 VDD pfet_03v3 L=0.28U W=0.36U AS=0.1278P AD=0.0567P
+ PS=1.07U PD=0.675U
M$371 VDD WECLK \$822 VDD pfet_03v3 L=0.28U W=0.36U AS=0.0567P AD=0.1584P
+ PS=0.675U PD=1.6U
M$372 \$699 D|Q VDD VDD pfet_03v3 L=0.28U W=0.72U AS=0.3168P AD=0.2097P
+ PS=2.32U PD=1.38U
M$373 VDD \$700 \$701 VDD pfet_03v3 L=0.28U W=0.36U AS=0.1584P AD=0.1764P
+ PS=1.6U PD=1.26U
M$374 \$702 \$700 VDD VDD pfet_03v3 L=0.28U W=0.72U AS=0.1764P AD=0.36P
+ PS=1.26U PD=2.44U
M$375 \$703 RA VDD VDD pfet_03v3 L=0.28U W=0.72U AS=0.3312P AD=0.3888P PS=2.36U
+ PD=2.52U
M$376 \$702 \$703 QAb VDD pfet_03v3 L=0.28U W=0.36U AS=0.1584P AD=0.1152P
+ PS=1.6U PD=1U
M$377 QBb \$704 \$702 VDD pfet_03v3 L=0.28U W=0.36U AS=0.1152P AD=0.1584P PS=1U
+ PD=1.6U
M$378 VDD RB \$704 VDD pfet_03v3 L=0.28U W=0.72U AS=0.3708P AD=0.3168P PS=2.47U
+ PD=2.32U
M$379 \$706 WECLKb \$705 VDD pfet_03v3 L=0.28U W=0.36U AS=0.2097P AD=0.1278P
+ PS=1.38U PD=1.07U
M$380 \$831 \$707 \$706 VDD pfet_03v3 L=0.28U W=0.36U AS=0.1278P AD=0.0567P
+ PS=1.07U PD=0.675U
M$381 VDD WECLK \$831 VDD pfet_03v3 L=0.28U W=0.36U AS=0.0567P AD=0.1584P
+ PS=0.675U PD=1.6U
M$382 \$705 D|Q VDD VDD pfet_03v3 L=0.28U W=0.72U AS=0.3168P AD=0.2097P
+ PS=2.32U PD=1.38U
M$383 VDD \$706 \$707 VDD pfet_03v3 L=0.28U W=0.36U AS=0.1584P AD=0.1764P
+ PS=1.6U PD=1.26U
M$384 \$708 \$706 VDD VDD pfet_03v3 L=0.28U W=0.72U AS=0.1764P AD=0.36P
+ PS=1.26U PD=2.44U
M$385 \$709 RA VDD VDD pfet_03v3 L=0.28U W=0.72U AS=0.3312P AD=0.3888P PS=2.36U
+ PD=2.52U
M$386 \$708 \$709 QAb VDD pfet_03v3 L=0.28U W=0.36U AS=0.1584P AD=0.1152P
+ PS=1.6U PD=1U
M$387 QBb \$710 \$708 VDD pfet_03v3 L=0.28U W=0.36U AS=0.1152P AD=0.1584P PS=1U
+ PD=1.6U
M$388 VDD RB \$710 VDD pfet_03v3 L=0.28U W=0.72U AS=0.3708P AD=0.3168P PS=2.47U
+ PD=2.32U
M$389 \$712 WECLKb \$711 VDD pfet_03v3 L=0.28U W=0.36U AS=0.2097P AD=0.1278P
+ PS=1.38U PD=1.07U
M$390 \$843 \$713 \$712 VDD pfet_03v3 L=0.28U W=0.36U AS=0.1278P AD=0.0567P
+ PS=1.07U PD=0.675U
M$391 VDD WECLK \$843 VDD pfet_03v3 L=0.28U W=0.36U AS=0.0567P AD=0.1584P
+ PS=0.675U PD=1.6U
M$392 \$711 D|Q VDD VDD pfet_03v3 L=0.28U W=0.72U AS=0.3168P AD=0.2097P
+ PS=2.32U PD=1.38U
M$393 VDD \$712 \$713 VDD pfet_03v3 L=0.28U W=0.36U AS=0.1584P AD=0.1764P
+ PS=1.6U PD=1.26U
M$394 \$714 \$712 VDD VDD pfet_03v3 L=0.28U W=0.72U AS=0.1764P AD=0.36P
+ PS=1.26U PD=2.44U
M$395 \$715 RA VDD VDD pfet_03v3 L=0.28U W=0.72U AS=0.3312P AD=0.3888P PS=2.36U
+ PD=2.52U
M$396 \$714 \$715 QAb VDD pfet_03v3 L=0.28U W=0.36U AS=0.1584P AD=0.1152P
+ PS=1.6U PD=1U
M$397 QBb \$716 \$714 VDD pfet_03v3 L=0.28U W=0.36U AS=0.1152P AD=0.1584P PS=1U
+ PD=1.6U
M$398 VDD RB \$716 VDD pfet_03v3 L=0.28U W=0.72U AS=0.3708P AD=0.3168P PS=2.47U
+ PD=2.32U
M$399 \$718 WECLKb \$717 VDD pfet_03v3 L=0.28U W=0.36U AS=0.2097P AD=0.1278P
+ PS=1.38U PD=1.07U
M$400 \$854 \$719 \$718 VDD pfet_03v3 L=0.28U W=0.36U AS=0.1278P AD=0.0567P
+ PS=1.07U PD=0.675U
M$401 VDD WECLK \$854 VDD pfet_03v3 L=0.28U W=0.36U AS=0.0567P AD=0.1584P
+ PS=0.675U PD=1.6U
M$402 \$717 D|Q VDD VDD pfet_03v3 L=0.28U W=0.72U AS=0.3168P AD=0.2097P
+ PS=2.32U PD=1.38U
M$403 VDD \$718 \$719 VDD pfet_03v3 L=0.28U W=0.36U AS=0.1584P AD=0.1764P
+ PS=1.6U PD=1.26U
M$404 \$720 \$718 VDD VDD pfet_03v3 L=0.28U W=0.72U AS=0.1764P AD=0.36P
+ PS=1.26U PD=2.44U
M$405 \$721 RA VDD VDD pfet_03v3 L=0.28U W=0.72U AS=0.3312P AD=0.3888P PS=2.36U
+ PD=2.52U
M$406 \$720 \$721 QAb VDD pfet_03v3 L=0.28U W=0.36U AS=0.1584P AD=0.1152P
+ PS=1.6U PD=1U
M$407 QBb \$722 \$720 VDD pfet_03v3 L=0.28U W=0.36U AS=0.1152P AD=0.1584P PS=1U
+ PD=1.6U
M$408 VDD RB \$722 VDD pfet_03v3 L=0.28U W=0.72U AS=0.3708P AD=0.3168P PS=2.47U
+ PD=2.32U
M$409 \$724 WECLKb \$723 VDD pfet_03v3 L=0.28U W=0.36U AS=0.2097P AD=0.1278P
+ PS=1.38U PD=1.07U
M$410 \$864 \$725 \$724 VDD pfet_03v3 L=0.28U W=0.36U AS=0.1278P AD=0.0567P
+ PS=1.07U PD=0.675U
M$411 VDD WECLK \$864 VDD pfet_03v3 L=0.28U W=0.36U AS=0.0567P AD=0.1584P
+ PS=0.675U PD=1.6U
M$412 \$723 D|Q VDD VDD pfet_03v3 L=0.28U W=0.72U AS=0.3168P AD=0.2097P
+ PS=2.32U PD=1.38U
M$413 VDD \$724 \$725 VDD pfet_03v3 L=0.28U W=0.36U AS=0.1584P AD=0.1764P
+ PS=1.6U PD=1.26U
M$414 \$726 \$724 VDD VDD pfet_03v3 L=0.28U W=0.72U AS=0.1764P AD=0.36P
+ PS=1.26U PD=2.44U
M$415 \$727 RA VDD VDD pfet_03v3 L=0.28U W=0.72U AS=0.3312P AD=0.3888P PS=2.36U
+ PD=2.52U
M$416 \$726 \$727 QAb VDD pfet_03v3 L=0.28U W=0.36U AS=0.1584P AD=0.1152P
+ PS=1.6U PD=1U
M$417 QBb \$728 \$726 VDD pfet_03v3 L=0.28U W=0.36U AS=0.1152P AD=0.1584P PS=1U
+ PD=1.6U
M$418 VDD RB \$728 VDD pfet_03v3 L=0.28U W=0.72U AS=0.3708P AD=0.3168P PS=2.47U
+ PD=2.32U
M$419 \$730 WECLKb \$729 VDD pfet_03v3 L=0.28U W=0.36U AS=0.2097P AD=0.1278P
+ PS=1.38U PD=1.07U
M$420 \$873 \$731 \$730 VDD pfet_03v3 L=0.28U W=0.36U AS=0.1278P AD=0.0567P
+ PS=1.07U PD=0.675U
M$421 VDD WECLK \$873 VDD pfet_03v3 L=0.28U W=0.36U AS=0.0567P AD=0.1584P
+ PS=0.675U PD=1.6U
M$422 \$729 D|Q VDD VDD pfet_03v3 L=0.28U W=0.72U AS=0.3168P AD=0.2097P
+ PS=2.32U PD=1.38U
M$423 VDD \$730 \$731 VDD pfet_03v3 L=0.28U W=0.36U AS=0.1584P AD=0.1764P
+ PS=1.6U PD=1.26U
M$424 \$732 \$730 VDD VDD pfet_03v3 L=0.28U W=0.72U AS=0.1764P AD=0.36P
+ PS=1.26U PD=2.44U
M$425 \$733 RA VDD VDD pfet_03v3 L=0.28U W=0.72U AS=0.3312P AD=0.3888P PS=2.36U
+ PD=2.52U
M$426 \$732 \$733 QAb VDD pfet_03v3 L=0.28U W=0.36U AS=0.1584P AD=0.1152P
+ PS=1.6U PD=1U
M$427 QBb \$734 \$732 VDD pfet_03v3 L=0.28U W=0.36U AS=0.1152P AD=0.1584P PS=1U
+ PD=1.6U
M$428 VDD RB \$734 VDD pfet_03v3 L=0.28U W=0.72U AS=0.3708P AD=0.3168P PS=2.47U
+ PD=2.32U
M$429 \$736 WECLKb \$735 VDD pfet_03v3 L=0.28U W=0.36U AS=0.2097P AD=0.1278P
+ PS=1.38U PD=1.07U
M$430 \$885 \$737 \$736 VDD pfet_03v3 L=0.28U W=0.36U AS=0.1278P AD=0.0567P
+ PS=1.07U PD=0.675U
M$431 VDD WECLK \$885 VDD pfet_03v3 L=0.28U W=0.36U AS=0.0567P AD=0.1584P
+ PS=0.675U PD=1.6U
M$432 \$735 D|Q VDD VDD pfet_03v3 L=0.28U W=0.72U AS=0.3168P AD=0.2097P
+ PS=2.32U PD=1.38U
M$433 VDD \$736 \$737 VDD pfet_03v3 L=0.28U W=0.36U AS=0.1584P AD=0.1764P
+ PS=1.6U PD=1.26U
M$434 \$738 \$736 VDD VDD pfet_03v3 L=0.28U W=0.72U AS=0.1764P AD=0.36P
+ PS=1.26U PD=2.44U
M$435 \$739 RA VDD VDD pfet_03v3 L=0.28U W=0.72U AS=0.3312P AD=0.3888P PS=2.36U
+ PD=2.52U
M$436 \$738 \$739 QAb VDD pfet_03v3 L=0.28U W=0.36U AS=0.1584P AD=0.1152P
+ PS=1.6U PD=1U
M$437 QBb \$740 \$738 VDD pfet_03v3 L=0.28U W=0.36U AS=0.1152P AD=0.1584P PS=1U
+ PD=1.6U
M$438 VDD RB \$740 VDD pfet_03v3 L=0.28U W=0.72U AS=0.3708P AD=0.3168P PS=2.47U
+ PD=2.32U
M$439 \$742 WECLKb \$741 VDD pfet_03v3 L=0.28U W=0.36U AS=0.2097P AD=0.1278P
+ PS=1.38U PD=1.07U
M$440 \$893 \$743 \$742 VDD pfet_03v3 L=0.28U W=0.36U AS=0.1278P AD=0.0567P
+ PS=1.07U PD=0.675U
M$441 VDD WECLK \$893 VDD pfet_03v3 L=0.28U W=0.36U AS=0.0567P AD=0.1584P
+ PS=0.675U PD=1.6U
M$442 \$741 D|Q VDD VDD pfet_03v3 L=0.28U W=0.72U AS=0.3168P AD=0.2097P
+ PS=2.32U PD=1.38U
M$443 VDD \$742 \$743 VDD pfet_03v3 L=0.28U W=0.36U AS=0.1584P AD=0.1764P
+ PS=1.6U PD=1.26U
M$444 \$744 \$742 VDD VDD pfet_03v3 L=0.28U W=0.72U AS=0.1764P AD=0.36P
+ PS=1.26U PD=2.44U
M$445 \$745 RA VDD VDD pfet_03v3 L=0.28U W=0.72U AS=0.3312P AD=0.3888P PS=2.36U
+ PD=2.52U
M$446 \$744 \$745 QAb VDD pfet_03v3 L=0.28U W=0.36U AS=0.1584P AD=0.1152P
+ PS=1.6U PD=1U
M$447 QBb \$746 \$744 VDD pfet_03v3 L=0.28U W=0.36U AS=0.1152P AD=0.1584P PS=1U
+ PD=1.6U
M$448 VDD RB \$746 VDD pfet_03v3 L=0.28U W=0.72U AS=0.3708P AD=0.3168P PS=2.47U
+ PD=2.32U
M$449 \$748 WECLKb \$747 VDD pfet_03v3 L=0.28U W=0.36U AS=0.2097P AD=0.1278P
+ PS=1.38U PD=1.07U
M$450 \$856 \$749 \$748 VDD pfet_03v3 L=0.28U W=0.36U AS=0.1278P AD=0.0567P
+ PS=1.07U PD=0.675U
M$451 VDD WECLK \$856 VDD pfet_03v3 L=0.28U W=0.36U AS=0.0567P AD=0.1584P
+ PS=0.675U PD=1.6U
M$452 \$747 D|Q VDD VDD pfet_03v3 L=0.28U W=0.72U AS=0.3168P AD=0.2097P
+ PS=2.32U PD=1.38U
M$453 VDD \$748 \$749 VDD pfet_03v3 L=0.28U W=0.36U AS=0.1584P AD=0.1764P
+ PS=1.6U PD=1.26U
M$454 \$750 \$748 VDD VDD pfet_03v3 L=0.28U W=0.72U AS=0.1764P AD=0.36P
+ PS=1.26U PD=2.44U
M$455 \$751 RA VDD VDD pfet_03v3 L=0.28U W=0.72U AS=0.3312P AD=0.3888P PS=2.36U
+ PD=2.52U
M$456 \$750 \$751 QAb VDD pfet_03v3 L=0.28U W=0.36U AS=0.1584P AD=0.1152P
+ PS=1.6U PD=1U
M$457 QBb \$752 \$750 VDD pfet_03v3 L=0.28U W=0.36U AS=0.1152P AD=0.1584P PS=1U
+ PD=1.6U
M$458 VDD RB \$752 VDD pfet_03v3 L=0.28U W=0.72U AS=0.3708P AD=0.3168P PS=2.47U
+ PD=2.32U
M$459 \$754 WECLKb \$753 VDD pfet_03v3 L=0.28U W=0.36U AS=0.2097P AD=0.1278P
+ PS=1.38U PD=1.07U
M$460 \$827 \$755 \$754 VDD pfet_03v3 L=0.28U W=0.36U AS=0.1278P AD=0.0567P
+ PS=1.07U PD=0.675U
M$461 VDD WECLK \$827 VDD pfet_03v3 L=0.28U W=0.36U AS=0.0567P AD=0.1584P
+ PS=0.675U PD=1.6U
M$462 \$753 D|Q VDD VDD pfet_03v3 L=0.28U W=0.72U AS=0.3168P AD=0.2097P
+ PS=2.32U PD=1.38U
M$463 VDD \$754 \$755 VDD pfet_03v3 L=0.28U W=0.36U AS=0.1584P AD=0.1764P
+ PS=1.6U PD=1.26U
M$464 \$756 \$754 VDD VDD pfet_03v3 L=0.28U W=0.72U AS=0.1764P AD=0.36P
+ PS=1.26U PD=2.44U
M$465 \$757 RA VDD VDD pfet_03v3 L=0.28U W=0.72U AS=0.3312P AD=0.3888P PS=2.36U
+ PD=2.52U
M$466 \$756 \$757 QAb VDD pfet_03v3 L=0.28U W=0.36U AS=0.1584P AD=0.1152P
+ PS=1.6U PD=1U
M$467 QBb \$758 \$756 VDD pfet_03v3 L=0.28U W=0.36U AS=0.1152P AD=0.1584P PS=1U
+ PD=1.6U
M$468 VDD RB \$758 VDD pfet_03v3 L=0.28U W=0.72U AS=0.3708P AD=0.3168P PS=2.47U
+ PD=2.32U
M$469 \$760 WECLKb \$759 VDD pfet_03v3 L=0.28U W=0.36U AS=0.2097P AD=0.1278P
+ PS=1.38U PD=1.07U
M$470 \$792 \$761 \$760 VDD pfet_03v3 L=0.28U W=0.36U AS=0.1278P AD=0.0567P
+ PS=1.07U PD=0.675U
M$471 VDD WECLK \$792 VDD pfet_03v3 L=0.28U W=0.36U AS=0.0567P AD=0.1584P
+ PS=0.675U PD=1.6U
M$472 \$759 D|Q VDD VDD pfet_03v3 L=0.28U W=0.72U AS=0.3168P AD=0.2097P
+ PS=2.32U PD=1.38U
M$473 VDD \$760 \$761 VDD pfet_03v3 L=0.28U W=0.36U AS=0.1584P AD=0.1764P
+ PS=1.6U PD=1.26U
M$474 \$762 \$760 VDD VDD pfet_03v3 L=0.28U W=0.72U AS=0.1764P AD=0.36P
+ PS=1.26U PD=2.44U
M$475 \$763 RA VDD VDD pfet_03v3 L=0.28U W=0.72U AS=0.3312P AD=0.3888P PS=2.36U
+ PD=2.52U
M$476 \$762 \$763 QAb VDD pfet_03v3 L=0.28U W=0.36U AS=0.1584P AD=0.1152P
+ PS=1.6U PD=1U
M$477 QBb \$764 \$762 VDD pfet_03v3 L=0.28U W=0.36U AS=0.1152P AD=0.1584P PS=1U
+ PD=1.6U
M$478 VDD RB \$764 VDD pfet_03v3 L=0.28U W=0.72U AS=0.3708P AD=0.3168P PS=2.47U
+ PD=2.32U
M$479 \$1014 WE VDD VDD pfet_03v3 L=0.28U W=0.72U AS=0.3168P AD=0.1872P
+ PS=2.32U PD=1.24U
M$480 VDD CLK \$1014 VDD pfet_03v3 L=0.28U W=0.72U AS=0.1872P AD=0.3168P
+ PS=1.24U PD=2.32U
M$481 WECLK \$1014 VDD VDD pfet_03v3 L=0.28U W=2.54U AS=0.8974P AD=0.6604P
+ PS=5.28U PD=3.58U
M$485 \$1017 D|Q VDD VDD pfet_03v3 L=0.28U W=0.72U AS=0.3168P AD=0.2097P
+ PS=2.32U PD=1.38U
M$486 \$1018 WECLKb \$1017 VDD pfet_03v3 L=0.28U W=0.36U AS=0.2097P AD=0.1278P
+ PS=1.38U PD=1.07U
M$487 \$1245 \$1019 \$1018 VDD pfet_03v3 L=0.28U W=0.36U AS=0.1278P AD=0.0567P
+ PS=1.07U PD=0.675U
M$488 VDD WECLK \$1245 VDD pfet_03v3 L=0.28U W=0.36U AS=0.0567P AD=0.1584P
+ PS=0.675U PD=1.6U
M$489 \$1019 \$1018 VDD VDD pfet_03v3 L=0.28U W=0.36U AS=0.1764P AD=0.1584P
+ PS=1.26U PD=1.6U
M$490 \$998 \$1018 VDD VDD pfet_03v3 L=0.28U W=0.72U AS=0.1764P AD=0.36P
+ PS=1.26U PD=2.44U
M$491 \$1122 RA VDD VDD pfet_03v3 L=0.28U W=0.72U AS=0.3312P AD=0.3888P
+ PS=2.36U PD=2.52U
M$492 \$998 \$1122 QAb VDD pfet_03v3 L=0.28U W=0.36U AS=0.1584P AD=0.1152P
+ PS=1.6U PD=1U
M$493 QBb \$1123 \$998 VDD pfet_03v3 L=0.28U W=0.36U AS=0.1152P AD=0.1584P
+ PS=1U PD=1.6U
M$494 VDD RB \$1123 VDD pfet_03v3 L=0.28U W=0.72U AS=0.3708P AD=0.3168P
+ PS=2.47U PD=2.32U
M$495 \$1020 D|Q VDD VDD pfet_03v3 L=0.28U W=0.72U AS=0.3168P AD=0.2097P
+ PS=2.32U PD=1.38U
M$496 \$1021 WECLKb \$1020 VDD pfet_03v3 L=0.28U W=0.36U AS=0.2097P AD=0.1278P
+ PS=1.38U PD=1.07U
M$497 \$1254 \$1022 \$1021 VDD pfet_03v3 L=0.28U W=0.36U AS=0.1278P AD=0.0567P
+ PS=1.07U PD=0.675U
M$498 VDD WECLK \$1254 VDD pfet_03v3 L=0.28U W=0.36U AS=0.0567P AD=0.1584P
+ PS=0.675U PD=1.6U
M$499 \$1022 \$1021 VDD VDD pfet_03v3 L=0.28U W=0.36U AS=0.1764P AD=0.1584P
+ PS=1.26U PD=1.6U
M$500 \$999 \$1021 VDD VDD pfet_03v3 L=0.28U W=0.72U AS=0.1764P AD=0.36P
+ PS=1.26U PD=2.44U
M$501 \$1124 RA VDD VDD pfet_03v3 L=0.28U W=0.72U AS=0.3312P AD=0.3888P
+ PS=2.36U PD=2.52U
M$502 \$999 \$1124 QAb VDD pfet_03v3 L=0.28U W=0.36U AS=0.1584P AD=0.1152P
+ PS=1.6U PD=1U
M$503 QBb \$1125 \$999 VDD pfet_03v3 L=0.28U W=0.36U AS=0.1152P AD=0.1584P
+ PS=1U PD=1.6U
M$504 VDD RB \$1125 VDD pfet_03v3 L=0.28U W=0.72U AS=0.3708P AD=0.3168P
+ PS=2.47U PD=2.32U
M$505 \$1023 D|Q VDD VDD pfet_03v3 L=0.28U W=0.72U AS=0.3168P AD=0.2097P
+ PS=2.32U PD=1.38U
M$506 \$1024 WECLKb \$1023 VDD pfet_03v3 L=0.28U W=0.36U AS=0.2097P AD=0.1278P
+ PS=1.38U PD=1.07U
M$507 \$1262 \$1025 \$1024 VDD pfet_03v3 L=0.28U W=0.36U AS=0.1278P AD=0.0567P
+ PS=1.07U PD=0.675U
M$508 VDD WECLK \$1262 VDD pfet_03v3 L=0.28U W=0.36U AS=0.0567P AD=0.1584P
+ PS=0.675U PD=1.6U
M$509 \$1025 \$1024 VDD VDD pfet_03v3 L=0.28U W=0.36U AS=0.1764P AD=0.1584P
+ PS=1.26U PD=1.6U
M$510 \$1000 \$1024 VDD VDD pfet_03v3 L=0.28U W=0.72U AS=0.1764P AD=0.36P
+ PS=1.26U PD=2.44U
M$511 \$1126 RA VDD VDD pfet_03v3 L=0.28U W=0.72U AS=0.3312P AD=0.3888P
+ PS=2.36U PD=2.52U
M$512 \$1000 \$1126 QAb VDD pfet_03v3 L=0.28U W=0.36U AS=0.1584P AD=0.1152P
+ PS=1.6U PD=1U
M$513 QBb \$1127 \$1000 VDD pfet_03v3 L=0.28U W=0.36U AS=0.1152P AD=0.1584P
+ PS=1U PD=1.6U
M$514 VDD RB \$1127 VDD pfet_03v3 L=0.28U W=0.72U AS=0.3708P AD=0.3168P
+ PS=2.47U PD=2.32U
M$515 \$1026 D|Q VDD VDD pfet_03v3 L=0.28U W=0.72U AS=0.3168P AD=0.2097P
+ PS=2.32U PD=1.38U
M$516 \$1027 WECLKb \$1026 VDD pfet_03v3 L=0.28U W=0.36U AS=0.2097P AD=0.1278P
+ PS=1.38U PD=1.07U
M$517 \$1271 \$1028 \$1027 VDD pfet_03v3 L=0.28U W=0.36U AS=0.1278P AD=0.0567P
+ PS=1.07U PD=0.675U
M$518 VDD WECLK \$1271 VDD pfet_03v3 L=0.28U W=0.36U AS=0.0567P AD=0.1584P
+ PS=0.675U PD=1.6U
M$519 \$1028 \$1027 VDD VDD pfet_03v3 L=0.28U W=0.36U AS=0.1764P AD=0.1584P
+ PS=1.26U PD=1.6U
M$520 \$1001 \$1027 VDD VDD pfet_03v3 L=0.28U W=0.72U AS=0.1764P AD=0.36P
+ PS=1.26U PD=2.44U
M$521 \$1128 RA VDD VDD pfet_03v3 L=0.28U W=0.72U AS=0.3312P AD=0.3888P
+ PS=2.36U PD=2.52U
M$522 \$1001 \$1128 QAb VDD pfet_03v3 L=0.28U W=0.36U AS=0.1584P AD=0.1152P
+ PS=1.6U PD=1U
M$523 QBb \$1129 \$1001 VDD pfet_03v3 L=0.28U W=0.36U AS=0.1152P AD=0.1584P
+ PS=1U PD=1.6U
M$524 VDD RB \$1129 VDD pfet_03v3 L=0.28U W=0.72U AS=0.3708P AD=0.3168P
+ PS=2.47U PD=2.32U
M$525 \$1029 D|Q VDD VDD pfet_03v3 L=0.28U W=0.72U AS=0.3168P AD=0.2097P
+ PS=2.32U PD=1.38U
M$526 \$1030 WECLKb \$1029 VDD pfet_03v3 L=0.28U W=0.36U AS=0.2097P AD=0.1278P
+ PS=1.38U PD=1.07U
M$527 \$1282 \$1031 \$1030 VDD pfet_03v3 L=0.28U W=0.36U AS=0.1278P AD=0.0567P
+ PS=1.07U PD=0.675U
M$528 VDD WECLK \$1282 VDD pfet_03v3 L=0.28U W=0.36U AS=0.0567P AD=0.1584P
+ PS=0.675U PD=1.6U
M$529 \$1031 \$1030 VDD VDD pfet_03v3 L=0.28U W=0.36U AS=0.1764P AD=0.1584P
+ PS=1.26U PD=1.6U
M$530 \$1002 \$1030 VDD VDD pfet_03v3 L=0.28U W=0.72U AS=0.1764P AD=0.36P
+ PS=1.26U PD=2.44U
M$531 \$1130 RA VDD VDD pfet_03v3 L=0.28U W=0.72U AS=0.3312P AD=0.3888P
+ PS=2.36U PD=2.52U
M$532 \$1002 \$1130 QAb VDD pfet_03v3 L=0.28U W=0.36U AS=0.1584P AD=0.1152P
+ PS=1.6U PD=1U
M$533 QBb \$1131 \$1002 VDD pfet_03v3 L=0.28U W=0.36U AS=0.1152P AD=0.1584P
+ PS=1U PD=1.6U
M$534 VDD RB \$1131 VDD pfet_03v3 L=0.28U W=0.72U AS=0.3708P AD=0.3168P
+ PS=2.47U PD=2.32U
M$535 \$1032 D|Q VDD VDD pfet_03v3 L=0.28U W=0.72U AS=0.3168P AD=0.2097P
+ PS=2.32U PD=1.38U
M$536 \$1033 WECLKb \$1032 VDD pfet_03v3 L=0.28U W=0.36U AS=0.2097P AD=0.1278P
+ PS=1.38U PD=1.07U
M$537 \$1291 \$1034 \$1033 VDD pfet_03v3 L=0.28U W=0.36U AS=0.1278P AD=0.0567P
+ PS=1.07U PD=0.675U
M$538 VDD WECLK \$1291 VDD pfet_03v3 L=0.28U W=0.36U AS=0.0567P AD=0.1584P
+ PS=0.675U PD=1.6U
M$539 \$1034 \$1033 VDD VDD pfet_03v3 L=0.28U W=0.36U AS=0.1764P AD=0.1584P
+ PS=1.26U PD=1.6U
M$540 \$1003 \$1033 VDD VDD pfet_03v3 L=0.28U W=0.72U AS=0.1764P AD=0.36P
+ PS=1.26U PD=2.44U
M$541 \$1132 RA VDD VDD pfet_03v3 L=0.28U W=0.72U AS=0.3312P AD=0.3888P
+ PS=2.36U PD=2.52U
M$542 \$1003 \$1132 QAb VDD pfet_03v3 L=0.28U W=0.36U AS=0.1584P AD=0.1152P
+ PS=1.6U PD=1U
M$543 QBb \$1133 \$1003 VDD pfet_03v3 L=0.28U W=0.36U AS=0.1152P AD=0.1584P
+ PS=1U PD=1.6U
M$544 VDD RB \$1133 VDD pfet_03v3 L=0.28U W=0.72U AS=0.3708P AD=0.3168P
+ PS=2.47U PD=2.32U
M$545 \$1035 D|Q VDD VDD pfet_03v3 L=0.28U W=0.72U AS=0.3168P AD=0.2097P
+ PS=2.32U PD=1.38U
M$546 \$1036 WECLKb \$1035 VDD pfet_03v3 L=0.28U W=0.36U AS=0.2097P AD=0.1278P
+ PS=1.38U PD=1.07U
M$547 \$1298 \$1037 \$1036 VDD pfet_03v3 L=0.28U W=0.36U AS=0.1278P AD=0.0567P
+ PS=1.07U PD=0.675U
M$548 VDD WECLK \$1298 VDD pfet_03v3 L=0.28U W=0.36U AS=0.0567P AD=0.1584P
+ PS=0.675U PD=1.6U
M$549 \$1037 \$1036 VDD VDD pfet_03v3 L=0.28U W=0.36U AS=0.1764P AD=0.1584P
+ PS=1.26U PD=1.6U
M$550 \$1004 \$1036 VDD VDD pfet_03v3 L=0.28U W=0.72U AS=0.1764P AD=0.36P
+ PS=1.26U PD=2.44U
M$551 \$1134 RA VDD VDD pfet_03v3 L=0.28U W=0.72U AS=0.3312P AD=0.3888P
+ PS=2.36U PD=2.52U
M$552 \$1004 \$1134 QAb VDD pfet_03v3 L=0.28U W=0.36U AS=0.1584P AD=0.1152P
+ PS=1.6U PD=1U
M$553 QBb \$1135 \$1004 VDD pfet_03v3 L=0.28U W=0.36U AS=0.1152P AD=0.1584P
+ PS=1U PD=1.6U
M$554 VDD RB \$1135 VDD pfet_03v3 L=0.28U W=0.72U AS=0.3708P AD=0.3168P
+ PS=2.47U PD=2.32U
M$555 \$1038 D|Q VDD VDD pfet_03v3 L=0.28U W=0.72U AS=0.3168P AD=0.2097P
+ PS=2.32U PD=1.38U
M$556 \$1039 WECLKb \$1038 VDD pfet_03v3 L=0.28U W=0.36U AS=0.2097P AD=0.1278P
+ PS=1.38U PD=1.07U
M$557 \$1307 \$1040 \$1039 VDD pfet_03v3 L=0.28U W=0.36U AS=0.1278P AD=0.0567P
+ PS=1.07U PD=0.675U
M$558 VDD WECLK \$1307 VDD pfet_03v3 L=0.28U W=0.36U AS=0.0567P AD=0.1584P
+ PS=0.675U PD=1.6U
M$559 \$1040 \$1039 VDD VDD pfet_03v3 L=0.28U W=0.36U AS=0.1764P AD=0.1584P
+ PS=1.26U PD=1.6U
M$560 \$1005 \$1039 VDD VDD pfet_03v3 L=0.28U W=0.72U AS=0.1764P AD=0.36P
+ PS=1.26U PD=2.44U
M$561 \$1136 RA VDD VDD pfet_03v3 L=0.28U W=0.72U AS=0.3312P AD=0.3888P
+ PS=2.36U PD=2.52U
M$562 \$1005 \$1136 QAb VDD pfet_03v3 L=0.28U W=0.36U AS=0.1584P AD=0.1152P
+ PS=1.6U PD=1U
M$563 QBb \$1137 \$1005 VDD pfet_03v3 L=0.28U W=0.36U AS=0.1152P AD=0.1584P
+ PS=1U PD=1.6U
M$564 VDD RB \$1137 VDD pfet_03v3 L=0.28U W=0.72U AS=0.3708P AD=0.3168P
+ PS=2.47U PD=2.32U
M$565 \$1041 D|Q VDD VDD pfet_03v3 L=0.28U W=0.72U AS=0.3168P AD=0.2097P
+ PS=2.32U PD=1.38U
M$566 \$1042 WECLKb \$1041 VDD pfet_03v3 L=0.28U W=0.36U AS=0.2097P AD=0.1278P
+ PS=1.38U PD=1.07U
M$567 \$1316 \$1043 \$1042 VDD pfet_03v3 L=0.28U W=0.36U AS=0.1278P AD=0.0567P
+ PS=1.07U PD=0.675U
M$568 VDD WECLK \$1316 VDD pfet_03v3 L=0.28U W=0.36U AS=0.0567P AD=0.1584P
+ PS=0.675U PD=1.6U
M$569 \$1043 \$1042 VDD VDD pfet_03v3 L=0.28U W=0.36U AS=0.1764P AD=0.1584P
+ PS=1.26U PD=1.6U
M$570 \$1006 \$1042 VDD VDD pfet_03v3 L=0.28U W=0.72U AS=0.1764P AD=0.36P
+ PS=1.26U PD=2.44U
M$571 \$1138 RA VDD VDD pfet_03v3 L=0.28U W=0.72U AS=0.3312P AD=0.3888P
+ PS=2.36U PD=2.52U
M$572 \$1006 \$1138 QAb VDD pfet_03v3 L=0.28U W=0.36U AS=0.1584P AD=0.1152P
+ PS=1.6U PD=1U
M$573 QBb \$1139 \$1006 VDD pfet_03v3 L=0.28U W=0.36U AS=0.1152P AD=0.1584P
+ PS=1U PD=1.6U
M$574 VDD RB \$1139 VDD pfet_03v3 L=0.28U W=0.72U AS=0.3708P AD=0.3168P
+ PS=2.47U PD=2.32U
M$575 \$1044 D|Q VDD VDD pfet_03v3 L=0.28U W=0.72U AS=0.3168P AD=0.2097P
+ PS=2.32U PD=1.38U
M$576 \$1045 WECLKb \$1044 VDD pfet_03v3 L=0.28U W=0.36U AS=0.2097P AD=0.1278P
+ PS=1.38U PD=1.07U
M$577 \$1325 \$1046 \$1045 VDD pfet_03v3 L=0.28U W=0.36U AS=0.1278P AD=0.0567P
+ PS=1.07U PD=0.675U
M$578 VDD WECLK \$1325 VDD pfet_03v3 L=0.28U W=0.36U AS=0.0567P AD=0.1584P
+ PS=0.675U PD=1.6U
M$579 \$1046 \$1045 VDD VDD pfet_03v3 L=0.28U W=0.36U AS=0.1764P AD=0.1584P
+ PS=1.26U PD=1.6U
M$580 \$1007 \$1045 VDD VDD pfet_03v3 L=0.28U W=0.72U AS=0.1764P AD=0.36P
+ PS=1.26U PD=2.44U
M$581 \$1140 RA VDD VDD pfet_03v3 L=0.28U W=0.72U AS=0.3312P AD=0.3888P
+ PS=2.36U PD=2.52U
M$582 \$1007 \$1140 QAb VDD pfet_03v3 L=0.28U W=0.36U AS=0.1584P AD=0.1152P
+ PS=1.6U PD=1U
M$583 QBb \$1141 \$1007 VDD pfet_03v3 L=0.28U W=0.36U AS=0.1152P AD=0.1584P
+ PS=1U PD=1.6U
M$584 VDD RB \$1141 VDD pfet_03v3 L=0.28U W=0.72U AS=0.3708P AD=0.3168P
+ PS=2.47U PD=2.32U
M$585 \$1047 D|Q VDD VDD pfet_03v3 L=0.28U W=0.72U AS=0.3168P AD=0.2097P
+ PS=2.32U PD=1.38U
M$586 \$1048 WECLKb \$1047 VDD pfet_03v3 L=0.28U W=0.36U AS=0.2097P AD=0.1278P
+ PS=1.38U PD=1.07U
M$587 \$1334 \$1049 \$1048 VDD pfet_03v3 L=0.28U W=0.36U AS=0.1278P AD=0.0567P
+ PS=1.07U PD=0.675U
M$588 VDD WECLK \$1334 VDD pfet_03v3 L=0.28U W=0.36U AS=0.0567P AD=0.1584P
+ PS=0.675U PD=1.6U
M$589 \$1049 \$1048 VDD VDD pfet_03v3 L=0.28U W=0.36U AS=0.1764P AD=0.1584P
+ PS=1.26U PD=1.6U
M$590 \$1008 \$1048 VDD VDD pfet_03v3 L=0.28U W=0.72U AS=0.1764P AD=0.36P
+ PS=1.26U PD=2.44U
M$591 \$1142 RA VDD VDD pfet_03v3 L=0.28U W=0.72U AS=0.3312P AD=0.3888P
+ PS=2.36U PD=2.52U
M$592 \$1008 \$1142 QAb VDD pfet_03v3 L=0.28U W=0.36U AS=0.1584P AD=0.1152P
+ PS=1.6U PD=1U
M$593 QBb \$1143 \$1008 VDD pfet_03v3 L=0.28U W=0.36U AS=0.1152P AD=0.1584P
+ PS=1U PD=1.6U
M$594 VDD RB \$1143 VDD pfet_03v3 L=0.28U W=0.72U AS=0.3708P AD=0.3168P
+ PS=2.47U PD=2.32U
M$595 \$1050 D|Q VDD VDD pfet_03v3 L=0.28U W=0.72U AS=0.3168P AD=0.2097P
+ PS=2.32U PD=1.38U
M$596 \$1051 WECLKb \$1050 VDD pfet_03v3 L=0.28U W=0.36U AS=0.2097P AD=0.1278P
+ PS=1.38U PD=1.07U
M$597 \$1341 \$1052 \$1051 VDD pfet_03v3 L=0.28U W=0.36U AS=0.1278P AD=0.0567P
+ PS=1.07U PD=0.675U
M$598 VDD WECLK \$1341 VDD pfet_03v3 L=0.28U W=0.36U AS=0.0567P AD=0.1584P
+ PS=0.675U PD=1.6U
M$599 \$1052 \$1051 VDD VDD pfet_03v3 L=0.28U W=0.36U AS=0.1764P AD=0.1584P
+ PS=1.26U PD=1.6U
M$600 \$1009 \$1051 VDD VDD pfet_03v3 L=0.28U W=0.72U AS=0.1764P AD=0.36P
+ PS=1.26U PD=2.44U
M$601 \$1144 RA VDD VDD pfet_03v3 L=0.28U W=0.72U AS=0.3312P AD=0.3888P
+ PS=2.36U PD=2.52U
M$602 \$1009 \$1144 QAb VDD pfet_03v3 L=0.28U W=0.36U AS=0.1584P AD=0.1152P
+ PS=1.6U PD=1U
M$603 QBb \$1145 \$1009 VDD pfet_03v3 L=0.28U W=0.36U AS=0.1152P AD=0.1584P
+ PS=1U PD=1.6U
M$604 VDD RB \$1145 VDD pfet_03v3 L=0.28U W=0.72U AS=0.3708P AD=0.3168P
+ PS=2.47U PD=2.32U
M$605 \$1053 D|Q VDD VDD pfet_03v3 L=0.28U W=0.72U AS=0.3168P AD=0.2097P
+ PS=2.32U PD=1.38U
M$606 \$1054 WECLKb \$1053 VDD pfet_03v3 L=0.28U W=0.36U AS=0.2097P AD=0.1278P
+ PS=1.38U PD=1.07U
M$607 \$1329 \$1055 \$1054 VDD pfet_03v3 L=0.28U W=0.36U AS=0.1278P AD=0.0567P
+ PS=1.07U PD=0.675U
M$608 VDD WECLK \$1329 VDD pfet_03v3 L=0.28U W=0.36U AS=0.0567P AD=0.1584P
+ PS=0.675U PD=1.6U
M$609 \$1055 \$1054 VDD VDD pfet_03v3 L=0.28U W=0.36U AS=0.1764P AD=0.1584P
+ PS=1.26U PD=1.6U
M$610 \$1010 \$1054 VDD VDD pfet_03v3 L=0.28U W=0.72U AS=0.1764P AD=0.36P
+ PS=1.26U PD=2.44U
M$611 \$1146 RA VDD VDD pfet_03v3 L=0.28U W=0.72U AS=0.3312P AD=0.3888P
+ PS=2.36U PD=2.52U
M$612 \$1010 \$1146 QAb VDD pfet_03v3 L=0.28U W=0.36U AS=0.1584P AD=0.1152P
+ PS=1.6U PD=1U
M$613 QBb \$1147 \$1010 VDD pfet_03v3 L=0.28U W=0.36U AS=0.1152P AD=0.1584P
+ PS=1U PD=1.6U
M$614 VDD RB \$1147 VDD pfet_03v3 L=0.28U W=0.72U AS=0.3708P AD=0.3168P
+ PS=2.47U PD=2.32U
M$615 \$1056 D|Q VDD VDD pfet_03v3 L=0.28U W=0.72U AS=0.3168P AD=0.2097P
+ PS=2.32U PD=1.38U
M$616 \$1057 WECLKb \$1056 VDD pfet_03v3 L=0.28U W=0.36U AS=0.2097P AD=0.1278P
+ PS=1.38U PD=1.07U
M$617 \$1303 \$1058 \$1057 VDD pfet_03v3 L=0.28U W=0.36U AS=0.1278P AD=0.0567P
+ PS=1.07U PD=0.675U
M$618 VDD WECLK \$1303 VDD pfet_03v3 L=0.28U W=0.36U AS=0.0567P AD=0.1584P
+ PS=0.675U PD=1.6U
M$619 \$1058 \$1057 VDD VDD pfet_03v3 L=0.28U W=0.36U AS=0.1764P AD=0.1584P
+ PS=1.26U PD=1.6U
M$620 \$1011 \$1057 VDD VDD pfet_03v3 L=0.28U W=0.72U AS=0.1764P AD=0.36P
+ PS=1.26U PD=2.44U
M$621 \$1148 RA VDD VDD pfet_03v3 L=0.28U W=0.72U AS=0.3312P AD=0.3888P
+ PS=2.36U PD=2.52U
M$622 \$1011 \$1148 QAb VDD pfet_03v3 L=0.28U W=0.36U AS=0.1584P AD=0.1152P
+ PS=1.6U PD=1U
M$623 QBb \$1149 \$1011 VDD pfet_03v3 L=0.28U W=0.36U AS=0.1152P AD=0.1584P
+ PS=1U PD=1.6U
M$624 VDD RB \$1149 VDD pfet_03v3 L=0.28U W=0.72U AS=0.3708P AD=0.3168P
+ PS=2.47U PD=2.32U
M$625 \$1059 D|Q VDD VDD pfet_03v3 L=0.28U W=0.72U AS=0.3168P AD=0.2097P
+ PS=2.32U PD=1.38U
M$626 \$1060 WECLKb \$1059 VDD pfet_03v3 L=0.28U W=0.36U AS=0.2097P AD=0.1278P
+ PS=1.38U PD=1.07U
M$627 \$1283 \$1061 \$1060 VDD pfet_03v3 L=0.28U W=0.36U AS=0.1278P AD=0.0567P
+ PS=1.07U PD=0.675U
M$628 VDD WECLK \$1283 VDD pfet_03v3 L=0.28U W=0.36U AS=0.0567P AD=0.1584P
+ PS=0.675U PD=1.6U
M$629 \$1061 \$1060 VDD VDD pfet_03v3 L=0.28U W=0.36U AS=0.1764P AD=0.1584P
+ PS=1.26U PD=1.6U
M$630 \$1012 \$1060 VDD VDD pfet_03v3 L=0.28U W=0.72U AS=0.1764P AD=0.36P
+ PS=1.26U PD=2.44U
M$631 \$1150 RA VDD VDD pfet_03v3 L=0.28U W=0.72U AS=0.3312P AD=0.3888P
+ PS=2.36U PD=2.52U
M$632 \$1012 \$1150 QAb VDD pfet_03v3 L=0.28U W=0.36U AS=0.1584P AD=0.1152P
+ PS=1.6U PD=1U
M$633 QBb \$1151 \$1012 VDD pfet_03v3 L=0.28U W=0.36U AS=0.1152P AD=0.1584P
+ PS=1U PD=1.6U
M$634 VDD RB \$1151 VDD pfet_03v3 L=0.28U W=0.72U AS=0.3708P AD=0.3168P
+ PS=2.47U PD=2.32U
M$635 \$1062 D|Q VDD VDD pfet_03v3 L=0.28U W=0.72U AS=0.3168P AD=0.2097P
+ PS=2.32U PD=1.38U
M$636 \$1063 WECLKb \$1062 VDD pfet_03v3 L=0.28U W=0.36U AS=0.2097P AD=0.1278P
+ PS=1.38U PD=1.07U
M$637 \$1255 \$1064 \$1063 VDD pfet_03v3 L=0.28U W=0.36U AS=0.1278P AD=0.0567P
+ PS=1.07U PD=0.675U
M$638 VDD WECLK \$1255 VDD pfet_03v3 L=0.28U W=0.36U AS=0.0567P AD=0.1584P
+ PS=0.675U PD=1.6U
M$639 \$1064 \$1063 VDD VDD pfet_03v3 L=0.28U W=0.36U AS=0.1764P AD=0.1584P
+ PS=1.26U PD=1.6U
M$640 \$1013 \$1063 VDD VDD pfet_03v3 L=0.28U W=0.72U AS=0.1764P AD=0.36P
+ PS=1.26U PD=2.44U
M$641 \$1152 RA VDD VDD pfet_03v3 L=0.28U W=0.72U AS=0.3312P AD=0.3888P
+ PS=2.36U PD=2.52U
M$642 \$1013 \$1152 QAb VDD pfet_03v3 L=0.28U W=0.36U AS=0.1584P AD=0.1152P
+ PS=1.6U PD=1U
M$643 QBb \$1153 \$1013 VDD pfet_03v3 L=0.28U W=0.36U AS=0.1152P AD=0.1584P
+ PS=1U PD=1.6U
M$644 VDD RB \$1153 VDD pfet_03v3 L=0.28U W=0.72U AS=0.3708P AD=0.3168P
+ PS=2.47U PD=2.32U
M$645 \$1346 WE VDD VDD pfet_03v3 L=0.28U W=0.72U AS=0.3168P AD=0.1872P
+ PS=2.32U PD=1.24U
M$646 VDD CLK \$1346 VDD pfet_03v3 L=0.28U W=0.72U AS=0.1872P AD=0.3168P
+ PS=1.24U PD=2.32U
M$647 WECLK \$1346 VDD VDD pfet_03v3 L=0.28U W=2.54U AS=0.889P AD=0.6688P
+ PS=5.21U PD=3.65U
M$651 \$1352 WECLKb \$1351 VDD pfet_03v3 L=0.28U W=0.36U AS=0.2097P AD=0.1278P
+ PS=1.38U PD=1.07U
M$652 \$1454 \$1353 \$1352 VDD pfet_03v3 L=0.28U W=0.36U AS=0.1278P AD=0.0567P
+ PS=1.07U PD=0.675U
M$653 VDD WECLK \$1454 VDD pfet_03v3 L=0.28U W=0.36U AS=0.0567P AD=0.1584P
+ PS=0.675U PD=1.6U
M$654 \$1351 D|Q VDD VDD pfet_03v3 L=0.28U W=0.72U AS=0.3168P AD=0.2097P
+ PS=2.32U PD=1.38U
M$655 VDD \$1352 \$1353 VDD pfet_03v3 L=0.28U W=0.36U AS=0.1584P AD=0.1764P
+ PS=1.6U PD=1.26U
M$656 \$1354 \$1352 VDD VDD pfet_03v3 L=0.28U W=0.72U AS=0.1764P AD=0.36P
+ PS=1.26U PD=2.44U
M$657 \$1355 RA VDD VDD pfet_03v3 L=0.28U W=0.72U AS=0.3312P AD=0.3888P
+ PS=2.36U PD=2.52U
M$658 \$1354 \$1355 QAb VDD pfet_03v3 L=0.28U W=0.36U AS=0.1584P AD=0.1152P
+ PS=1.6U PD=1U
M$659 QBb \$1356 \$1354 VDD pfet_03v3 L=0.28U W=0.36U AS=0.1152P AD=0.1584P
+ PS=1U PD=1.6U
M$660 VDD RB \$1356 VDD pfet_03v3 L=0.28U W=0.72U AS=0.3708P AD=0.3168P
+ PS=2.47U PD=2.32U
M$661 \$1359 WECLKb \$1358 VDD pfet_03v3 L=0.28U W=0.36U AS=0.2097P AD=0.1278P
+ PS=1.38U PD=1.07U
M$662 \$1463 \$1360 \$1359 VDD pfet_03v3 L=0.28U W=0.36U AS=0.1278P AD=0.0567P
+ PS=1.07U PD=0.675U
M$663 VDD WECLK \$1463 VDD pfet_03v3 L=0.28U W=0.36U AS=0.0567P AD=0.1584P
+ PS=0.675U PD=1.6U
M$664 \$1358 D|Q VDD VDD pfet_03v3 L=0.28U W=0.72U AS=0.3168P AD=0.2097P
+ PS=2.32U PD=1.38U
M$665 VDD \$1359 \$1360 VDD pfet_03v3 L=0.28U W=0.36U AS=0.1584P AD=0.1764P
+ PS=1.6U PD=1.26U
M$666 \$1361 \$1359 VDD VDD pfet_03v3 L=0.28U W=0.72U AS=0.1764P AD=0.36P
+ PS=1.26U PD=2.44U
M$667 \$1362 RA VDD VDD pfet_03v3 L=0.28U W=0.72U AS=0.3312P AD=0.3888P
+ PS=2.36U PD=2.52U
M$668 \$1361 \$1362 QAb VDD pfet_03v3 L=0.28U W=0.36U AS=0.1584P AD=0.1152P
+ PS=1.6U PD=1U
M$669 QBb \$1363 \$1361 VDD pfet_03v3 L=0.28U W=0.36U AS=0.1152P AD=0.1584P
+ PS=1U PD=1.6U
M$670 VDD RB \$1363 VDD pfet_03v3 L=0.28U W=0.72U AS=0.3708P AD=0.3168P
+ PS=2.47U PD=2.32U
M$671 \$1365 WECLKb \$1364 VDD pfet_03v3 L=0.28U W=0.36U AS=0.2097P AD=0.1278P
+ PS=1.38U PD=1.07U
M$672 \$1473 \$1366 \$1365 VDD pfet_03v3 L=0.28U W=0.36U AS=0.1278P AD=0.0567P
+ PS=1.07U PD=0.675U
M$673 VDD WECLK \$1473 VDD pfet_03v3 L=0.28U W=0.36U AS=0.0567P AD=0.1584P
+ PS=0.675U PD=1.6U
M$674 \$1364 D|Q VDD VDD pfet_03v3 L=0.28U W=0.72U AS=0.3168P AD=0.2097P
+ PS=2.32U PD=1.38U
M$675 VDD \$1365 \$1366 VDD pfet_03v3 L=0.28U W=0.36U AS=0.1584P AD=0.1764P
+ PS=1.6U PD=1.26U
M$676 \$1367 \$1365 VDD VDD pfet_03v3 L=0.28U W=0.72U AS=0.1764P AD=0.36P
+ PS=1.26U PD=2.44U
M$677 \$1368 RA VDD VDD pfet_03v3 L=0.28U W=0.72U AS=0.3312P AD=0.3888P
+ PS=2.36U PD=2.52U
M$678 \$1367 \$1368 QAb VDD pfet_03v3 L=0.28U W=0.36U AS=0.1584P AD=0.1152P
+ PS=1.6U PD=1U
M$679 QBb \$1369 \$1367 VDD pfet_03v3 L=0.28U W=0.36U AS=0.1152P AD=0.1584P
+ PS=1U PD=1.6U
M$680 VDD RB \$1369 VDD pfet_03v3 L=0.28U W=0.72U AS=0.3708P AD=0.3168P
+ PS=2.47U PD=2.32U
M$681 \$1371 WECLKb \$1370 VDD pfet_03v3 L=0.28U W=0.36U AS=0.2097P AD=0.1278P
+ PS=1.38U PD=1.07U
M$682 \$1484 \$1372 \$1371 VDD pfet_03v3 L=0.28U W=0.36U AS=0.1278P AD=0.0567P
+ PS=1.07U PD=0.675U
M$683 VDD WECLK \$1484 VDD pfet_03v3 L=0.28U W=0.36U AS=0.0567P AD=0.1584P
+ PS=0.675U PD=1.6U
M$684 \$1370 D|Q VDD VDD pfet_03v3 L=0.28U W=0.72U AS=0.3168P AD=0.2097P
+ PS=2.32U PD=1.38U
M$685 VDD \$1371 \$1372 VDD pfet_03v3 L=0.28U W=0.36U AS=0.1584P AD=0.1764P
+ PS=1.6U PD=1.26U
M$686 \$1373 \$1371 VDD VDD pfet_03v3 L=0.28U W=0.72U AS=0.1764P AD=0.36P
+ PS=1.26U PD=2.44U
M$687 \$1374 RA VDD VDD pfet_03v3 L=0.28U W=0.72U AS=0.3312P AD=0.3888P
+ PS=2.36U PD=2.52U
M$688 \$1373 \$1374 QAb VDD pfet_03v3 L=0.28U W=0.36U AS=0.1584P AD=0.1152P
+ PS=1.6U PD=1U
M$689 QBb \$1375 \$1373 VDD pfet_03v3 L=0.28U W=0.36U AS=0.1152P AD=0.1584P
+ PS=1U PD=1.6U
M$690 VDD RB \$1375 VDD pfet_03v3 L=0.28U W=0.72U AS=0.3708P AD=0.3168P
+ PS=2.47U PD=2.32U
M$691 \$1377 WECLKb \$1376 VDD pfet_03v3 L=0.28U W=0.36U AS=0.2097P AD=0.1278P
+ PS=1.38U PD=1.07U
M$692 \$1496 \$1378 \$1377 VDD pfet_03v3 L=0.28U W=0.36U AS=0.1278P AD=0.0567P
+ PS=1.07U PD=0.675U
M$693 VDD WECLK \$1496 VDD pfet_03v3 L=0.28U W=0.36U AS=0.0567P AD=0.1584P
+ PS=0.675U PD=1.6U
M$694 \$1376 D|Q VDD VDD pfet_03v3 L=0.28U W=0.72U AS=0.3168P AD=0.2097P
+ PS=2.32U PD=1.38U
M$695 VDD \$1377 \$1378 VDD pfet_03v3 L=0.28U W=0.36U AS=0.1584P AD=0.1764P
+ PS=1.6U PD=1.26U
M$696 \$1379 \$1377 VDD VDD pfet_03v3 L=0.28U W=0.72U AS=0.1764P AD=0.36P
+ PS=1.26U PD=2.44U
M$697 \$1380 RA VDD VDD pfet_03v3 L=0.28U W=0.72U AS=0.3312P AD=0.3888P
+ PS=2.36U PD=2.52U
M$698 \$1379 \$1380 QAb VDD pfet_03v3 L=0.28U W=0.36U AS=0.1584P AD=0.1152P
+ PS=1.6U PD=1U
M$699 QBb \$1381 \$1379 VDD pfet_03v3 L=0.28U W=0.36U AS=0.1152P AD=0.1584P
+ PS=1U PD=1.6U
M$700 VDD RB \$1381 VDD pfet_03v3 L=0.28U W=0.72U AS=0.3708P AD=0.3168P
+ PS=2.47U PD=2.32U
M$701 \$1383 WECLKb \$1382 VDD pfet_03v3 L=0.28U W=0.36U AS=0.2097P AD=0.1278P
+ PS=1.38U PD=1.07U
M$702 \$1505 \$1384 \$1383 VDD pfet_03v3 L=0.28U W=0.36U AS=0.1278P AD=0.0567P
+ PS=1.07U PD=0.675U
M$703 VDD WECLK \$1505 VDD pfet_03v3 L=0.28U W=0.36U AS=0.0567P AD=0.1584P
+ PS=0.675U PD=1.6U
M$704 \$1382 D|Q VDD VDD pfet_03v3 L=0.28U W=0.72U AS=0.3168P AD=0.2097P
+ PS=2.32U PD=1.38U
M$705 VDD \$1383 \$1384 VDD pfet_03v3 L=0.28U W=0.36U AS=0.1584P AD=0.1764P
+ PS=1.6U PD=1.26U
M$706 \$1385 \$1383 VDD VDD pfet_03v3 L=0.28U W=0.72U AS=0.1764P AD=0.36P
+ PS=1.26U PD=2.44U
M$707 \$1386 RA VDD VDD pfet_03v3 L=0.28U W=0.72U AS=0.3312P AD=0.3888P
+ PS=2.36U PD=2.52U
M$708 \$1385 \$1386 QAb VDD pfet_03v3 L=0.28U W=0.36U AS=0.1584P AD=0.1152P
+ PS=1.6U PD=1U
M$709 QBb \$1387 \$1385 VDD pfet_03v3 L=0.28U W=0.36U AS=0.1152P AD=0.1584P
+ PS=1U PD=1.6U
M$710 VDD RB \$1387 VDD pfet_03v3 L=0.28U W=0.72U AS=0.3708P AD=0.3168P
+ PS=2.47U PD=2.32U
M$711 \$1389 WECLKb \$1388 VDD pfet_03v3 L=0.28U W=0.36U AS=0.2097P AD=0.1278P
+ PS=1.38U PD=1.07U
M$712 \$1514 \$1390 \$1389 VDD pfet_03v3 L=0.28U W=0.36U AS=0.1278P AD=0.0567P
+ PS=1.07U PD=0.675U
M$713 VDD WECLK \$1514 VDD pfet_03v3 L=0.28U W=0.36U AS=0.0567P AD=0.1584P
+ PS=0.675U PD=1.6U
M$714 \$1388 D|Q VDD VDD pfet_03v3 L=0.28U W=0.72U AS=0.3168P AD=0.2097P
+ PS=2.32U PD=1.38U
M$715 VDD \$1389 \$1390 VDD pfet_03v3 L=0.28U W=0.36U AS=0.1584P AD=0.1764P
+ PS=1.6U PD=1.26U
M$716 \$1391 \$1389 VDD VDD pfet_03v3 L=0.28U W=0.72U AS=0.1764P AD=0.36P
+ PS=1.26U PD=2.44U
M$717 \$1392 RA VDD VDD pfet_03v3 L=0.28U W=0.72U AS=0.3312P AD=0.3888P
+ PS=2.36U PD=2.52U
M$718 \$1391 \$1392 QAb VDD pfet_03v3 L=0.28U W=0.36U AS=0.1584P AD=0.1152P
+ PS=1.6U PD=1U
M$719 QBb \$1393 \$1391 VDD pfet_03v3 L=0.28U W=0.36U AS=0.1152P AD=0.1584P
+ PS=1U PD=1.6U
M$720 VDD RB \$1393 VDD pfet_03v3 L=0.28U W=0.72U AS=0.3708P AD=0.3168P
+ PS=2.47U PD=2.32U
M$721 \$1395 WECLKb \$1394 VDD pfet_03v3 L=0.28U W=0.36U AS=0.2097P AD=0.1278P
+ PS=1.38U PD=1.07U
M$722 \$1526 \$1396 \$1395 VDD pfet_03v3 L=0.28U W=0.36U AS=0.1278P AD=0.0567P
+ PS=1.07U PD=0.675U
M$723 VDD WECLK \$1526 VDD pfet_03v3 L=0.28U W=0.36U AS=0.0567P AD=0.1584P
+ PS=0.675U PD=1.6U
M$724 \$1394 D|Q VDD VDD pfet_03v3 L=0.28U W=0.72U AS=0.3168P AD=0.2097P
+ PS=2.32U PD=1.38U
M$725 VDD \$1395 \$1396 VDD pfet_03v3 L=0.28U W=0.36U AS=0.1584P AD=0.1764P
+ PS=1.6U PD=1.26U
M$726 \$1397 \$1395 VDD VDD pfet_03v3 L=0.28U W=0.72U AS=0.1764P AD=0.36P
+ PS=1.26U PD=2.44U
M$727 \$1398 RA VDD VDD pfet_03v3 L=0.28U W=0.72U AS=0.3312P AD=0.3888P
+ PS=2.36U PD=2.52U
M$728 \$1397 \$1398 QAb VDD pfet_03v3 L=0.28U W=0.36U AS=0.1584P AD=0.1152P
+ PS=1.6U PD=1U
M$729 QBb \$1399 \$1397 VDD pfet_03v3 L=0.28U W=0.36U AS=0.1152P AD=0.1584P
+ PS=1U PD=1.6U
M$730 VDD RB \$1399 VDD pfet_03v3 L=0.28U W=0.72U AS=0.3708P AD=0.3168P
+ PS=2.47U PD=2.32U
M$731 \$1401 WECLKb \$1400 VDD pfet_03v3 L=0.28U W=0.36U AS=0.2097P AD=0.1278P
+ PS=1.38U PD=1.07U
M$732 \$1537 \$1402 \$1401 VDD pfet_03v3 L=0.28U W=0.36U AS=0.1278P AD=0.0567P
+ PS=1.07U PD=0.675U
M$733 VDD WECLK \$1537 VDD pfet_03v3 L=0.28U W=0.36U AS=0.0567P AD=0.1584P
+ PS=0.675U PD=1.6U
M$734 \$1400 D|Q VDD VDD pfet_03v3 L=0.28U W=0.72U AS=0.3168P AD=0.2097P
+ PS=2.32U PD=1.38U
M$735 VDD \$1401 \$1402 VDD pfet_03v3 L=0.28U W=0.36U AS=0.1584P AD=0.1764P
+ PS=1.6U PD=1.26U
M$736 \$1403 \$1401 VDD VDD pfet_03v3 L=0.28U W=0.72U AS=0.1764P AD=0.36P
+ PS=1.26U PD=2.44U
M$737 \$1404 RA VDD VDD pfet_03v3 L=0.28U W=0.72U AS=0.3312P AD=0.3888P
+ PS=2.36U PD=2.52U
M$738 \$1403 \$1404 QAb VDD pfet_03v3 L=0.28U W=0.36U AS=0.1584P AD=0.1152P
+ PS=1.6U PD=1U
M$739 QBb \$1405 \$1403 VDD pfet_03v3 L=0.28U W=0.36U AS=0.1152P AD=0.1584P
+ PS=1U PD=1.6U
M$740 VDD RB \$1405 VDD pfet_03v3 L=0.28U W=0.72U AS=0.3708P AD=0.3168P
+ PS=2.47U PD=2.32U
M$741 \$1407 WECLKb \$1406 VDD pfet_03v3 L=0.28U W=0.36U AS=0.2097P AD=0.1278P
+ PS=1.38U PD=1.07U
M$742 \$1547 \$1408 \$1407 VDD pfet_03v3 L=0.28U W=0.36U AS=0.1278P AD=0.0567P
+ PS=1.07U PD=0.675U
M$743 VDD WECLK \$1547 VDD pfet_03v3 L=0.28U W=0.36U AS=0.0567P AD=0.1584P
+ PS=0.675U PD=1.6U
M$744 \$1406 D|Q VDD VDD pfet_03v3 L=0.28U W=0.72U AS=0.3168P AD=0.2097P
+ PS=2.32U PD=1.38U
M$745 VDD \$1407 \$1408 VDD pfet_03v3 L=0.28U W=0.36U AS=0.1584P AD=0.1764P
+ PS=1.6U PD=1.26U
M$746 \$1409 \$1407 VDD VDD pfet_03v3 L=0.28U W=0.72U AS=0.1764P AD=0.36P
+ PS=1.26U PD=2.44U
M$747 \$1410 RA VDD VDD pfet_03v3 L=0.28U W=0.72U AS=0.3312P AD=0.3888P
+ PS=2.36U PD=2.52U
M$748 \$1409 \$1410 QAb VDD pfet_03v3 L=0.28U W=0.36U AS=0.1584P AD=0.1152P
+ PS=1.6U PD=1U
M$749 QBb \$1411 \$1409 VDD pfet_03v3 L=0.28U W=0.36U AS=0.1152P AD=0.1584P
+ PS=1U PD=1.6U
M$750 VDD RB \$1411 VDD pfet_03v3 L=0.28U W=0.72U AS=0.3708P AD=0.3168P
+ PS=2.47U PD=2.32U
M$751 \$1413 WECLKb \$1412 VDD pfet_03v3 L=0.28U W=0.36U AS=0.2097P AD=0.1278P
+ PS=1.38U PD=1.07U
M$752 \$1556 \$1414 \$1413 VDD pfet_03v3 L=0.28U W=0.36U AS=0.1278P AD=0.0567P
+ PS=1.07U PD=0.675U
M$753 VDD WECLK \$1556 VDD pfet_03v3 L=0.28U W=0.36U AS=0.0567P AD=0.1584P
+ PS=0.675U PD=1.6U
M$754 \$1412 D|Q VDD VDD pfet_03v3 L=0.28U W=0.72U AS=0.3168P AD=0.2097P
+ PS=2.32U PD=1.38U
M$755 VDD \$1413 \$1414 VDD pfet_03v3 L=0.28U W=0.36U AS=0.1584P AD=0.1764P
+ PS=1.6U PD=1.26U
M$756 \$1415 \$1413 VDD VDD pfet_03v3 L=0.28U W=0.72U AS=0.1764P AD=0.36P
+ PS=1.26U PD=2.44U
M$757 \$1416 RA VDD VDD pfet_03v3 L=0.28U W=0.72U AS=0.3312P AD=0.3888P
+ PS=2.36U PD=2.52U
M$758 \$1415 \$1416 QAb VDD pfet_03v3 L=0.28U W=0.36U AS=0.1584P AD=0.1152P
+ PS=1.6U PD=1U
M$759 QBb \$1417 \$1415 VDD pfet_03v3 L=0.28U W=0.36U AS=0.1152P AD=0.1584P
+ PS=1U PD=1.6U
M$760 VDD RB \$1417 VDD pfet_03v3 L=0.28U W=0.72U AS=0.3708P AD=0.3168P
+ PS=2.47U PD=2.32U
M$761 \$1419 WECLKb \$1418 VDD pfet_03v3 L=0.28U W=0.36U AS=0.2097P AD=0.1278P
+ PS=1.38U PD=1.07U
M$762 \$1568 \$1420 \$1419 VDD pfet_03v3 L=0.28U W=0.36U AS=0.1278P AD=0.0567P
+ PS=1.07U PD=0.675U
M$763 VDD WECLK \$1568 VDD pfet_03v3 L=0.28U W=0.36U AS=0.0567P AD=0.1584P
+ PS=0.675U PD=1.6U
M$764 \$1418 D|Q VDD VDD pfet_03v3 L=0.28U W=0.72U AS=0.3168P AD=0.2097P
+ PS=2.32U PD=1.38U
M$765 VDD \$1419 \$1420 VDD pfet_03v3 L=0.28U W=0.36U AS=0.1584P AD=0.1764P
+ PS=1.6U PD=1.26U
M$766 \$1421 \$1419 VDD VDD pfet_03v3 L=0.28U W=0.72U AS=0.1764P AD=0.36P
+ PS=1.26U PD=2.44U
M$767 \$1422 RA VDD VDD pfet_03v3 L=0.28U W=0.72U AS=0.3312P AD=0.3888P
+ PS=2.36U PD=2.52U
M$768 \$1421 \$1422 QAb VDD pfet_03v3 L=0.28U W=0.36U AS=0.1584P AD=0.1152P
+ PS=1.6U PD=1U
M$769 QBb \$1423 \$1421 VDD pfet_03v3 L=0.28U W=0.36U AS=0.1152P AD=0.1584P
+ PS=1U PD=1.6U
M$770 VDD RB \$1423 VDD pfet_03v3 L=0.28U W=0.72U AS=0.3708P AD=0.3168P
+ PS=2.47U PD=2.32U
M$771 \$1425 WECLKb \$1424 VDD pfet_03v3 L=0.28U W=0.36U AS=0.2097P AD=0.1278P
+ PS=1.38U PD=1.07U
M$772 \$1576 \$1426 \$1425 VDD pfet_03v3 L=0.28U W=0.36U AS=0.1278P AD=0.0567P
+ PS=1.07U PD=0.675U
M$773 VDD WECLK \$1576 VDD pfet_03v3 L=0.28U W=0.36U AS=0.0567P AD=0.1584P
+ PS=0.675U PD=1.6U
M$774 \$1424 D|Q VDD VDD pfet_03v3 L=0.28U W=0.72U AS=0.3168P AD=0.2097P
+ PS=2.32U PD=1.38U
M$775 VDD \$1425 \$1426 VDD pfet_03v3 L=0.28U W=0.36U AS=0.1584P AD=0.1764P
+ PS=1.6U PD=1.26U
M$776 \$1427 \$1425 VDD VDD pfet_03v3 L=0.28U W=0.72U AS=0.1764P AD=0.36P
+ PS=1.26U PD=2.44U
M$777 \$1428 RA VDD VDD pfet_03v3 L=0.28U W=0.72U AS=0.3312P AD=0.3888P
+ PS=2.36U PD=2.52U
M$778 \$1427 \$1428 QAb VDD pfet_03v3 L=0.28U W=0.36U AS=0.1584P AD=0.1152P
+ PS=1.6U PD=1U
M$779 QBb \$1429 \$1427 VDD pfet_03v3 L=0.28U W=0.36U AS=0.1152P AD=0.1584P
+ PS=1U PD=1.6U
M$780 VDD RB \$1429 VDD pfet_03v3 L=0.28U W=0.72U AS=0.3708P AD=0.3168P
+ PS=2.47U PD=2.32U
M$781 \$1431 WECLKb \$1430 VDD pfet_03v3 L=0.28U W=0.36U AS=0.2097P AD=0.1278P
+ PS=1.38U PD=1.07U
M$782 \$1539 \$1432 \$1431 VDD pfet_03v3 L=0.28U W=0.36U AS=0.1278P AD=0.0567P
+ PS=1.07U PD=0.675U
M$783 VDD WECLK \$1539 VDD pfet_03v3 L=0.28U W=0.36U AS=0.0567P AD=0.1584P
+ PS=0.675U PD=1.6U
M$784 \$1430 D|Q VDD VDD pfet_03v3 L=0.28U W=0.72U AS=0.3168P AD=0.2097P
+ PS=2.32U PD=1.38U
M$785 VDD \$1431 \$1432 VDD pfet_03v3 L=0.28U W=0.36U AS=0.1584P AD=0.1764P
+ PS=1.6U PD=1.26U
M$786 \$1433 \$1431 VDD VDD pfet_03v3 L=0.28U W=0.72U AS=0.1764P AD=0.36P
+ PS=1.26U PD=2.44U
M$787 \$1434 RA VDD VDD pfet_03v3 L=0.28U W=0.72U AS=0.3312P AD=0.3888P
+ PS=2.36U PD=2.52U
M$788 \$1433 \$1434 QAb VDD pfet_03v3 L=0.28U W=0.36U AS=0.1584P AD=0.1152P
+ PS=1.6U PD=1U
M$789 QBb \$1435 \$1433 VDD pfet_03v3 L=0.28U W=0.36U AS=0.1152P AD=0.1584P
+ PS=1U PD=1.6U
M$790 VDD RB \$1435 VDD pfet_03v3 L=0.28U W=0.72U AS=0.3708P AD=0.3168P
+ PS=2.47U PD=2.32U
M$791 \$1437 WECLKb \$1436 VDD pfet_03v3 L=0.28U W=0.36U AS=0.2097P AD=0.1278P
+ PS=1.38U PD=1.07U
M$792 \$1510 \$1438 \$1437 VDD pfet_03v3 L=0.28U W=0.36U AS=0.1278P AD=0.0567P
+ PS=1.07U PD=0.675U
M$793 VDD WECLK \$1510 VDD pfet_03v3 L=0.28U W=0.36U AS=0.0567P AD=0.1584P
+ PS=0.675U PD=1.6U
M$794 \$1436 D|Q VDD VDD pfet_03v3 L=0.28U W=0.72U AS=0.3168P AD=0.2097P
+ PS=2.32U PD=1.38U
M$795 VDD \$1437 \$1438 VDD pfet_03v3 L=0.28U W=0.36U AS=0.1584P AD=0.1764P
+ PS=1.6U PD=1.26U
M$796 \$1439 \$1437 VDD VDD pfet_03v3 L=0.28U W=0.72U AS=0.1764P AD=0.36P
+ PS=1.26U PD=2.44U
M$797 \$1440 RA VDD VDD pfet_03v3 L=0.28U W=0.72U AS=0.3312P AD=0.3888P
+ PS=2.36U PD=2.52U
M$798 \$1439 \$1440 QAb VDD pfet_03v3 L=0.28U W=0.36U AS=0.1584P AD=0.1152P
+ PS=1.6U PD=1U
M$799 QBb \$1441 \$1439 VDD pfet_03v3 L=0.28U W=0.36U AS=0.1152P AD=0.1584P
+ PS=1U PD=1.6U
M$800 VDD RB \$1441 VDD pfet_03v3 L=0.28U W=0.72U AS=0.3708P AD=0.3168P
+ PS=2.47U PD=2.32U
M$801 \$1443 WECLKb \$1442 VDD pfet_03v3 L=0.28U W=0.36U AS=0.2097P AD=0.1278P
+ PS=1.38U PD=1.07U
M$802 \$1475 \$1444 \$1443 VDD pfet_03v3 L=0.28U W=0.36U AS=0.1278P AD=0.0567P
+ PS=1.07U PD=0.675U
M$803 VDD WECLK \$1475 VDD pfet_03v3 L=0.28U W=0.36U AS=0.0567P AD=0.1584P
+ PS=0.675U PD=1.6U
M$804 \$1442 D|Q VDD VDD pfet_03v3 L=0.28U W=0.72U AS=0.3168P AD=0.2097P
+ PS=2.32U PD=1.38U
M$805 VDD \$1443 \$1444 VDD pfet_03v3 L=0.28U W=0.36U AS=0.1584P AD=0.1764P
+ PS=1.6U PD=1.26U
M$806 \$1445 \$1443 VDD VDD pfet_03v3 L=0.28U W=0.72U AS=0.1764P AD=0.36P
+ PS=1.26U PD=2.44U
M$807 \$1446 RA VDD VDD pfet_03v3 L=0.28U W=0.72U AS=0.3312P AD=0.3888P
+ PS=2.36U PD=2.52U
M$808 \$1445 \$1446 QAb VDD pfet_03v3 L=0.28U W=0.36U AS=0.1584P AD=0.1152P
+ PS=1.6U PD=1U
M$809 QBb \$1447 \$1445 VDD pfet_03v3 L=0.28U W=0.36U AS=0.1152P AD=0.1584P
+ PS=1U PD=1.6U
M$810 VDD RB \$1447 VDD pfet_03v3 L=0.28U W=0.72U AS=0.3708P AD=0.3168P
+ PS=2.47U PD=2.32U
M$811 \$1697 WE VDD VDD pfet_03v3 L=0.28U W=0.72U AS=0.3168P AD=0.1872P
+ PS=2.32U PD=1.24U
M$812 VDD CLK \$1697 VDD pfet_03v3 L=0.28U W=0.72U AS=0.1872P AD=0.3168P
+ PS=1.24U PD=2.32U
M$813 WECLK \$1697 VDD VDD pfet_03v3 L=0.28U W=2.54U AS=0.8974P AD=0.6604P
+ PS=5.28U PD=3.58U
M$817 \$1700 D|Q VDD VDD pfet_03v3 L=0.28U W=0.72U AS=0.3168P AD=0.2097P
+ PS=2.32U PD=1.38U
M$818 \$1701 WECLKb \$1700 VDD pfet_03v3 L=0.28U W=0.36U AS=0.2097P AD=0.1278P
+ PS=1.38U PD=1.07U
M$819 \$1922 \$1702 \$1701 VDD pfet_03v3 L=0.28U W=0.36U AS=0.1278P AD=0.0567P
+ PS=1.07U PD=0.675U
M$820 VDD WECLK \$1922 VDD pfet_03v3 L=0.28U W=0.36U AS=0.0567P AD=0.1584P
+ PS=0.675U PD=1.6U
M$821 \$1702 \$1701 VDD VDD pfet_03v3 L=0.28U W=0.36U AS=0.1764P AD=0.1584P
+ PS=1.26U PD=1.6U
M$822 \$1681 \$1701 VDD VDD pfet_03v3 L=0.28U W=0.72U AS=0.1764P AD=0.36P
+ PS=1.26U PD=2.44U
M$823 \$1799 RA VDD VDD pfet_03v3 L=0.28U W=0.72U AS=0.3312P AD=0.3888P
+ PS=2.36U PD=2.52U
M$824 \$1681 \$1799 QAb VDD pfet_03v3 L=0.28U W=0.36U AS=0.1584P AD=0.1152P
+ PS=1.6U PD=1U
M$825 QBb \$1800 \$1681 VDD pfet_03v3 L=0.28U W=0.36U AS=0.1152P AD=0.1584P
+ PS=1U PD=1.6U
M$826 VDD RB \$1800 VDD pfet_03v3 L=0.28U W=0.72U AS=0.3708P AD=0.3168P
+ PS=2.47U PD=2.32U
M$827 \$1703 D|Q VDD VDD pfet_03v3 L=0.28U W=0.72U AS=0.3168P AD=0.2097P
+ PS=2.32U PD=1.38U
M$828 \$1704 WECLKb \$1703 VDD pfet_03v3 L=0.28U W=0.36U AS=0.2097P AD=0.1278P
+ PS=1.38U PD=1.07U
M$829 \$1932 \$1705 \$1704 VDD pfet_03v3 L=0.28U W=0.36U AS=0.1278P AD=0.0567P
+ PS=1.07U PD=0.675U
M$830 VDD WECLK \$1932 VDD pfet_03v3 L=0.28U W=0.36U AS=0.0567P AD=0.1584P
+ PS=0.675U PD=1.6U
M$831 \$1705 \$1704 VDD VDD pfet_03v3 L=0.28U W=0.36U AS=0.1764P AD=0.1584P
+ PS=1.26U PD=1.6U
M$832 \$1682 \$1704 VDD VDD pfet_03v3 L=0.28U W=0.72U AS=0.1764P AD=0.36P
+ PS=1.26U PD=2.44U
M$833 \$1801 RA VDD VDD pfet_03v3 L=0.28U W=0.72U AS=0.3312P AD=0.3888P
+ PS=2.36U PD=2.52U
M$834 \$1682 \$1801 QAb VDD pfet_03v3 L=0.28U W=0.36U AS=0.1584P AD=0.1152P
+ PS=1.6U PD=1U
M$835 QBb \$1802 \$1682 VDD pfet_03v3 L=0.28U W=0.36U AS=0.1152P AD=0.1584P
+ PS=1U PD=1.6U
M$836 VDD RB \$1802 VDD pfet_03v3 L=0.28U W=0.72U AS=0.3708P AD=0.3168P
+ PS=2.47U PD=2.32U
M$837 \$1706 D|Q VDD VDD pfet_03v3 L=0.28U W=0.72U AS=0.3168P AD=0.2097P
+ PS=2.32U PD=1.38U
M$838 \$1707 WECLKb \$1706 VDD pfet_03v3 L=0.28U W=0.36U AS=0.2097P AD=0.1278P
+ PS=1.38U PD=1.07U
M$839 \$1939 \$1708 \$1707 VDD pfet_03v3 L=0.28U W=0.36U AS=0.1278P AD=0.0567P
+ PS=1.07U PD=0.675U
M$840 VDD WECLK \$1939 VDD pfet_03v3 L=0.28U W=0.36U AS=0.0567P AD=0.1584P
+ PS=0.675U PD=1.6U
M$841 \$1708 \$1707 VDD VDD pfet_03v3 L=0.28U W=0.36U AS=0.1764P AD=0.1584P
+ PS=1.26U PD=1.6U
M$842 \$1683 \$1707 VDD VDD pfet_03v3 L=0.28U W=0.72U AS=0.1764P AD=0.36P
+ PS=1.26U PD=2.44U
M$843 \$1803 RA VDD VDD pfet_03v3 L=0.28U W=0.72U AS=0.3312P AD=0.3888P
+ PS=2.36U PD=2.52U
M$844 \$1683 \$1803 QAb VDD pfet_03v3 L=0.28U W=0.36U AS=0.1584P AD=0.1152P
+ PS=1.6U PD=1U
M$845 QBb \$1804 \$1683 VDD pfet_03v3 L=0.28U W=0.36U AS=0.1152P AD=0.1584P
+ PS=1U PD=1.6U
M$846 VDD RB \$1804 VDD pfet_03v3 L=0.28U W=0.72U AS=0.3708P AD=0.3168P
+ PS=2.47U PD=2.32U
M$847 \$1709 D|Q VDD VDD pfet_03v3 L=0.28U W=0.72U AS=0.3168P AD=0.2097P
+ PS=2.32U PD=1.38U
M$848 \$1710 WECLKb \$1709 VDD pfet_03v3 L=0.28U W=0.36U AS=0.2097P AD=0.1278P
+ PS=1.38U PD=1.07U
M$849 \$1948 \$1711 \$1710 VDD pfet_03v3 L=0.28U W=0.36U AS=0.1278P AD=0.0567P
+ PS=1.07U PD=0.675U
M$850 VDD WECLK \$1948 VDD pfet_03v3 L=0.28U W=0.36U AS=0.0567P AD=0.1584P
+ PS=0.675U PD=1.6U
M$851 \$1711 \$1710 VDD VDD pfet_03v3 L=0.28U W=0.36U AS=0.1764P AD=0.1584P
+ PS=1.26U PD=1.6U
M$852 \$1684 \$1710 VDD VDD pfet_03v3 L=0.28U W=0.72U AS=0.1764P AD=0.36P
+ PS=1.26U PD=2.44U
M$853 \$1805 RA VDD VDD pfet_03v3 L=0.28U W=0.72U AS=0.3312P AD=0.3888P
+ PS=2.36U PD=2.52U
M$854 \$1684 \$1805 QAb VDD pfet_03v3 L=0.28U W=0.36U AS=0.1584P AD=0.1152P
+ PS=1.6U PD=1U
M$855 QBb \$1806 \$1684 VDD pfet_03v3 L=0.28U W=0.36U AS=0.1152P AD=0.1584P
+ PS=1U PD=1.6U
M$856 VDD RB \$1806 VDD pfet_03v3 L=0.28U W=0.72U AS=0.3708P AD=0.3168P
+ PS=2.47U PD=2.32U
M$857 \$1712 D|Q VDD VDD pfet_03v3 L=0.28U W=0.72U AS=0.3168P AD=0.2097P
+ PS=2.32U PD=1.38U
M$858 \$1713 WECLKb \$1712 VDD pfet_03v3 L=0.28U W=0.36U AS=0.2097P AD=0.1278P
+ PS=1.38U PD=1.07U
M$859 \$1959 \$1714 \$1713 VDD pfet_03v3 L=0.28U W=0.36U AS=0.1278P AD=0.0567P
+ PS=1.07U PD=0.675U
M$860 VDD WECLK \$1959 VDD pfet_03v3 L=0.28U W=0.36U AS=0.0567P AD=0.1584P
+ PS=0.675U PD=1.6U
M$861 \$1714 \$1713 VDD VDD pfet_03v3 L=0.28U W=0.36U AS=0.1764P AD=0.1584P
+ PS=1.26U PD=1.6U
M$862 \$1685 \$1713 VDD VDD pfet_03v3 L=0.28U W=0.72U AS=0.1764P AD=0.36P
+ PS=1.26U PD=2.44U
M$863 \$1807 RA VDD VDD pfet_03v3 L=0.28U W=0.72U AS=0.3312P AD=0.3888P
+ PS=2.36U PD=2.52U
M$864 \$1685 \$1807 QAb VDD pfet_03v3 L=0.28U W=0.36U AS=0.1584P AD=0.1152P
+ PS=1.6U PD=1U
M$865 QBb \$1808 \$1685 VDD pfet_03v3 L=0.28U W=0.36U AS=0.1152P AD=0.1584P
+ PS=1U PD=1.6U
M$866 VDD RB \$1808 VDD pfet_03v3 L=0.28U W=0.72U AS=0.3708P AD=0.3168P
+ PS=2.47U PD=2.32U
M$867 \$1715 D|Q VDD VDD pfet_03v3 L=0.28U W=0.72U AS=0.3168P AD=0.2097P
+ PS=2.32U PD=1.38U
M$868 \$1716 WECLKb \$1715 VDD pfet_03v3 L=0.28U W=0.36U AS=0.2097P AD=0.1278P
+ PS=1.38U PD=1.07U
M$869 \$1967 \$1717 \$1716 VDD pfet_03v3 L=0.28U W=0.36U AS=0.1278P AD=0.0567P
+ PS=1.07U PD=0.675U
M$870 VDD WECLK \$1967 VDD pfet_03v3 L=0.28U W=0.36U AS=0.0567P AD=0.1584P
+ PS=0.675U PD=1.6U
M$871 \$1717 \$1716 VDD VDD pfet_03v3 L=0.28U W=0.36U AS=0.1764P AD=0.1584P
+ PS=1.26U PD=1.6U
M$872 \$1686 \$1716 VDD VDD pfet_03v3 L=0.28U W=0.72U AS=0.1764P AD=0.36P
+ PS=1.26U PD=2.44U
M$873 \$1809 RA VDD VDD pfet_03v3 L=0.28U W=0.72U AS=0.3312P AD=0.3888P
+ PS=2.36U PD=2.52U
M$874 \$1686 \$1809 QAb VDD pfet_03v3 L=0.28U W=0.36U AS=0.1584P AD=0.1152P
+ PS=1.6U PD=1U
M$875 QBb \$1810 \$1686 VDD pfet_03v3 L=0.28U W=0.36U AS=0.1152P AD=0.1584P
+ PS=1U PD=1.6U
M$876 VDD RB \$1810 VDD pfet_03v3 L=0.28U W=0.72U AS=0.3708P AD=0.3168P
+ PS=2.47U PD=2.32U
M$877 \$1718 D|Q VDD VDD pfet_03v3 L=0.28U W=0.72U AS=0.3168P AD=0.2097P
+ PS=2.32U PD=1.38U
M$878 \$1719 WECLKb \$1718 VDD pfet_03v3 L=0.28U W=0.36U AS=0.2097P AD=0.1278P
+ PS=1.38U PD=1.07U
M$879 \$1975 \$1720 \$1719 VDD pfet_03v3 L=0.28U W=0.36U AS=0.1278P AD=0.0567P
+ PS=1.07U PD=0.675U
M$880 VDD WECLK \$1975 VDD pfet_03v3 L=0.28U W=0.36U AS=0.0567P AD=0.1584P
+ PS=0.675U PD=1.6U
M$881 \$1720 \$1719 VDD VDD pfet_03v3 L=0.28U W=0.36U AS=0.1764P AD=0.1584P
+ PS=1.26U PD=1.6U
M$882 \$1687 \$1719 VDD VDD pfet_03v3 L=0.28U W=0.72U AS=0.1764P AD=0.36P
+ PS=1.26U PD=2.44U
M$883 \$1811 RA VDD VDD pfet_03v3 L=0.28U W=0.72U AS=0.3312P AD=0.3888P
+ PS=2.36U PD=2.52U
M$884 \$1687 \$1811 QAb VDD pfet_03v3 L=0.28U W=0.36U AS=0.1584P AD=0.1152P
+ PS=1.6U PD=1U
M$885 QBb \$1812 \$1687 VDD pfet_03v3 L=0.28U W=0.36U AS=0.1152P AD=0.1584P
+ PS=1U PD=1.6U
M$886 VDD RB \$1812 VDD pfet_03v3 L=0.28U W=0.72U AS=0.3708P AD=0.3168P
+ PS=2.47U PD=2.32U
M$887 \$1721 D|Q VDD VDD pfet_03v3 L=0.28U W=0.72U AS=0.3168P AD=0.2097P
+ PS=2.32U PD=1.38U
M$888 \$1722 WECLKb \$1721 VDD pfet_03v3 L=0.28U W=0.36U AS=0.2097P AD=0.1278P
+ PS=1.38U PD=1.07U
M$889 \$1984 \$1723 \$1722 VDD pfet_03v3 L=0.28U W=0.36U AS=0.1278P AD=0.0567P
+ PS=1.07U PD=0.675U
M$890 VDD WECLK \$1984 VDD pfet_03v3 L=0.28U W=0.36U AS=0.0567P AD=0.1584P
+ PS=0.675U PD=1.6U
M$891 \$1723 \$1722 VDD VDD pfet_03v3 L=0.28U W=0.36U AS=0.1764P AD=0.1584P
+ PS=1.26U PD=1.6U
M$892 \$1688 \$1722 VDD VDD pfet_03v3 L=0.28U W=0.72U AS=0.1764P AD=0.36P
+ PS=1.26U PD=2.44U
M$893 \$1813 RA VDD VDD pfet_03v3 L=0.28U W=0.72U AS=0.3312P AD=0.3888P
+ PS=2.36U PD=2.52U
M$894 \$1688 \$1813 QAb VDD pfet_03v3 L=0.28U W=0.36U AS=0.1584P AD=0.1152P
+ PS=1.6U PD=1U
M$895 QBb \$1814 \$1688 VDD pfet_03v3 L=0.28U W=0.36U AS=0.1152P AD=0.1584P
+ PS=1U PD=1.6U
M$896 VDD RB \$1814 VDD pfet_03v3 L=0.28U W=0.72U AS=0.3708P AD=0.3168P
+ PS=2.47U PD=2.32U
M$897 \$1724 D|Q VDD VDD pfet_03v3 L=0.28U W=0.72U AS=0.3168P AD=0.2097P
+ PS=2.32U PD=1.38U
M$898 \$1725 WECLKb \$1724 VDD pfet_03v3 L=0.28U W=0.36U AS=0.2097P AD=0.1278P
+ PS=1.38U PD=1.07U
M$899 \$1993 \$1726 \$1725 VDD pfet_03v3 L=0.28U W=0.36U AS=0.1278P AD=0.0567P
+ PS=1.07U PD=0.675U
M$900 VDD WECLK \$1993 VDD pfet_03v3 L=0.28U W=0.36U AS=0.0567P AD=0.1584P
+ PS=0.675U PD=1.6U
M$901 \$1726 \$1725 VDD VDD pfet_03v3 L=0.28U W=0.36U AS=0.1764P AD=0.1584P
+ PS=1.26U PD=1.6U
M$902 \$1689 \$1725 VDD VDD pfet_03v3 L=0.28U W=0.72U AS=0.1764P AD=0.36P
+ PS=1.26U PD=2.44U
M$903 \$1815 RA VDD VDD pfet_03v3 L=0.28U W=0.72U AS=0.3312P AD=0.3888P
+ PS=2.36U PD=2.52U
M$904 \$1689 \$1815 QAb VDD pfet_03v3 L=0.28U W=0.36U AS=0.1584P AD=0.1152P
+ PS=1.6U PD=1U
M$905 QBb \$1816 \$1689 VDD pfet_03v3 L=0.28U W=0.36U AS=0.1152P AD=0.1584P
+ PS=1U PD=1.6U
M$906 VDD RB \$1816 VDD pfet_03v3 L=0.28U W=0.72U AS=0.3708P AD=0.3168P
+ PS=2.47U PD=2.32U
M$907 \$1727 D|Q VDD VDD pfet_03v3 L=0.28U W=0.72U AS=0.3168P AD=0.2097P
+ PS=2.32U PD=1.38U
M$908 \$1728 WECLKb \$1727 VDD pfet_03v3 L=0.28U W=0.36U AS=0.2097P AD=0.1278P
+ PS=1.38U PD=1.07U
M$909 \$2002 \$1729 \$1728 VDD pfet_03v3 L=0.28U W=0.36U AS=0.1278P AD=0.0567P
+ PS=1.07U PD=0.675U
M$910 VDD WECLK \$2002 VDD pfet_03v3 L=0.28U W=0.36U AS=0.0567P AD=0.1584P
+ PS=0.675U PD=1.6U
M$911 \$1729 \$1728 VDD VDD pfet_03v3 L=0.28U W=0.36U AS=0.1764P AD=0.1584P
+ PS=1.26U PD=1.6U
M$912 \$1690 \$1728 VDD VDD pfet_03v3 L=0.28U W=0.72U AS=0.1764P AD=0.36P
+ PS=1.26U PD=2.44U
M$913 \$1817 RA VDD VDD pfet_03v3 L=0.28U W=0.72U AS=0.3312P AD=0.3888P
+ PS=2.36U PD=2.52U
M$914 \$1690 \$1817 QAb VDD pfet_03v3 L=0.28U W=0.36U AS=0.1584P AD=0.1152P
+ PS=1.6U PD=1U
M$915 QBb \$1818 \$1690 VDD pfet_03v3 L=0.28U W=0.36U AS=0.1152P AD=0.1584P
+ PS=1U PD=1.6U
M$916 VDD RB \$1818 VDD pfet_03v3 L=0.28U W=0.72U AS=0.3708P AD=0.3168P
+ PS=2.47U PD=2.32U
M$917 \$1730 D|Q VDD VDD pfet_03v3 L=0.28U W=0.72U AS=0.3168P AD=0.2097P
+ PS=2.32U PD=1.38U
M$918 \$1731 WECLKb \$1730 VDD pfet_03v3 L=0.28U W=0.36U AS=0.2097P AD=0.1278P
+ PS=1.38U PD=1.07U
M$919 \$2011 \$1732 \$1731 VDD pfet_03v3 L=0.28U W=0.36U AS=0.1278P AD=0.0567P
+ PS=1.07U PD=0.675U
M$920 VDD WECLK \$2011 VDD pfet_03v3 L=0.28U W=0.36U AS=0.0567P AD=0.1584P
+ PS=0.675U PD=1.6U
M$921 \$1732 \$1731 VDD VDD pfet_03v3 L=0.28U W=0.36U AS=0.1764P AD=0.1584P
+ PS=1.26U PD=1.6U
M$922 \$1691 \$1731 VDD VDD pfet_03v3 L=0.28U W=0.72U AS=0.1764P AD=0.36P
+ PS=1.26U PD=2.44U
M$923 \$1819 RA VDD VDD pfet_03v3 L=0.28U W=0.72U AS=0.3312P AD=0.3888P
+ PS=2.36U PD=2.52U
M$924 \$1691 \$1819 QAb VDD pfet_03v3 L=0.28U W=0.36U AS=0.1584P AD=0.1152P
+ PS=1.6U PD=1U
M$925 QBb \$1820 \$1691 VDD pfet_03v3 L=0.28U W=0.36U AS=0.1152P AD=0.1584P
+ PS=1U PD=1.6U
M$926 VDD RB \$1820 VDD pfet_03v3 L=0.28U W=0.72U AS=0.3708P AD=0.3168P
+ PS=2.47U PD=2.32U
M$927 \$1733 D|Q VDD VDD pfet_03v3 L=0.28U W=0.72U AS=0.3168P AD=0.2097P
+ PS=2.32U PD=1.38U
M$928 \$1734 WECLKb \$1733 VDD pfet_03v3 L=0.28U W=0.36U AS=0.2097P AD=0.1278P
+ PS=1.38U PD=1.07U
M$929 \$2018 \$1735 \$1734 VDD pfet_03v3 L=0.28U W=0.36U AS=0.1278P AD=0.0567P
+ PS=1.07U PD=0.675U
M$930 VDD WECLK \$2018 VDD pfet_03v3 L=0.28U W=0.36U AS=0.0567P AD=0.1584P
+ PS=0.675U PD=1.6U
M$931 \$1735 \$1734 VDD VDD pfet_03v3 L=0.28U W=0.36U AS=0.1764P AD=0.1584P
+ PS=1.26U PD=1.6U
M$932 \$1692 \$1734 VDD VDD pfet_03v3 L=0.28U W=0.72U AS=0.1764P AD=0.36P
+ PS=1.26U PD=2.44U
M$933 \$1821 RA VDD VDD pfet_03v3 L=0.28U W=0.72U AS=0.3312P AD=0.3888P
+ PS=2.36U PD=2.52U
M$934 \$1692 \$1821 QAb VDD pfet_03v3 L=0.28U W=0.36U AS=0.1584P AD=0.1152P
+ PS=1.6U PD=1U
M$935 QBb \$1822 \$1692 VDD pfet_03v3 L=0.28U W=0.36U AS=0.1152P AD=0.1584P
+ PS=1U PD=1.6U
M$936 VDD RB \$1822 VDD pfet_03v3 L=0.28U W=0.72U AS=0.3708P AD=0.3168P
+ PS=2.47U PD=2.32U
M$937 \$1736 D|Q VDD VDD pfet_03v3 L=0.28U W=0.72U AS=0.3168P AD=0.2097P
+ PS=2.32U PD=1.38U
M$938 \$1737 WECLKb \$1736 VDD pfet_03v3 L=0.28U W=0.36U AS=0.2097P AD=0.1278P
+ PS=1.38U PD=1.07U
M$939 \$2006 \$1738 \$1737 VDD pfet_03v3 L=0.28U W=0.36U AS=0.1278P AD=0.0567P
+ PS=1.07U PD=0.675U
M$940 VDD WECLK \$2006 VDD pfet_03v3 L=0.28U W=0.36U AS=0.0567P AD=0.1584P
+ PS=0.675U PD=1.6U
M$941 \$1738 \$1737 VDD VDD pfet_03v3 L=0.28U W=0.36U AS=0.1764P AD=0.1584P
+ PS=1.26U PD=1.6U
M$942 \$1693 \$1737 VDD VDD pfet_03v3 L=0.28U W=0.72U AS=0.1764P AD=0.36P
+ PS=1.26U PD=2.44U
M$943 \$1823 RA VDD VDD pfet_03v3 L=0.28U W=0.72U AS=0.3312P AD=0.3888P
+ PS=2.36U PD=2.52U
M$944 \$1693 \$1823 QAb VDD pfet_03v3 L=0.28U W=0.36U AS=0.1584P AD=0.1152P
+ PS=1.6U PD=1U
M$945 QBb \$1824 \$1693 VDD pfet_03v3 L=0.28U W=0.36U AS=0.1152P AD=0.1584P
+ PS=1U PD=1.6U
M$946 VDD RB \$1824 VDD pfet_03v3 L=0.28U W=0.72U AS=0.3708P AD=0.3168P
+ PS=2.47U PD=2.32U
M$947 \$1739 D|Q VDD VDD pfet_03v3 L=0.28U W=0.72U AS=0.3168P AD=0.2097P
+ PS=2.32U PD=1.38U
M$948 \$1740 WECLKb \$1739 VDD pfet_03v3 L=0.28U W=0.36U AS=0.2097P AD=0.1278P
+ PS=1.38U PD=1.07U
M$949 \$1980 \$1741 \$1740 VDD pfet_03v3 L=0.28U W=0.36U AS=0.1278P AD=0.0567P
+ PS=1.07U PD=0.675U
M$950 VDD WECLK \$1980 VDD pfet_03v3 L=0.28U W=0.36U AS=0.0567P AD=0.1584P
+ PS=0.675U PD=1.6U
M$951 \$1741 \$1740 VDD VDD pfet_03v3 L=0.28U W=0.36U AS=0.1764P AD=0.1584P
+ PS=1.26U PD=1.6U
M$952 \$1694 \$1740 VDD VDD pfet_03v3 L=0.28U W=0.72U AS=0.1764P AD=0.36P
+ PS=1.26U PD=2.44U
M$953 \$1825 RA VDD VDD pfet_03v3 L=0.28U W=0.72U AS=0.3312P AD=0.3888P
+ PS=2.36U PD=2.52U
M$954 \$1694 \$1825 QAb VDD pfet_03v3 L=0.28U W=0.36U AS=0.1584P AD=0.1152P
+ PS=1.6U PD=1U
M$955 QBb \$1826 \$1694 VDD pfet_03v3 L=0.28U W=0.36U AS=0.1152P AD=0.1584P
+ PS=1U PD=1.6U
M$956 VDD RB \$1826 VDD pfet_03v3 L=0.28U W=0.72U AS=0.3708P AD=0.3168P
+ PS=2.47U PD=2.32U
M$957 \$1742 D|Q VDD VDD pfet_03v3 L=0.28U W=0.72U AS=0.3168P AD=0.2097P
+ PS=2.32U PD=1.38U
M$958 \$1743 WECLKb \$1742 VDD pfet_03v3 L=0.28U W=0.36U AS=0.2097P AD=0.1278P
+ PS=1.38U PD=1.07U
M$959 \$1960 \$1744 \$1743 VDD pfet_03v3 L=0.28U W=0.36U AS=0.1278P AD=0.0567P
+ PS=1.07U PD=0.675U
M$960 VDD WECLK \$1960 VDD pfet_03v3 L=0.28U W=0.36U AS=0.0567P AD=0.1584P
+ PS=0.675U PD=1.6U
M$961 \$1744 \$1743 VDD VDD pfet_03v3 L=0.28U W=0.36U AS=0.1764P AD=0.1584P
+ PS=1.26U PD=1.6U
M$962 \$1695 \$1743 VDD VDD pfet_03v3 L=0.28U W=0.72U AS=0.1764P AD=0.36P
+ PS=1.26U PD=2.44U
M$963 \$1827 RA VDD VDD pfet_03v3 L=0.28U W=0.72U AS=0.3312P AD=0.3888P
+ PS=2.36U PD=2.52U
M$964 \$1695 \$1827 QAb VDD pfet_03v3 L=0.28U W=0.36U AS=0.1584P AD=0.1152P
+ PS=1.6U PD=1U
M$965 QBb \$1828 \$1695 VDD pfet_03v3 L=0.28U W=0.36U AS=0.1152P AD=0.1584P
+ PS=1U PD=1.6U
M$966 VDD RB \$1828 VDD pfet_03v3 L=0.28U W=0.72U AS=0.3708P AD=0.3168P
+ PS=2.47U PD=2.32U
M$967 \$1745 D|Q VDD VDD pfet_03v3 L=0.28U W=0.72U AS=0.3168P AD=0.2097P
+ PS=2.32U PD=1.38U
M$968 \$1746 WECLKb \$1745 VDD pfet_03v3 L=0.28U W=0.36U AS=0.2097P AD=0.1278P
+ PS=1.38U PD=1.07U
M$969 \$1931 \$1747 \$1746 VDD pfet_03v3 L=0.28U W=0.36U AS=0.1278P AD=0.0567P
+ PS=1.07U PD=0.675U
M$970 VDD WECLK \$1931 VDD pfet_03v3 L=0.28U W=0.36U AS=0.0567P AD=0.1584P
+ PS=0.675U PD=1.6U
M$971 \$1747 \$1746 VDD VDD pfet_03v3 L=0.28U W=0.36U AS=0.1764P AD=0.1584P
+ PS=1.26U PD=1.6U
M$972 \$1696 \$1746 VDD VDD pfet_03v3 L=0.28U W=0.72U AS=0.1764P AD=0.36P
+ PS=1.26U PD=2.44U
M$973 \$1829 RA VDD VDD pfet_03v3 L=0.28U W=0.72U AS=0.3312P AD=0.3888P
+ PS=2.36U PD=2.52U
M$974 \$1696 \$1829 QAb VDD pfet_03v3 L=0.28U W=0.36U AS=0.1584P AD=0.1152P
+ PS=1.6U PD=1U
M$975 QBb \$1830 \$1696 VDD pfet_03v3 L=0.28U W=0.36U AS=0.1152P AD=0.1584P
+ PS=1U PD=1.6U
M$976 VDD RB \$1830 VDD pfet_03v3 L=0.28U W=0.72U AS=0.3708P AD=0.3168P
+ PS=2.47U PD=2.32U
M$977 \$2023 WE VDD VDD pfet_03v3 L=0.28U W=0.72U AS=0.3168P AD=0.1872P
+ PS=2.32U PD=1.24U
M$978 VDD CLK \$2023 VDD pfet_03v3 L=0.28U W=0.72U AS=0.1872P AD=0.3168P
+ PS=1.24U PD=2.32U
M$979 WECLK \$2023 VDD VDD pfet_03v3 L=0.28U W=2.54U AS=0.889P AD=0.6688P
+ PS=5.21U PD=3.65U
M$983 \$2029 WECLKb \$2028 VDD pfet_03v3 L=0.28U W=0.36U AS=0.2097P AD=0.1278P
+ PS=1.38U PD=1.07U
M$984 \$2131 \$2030 \$2029 VDD pfet_03v3 L=0.28U W=0.36U AS=0.1278P AD=0.0567P
+ PS=1.07U PD=0.675U
M$985 VDD WECLK \$2131 VDD pfet_03v3 L=0.28U W=0.36U AS=0.0567P AD=0.1584P
+ PS=0.675U PD=1.6U
M$986 \$2028 D|Q VDD VDD pfet_03v3 L=0.28U W=0.72U AS=0.3168P AD=0.2097P
+ PS=2.32U PD=1.38U
M$987 VDD \$2029 \$2030 VDD pfet_03v3 L=0.28U W=0.36U AS=0.1584P AD=0.1764P
+ PS=1.6U PD=1.26U
M$988 \$2031 \$2029 VDD VDD pfet_03v3 L=0.28U W=0.72U AS=0.1764P AD=0.36P
+ PS=1.26U PD=2.44U
M$989 \$2032 RA VDD VDD pfet_03v3 L=0.28U W=0.72U AS=0.3312P AD=0.3888P
+ PS=2.36U PD=2.52U
M$990 \$2031 \$2032 QAb VDD pfet_03v3 L=0.28U W=0.36U AS=0.1584P AD=0.1152P
+ PS=1.6U PD=1U
M$991 QBb \$2033 \$2031 VDD pfet_03v3 L=0.28U W=0.36U AS=0.1152P AD=0.1584P
+ PS=1U PD=1.6U
M$992 VDD RB \$2033 VDD pfet_03v3 L=0.28U W=0.72U AS=0.3708P AD=0.3168P
+ PS=2.47U PD=2.32U
M$993 \$2036 WECLKb \$2035 VDD pfet_03v3 L=0.28U W=0.36U AS=0.2097P AD=0.1278P
+ PS=1.38U PD=1.07U
M$994 \$2140 \$2037 \$2036 VDD pfet_03v3 L=0.28U W=0.36U AS=0.1278P AD=0.0567P
+ PS=1.07U PD=0.675U
M$995 VDD WECLK \$2140 VDD pfet_03v3 L=0.28U W=0.36U AS=0.0567P AD=0.1584P
+ PS=0.675U PD=1.6U
M$996 \$2035 D|Q VDD VDD pfet_03v3 L=0.28U W=0.72U AS=0.3168P AD=0.2097P
+ PS=2.32U PD=1.38U
M$997 VDD \$2036 \$2037 VDD pfet_03v3 L=0.28U W=0.36U AS=0.1584P AD=0.1764P
+ PS=1.6U PD=1.26U
M$998 \$2038 \$2036 VDD VDD pfet_03v3 L=0.28U W=0.72U AS=0.1764P AD=0.36P
+ PS=1.26U PD=2.44U
M$999 \$2039 RA VDD VDD pfet_03v3 L=0.28U W=0.72U AS=0.3312P AD=0.3888P
+ PS=2.36U PD=2.52U
M$1000 \$2038 \$2039 QAb VDD pfet_03v3 L=0.28U W=0.36U AS=0.1584P AD=0.1152P
+ PS=1.6U PD=1U
M$1001 QBb \$2040 \$2038 VDD pfet_03v3 L=0.28U W=0.36U AS=0.1152P AD=0.1584P
+ PS=1U PD=1.6U
M$1002 VDD RB \$2040 VDD pfet_03v3 L=0.28U W=0.72U AS=0.3708P AD=0.3168P
+ PS=2.47U PD=2.32U
M$1003 \$2042 WECLKb \$2041 VDD pfet_03v3 L=0.28U W=0.36U AS=0.2097P AD=0.1278P
+ PS=1.38U PD=1.07U
M$1004 \$2150 \$2043 \$2042 VDD pfet_03v3 L=0.28U W=0.36U AS=0.1278P AD=0.0567P
+ PS=1.07U PD=0.675U
M$1005 VDD WECLK \$2150 VDD pfet_03v3 L=0.28U W=0.36U AS=0.0567P AD=0.1584P
+ PS=0.675U PD=1.6U
M$1006 \$2041 D|Q VDD VDD pfet_03v3 L=0.28U W=0.72U AS=0.3168P AD=0.2097P
+ PS=2.32U PD=1.38U
M$1007 VDD \$2042 \$2043 VDD pfet_03v3 L=0.28U W=0.36U AS=0.1584P AD=0.1764P
+ PS=1.6U PD=1.26U
M$1008 \$2044 \$2042 VDD VDD pfet_03v3 L=0.28U W=0.72U AS=0.1764P AD=0.36P
+ PS=1.26U PD=2.44U
M$1009 \$2045 RA VDD VDD pfet_03v3 L=0.28U W=0.72U AS=0.3312P AD=0.3888P
+ PS=2.36U PD=2.52U
M$1010 \$2044 \$2045 QAb VDD pfet_03v3 L=0.28U W=0.36U AS=0.1584P AD=0.1152P
+ PS=1.6U PD=1U
M$1011 QBb \$2046 \$2044 VDD pfet_03v3 L=0.28U W=0.36U AS=0.1152P AD=0.1584P
+ PS=1U PD=1.6U
M$1012 VDD RB \$2046 VDD pfet_03v3 L=0.28U W=0.72U AS=0.3708P AD=0.3168P
+ PS=2.47U PD=2.32U
M$1013 \$2048 WECLKb \$2047 VDD pfet_03v3 L=0.28U W=0.36U AS=0.2097P AD=0.1278P
+ PS=1.38U PD=1.07U
M$1014 \$2161 \$2049 \$2048 VDD pfet_03v3 L=0.28U W=0.36U AS=0.1278P AD=0.0567P
+ PS=1.07U PD=0.675U
M$1015 VDD WECLK \$2161 VDD pfet_03v3 L=0.28U W=0.36U AS=0.0567P AD=0.1584P
+ PS=0.675U PD=1.6U
M$1016 \$2047 D|Q VDD VDD pfet_03v3 L=0.28U W=0.72U AS=0.3168P AD=0.2097P
+ PS=2.32U PD=1.38U
M$1017 VDD \$2048 \$2049 VDD pfet_03v3 L=0.28U W=0.36U AS=0.1584P AD=0.1764P
+ PS=1.6U PD=1.26U
M$1018 \$2050 \$2048 VDD VDD pfet_03v3 L=0.28U W=0.72U AS=0.1764P AD=0.36P
+ PS=1.26U PD=2.44U
M$1019 \$2051 RA VDD VDD pfet_03v3 L=0.28U W=0.72U AS=0.3312P AD=0.3888P
+ PS=2.36U PD=2.52U
M$1020 \$2050 \$2051 QAb VDD pfet_03v3 L=0.28U W=0.36U AS=0.1584P AD=0.1152P
+ PS=1.6U PD=1U
M$1021 QBb \$2052 \$2050 VDD pfet_03v3 L=0.28U W=0.36U AS=0.1152P AD=0.1584P
+ PS=1U PD=1.6U
M$1022 VDD RB \$2052 VDD pfet_03v3 L=0.28U W=0.72U AS=0.3708P AD=0.3168P
+ PS=2.47U PD=2.32U
M$1023 \$2054 WECLKb \$2053 VDD pfet_03v3 L=0.28U W=0.36U AS=0.2097P AD=0.1278P
+ PS=1.38U PD=1.07U
M$1024 \$2173 \$2055 \$2054 VDD pfet_03v3 L=0.28U W=0.36U AS=0.1278P AD=0.0567P
+ PS=1.07U PD=0.675U
M$1025 VDD WECLK \$2173 VDD pfet_03v3 L=0.28U W=0.36U AS=0.0567P AD=0.1584P
+ PS=0.675U PD=1.6U
M$1026 \$2053 D|Q VDD VDD pfet_03v3 L=0.28U W=0.72U AS=0.3168P AD=0.2097P
+ PS=2.32U PD=1.38U
M$1027 VDD \$2054 \$2055 VDD pfet_03v3 L=0.28U W=0.36U AS=0.1584P AD=0.1764P
+ PS=1.6U PD=1.26U
M$1028 \$2056 \$2054 VDD VDD pfet_03v3 L=0.28U W=0.72U AS=0.1764P AD=0.36P
+ PS=1.26U PD=2.44U
M$1029 \$2057 RA VDD VDD pfet_03v3 L=0.28U W=0.72U AS=0.3312P AD=0.3888P
+ PS=2.36U PD=2.52U
M$1030 \$2056 \$2057 QAb VDD pfet_03v3 L=0.28U W=0.36U AS=0.1584P AD=0.1152P
+ PS=1.6U PD=1U
M$1031 QBb \$2058 \$2056 VDD pfet_03v3 L=0.28U W=0.36U AS=0.1152P AD=0.1584P
+ PS=1U PD=1.6U
M$1032 VDD RB \$2058 VDD pfet_03v3 L=0.28U W=0.72U AS=0.3708P AD=0.3168P
+ PS=2.47U PD=2.32U
M$1033 \$2060 WECLKb \$2059 VDD pfet_03v3 L=0.28U W=0.36U AS=0.2097P AD=0.1278P
+ PS=1.38U PD=1.07U
M$1034 \$2182 \$2061 \$2060 VDD pfet_03v3 L=0.28U W=0.36U AS=0.1278P AD=0.0567P
+ PS=1.07U PD=0.675U
M$1035 VDD WECLK \$2182 VDD pfet_03v3 L=0.28U W=0.36U AS=0.0567P AD=0.1584P
+ PS=0.675U PD=1.6U
M$1036 \$2059 D|Q VDD VDD pfet_03v3 L=0.28U W=0.72U AS=0.3168P AD=0.2097P
+ PS=2.32U PD=1.38U
M$1037 VDD \$2060 \$2061 VDD pfet_03v3 L=0.28U W=0.36U AS=0.1584P AD=0.1764P
+ PS=1.6U PD=1.26U
M$1038 \$2062 \$2060 VDD VDD pfet_03v3 L=0.28U W=0.72U AS=0.1764P AD=0.36P
+ PS=1.26U PD=2.44U
M$1039 \$2063 RA VDD VDD pfet_03v3 L=0.28U W=0.72U AS=0.3312P AD=0.3888P
+ PS=2.36U PD=2.52U
M$1040 \$2062 \$2063 QAb VDD pfet_03v3 L=0.28U W=0.36U AS=0.1584P AD=0.1152P
+ PS=1.6U PD=1U
M$1041 QBb \$2064 \$2062 VDD pfet_03v3 L=0.28U W=0.36U AS=0.1152P AD=0.1584P
+ PS=1U PD=1.6U
M$1042 VDD RB \$2064 VDD pfet_03v3 L=0.28U W=0.72U AS=0.3708P AD=0.3168P
+ PS=2.47U PD=2.32U
M$1043 \$2066 WECLKb \$2065 VDD pfet_03v3 L=0.28U W=0.36U AS=0.2097P AD=0.1278P
+ PS=1.38U PD=1.07U
M$1044 \$2191 \$2067 \$2066 VDD pfet_03v3 L=0.28U W=0.36U AS=0.1278P AD=0.0567P
+ PS=1.07U PD=0.675U
M$1045 VDD WECLK \$2191 VDD pfet_03v3 L=0.28U W=0.36U AS=0.0567P AD=0.1584P
+ PS=0.675U PD=1.6U
M$1046 \$2065 D|Q VDD VDD pfet_03v3 L=0.28U W=0.72U AS=0.3168P AD=0.2097P
+ PS=2.32U PD=1.38U
M$1047 VDD \$2066 \$2067 VDD pfet_03v3 L=0.28U W=0.36U AS=0.1584P AD=0.1764P
+ PS=1.6U PD=1.26U
M$1048 \$2068 \$2066 VDD VDD pfet_03v3 L=0.28U W=0.72U AS=0.1764P AD=0.36P
+ PS=1.26U PD=2.44U
M$1049 \$2069 RA VDD VDD pfet_03v3 L=0.28U W=0.72U AS=0.3312P AD=0.3888P
+ PS=2.36U PD=2.52U
M$1050 \$2068 \$2069 QAb VDD pfet_03v3 L=0.28U W=0.36U AS=0.1584P AD=0.1152P
+ PS=1.6U PD=1U
M$1051 QBb \$2070 \$2068 VDD pfet_03v3 L=0.28U W=0.36U AS=0.1152P AD=0.1584P
+ PS=1U PD=1.6U
M$1052 VDD RB \$2070 VDD pfet_03v3 L=0.28U W=0.72U AS=0.3708P AD=0.3168P
+ PS=2.47U PD=2.32U
M$1053 \$2072 WECLKb \$2071 VDD pfet_03v3 L=0.28U W=0.36U AS=0.2097P AD=0.1278P
+ PS=1.38U PD=1.07U
M$1054 \$2203 \$2073 \$2072 VDD pfet_03v3 L=0.28U W=0.36U AS=0.1278P AD=0.0567P
+ PS=1.07U PD=0.675U
M$1055 VDD WECLK \$2203 VDD pfet_03v3 L=0.28U W=0.36U AS=0.0567P AD=0.1584P
+ PS=0.675U PD=1.6U
M$1056 \$2071 D|Q VDD VDD pfet_03v3 L=0.28U W=0.72U AS=0.3168P AD=0.2097P
+ PS=2.32U PD=1.38U
M$1057 VDD \$2072 \$2073 VDD pfet_03v3 L=0.28U W=0.36U AS=0.1584P AD=0.1764P
+ PS=1.6U PD=1.26U
M$1058 \$2074 \$2072 VDD VDD pfet_03v3 L=0.28U W=0.72U AS=0.1764P AD=0.36P
+ PS=1.26U PD=2.44U
M$1059 \$2075 RA VDD VDD pfet_03v3 L=0.28U W=0.72U AS=0.3312P AD=0.3888P
+ PS=2.36U PD=2.52U
M$1060 \$2074 \$2075 QAb VDD pfet_03v3 L=0.28U W=0.36U AS=0.1584P AD=0.1152P
+ PS=1.6U PD=1U
M$1061 QBb \$2076 \$2074 VDD pfet_03v3 L=0.28U W=0.36U AS=0.1152P AD=0.1584P
+ PS=1U PD=1.6U
M$1062 VDD RB \$2076 VDD pfet_03v3 L=0.28U W=0.72U AS=0.3708P AD=0.3168P
+ PS=2.47U PD=2.32U
M$1063 \$2078 WECLKb \$2077 VDD pfet_03v3 L=0.28U W=0.36U AS=0.2097P AD=0.1278P
+ PS=1.38U PD=1.07U
M$1064 \$2214 \$2079 \$2078 VDD pfet_03v3 L=0.28U W=0.36U AS=0.1278P AD=0.0567P
+ PS=1.07U PD=0.675U
M$1065 VDD WECLK \$2214 VDD pfet_03v3 L=0.28U W=0.36U AS=0.0567P AD=0.1584P
+ PS=0.675U PD=1.6U
M$1066 \$2077 D|Q VDD VDD pfet_03v3 L=0.28U W=0.72U AS=0.3168P AD=0.2097P
+ PS=2.32U PD=1.38U
M$1067 VDD \$2078 \$2079 VDD pfet_03v3 L=0.28U W=0.36U AS=0.1584P AD=0.1764P
+ PS=1.6U PD=1.26U
M$1068 \$2080 \$2078 VDD VDD pfet_03v3 L=0.28U W=0.72U AS=0.1764P AD=0.36P
+ PS=1.26U PD=2.44U
M$1069 \$2081 RA VDD VDD pfet_03v3 L=0.28U W=0.72U AS=0.3312P AD=0.3888P
+ PS=2.36U PD=2.52U
M$1070 \$2080 \$2081 QAb VDD pfet_03v3 L=0.28U W=0.36U AS=0.1584P AD=0.1152P
+ PS=1.6U PD=1U
M$1071 QBb \$2082 \$2080 VDD pfet_03v3 L=0.28U W=0.36U AS=0.1152P AD=0.1584P
+ PS=1U PD=1.6U
M$1072 VDD RB \$2082 VDD pfet_03v3 L=0.28U W=0.72U AS=0.3708P AD=0.3168P
+ PS=2.47U PD=2.32U
M$1073 \$2084 WECLKb \$2083 VDD pfet_03v3 L=0.28U W=0.36U AS=0.2097P AD=0.1278P
+ PS=1.38U PD=1.07U
M$1074 \$2224 \$2085 \$2084 VDD pfet_03v3 L=0.28U W=0.36U AS=0.1278P AD=0.0567P
+ PS=1.07U PD=0.675U
M$1075 VDD WECLK \$2224 VDD pfet_03v3 L=0.28U W=0.36U AS=0.0567P AD=0.1584P
+ PS=0.675U PD=1.6U
M$1076 \$2083 D|Q VDD VDD pfet_03v3 L=0.28U W=0.72U AS=0.3168P AD=0.2097P
+ PS=2.32U PD=1.38U
M$1077 VDD \$2084 \$2085 VDD pfet_03v3 L=0.28U W=0.36U AS=0.1584P AD=0.1764P
+ PS=1.6U PD=1.26U
M$1078 \$2086 \$2084 VDD VDD pfet_03v3 L=0.28U W=0.72U AS=0.1764P AD=0.36P
+ PS=1.26U PD=2.44U
M$1079 \$2087 RA VDD VDD pfet_03v3 L=0.28U W=0.72U AS=0.3312P AD=0.3888P
+ PS=2.36U PD=2.52U
M$1080 \$2086 \$2087 QAb VDD pfet_03v3 L=0.28U W=0.36U AS=0.1584P AD=0.1152P
+ PS=1.6U PD=1U
M$1081 QBb \$2088 \$2086 VDD pfet_03v3 L=0.28U W=0.36U AS=0.1152P AD=0.1584P
+ PS=1U PD=1.6U
M$1082 VDD RB \$2088 VDD pfet_03v3 L=0.28U W=0.72U AS=0.3708P AD=0.3168P
+ PS=2.47U PD=2.32U
M$1083 \$2090 WECLKb \$2089 VDD pfet_03v3 L=0.28U W=0.36U AS=0.2097P AD=0.1278P
+ PS=1.38U PD=1.07U
M$1084 \$2233 \$2091 \$2090 VDD pfet_03v3 L=0.28U W=0.36U AS=0.1278P AD=0.0567P
+ PS=1.07U PD=0.675U
M$1085 VDD WECLK \$2233 VDD pfet_03v3 L=0.28U W=0.36U AS=0.0567P AD=0.1584P
+ PS=0.675U PD=1.6U
M$1086 \$2089 D|Q VDD VDD pfet_03v3 L=0.28U W=0.72U AS=0.3168P AD=0.2097P
+ PS=2.32U PD=1.38U
M$1087 VDD \$2090 \$2091 VDD pfet_03v3 L=0.28U W=0.36U AS=0.1584P AD=0.1764P
+ PS=1.6U PD=1.26U
M$1088 \$2092 \$2090 VDD VDD pfet_03v3 L=0.28U W=0.72U AS=0.1764P AD=0.36P
+ PS=1.26U PD=2.44U
M$1089 \$2093 RA VDD VDD pfet_03v3 L=0.28U W=0.72U AS=0.3312P AD=0.3888P
+ PS=2.36U PD=2.52U
M$1090 \$2092 \$2093 QAb VDD pfet_03v3 L=0.28U W=0.36U AS=0.1584P AD=0.1152P
+ PS=1.6U PD=1U
M$1091 QBb \$2094 \$2092 VDD pfet_03v3 L=0.28U W=0.36U AS=0.1152P AD=0.1584P
+ PS=1U PD=1.6U
M$1092 VDD RB \$2094 VDD pfet_03v3 L=0.28U W=0.72U AS=0.3708P AD=0.3168P
+ PS=2.47U PD=2.32U
M$1093 \$2096 WECLKb \$2095 VDD pfet_03v3 L=0.28U W=0.36U AS=0.2097P AD=0.1278P
+ PS=1.38U PD=1.07U
M$1094 \$2245 \$2097 \$2096 VDD pfet_03v3 L=0.28U W=0.36U AS=0.1278P AD=0.0567P
+ PS=1.07U PD=0.675U
M$1095 VDD WECLK \$2245 VDD pfet_03v3 L=0.28U W=0.36U AS=0.0567P AD=0.1584P
+ PS=0.675U PD=1.6U
M$1096 \$2095 D|Q VDD VDD pfet_03v3 L=0.28U W=0.72U AS=0.3168P AD=0.2097P
+ PS=2.32U PD=1.38U
M$1097 VDD \$2096 \$2097 VDD pfet_03v3 L=0.28U W=0.36U AS=0.1584P AD=0.1764P
+ PS=1.6U PD=1.26U
M$1098 \$2098 \$2096 VDD VDD pfet_03v3 L=0.28U W=0.72U AS=0.1764P AD=0.36P
+ PS=1.26U PD=2.44U
M$1099 \$2099 RA VDD VDD pfet_03v3 L=0.28U W=0.72U AS=0.3312P AD=0.3888P
+ PS=2.36U PD=2.52U
M$1100 \$2098 \$2099 QAb VDD pfet_03v3 L=0.28U W=0.36U AS=0.1584P AD=0.1152P
+ PS=1.6U PD=1U
M$1101 QBb \$2100 \$2098 VDD pfet_03v3 L=0.28U W=0.36U AS=0.1152P AD=0.1584P
+ PS=1U PD=1.6U
M$1102 VDD RB \$2100 VDD pfet_03v3 L=0.28U W=0.72U AS=0.3708P AD=0.3168P
+ PS=2.47U PD=2.32U
M$1103 \$2102 WECLKb \$2101 VDD pfet_03v3 L=0.28U W=0.36U AS=0.2097P AD=0.1278P
+ PS=1.38U PD=1.07U
M$1104 \$2253 \$2103 \$2102 VDD pfet_03v3 L=0.28U W=0.36U AS=0.1278P AD=0.0567P
+ PS=1.07U PD=0.675U
M$1105 VDD WECLK \$2253 VDD pfet_03v3 L=0.28U W=0.36U AS=0.0567P AD=0.1584P
+ PS=0.675U PD=1.6U
M$1106 \$2101 D|Q VDD VDD pfet_03v3 L=0.28U W=0.72U AS=0.3168P AD=0.2097P
+ PS=2.32U PD=1.38U
M$1107 VDD \$2102 \$2103 VDD pfet_03v3 L=0.28U W=0.36U AS=0.1584P AD=0.1764P
+ PS=1.6U PD=1.26U
M$1108 \$2104 \$2102 VDD VDD pfet_03v3 L=0.28U W=0.72U AS=0.1764P AD=0.36P
+ PS=1.26U PD=2.44U
M$1109 \$2105 RA VDD VDD pfet_03v3 L=0.28U W=0.72U AS=0.3312P AD=0.3888P
+ PS=2.36U PD=2.52U
M$1110 \$2104 \$2105 QAb VDD pfet_03v3 L=0.28U W=0.36U AS=0.1584P AD=0.1152P
+ PS=1.6U PD=1U
M$1111 QBb \$2106 \$2104 VDD pfet_03v3 L=0.28U W=0.36U AS=0.1152P AD=0.1584P
+ PS=1U PD=1.6U
M$1112 VDD RB \$2106 VDD pfet_03v3 L=0.28U W=0.72U AS=0.3708P AD=0.3168P
+ PS=2.47U PD=2.32U
M$1113 \$2108 WECLKb \$2107 VDD pfet_03v3 L=0.28U W=0.36U AS=0.2097P AD=0.1278P
+ PS=1.38U PD=1.07U
M$1114 \$2216 \$2109 \$2108 VDD pfet_03v3 L=0.28U W=0.36U AS=0.1278P AD=0.0567P
+ PS=1.07U PD=0.675U
M$1115 VDD WECLK \$2216 VDD pfet_03v3 L=0.28U W=0.36U AS=0.0567P AD=0.1584P
+ PS=0.675U PD=1.6U
M$1116 \$2107 D|Q VDD VDD pfet_03v3 L=0.28U W=0.72U AS=0.3168P AD=0.2097P
+ PS=2.32U PD=1.38U
M$1117 VDD \$2108 \$2109 VDD pfet_03v3 L=0.28U W=0.36U AS=0.1584P AD=0.1764P
+ PS=1.6U PD=1.26U
M$1118 \$2110 \$2108 VDD VDD pfet_03v3 L=0.28U W=0.72U AS=0.1764P AD=0.36P
+ PS=1.26U PD=2.44U
M$1119 \$2111 RA VDD VDD pfet_03v3 L=0.28U W=0.72U AS=0.3312P AD=0.3888P
+ PS=2.36U PD=2.52U
M$1120 \$2110 \$2111 QAb VDD pfet_03v3 L=0.28U W=0.36U AS=0.1584P AD=0.1152P
+ PS=1.6U PD=1U
M$1121 QBb \$2112 \$2110 VDD pfet_03v3 L=0.28U W=0.36U AS=0.1152P AD=0.1584P
+ PS=1U PD=1.6U
M$1122 VDD RB \$2112 VDD pfet_03v3 L=0.28U W=0.72U AS=0.3708P AD=0.3168P
+ PS=2.47U PD=2.32U
M$1123 \$2114 WECLKb \$2113 VDD pfet_03v3 L=0.28U W=0.36U AS=0.2097P AD=0.1278P
+ PS=1.38U PD=1.07U
M$1124 \$2187 \$2115 \$2114 VDD pfet_03v3 L=0.28U W=0.36U AS=0.1278P AD=0.0567P
+ PS=1.07U PD=0.675U
M$1125 VDD WECLK \$2187 VDD pfet_03v3 L=0.28U W=0.36U AS=0.0567P AD=0.1584P
+ PS=0.675U PD=1.6U
M$1126 \$2113 D|Q VDD VDD pfet_03v3 L=0.28U W=0.72U AS=0.3168P AD=0.2097P
+ PS=2.32U PD=1.38U
M$1127 VDD \$2114 \$2115 VDD pfet_03v3 L=0.28U W=0.36U AS=0.1584P AD=0.1764P
+ PS=1.6U PD=1.26U
M$1128 \$2116 \$2114 VDD VDD pfet_03v3 L=0.28U W=0.72U AS=0.1764P AD=0.36P
+ PS=1.26U PD=2.44U
M$1129 \$2117 RA VDD VDD pfet_03v3 L=0.28U W=0.72U AS=0.3312P AD=0.3888P
+ PS=2.36U PD=2.52U
M$1130 \$2116 \$2117 QAb VDD pfet_03v3 L=0.28U W=0.36U AS=0.1584P AD=0.1152P
+ PS=1.6U PD=1U
M$1131 QBb \$2118 \$2116 VDD pfet_03v3 L=0.28U W=0.36U AS=0.1152P AD=0.1584P
+ PS=1U PD=1.6U
M$1132 VDD RB \$2118 VDD pfet_03v3 L=0.28U W=0.72U AS=0.3708P AD=0.3168P
+ PS=2.47U PD=2.32U
M$1133 \$2120 WECLKb \$2119 VDD pfet_03v3 L=0.28U W=0.36U AS=0.2097P AD=0.1278P
+ PS=1.38U PD=1.07U
M$1134 \$2152 \$2121 \$2120 VDD pfet_03v3 L=0.28U W=0.36U AS=0.1278P AD=0.0567P
+ PS=1.07U PD=0.675U
M$1135 VDD WECLK \$2152 VDD pfet_03v3 L=0.28U W=0.36U AS=0.0567P AD=0.1584P
+ PS=0.675U PD=1.6U
M$1136 \$2119 D|Q VDD VDD pfet_03v3 L=0.28U W=0.72U AS=0.3168P AD=0.2097P
+ PS=2.32U PD=1.38U
M$1137 VDD \$2120 \$2121 VDD pfet_03v3 L=0.28U W=0.36U AS=0.1584P AD=0.1764P
+ PS=1.6U PD=1.26U
M$1138 \$2122 \$2120 VDD VDD pfet_03v3 L=0.28U W=0.72U AS=0.1764P AD=0.36P
+ PS=1.26U PD=2.44U
M$1139 \$2123 RA VDD VDD pfet_03v3 L=0.28U W=0.72U AS=0.3312P AD=0.3888P
+ PS=2.36U PD=2.52U
M$1140 \$2122 \$2123 QAb VDD pfet_03v3 L=0.28U W=0.36U AS=0.1584P AD=0.1152P
+ PS=1.6U PD=1U
M$1141 QBb \$2124 \$2122 VDD pfet_03v3 L=0.28U W=0.36U AS=0.1152P AD=0.1584P
+ PS=1U PD=1.6U
M$1142 VDD RB \$2124 VDD pfet_03v3 L=0.28U W=0.72U AS=0.3708P AD=0.3168P
+ PS=2.47U PD=2.32U
M$1143 \$2374 WE VDD VDD pfet_03v3 L=0.28U W=0.72U AS=0.3168P AD=0.1872P
+ PS=2.32U PD=1.24U
M$1144 VDD CLK \$2374 VDD pfet_03v3 L=0.28U W=0.72U AS=0.1872P AD=0.3168P
+ PS=1.24U PD=2.32U
M$1145 WECLK \$2374 VDD VDD pfet_03v3 L=0.28U W=2.54U AS=0.8974P AD=0.6604P
+ PS=5.28U PD=3.58U
M$1149 \$2377 D|Q VDD VDD pfet_03v3 L=0.28U W=0.72U AS=0.3168P AD=0.2097P
+ PS=2.32U PD=1.38U
M$1150 \$2378 WECLKb \$2377 VDD pfet_03v3 L=0.28U W=0.36U AS=0.2097P AD=0.1278P
+ PS=1.38U PD=1.07U
M$1151 \$2599 \$2379 \$2378 VDD pfet_03v3 L=0.28U W=0.36U AS=0.1278P AD=0.0567P
+ PS=1.07U PD=0.675U
M$1152 VDD WECLK \$2599 VDD pfet_03v3 L=0.28U W=0.36U AS=0.0567P AD=0.1584P
+ PS=0.675U PD=1.6U
M$1153 \$2379 \$2378 VDD VDD pfet_03v3 L=0.28U W=0.36U AS=0.1764P AD=0.1584P
+ PS=1.26U PD=1.6U
M$1154 \$2358 \$2378 VDD VDD pfet_03v3 L=0.28U W=0.72U AS=0.1764P AD=0.36P
+ PS=1.26U PD=2.44U
M$1155 \$2476 RA VDD VDD pfet_03v3 L=0.28U W=0.72U AS=0.3312P AD=0.3888P
+ PS=2.36U PD=2.52U
M$1156 \$2358 \$2476 QAb VDD pfet_03v3 L=0.28U W=0.36U AS=0.1584P AD=0.1152P
+ PS=1.6U PD=1U
M$1157 QBb \$2477 \$2358 VDD pfet_03v3 L=0.28U W=0.36U AS=0.1152P AD=0.1584P
+ PS=1U PD=1.6U
M$1158 VDD RB \$2477 VDD pfet_03v3 L=0.28U W=0.72U AS=0.3708P AD=0.3168P
+ PS=2.47U PD=2.32U
M$1159 \$2380 D|Q VDD VDD pfet_03v3 L=0.28U W=0.72U AS=0.3168P AD=0.2097P
+ PS=2.32U PD=1.38U
M$1160 \$2381 WECLKb \$2380 VDD pfet_03v3 L=0.28U W=0.36U AS=0.2097P AD=0.1278P
+ PS=1.38U PD=1.07U
M$1161 \$2608 \$2382 \$2381 VDD pfet_03v3 L=0.28U W=0.36U AS=0.1278P AD=0.0567P
+ PS=1.07U PD=0.675U
M$1162 VDD WECLK \$2608 VDD pfet_03v3 L=0.28U W=0.36U AS=0.0567P AD=0.1584P
+ PS=0.675U PD=1.6U
M$1163 \$2382 \$2381 VDD VDD pfet_03v3 L=0.28U W=0.36U AS=0.1764P AD=0.1584P
+ PS=1.26U PD=1.6U
M$1164 \$2359 \$2381 VDD VDD pfet_03v3 L=0.28U W=0.72U AS=0.1764P AD=0.36P
+ PS=1.26U PD=2.44U
M$1165 \$2478 RA VDD VDD pfet_03v3 L=0.28U W=0.72U AS=0.3312P AD=0.3888P
+ PS=2.36U PD=2.52U
M$1166 \$2359 \$2478 QAb VDD pfet_03v3 L=0.28U W=0.36U AS=0.1584P AD=0.1152P
+ PS=1.6U PD=1U
M$1167 QBb \$2479 \$2359 VDD pfet_03v3 L=0.28U W=0.36U AS=0.1152P AD=0.1584P
+ PS=1U PD=1.6U
M$1168 VDD RB \$2479 VDD pfet_03v3 L=0.28U W=0.72U AS=0.3708P AD=0.3168P
+ PS=2.47U PD=2.32U
M$1169 \$2383 D|Q VDD VDD pfet_03v3 L=0.28U W=0.72U AS=0.3168P AD=0.2097P
+ PS=2.32U PD=1.38U
M$1170 \$2384 WECLKb \$2383 VDD pfet_03v3 L=0.28U W=0.36U AS=0.2097P AD=0.1278P
+ PS=1.38U PD=1.07U
M$1171 \$2616 \$2385 \$2384 VDD pfet_03v3 L=0.28U W=0.36U AS=0.1278P AD=0.0567P
+ PS=1.07U PD=0.675U
M$1172 VDD WECLK \$2616 VDD pfet_03v3 L=0.28U W=0.36U AS=0.0567P AD=0.1584P
+ PS=0.675U PD=1.6U
M$1173 \$2385 \$2384 VDD VDD pfet_03v3 L=0.28U W=0.36U AS=0.1764P AD=0.1584P
+ PS=1.26U PD=1.6U
M$1174 \$2360 \$2384 VDD VDD pfet_03v3 L=0.28U W=0.72U AS=0.1764P AD=0.36P
+ PS=1.26U PD=2.44U
M$1175 \$2480 RA VDD VDD pfet_03v3 L=0.28U W=0.72U AS=0.3312P AD=0.3888P
+ PS=2.36U PD=2.52U
M$1176 \$2360 \$2480 QAb VDD pfet_03v3 L=0.28U W=0.36U AS=0.1584P AD=0.1152P
+ PS=1.6U PD=1U
M$1177 QBb \$2481 \$2360 VDD pfet_03v3 L=0.28U W=0.36U AS=0.1152P AD=0.1584P
+ PS=1U PD=1.6U
M$1178 VDD RB \$2481 VDD pfet_03v3 L=0.28U W=0.72U AS=0.3708P AD=0.3168P
+ PS=2.47U PD=2.32U
M$1179 \$2386 D|Q VDD VDD pfet_03v3 L=0.28U W=0.72U AS=0.3168P AD=0.2097P
+ PS=2.32U PD=1.38U
M$1180 \$2387 WECLKb \$2386 VDD pfet_03v3 L=0.28U W=0.36U AS=0.2097P AD=0.1278P
+ PS=1.38U PD=1.07U
M$1181 \$2625 \$2388 \$2387 VDD pfet_03v3 L=0.28U W=0.36U AS=0.1278P AD=0.0567P
+ PS=1.07U PD=0.675U
M$1182 VDD WECLK \$2625 VDD pfet_03v3 L=0.28U W=0.36U AS=0.0567P AD=0.1584P
+ PS=0.675U PD=1.6U
M$1183 \$2388 \$2387 VDD VDD pfet_03v3 L=0.28U W=0.36U AS=0.1764P AD=0.1584P
+ PS=1.26U PD=1.6U
M$1184 \$2361 \$2387 VDD VDD pfet_03v3 L=0.28U W=0.72U AS=0.1764P AD=0.36P
+ PS=1.26U PD=2.44U
M$1185 \$2482 RA VDD VDD pfet_03v3 L=0.28U W=0.72U AS=0.3312P AD=0.3888P
+ PS=2.36U PD=2.52U
M$1186 \$2361 \$2482 QAb VDD pfet_03v3 L=0.28U W=0.36U AS=0.1584P AD=0.1152P
+ PS=1.6U PD=1U
M$1187 QBb \$2483 \$2361 VDD pfet_03v3 L=0.28U W=0.36U AS=0.1152P AD=0.1584P
+ PS=1U PD=1.6U
M$1188 VDD RB \$2483 VDD pfet_03v3 L=0.28U W=0.72U AS=0.3708P AD=0.3168P
+ PS=2.47U PD=2.32U
M$1189 \$2389 D|Q VDD VDD pfet_03v3 L=0.28U W=0.72U AS=0.3168P AD=0.2097P
+ PS=2.32U PD=1.38U
M$1190 \$2390 WECLKb \$2389 VDD pfet_03v3 L=0.28U W=0.36U AS=0.2097P AD=0.1278P
+ PS=1.38U PD=1.07U
M$1191 \$2636 \$2391 \$2390 VDD pfet_03v3 L=0.28U W=0.36U AS=0.1278P AD=0.0567P
+ PS=1.07U PD=0.675U
M$1192 VDD WECLK \$2636 VDD pfet_03v3 L=0.28U W=0.36U AS=0.0567P AD=0.1584P
+ PS=0.675U PD=1.6U
M$1193 \$2391 \$2390 VDD VDD pfet_03v3 L=0.28U W=0.36U AS=0.1764P AD=0.1584P
+ PS=1.26U PD=1.6U
M$1194 \$2362 \$2390 VDD VDD pfet_03v3 L=0.28U W=0.72U AS=0.1764P AD=0.36P
+ PS=1.26U PD=2.44U
M$1195 \$2484 RA VDD VDD pfet_03v3 L=0.28U W=0.72U AS=0.3312P AD=0.3888P
+ PS=2.36U PD=2.52U
M$1196 \$2362 \$2484 QAb VDD pfet_03v3 L=0.28U W=0.36U AS=0.1584P AD=0.1152P
+ PS=1.6U PD=1U
M$1197 QBb \$2485 \$2362 VDD pfet_03v3 L=0.28U W=0.36U AS=0.1152P AD=0.1584P
+ PS=1U PD=1.6U
M$1198 VDD RB \$2485 VDD pfet_03v3 L=0.28U W=0.72U AS=0.3708P AD=0.3168P
+ PS=2.47U PD=2.32U
M$1199 \$2392 D|Q VDD VDD pfet_03v3 L=0.28U W=0.72U AS=0.3168P AD=0.2097P
+ PS=2.32U PD=1.38U
M$1200 \$2393 WECLKb \$2392 VDD pfet_03v3 L=0.28U W=0.36U AS=0.2097P AD=0.1278P
+ PS=1.38U PD=1.07U
M$1201 \$2644 \$2394 \$2393 VDD pfet_03v3 L=0.28U W=0.36U AS=0.1278P AD=0.0567P
+ PS=1.07U PD=0.675U
M$1202 VDD WECLK \$2644 VDD pfet_03v3 L=0.28U W=0.36U AS=0.0567P AD=0.1584P
+ PS=0.675U PD=1.6U
M$1203 \$2394 \$2393 VDD VDD pfet_03v3 L=0.28U W=0.36U AS=0.1764P AD=0.1584P
+ PS=1.26U PD=1.6U
M$1204 \$2363 \$2393 VDD VDD pfet_03v3 L=0.28U W=0.72U AS=0.1764P AD=0.36P
+ PS=1.26U PD=2.44U
M$1205 \$2486 RA VDD VDD pfet_03v3 L=0.28U W=0.72U AS=0.3312P AD=0.3888P
+ PS=2.36U PD=2.52U
M$1206 \$2363 \$2486 QAb VDD pfet_03v3 L=0.28U W=0.36U AS=0.1584P AD=0.1152P
+ PS=1.6U PD=1U
M$1207 QBb \$2487 \$2363 VDD pfet_03v3 L=0.28U W=0.36U AS=0.1152P AD=0.1584P
+ PS=1U PD=1.6U
M$1208 VDD RB \$2487 VDD pfet_03v3 L=0.28U W=0.72U AS=0.3708P AD=0.3168P
+ PS=2.47U PD=2.32U
M$1209 \$2395 D|Q VDD VDD pfet_03v3 L=0.28U W=0.72U AS=0.3168P AD=0.2097P
+ PS=2.32U PD=1.38U
M$1210 \$2396 WECLKb \$2395 VDD pfet_03v3 L=0.28U W=0.36U AS=0.2097P AD=0.1278P
+ PS=1.38U PD=1.07U
M$1211 \$2652 \$2397 \$2396 VDD pfet_03v3 L=0.28U W=0.36U AS=0.1278P AD=0.0567P
+ PS=1.07U PD=0.675U
M$1212 VDD WECLK \$2652 VDD pfet_03v3 L=0.28U W=0.36U AS=0.0567P AD=0.1584P
+ PS=0.675U PD=1.6U
M$1213 \$2397 \$2396 VDD VDD pfet_03v3 L=0.28U W=0.36U AS=0.1764P AD=0.1584P
+ PS=1.26U PD=1.6U
M$1214 \$2364 \$2396 VDD VDD pfet_03v3 L=0.28U W=0.72U AS=0.1764P AD=0.36P
+ PS=1.26U PD=2.44U
M$1215 \$2488 RA VDD VDD pfet_03v3 L=0.28U W=0.72U AS=0.3312P AD=0.3888P
+ PS=2.36U PD=2.52U
M$1216 \$2364 \$2488 QAb VDD pfet_03v3 L=0.28U W=0.36U AS=0.1584P AD=0.1152P
+ PS=1.6U PD=1U
M$1217 QBb \$2489 \$2364 VDD pfet_03v3 L=0.28U W=0.36U AS=0.1152P AD=0.1584P
+ PS=1U PD=1.6U
M$1218 VDD RB \$2489 VDD pfet_03v3 L=0.28U W=0.72U AS=0.3708P AD=0.3168P
+ PS=2.47U PD=2.32U
M$1219 \$2398 D|Q VDD VDD pfet_03v3 L=0.28U W=0.72U AS=0.3168P AD=0.2097P
+ PS=2.32U PD=1.38U
M$1220 \$2399 WECLKb \$2398 VDD pfet_03v3 L=0.28U W=0.36U AS=0.2097P AD=0.1278P
+ PS=1.38U PD=1.07U
M$1221 \$2661 \$2400 \$2399 VDD pfet_03v3 L=0.28U W=0.36U AS=0.1278P AD=0.0567P
+ PS=1.07U PD=0.675U
M$1222 VDD WECLK \$2661 VDD pfet_03v3 L=0.28U W=0.36U AS=0.0567P AD=0.1584P
+ PS=0.675U PD=1.6U
M$1223 \$2400 \$2399 VDD VDD pfet_03v3 L=0.28U W=0.36U AS=0.1764P AD=0.1584P
+ PS=1.26U PD=1.6U
M$1224 \$2365 \$2399 VDD VDD pfet_03v3 L=0.28U W=0.72U AS=0.1764P AD=0.36P
+ PS=1.26U PD=2.44U
M$1225 \$2490 RA VDD VDD pfet_03v3 L=0.28U W=0.72U AS=0.3312P AD=0.3888P
+ PS=2.36U PD=2.52U
M$1226 \$2365 \$2490 QAb VDD pfet_03v3 L=0.28U W=0.36U AS=0.1584P AD=0.1152P
+ PS=1.6U PD=1U
M$1227 QBb \$2491 \$2365 VDD pfet_03v3 L=0.28U W=0.36U AS=0.1152P AD=0.1584P
+ PS=1U PD=1.6U
M$1228 VDD RB \$2491 VDD pfet_03v3 L=0.28U W=0.72U AS=0.3708P AD=0.3168P
+ PS=2.47U PD=2.32U
M$1229 \$2401 D|Q VDD VDD pfet_03v3 L=0.28U W=0.72U AS=0.3168P AD=0.2097P
+ PS=2.32U PD=1.38U
M$1230 \$2402 WECLKb \$2401 VDD pfet_03v3 L=0.28U W=0.36U AS=0.2097P AD=0.1278P
+ PS=1.38U PD=1.07U
M$1231 \$2670 \$2403 \$2402 VDD pfet_03v3 L=0.28U W=0.36U AS=0.1278P AD=0.0567P
+ PS=1.07U PD=0.675U
M$1232 VDD WECLK \$2670 VDD pfet_03v3 L=0.28U W=0.36U AS=0.0567P AD=0.1584P
+ PS=0.675U PD=1.6U
M$1233 \$2403 \$2402 VDD VDD pfet_03v3 L=0.28U W=0.36U AS=0.1764P AD=0.1584P
+ PS=1.26U PD=1.6U
M$1234 \$2366 \$2402 VDD VDD pfet_03v3 L=0.28U W=0.72U AS=0.1764P AD=0.36P
+ PS=1.26U PD=2.44U
M$1235 \$2492 RA VDD VDD pfet_03v3 L=0.28U W=0.72U AS=0.3312P AD=0.3888P
+ PS=2.36U PD=2.52U
M$1236 \$2366 \$2492 QAb VDD pfet_03v3 L=0.28U W=0.36U AS=0.1584P AD=0.1152P
+ PS=1.6U PD=1U
M$1237 QBb \$2493 \$2366 VDD pfet_03v3 L=0.28U W=0.36U AS=0.1152P AD=0.1584P
+ PS=1U PD=1.6U
M$1238 VDD RB \$2493 VDD pfet_03v3 L=0.28U W=0.72U AS=0.3708P AD=0.3168P
+ PS=2.47U PD=2.32U
M$1239 \$2404 D|Q VDD VDD pfet_03v3 L=0.28U W=0.72U AS=0.3168P AD=0.2097P
+ PS=2.32U PD=1.38U
M$1240 \$2405 WECLKb \$2404 VDD pfet_03v3 L=0.28U W=0.36U AS=0.2097P AD=0.1278P
+ PS=1.38U PD=1.07U
M$1241 \$2679 \$2406 \$2405 VDD pfet_03v3 L=0.28U W=0.36U AS=0.1278P AD=0.0567P
+ PS=1.07U PD=0.675U
M$1242 VDD WECLK \$2679 VDD pfet_03v3 L=0.28U W=0.36U AS=0.0567P AD=0.1584P
+ PS=0.675U PD=1.6U
M$1243 \$2406 \$2405 VDD VDD pfet_03v3 L=0.28U W=0.36U AS=0.1764P AD=0.1584P
+ PS=1.26U PD=1.6U
M$1244 \$2367 \$2405 VDD VDD pfet_03v3 L=0.28U W=0.72U AS=0.1764P AD=0.36P
+ PS=1.26U PD=2.44U
M$1245 \$2494 RA VDD VDD pfet_03v3 L=0.28U W=0.72U AS=0.3312P AD=0.3888P
+ PS=2.36U PD=2.52U
M$1246 \$2367 \$2494 QAb VDD pfet_03v3 L=0.28U W=0.36U AS=0.1584P AD=0.1152P
+ PS=1.6U PD=1U
M$1247 QBb \$2495 \$2367 VDD pfet_03v3 L=0.28U W=0.36U AS=0.1152P AD=0.1584P
+ PS=1U PD=1.6U
M$1248 VDD RB \$2495 VDD pfet_03v3 L=0.28U W=0.72U AS=0.3708P AD=0.3168P
+ PS=2.47U PD=2.32U
M$1249 \$2407 D|Q VDD VDD pfet_03v3 L=0.28U W=0.72U AS=0.3168P AD=0.2097P
+ PS=2.32U PD=1.38U
M$1250 \$2408 WECLKb \$2407 VDD pfet_03v3 L=0.28U W=0.36U AS=0.2097P AD=0.1278P
+ PS=1.38U PD=1.07U
M$1251 \$2688 \$2409 \$2408 VDD pfet_03v3 L=0.28U W=0.36U AS=0.1278P AD=0.0567P
+ PS=1.07U PD=0.675U
M$1252 VDD WECLK \$2688 VDD pfet_03v3 L=0.28U W=0.36U AS=0.0567P AD=0.1584P
+ PS=0.675U PD=1.6U
M$1253 \$2409 \$2408 VDD VDD pfet_03v3 L=0.28U W=0.36U AS=0.1764P AD=0.1584P
+ PS=1.26U PD=1.6U
M$1254 \$2368 \$2408 VDD VDD pfet_03v3 L=0.28U W=0.72U AS=0.1764P AD=0.36P
+ PS=1.26U PD=2.44U
M$1255 \$2496 RA VDD VDD pfet_03v3 L=0.28U W=0.72U AS=0.3312P AD=0.3888P
+ PS=2.36U PD=2.52U
M$1256 \$2368 \$2496 QAb VDD pfet_03v3 L=0.28U W=0.36U AS=0.1584P AD=0.1152P
+ PS=1.6U PD=1U
M$1257 QBb \$2497 \$2368 VDD pfet_03v3 L=0.28U W=0.36U AS=0.1152P AD=0.1584P
+ PS=1U PD=1.6U
M$1258 VDD RB \$2497 VDD pfet_03v3 L=0.28U W=0.72U AS=0.3708P AD=0.3168P
+ PS=2.47U PD=2.32U
M$1259 \$2410 D|Q VDD VDD pfet_03v3 L=0.28U W=0.72U AS=0.3168P AD=0.2097P
+ PS=2.32U PD=1.38U
M$1260 \$2411 WECLKb \$2410 VDD pfet_03v3 L=0.28U W=0.36U AS=0.2097P AD=0.1278P
+ PS=1.38U PD=1.07U
M$1261 \$2695 \$2412 \$2411 VDD pfet_03v3 L=0.28U W=0.36U AS=0.1278P AD=0.0567P
+ PS=1.07U PD=0.675U
M$1262 VDD WECLK \$2695 VDD pfet_03v3 L=0.28U W=0.36U AS=0.0567P AD=0.1584P
+ PS=0.675U PD=1.6U
M$1263 \$2412 \$2411 VDD VDD pfet_03v3 L=0.28U W=0.36U AS=0.1764P AD=0.1584P
+ PS=1.26U PD=1.6U
M$1264 \$2369 \$2411 VDD VDD pfet_03v3 L=0.28U W=0.72U AS=0.1764P AD=0.36P
+ PS=1.26U PD=2.44U
M$1265 \$2498 RA VDD VDD pfet_03v3 L=0.28U W=0.72U AS=0.3312P AD=0.3888P
+ PS=2.36U PD=2.52U
M$1266 \$2369 \$2498 QAb VDD pfet_03v3 L=0.28U W=0.36U AS=0.1584P AD=0.1152P
+ PS=1.6U PD=1U
M$1267 QBb \$2499 \$2369 VDD pfet_03v3 L=0.28U W=0.36U AS=0.1152P AD=0.1584P
+ PS=1U PD=1.6U
M$1268 VDD RB \$2499 VDD pfet_03v3 L=0.28U W=0.72U AS=0.3708P AD=0.3168P
+ PS=2.47U PD=2.32U
M$1269 \$2413 D|Q VDD VDD pfet_03v3 L=0.28U W=0.72U AS=0.3168P AD=0.2097P
+ PS=2.32U PD=1.38U
M$1270 \$2414 WECLKb \$2413 VDD pfet_03v3 L=0.28U W=0.36U AS=0.2097P AD=0.1278P
+ PS=1.38U PD=1.07U
M$1271 \$2683 \$2415 \$2414 VDD pfet_03v3 L=0.28U W=0.36U AS=0.1278P AD=0.0567P
+ PS=1.07U PD=0.675U
M$1272 VDD WECLK \$2683 VDD pfet_03v3 L=0.28U W=0.36U AS=0.0567P AD=0.1584P
+ PS=0.675U PD=1.6U
M$1273 \$2415 \$2414 VDD VDD pfet_03v3 L=0.28U W=0.36U AS=0.1764P AD=0.1584P
+ PS=1.26U PD=1.6U
M$1274 \$2370 \$2414 VDD VDD pfet_03v3 L=0.28U W=0.72U AS=0.1764P AD=0.36P
+ PS=1.26U PD=2.44U
M$1275 \$2500 RA VDD VDD pfet_03v3 L=0.28U W=0.72U AS=0.3312P AD=0.3888P
+ PS=2.36U PD=2.52U
M$1276 \$2370 \$2500 QAb VDD pfet_03v3 L=0.28U W=0.36U AS=0.1584P AD=0.1152P
+ PS=1.6U PD=1U
M$1277 QBb \$2501 \$2370 VDD pfet_03v3 L=0.28U W=0.36U AS=0.1152P AD=0.1584P
+ PS=1U PD=1.6U
M$1278 VDD RB \$2501 VDD pfet_03v3 L=0.28U W=0.72U AS=0.3708P AD=0.3168P
+ PS=2.47U PD=2.32U
M$1279 \$2416 D|Q VDD VDD pfet_03v3 L=0.28U W=0.72U AS=0.3168P AD=0.2097P
+ PS=2.32U PD=1.38U
M$1280 \$2417 WECLKb \$2416 VDD pfet_03v3 L=0.28U W=0.36U AS=0.2097P AD=0.1278P
+ PS=1.38U PD=1.07U
M$1281 \$2657 \$2418 \$2417 VDD pfet_03v3 L=0.28U W=0.36U AS=0.1278P AD=0.0567P
+ PS=1.07U PD=0.675U
M$1282 VDD WECLK \$2657 VDD pfet_03v3 L=0.28U W=0.36U AS=0.0567P AD=0.1584P
+ PS=0.675U PD=1.6U
M$1283 \$2418 \$2417 VDD VDD pfet_03v3 L=0.28U W=0.36U AS=0.1764P AD=0.1584P
+ PS=1.26U PD=1.6U
M$1284 \$2371 \$2417 VDD VDD pfet_03v3 L=0.28U W=0.72U AS=0.1764P AD=0.36P
+ PS=1.26U PD=2.44U
M$1285 \$2502 RA VDD VDD pfet_03v3 L=0.28U W=0.72U AS=0.3312P AD=0.3888P
+ PS=2.36U PD=2.52U
M$1286 \$2371 \$2502 QAb VDD pfet_03v3 L=0.28U W=0.36U AS=0.1584P AD=0.1152P
+ PS=1.6U PD=1U
M$1287 QBb \$2503 \$2371 VDD pfet_03v3 L=0.28U W=0.36U AS=0.1152P AD=0.1584P
+ PS=1U PD=1.6U
M$1288 VDD RB \$2503 VDD pfet_03v3 L=0.28U W=0.72U AS=0.3708P AD=0.3168P
+ PS=2.47U PD=2.32U
M$1289 \$2419 D|Q VDD VDD pfet_03v3 L=0.28U W=0.72U AS=0.3168P AD=0.2097P
+ PS=2.32U PD=1.38U
M$1290 \$2420 WECLKb \$2419 VDD pfet_03v3 L=0.28U W=0.36U AS=0.2097P AD=0.1278P
+ PS=1.38U PD=1.07U
M$1291 \$2637 \$2421 \$2420 VDD pfet_03v3 L=0.28U W=0.36U AS=0.1278P AD=0.0567P
+ PS=1.07U PD=0.675U
M$1292 VDD WECLK \$2637 VDD pfet_03v3 L=0.28U W=0.36U AS=0.0567P AD=0.1584P
+ PS=0.675U PD=1.6U
M$1293 \$2421 \$2420 VDD VDD pfet_03v3 L=0.28U W=0.36U AS=0.1764P AD=0.1584P
+ PS=1.26U PD=1.6U
M$1294 \$2372 \$2420 VDD VDD pfet_03v3 L=0.28U W=0.72U AS=0.1764P AD=0.36P
+ PS=1.26U PD=2.44U
M$1295 \$2504 RA VDD VDD pfet_03v3 L=0.28U W=0.72U AS=0.3312P AD=0.3888P
+ PS=2.36U PD=2.52U
M$1296 \$2372 \$2504 QAb VDD pfet_03v3 L=0.28U W=0.36U AS=0.1584P AD=0.1152P
+ PS=1.6U PD=1U
M$1297 QBb \$2505 \$2372 VDD pfet_03v3 L=0.28U W=0.36U AS=0.1152P AD=0.1584P
+ PS=1U PD=1.6U
M$1298 VDD RB \$2505 VDD pfet_03v3 L=0.28U W=0.72U AS=0.3708P AD=0.3168P
+ PS=2.47U PD=2.32U
M$1299 \$2422 D|Q VDD VDD pfet_03v3 L=0.28U W=0.72U AS=0.3168P AD=0.2097P
+ PS=2.32U PD=1.38U
M$1300 \$2423 WECLKb \$2422 VDD pfet_03v3 L=0.28U W=0.36U AS=0.2097P AD=0.1278P
+ PS=1.38U PD=1.07U
M$1301 \$2609 \$2424 \$2423 VDD pfet_03v3 L=0.28U W=0.36U AS=0.1278P AD=0.0567P
+ PS=1.07U PD=0.675U
M$1302 VDD WECLK \$2609 VDD pfet_03v3 L=0.28U W=0.36U AS=0.0567P AD=0.1584P
+ PS=0.675U PD=1.6U
M$1303 \$2424 \$2423 VDD VDD pfet_03v3 L=0.28U W=0.36U AS=0.1764P AD=0.1584P
+ PS=1.26U PD=1.6U
M$1304 \$2373 \$2423 VDD VDD pfet_03v3 L=0.28U W=0.72U AS=0.1764P AD=0.36P
+ PS=1.26U PD=2.44U
M$1305 \$2506 RA VDD VDD pfet_03v3 L=0.28U W=0.72U AS=0.3312P AD=0.3888P
+ PS=2.36U PD=2.52U
M$1306 \$2373 \$2506 QAb VDD pfet_03v3 L=0.28U W=0.36U AS=0.1584P AD=0.1152P
+ PS=1.6U PD=1U
M$1307 QBb \$2507 \$2373 VDD pfet_03v3 L=0.28U W=0.36U AS=0.1152P AD=0.1584P
+ PS=1U PD=1.6U
M$1308 VDD RB \$2507 VDD pfet_03v3 L=0.28U W=0.72U AS=0.3708P AD=0.3168P
+ PS=2.47U PD=2.32U
M$1309 \$2700 WE VDD VDD pfet_03v3 L=0.28U W=0.72U AS=0.3168P AD=0.1872P
+ PS=2.32U PD=1.24U
M$1310 VDD CLK \$2700 VDD pfet_03v3 L=0.28U W=0.72U AS=0.1872P AD=0.3168P
+ PS=1.24U PD=2.32U
M$1311 WECLK \$2700 VDD VDD pfet_03v3 L=0.28U W=2.54U AS=0.889P AD=0.6688P
+ PS=5.21U PD=3.65U
M$1315 \$2706 WECLKb \$2705 VDD pfet_03v3 L=0.28U W=0.36U AS=0.2097P AD=0.1278P
+ PS=1.38U PD=1.07U
M$1316 \$2808 \$2707 \$2706 VDD pfet_03v3 L=0.28U W=0.36U AS=0.1278P AD=0.0567P
+ PS=1.07U PD=0.675U
M$1317 VDD WECLK \$2808 VDD pfet_03v3 L=0.28U W=0.36U AS=0.0567P AD=0.1584P
+ PS=0.675U PD=1.6U
M$1318 \$2705 D|Q VDD VDD pfet_03v3 L=0.28U W=0.72U AS=0.3168P AD=0.2097P
+ PS=2.32U PD=1.38U
M$1319 VDD \$2706 \$2707 VDD pfet_03v3 L=0.28U W=0.36U AS=0.1584P AD=0.1764P
+ PS=1.6U PD=1.26U
M$1320 \$2708 \$2706 VDD VDD pfet_03v3 L=0.28U W=0.72U AS=0.1764P AD=0.36P
+ PS=1.26U PD=2.44U
M$1321 \$2709 RA VDD VDD pfet_03v3 L=0.28U W=0.72U AS=0.3312P AD=0.3888P
+ PS=2.36U PD=2.52U
M$1322 \$2708 \$2709 QAb VDD pfet_03v3 L=0.28U W=0.36U AS=0.1584P AD=0.1152P
+ PS=1.6U PD=1U
M$1323 QBb \$2710 \$2708 VDD pfet_03v3 L=0.28U W=0.36U AS=0.1152P AD=0.1584P
+ PS=1U PD=1.6U
M$1324 VDD RB \$2710 VDD pfet_03v3 L=0.28U W=0.72U AS=0.3708P AD=0.3168P
+ PS=2.47U PD=2.32U
M$1325 \$2713 WECLKb \$2712 VDD pfet_03v3 L=0.28U W=0.36U AS=0.2097P AD=0.1278P
+ PS=1.38U PD=1.07U
M$1326 \$2817 \$2714 \$2713 VDD pfet_03v3 L=0.28U W=0.36U AS=0.1278P AD=0.0567P
+ PS=1.07U PD=0.675U
M$1327 VDD WECLK \$2817 VDD pfet_03v3 L=0.28U W=0.36U AS=0.0567P AD=0.1584P
+ PS=0.675U PD=1.6U
M$1328 \$2712 D|Q VDD VDD pfet_03v3 L=0.28U W=0.72U AS=0.3168P AD=0.2097P
+ PS=2.32U PD=1.38U
M$1329 VDD \$2713 \$2714 VDD pfet_03v3 L=0.28U W=0.36U AS=0.1584P AD=0.1764P
+ PS=1.6U PD=1.26U
M$1330 \$2715 \$2713 VDD VDD pfet_03v3 L=0.28U W=0.72U AS=0.1764P AD=0.36P
+ PS=1.26U PD=2.44U
M$1331 \$2716 RA VDD VDD pfet_03v3 L=0.28U W=0.72U AS=0.3312P AD=0.3888P
+ PS=2.36U PD=2.52U
M$1332 \$2715 \$2716 QAb VDD pfet_03v3 L=0.28U W=0.36U AS=0.1584P AD=0.1152P
+ PS=1.6U PD=1U
M$1333 QBb \$2717 \$2715 VDD pfet_03v3 L=0.28U W=0.36U AS=0.1152P AD=0.1584P
+ PS=1U PD=1.6U
M$1334 VDD RB \$2717 VDD pfet_03v3 L=0.28U W=0.72U AS=0.3708P AD=0.3168P
+ PS=2.47U PD=2.32U
M$1335 \$2719 WECLKb \$2718 VDD pfet_03v3 L=0.28U W=0.36U AS=0.2097P AD=0.1278P
+ PS=1.38U PD=1.07U
M$1336 \$2827 \$2720 \$2719 VDD pfet_03v3 L=0.28U W=0.36U AS=0.1278P AD=0.0567P
+ PS=1.07U PD=0.675U
M$1337 VDD WECLK \$2827 VDD pfet_03v3 L=0.28U W=0.36U AS=0.0567P AD=0.1584P
+ PS=0.675U PD=1.6U
M$1338 \$2718 D|Q VDD VDD pfet_03v3 L=0.28U W=0.72U AS=0.3168P AD=0.2097P
+ PS=2.32U PD=1.38U
M$1339 VDD \$2719 \$2720 VDD pfet_03v3 L=0.28U W=0.36U AS=0.1584P AD=0.1764P
+ PS=1.6U PD=1.26U
M$1340 \$2721 \$2719 VDD VDD pfet_03v3 L=0.28U W=0.72U AS=0.1764P AD=0.36P
+ PS=1.26U PD=2.44U
M$1341 \$2722 RA VDD VDD pfet_03v3 L=0.28U W=0.72U AS=0.3312P AD=0.3888P
+ PS=2.36U PD=2.52U
M$1342 \$2721 \$2722 QAb VDD pfet_03v3 L=0.28U W=0.36U AS=0.1584P AD=0.1152P
+ PS=1.6U PD=1U
M$1343 QBb \$2723 \$2721 VDD pfet_03v3 L=0.28U W=0.36U AS=0.1152P AD=0.1584P
+ PS=1U PD=1.6U
M$1344 VDD RB \$2723 VDD pfet_03v3 L=0.28U W=0.72U AS=0.3708P AD=0.3168P
+ PS=2.47U PD=2.32U
M$1345 \$2725 WECLKb \$2724 VDD pfet_03v3 L=0.28U W=0.36U AS=0.2097P AD=0.1278P
+ PS=1.38U PD=1.07U
M$1346 \$2838 \$2726 \$2725 VDD pfet_03v3 L=0.28U W=0.36U AS=0.1278P AD=0.0567P
+ PS=1.07U PD=0.675U
M$1347 VDD WECLK \$2838 VDD pfet_03v3 L=0.28U W=0.36U AS=0.0567P AD=0.1584P
+ PS=0.675U PD=1.6U
M$1348 \$2724 D|Q VDD VDD pfet_03v3 L=0.28U W=0.72U AS=0.3168P AD=0.2097P
+ PS=2.32U PD=1.38U
M$1349 VDD \$2725 \$2726 VDD pfet_03v3 L=0.28U W=0.36U AS=0.1584P AD=0.1764P
+ PS=1.6U PD=1.26U
M$1350 \$2727 \$2725 VDD VDD pfet_03v3 L=0.28U W=0.72U AS=0.1764P AD=0.36P
+ PS=1.26U PD=2.44U
M$1351 \$2728 RA VDD VDD pfet_03v3 L=0.28U W=0.72U AS=0.3312P AD=0.3888P
+ PS=2.36U PD=2.52U
M$1352 \$2727 \$2728 QAb VDD pfet_03v3 L=0.28U W=0.36U AS=0.1584P AD=0.1152P
+ PS=1.6U PD=1U
M$1353 QBb \$2729 \$2727 VDD pfet_03v3 L=0.28U W=0.36U AS=0.1152P AD=0.1584P
+ PS=1U PD=1.6U
M$1354 VDD RB \$2729 VDD pfet_03v3 L=0.28U W=0.72U AS=0.3708P AD=0.3168P
+ PS=2.47U PD=2.32U
M$1355 \$2731 WECLKb \$2730 VDD pfet_03v3 L=0.28U W=0.36U AS=0.2097P AD=0.1278P
+ PS=1.38U PD=1.07U
M$1356 \$2850 \$2732 \$2731 VDD pfet_03v3 L=0.28U W=0.36U AS=0.1278P AD=0.0567P
+ PS=1.07U PD=0.675U
M$1357 VDD WECLK \$2850 VDD pfet_03v3 L=0.28U W=0.36U AS=0.0567P AD=0.1584P
+ PS=0.675U PD=1.6U
M$1358 \$2730 D|Q VDD VDD pfet_03v3 L=0.28U W=0.72U AS=0.3168P AD=0.2097P
+ PS=2.32U PD=1.38U
M$1359 VDD \$2731 \$2732 VDD pfet_03v3 L=0.28U W=0.36U AS=0.1584P AD=0.1764P
+ PS=1.6U PD=1.26U
M$1360 \$2733 \$2731 VDD VDD pfet_03v3 L=0.28U W=0.72U AS=0.1764P AD=0.36P
+ PS=1.26U PD=2.44U
M$1361 \$2734 RA VDD VDD pfet_03v3 L=0.28U W=0.72U AS=0.3312P AD=0.3888P
+ PS=2.36U PD=2.52U
M$1362 \$2733 \$2734 QAb VDD pfet_03v3 L=0.28U W=0.36U AS=0.1584P AD=0.1152P
+ PS=1.6U PD=1U
M$1363 QBb \$2735 \$2733 VDD pfet_03v3 L=0.28U W=0.36U AS=0.1152P AD=0.1584P
+ PS=1U PD=1.6U
M$1364 VDD RB \$2735 VDD pfet_03v3 L=0.28U W=0.72U AS=0.3708P AD=0.3168P
+ PS=2.47U PD=2.32U
M$1365 \$2737 WECLKb \$2736 VDD pfet_03v3 L=0.28U W=0.36U AS=0.2097P AD=0.1278P
+ PS=1.38U PD=1.07U
M$1366 \$2859 \$2738 \$2737 VDD pfet_03v3 L=0.28U W=0.36U AS=0.1278P AD=0.0567P
+ PS=1.07U PD=0.675U
M$1367 VDD WECLK \$2859 VDD pfet_03v3 L=0.28U W=0.36U AS=0.0567P AD=0.1584P
+ PS=0.675U PD=1.6U
M$1368 \$2736 D|Q VDD VDD pfet_03v3 L=0.28U W=0.72U AS=0.3168P AD=0.2097P
+ PS=2.32U PD=1.38U
M$1369 VDD \$2737 \$2738 VDD pfet_03v3 L=0.28U W=0.36U AS=0.1584P AD=0.1764P
+ PS=1.6U PD=1.26U
M$1370 \$2739 \$2737 VDD VDD pfet_03v3 L=0.28U W=0.72U AS=0.1764P AD=0.36P
+ PS=1.26U PD=2.44U
M$1371 \$2740 RA VDD VDD pfet_03v3 L=0.28U W=0.72U AS=0.3312P AD=0.3888P
+ PS=2.36U PD=2.52U
M$1372 \$2739 \$2740 QAb VDD pfet_03v3 L=0.28U W=0.36U AS=0.1584P AD=0.1152P
+ PS=1.6U PD=1U
M$1373 QBb \$2741 \$2739 VDD pfet_03v3 L=0.28U W=0.36U AS=0.1152P AD=0.1584P
+ PS=1U PD=1.6U
M$1374 VDD RB \$2741 VDD pfet_03v3 L=0.28U W=0.72U AS=0.3708P AD=0.3168P
+ PS=2.47U PD=2.32U
M$1375 \$2743 WECLKb \$2742 VDD pfet_03v3 L=0.28U W=0.36U AS=0.2097P AD=0.1278P
+ PS=1.38U PD=1.07U
M$1376 \$2868 \$2744 \$2743 VDD pfet_03v3 L=0.28U W=0.36U AS=0.1278P AD=0.0567P
+ PS=1.07U PD=0.675U
M$1377 VDD WECLK \$2868 VDD pfet_03v3 L=0.28U W=0.36U AS=0.0567P AD=0.1584P
+ PS=0.675U PD=1.6U
M$1378 \$2742 D|Q VDD VDD pfet_03v3 L=0.28U W=0.72U AS=0.3168P AD=0.2097P
+ PS=2.32U PD=1.38U
M$1379 VDD \$2743 \$2744 VDD pfet_03v3 L=0.28U W=0.36U AS=0.1584P AD=0.1764P
+ PS=1.6U PD=1.26U
M$1380 \$2745 \$2743 VDD VDD pfet_03v3 L=0.28U W=0.72U AS=0.1764P AD=0.36P
+ PS=1.26U PD=2.44U
M$1381 \$2746 RA VDD VDD pfet_03v3 L=0.28U W=0.72U AS=0.3312P AD=0.3888P
+ PS=2.36U PD=2.52U
M$1382 \$2745 \$2746 QAb VDD pfet_03v3 L=0.28U W=0.36U AS=0.1584P AD=0.1152P
+ PS=1.6U PD=1U
M$1383 QBb \$2747 \$2745 VDD pfet_03v3 L=0.28U W=0.36U AS=0.1152P AD=0.1584P
+ PS=1U PD=1.6U
M$1384 VDD RB \$2747 VDD pfet_03v3 L=0.28U W=0.72U AS=0.3708P AD=0.3168P
+ PS=2.47U PD=2.32U
M$1385 \$2749 WECLKb \$2748 VDD pfet_03v3 L=0.28U W=0.36U AS=0.2097P AD=0.1278P
+ PS=1.38U PD=1.07U
M$1386 \$2880 \$2750 \$2749 VDD pfet_03v3 L=0.28U W=0.36U AS=0.1278P AD=0.0567P
+ PS=1.07U PD=0.675U
M$1387 VDD WECLK \$2880 VDD pfet_03v3 L=0.28U W=0.36U AS=0.0567P AD=0.1584P
+ PS=0.675U PD=1.6U
M$1388 \$2748 D|Q VDD VDD pfet_03v3 L=0.28U W=0.72U AS=0.3168P AD=0.2097P
+ PS=2.32U PD=1.38U
M$1389 VDD \$2749 \$2750 VDD pfet_03v3 L=0.28U W=0.36U AS=0.1584P AD=0.1764P
+ PS=1.6U PD=1.26U
M$1390 \$2751 \$2749 VDD VDD pfet_03v3 L=0.28U W=0.72U AS=0.1764P AD=0.36P
+ PS=1.26U PD=2.44U
M$1391 \$2752 RA VDD VDD pfet_03v3 L=0.28U W=0.72U AS=0.3312P AD=0.3888P
+ PS=2.36U PD=2.52U
M$1392 \$2751 \$2752 QAb VDD pfet_03v3 L=0.28U W=0.36U AS=0.1584P AD=0.1152P
+ PS=1.6U PD=1U
M$1393 QBb \$2753 \$2751 VDD pfet_03v3 L=0.28U W=0.36U AS=0.1152P AD=0.1584P
+ PS=1U PD=1.6U
M$1394 VDD RB \$2753 VDD pfet_03v3 L=0.28U W=0.72U AS=0.3708P AD=0.3168P
+ PS=2.47U PD=2.32U
M$1395 \$2755 WECLKb \$2754 VDD pfet_03v3 L=0.28U W=0.36U AS=0.2097P AD=0.1278P
+ PS=1.38U PD=1.07U
M$1396 \$2891 \$2756 \$2755 VDD pfet_03v3 L=0.28U W=0.36U AS=0.1278P AD=0.0567P
+ PS=1.07U PD=0.675U
M$1397 VDD WECLK \$2891 VDD pfet_03v3 L=0.28U W=0.36U AS=0.0567P AD=0.1584P
+ PS=0.675U PD=1.6U
M$1398 \$2754 D|Q VDD VDD pfet_03v3 L=0.28U W=0.72U AS=0.3168P AD=0.2097P
+ PS=2.32U PD=1.38U
M$1399 VDD \$2755 \$2756 VDD pfet_03v3 L=0.28U W=0.36U AS=0.1584P AD=0.1764P
+ PS=1.6U PD=1.26U
M$1400 \$2757 \$2755 VDD VDD pfet_03v3 L=0.28U W=0.72U AS=0.1764P AD=0.36P
+ PS=1.26U PD=2.44U
M$1401 \$2758 RA VDD VDD pfet_03v3 L=0.28U W=0.72U AS=0.3312P AD=0.3888P
+ PS=2.36U PD=2.52U
M$1402 \$2757 \$2758 QAb VDD pfet_03v3 L=0.28U W=0.36U AS=0.1584P AD=0.1152P
+ PS=1.6U PD=1U
M$1403 QBb \$2759 \$2757 VDD pfet_03v3 L=0.28U W=0.36U AS=0.1152P AD=0.1584P
+ PS=1U PD=1.6U
M$1404 VDD RB \$2759 VDD pfet_03v3 L=0.28U W=0.72U AS=0.3708P AD=0.3168P
+ PS=2.47U PD=2.32U
M$1405 \$2761 WECLKb \$2760 VDD pfet_03v3 L=0.28U W=0.36U AS=0.2097P AD=0.1278P
+ PS=1.38U PD=1.07U
M$1406 \$2901 \$2762 \$2761 VDD pfet_03v3 L=0.28U W=0.36U AS=0.1278P AD=0.0567P
+ PS=1.07U PD=0.675U
M$1407 VDD WECLK \$2901 VDD pfet_03v3 L=0.28U W=0.36U AS=0.0567P AD=0.1584P
+ PS=0.675U PD=1.6U
M$1408 \$2760 D|Q VDD VDD pfet_03v3 L=0.28U W=0.72U AS=0.3168P AD=0.2097P
+ PS=2.32U PD=1.38U
M$1409 VDD \$2761 \$2762 VDD pfet_03v3 L=0.28U W=0.36U AS=0.1584P AD=0.1764P
+ PS=1.6U PD=1.26U
M$1410 \$2763 \$2761 VDD VDD pfet_03v3 L=0.28U W=0.72U AS=0.1764P AD=0.36P
+ PS=1.26U PD=2.44U
M$1411 \$2764 RA VDD VDD pfet_03v3 L=0.28U W=0.72U AS=0.3312P AD=0.3888P
+ PS=2.36U PD=2.52U
M$1412 \$2763 \$2764 QAb VDD pfet_03v3 L=0.28U W=0.36U AS=0.1584P AD=0.1152P
+ PS=1.6U PD=1U
M$1413 QBb \$2765 \$2763 VDD pfet_03v3 L=0.28U W=0.36U AS=0.1152P AD=0.1584P
+ PS=1U PD=1.6U
M$1414 VDD RB \$2765 VDD pfet_03v3 L=0.28U W=0.72U AS=0.3708P AD=0.3168P
+ PS=2.47U PD=2.32U
M$1415 \$2767 WECLKb \$2766 VDD pfet_03v3 L=0.28U W=0.36U AS=0.2097P AD=0.1278P
+ PS=1.38U PD=1.07U
M$1416 \$2910 \$2768 \$2767 VDD pfet_03v3 L=0.28U W=0.36U AS=0.1278P AD=0.0567P
+ PS=1.07U PD=0.675U
M$1417 VDD WECLK \$2910 VDD pfet_03v3 L=0.28U W=0.36U AS=0.0567P AD=0.1584P
+ PS=0.675U PD=1.6U
M$1418 \$2766 D|Q VDD VDD pfet_03v3 L=0.28U W=0.72U AS=0.3168P AD=0.2097P
+ PS=2.32U PD=1.38U
M$1419 VDD \$2767 \$2768 VDD pfet_03v3 L=0.28U W=0.36U AS=0.1584P AD=0.1764P
+ PS=1.6U PD=1.26U
M$1420 \$2769 \$2767 VDD VDD pfet_03v3 L=0.28U W=0.72U AS=0.1764P AD=0.36P
+ PS=1.26U PD=2.44U
M$1421 \$2770 RA VDD VDD pfet_03v3 L=0.28U W=0.72U AS=0.3312P AD=0.3888P
+ PS=2.36U PD=2.52U
M$1422 \$2769 \$2770 QAb VDD pfet_03v3 L=0.28U W=0.36U AS=0.1584P AD=0.1152P
+ PS=1.6U PD=1U
M$1423 QBb \$2771 \$2769 VDD pfet_03v3 L=0.28U W=0.36U AS=0.1152P AD=0.1584P
+ PS=1U PD=1.6U
M$1424 VDD RB \$2771 VDD pfet_03v3 L=0.28U W=0.72U AS=0.3708P AD=0.3168P
+ PS=2.47U PD=2.32U
M$1425 \$2773 WECLKb \$2772 VDD pfet_03v3 L=0.28U W=0.36U AS=0.2097P AD=0.1278P
+ PS=1.38U PD=1.07U
M$1426 \$2922 \$2774 \$2773 VDD pfet_03v3 L=0.28U W=0.36U AS=0.1278P AD=0.0567P
+ PS=1.07U PD=0.675U
M$1427 VDD WECLK \$2922 VDD pfet_03v3 L=0.28U W=0.36U AS=0.0567P AD=0.1584P
+ PS=0.675U PD=1.6U
M$1428 \$2772 D|Q VDD VDD pfet_03v3 L=0.28U W=0.72U AS=0.3168P AD=0.2097P
+ PS=2.32U PD=1.38U
M$1429 VDD \$2773 \$2774 VDD pfet_03v3 L=0.28U W=0.36U AS=0.1584P AD=0.1764P
+ PS=1.6U PD=1.26U
M$1430 \$2775 \$2773 VDD VDD pfet_03v3 L=0.28U W=0.72U AS=0.1764P AD=0.36P
+ PS=1.26U PD=2.44U
M$1431 \$2776 RA VDD VDD pfet_03v3 L=0.28U W=0.72U AS=0.3312P AD=0.3888P
+ PS=2.36U PD=2.52U
M$1432 \$2775 \$2776 QAb VDD pfet_03v3 L=0.28U W=0.36U AS=0.1584P AD=0.1152P
+ PS=1.6U PD=1U
M$1433 QBb \$2777 \$2775 VDD pfet_03v3 L=0.28U W=0.36U AS=0.1152P AD=0.1584P
+ PS=1U PD=1.6U
M$1434 VDD RB \$2777 VDD pfet_03v3 L=0.28U W=0.72U AS=0.3708P AD=0.3168P
+ PS=2.47U PD=2.32U
M$1435 \$2779 WECLKb \$2778 VDD pfet_03v3 L=0.28U W=0.36U AS=0.2097P AD=0.1278P
+ PS=1.38U PD=1.07U
M$1436 \$2930 \$2780 \$2779 VDD pfet_03v3 L=0.28U W=0.36U AS=0.1278P AD=0.0567P
+ PS=1.07U PD=0.675U
M$1437 VDD WECLK \$2930 VDD pfet_03v3 L=0.28U W=0.36U AS=0.0567P AD=0.1584P
+ PS=0.675U PD=1.6U
M$1438 \$2778 D|Q VDD VDD pfet_03v3 L=0.28U W=0.72U AS=0.3168P AD=0.2097P
+ PS=2.32U PD=1.38U
M$1439 VDD \$2779 \$2780 VDD pfet_03v3 L=0.28U W=0.36U AS=0.1584P AD=0.1764P
+ PS=1.6U PD=1.26U
M$1440 \$2781 \$2779 VDD VDD pfet_03v3 L=0.28U W=0.72U AS=0.1764P AD=0.36P
+ PS=1.26U PD=2.44U
M$1441 \$2782 RA VDD VDD pfet_03v3 L=0.28U W=0.72U AS=0.3312P AD=0.3888P
+ PS=2.36U PD=2.52U
M$1442 \$2781 \$2782 QAb VDD pfet_03v3 L=0.28U W=0.36U AS=0.1584P AD=0.1152P
+ PS=1.6U PD=1U
M$1443 QBb \$2783 \$2781 VDD pfet_03v3 L=0.28U W=0.36U AS=0.1152P AD=0.1584P
+ PS=1U PD=1.6U
M$1444 VDD RB \$2783 VDD pfet_03v3 L=0.28U W=0.72U AS=0.3708P AD=0.3168P
+ PS=2.47U PD=2.32U
M$1445 \$2785 WECLKb \$2784 VDD pfet_03v3 L=0.28U W=0.36U AS=0.2097P AD=0.1278P
+ PS=1.38U PD=1.07U
M$1446 \$2893 \$2786 \$2785 VDD pfet_03v3 L=0.28U W=0.36U AS=0.1278P AD=0.0567P
+ PS=1.07U PD=0.675U
M$1447 VDD WECLK \$2893 VDD pfet_03v3 L=0.28U W=0.36U AS=0.0567P AD=0.1584P
+ PS=0.675U PD=1.6U
M$1448 \$2784 D|Q VDD VDD pfet_03v3 L=0.28U W=0.72U AS=0.3168P AD=0.2097P
+ PS=2.32U PD=1.38U
M$1449 VDD \$2785 \$2786 VDD pfet_03v3 L=0.28U W=0.36U AS=0.1584P AD=0.1764P
+ PS=1.6U PD=1.26U
M$1450 \$2787 \$2785 VDD VDD pfet_03v3 L=0.28U W=0.72U AS=0.1764P AD=0.36P
+ PS=1.26U PD=2.44U
M$1451 \$2788 RA VDD VDD pfet_03v3 L=0.28U W=0.72U AS=0.3312P AD=0.3888P
+ PS=2.36U PD=2.52U
M$1452 \$2787 \$2788 QAb VDD pfet_03v3 L=0.28U W=0.36U AS=0.1584P AD=0.1152P
+ PS=1.6U PD=1U
M$1453 QBb \$2789 \$2787 VDD pfet_03v3 L=0.28U W=0.36U AS=0.1152P AD=0.1584P
+ PS=1U PD=1.6U
M$1454 VDD RB \$2789 VDD pfet_03v3 L=0.28U W=0.72U AS=0.3708P AD=0.3168P
+ PS=2.47U PD=2.32U
M$1455 \$2791 WECLKb \$2790 VDD pfet_03v3 L=0.28U W=0.36U AS=0.2097P AD=0.1278P
+ PS=1.38U PD=1.07U
M$1456 \$2864 \$2792 \$2791 VDD pfet_03v3 L=0.28U W=0.36U AS=0.1278P AD=0.0567P
+ PS=1.07U PD=0.675U
M$1457 VDD WECLK \$2864 VDD pfet_03v3 L=0.28U W=0.36U AS=0.0567P AD=0.1584P
+ PS=0.675U PD=1.6U
M$1458 \$2790 D|Q VDD VDD pfet_03v3 L=0.28U W=0.72U AS=0.3168P AD=0.2097P
+ PS=2.32U PD=1.38U
M$1459 VDD \$2791 \$2792 VDD pfet_03v3 L=0.28U W=0.36U AS=0.1584P AD=0.1764P
+ PS=1.6U PD=1.26U
M$1460 \$2793 \$2791 VDD VDD pfet_03v3 L=0.28U W=0.72U AS=0.1764P AD=0.36P
+ PS=1.26U PD=2.44U
M$1461 \$2794 RA VDD VDD pfet_03v3 L=0.28U W=0.72U AS=0.3312P AD=0.3888P
+ PS=2.36U PD=2.52U
M$1462 \$2793 \$2794 QAb VDD pfet_03v3 L=0.28U W=0.36U AS=0.1584P AD=0.1152P
+ PS=1.6U PD=1U
M$1463 QBb \$2795 \$2793 VDD pfet_03v3 L=0.28U W=0.36U AS=0.1152P AD=0.1584P
+ PS=1U PD=1.6U
M$1464 VDD RB \$2795 VDD pfet_03v3 L=0.28U W=0.72U AS=0.3708P AD=0.3168P
+ PS=2.47U PD=2.32U
M$1465 \$2797 WECLKb \$2796 VDD pfet_03v3 L=0.28U W=0.36U AS=0.2097P AD=0.1278P
+ PS=1.38U PD=1.07U
M$1466 \$2829 \$2798 \$2797 VDD pfet_03v3 L=0.28U W=0.36U AS=0.1278P AD=0.0567P
+ PS=1.07U PD=0.675U
M$1467 VDD WECLK \$2829 VDD pfet_03v3 L=0.28U W=0.36U AS=0.0567P AD=0.1584P
+ PS=0.675U PD=1.6U
M$1468 \$2796 D|Q VDD VDD pfet_03v3 L=0.28U W=0.72U AS=0.3168P AD=0.2097P
+ PS=2.32U PD=1.38U
M$1469 VDD \$2797 \$2798 VDD pfet_03v3 L=0.28U W=0.36U AS=0.1584P AD=0.1764P
+ PS=1.6U PD=1.26U
M$1470 \$2799 \$2797 VDD VDD pfet_03v3 L=0.28U W=0.72U AS=0.1764P AD=0.36P
+ PS=1.26U PD=2.44U
M$1471 \$2800 RA VDD VDD pfet_03v3 L=0.28U W=0.72U AS=0.3312P AD=0.3888P
+ PS=2.36U PD=2.52U
M$1472 \$2799 \$2800 QAb VDD pfet_03v3 L=0.28U W=0.36U AS=0.1584P AD=0.1152P
+ PS=1.6U PD=1U
M$1473 QBb \$2801 \$2799 VDD pfet_03v3 L=0.28U W=0.36U AS=0.1152P AD=0.1584P
+ PS=1U PD=1.6U
M$1474 VDD RB \$2801 VDD pfet_03v3 L=0.28U W=0.72U AS=0.3708P AD=0.3168P
+ PS=2.47U PD=2.32U
M$1475 \$3051 WE VDD VDD pfet_03v3 L=0.28U W=0.72U AS=0.3168P AD=0.1872P
+ PS=2.32U PD=1.24U
M$1476 VDD CLK \$3051 VDD pfet_03v3 L=0.28U W=0.72U AS=0.1872P AD=0.3168P
+ PS=1.24U PD=2.32U
M$1477 WECLK \$3051 VDD VDD pfet_03v3 L=0.28U W=2.54U AS=0.8974P AD=0.6604P
+ PS=5.28U PD=3.58U
M$1481 \$3054 D|Q VDD VDD pfet_03v3 L=0.28U W=0.72U AS=0.3168P AD=0.2097P
+ PS=2.32U PD=1.38U
M$1482 \$3055 WECLKb \$3054 VDD pfet_03v3 L=0.28U W=0.36U AS=0.2097P AD=0.1278P
+ PS=1.38U PD=1.07U
M$1483 \$3282 \$3056 \$3055 VDD pfet_03v3 L=0.28U W=0.36U AS=0.1278P AD=0.0567P
+ PS=1.07U PD=0.675U
M$1484 VDD WECLK \$3282 VDD pfet_03v3 L=0.28U W=0.36U AS=0.0567P AD=0.1584P
+ PS=0.675U PD=1.6U
M$1485 \$3056 \$3055 VDD VDD pfet_03v3 L=0.28U W=0.36U AS=0.1764P AD=0.1584P
+ PS=1.26U PD=1.6U
M$1486 \$3035 \$3055 VDD VDD pfet_03v3 L=0.28U W=0.72U AS=0.1764P AD=0.36P
+ PS=1.26U PD=2.44U
M$1487 \$3159 RA VDD VDD pfet_03v3 L=0.28U W=0.72U AS=0.3312P AD=0.3888P
+ PS=2.36U PD=2.52U
M$1488 \$3035 \$3159 QAb VDD pfet_03v3 L=0.28U W=0.36U AS=0.1584P AD=0.1152P
+ PS=1.6U PD=1U
M$1489 QBb \$3160 \$3035 VDD pfet_03v3 L=0.28U W=0.36U AS=0.1152P AD=0.1584P
+ PS=1U PD=1.6U
M$1490 VDD RB \$3160 VDD pfet_03v3 L=0.28U W=0.72U AS=0.3708P AD=0.3168P
+ PS=2.47U PD=2.32U
M$1491 \$3057 D|Q VDD VDD pfet_03v3 L=0.28U W=0.72U AS=0.3168P AD=0.2097P
+ PS=2.32U PD=1.38U
M$1492 \$3058 WECLKb \$3057 VDD pfet_03v3 L=0.28U W=0.36U AS=0.2097P AD=0.1278P
+ PS=1.38U PD=1.07U
M$1493 \$3291 \$3059 \$3058 VDD pfet_03v3 L=0.28U W=0.36U AS=0.1278P AD=0.0567P
+ PS=1.07U PD=0.675U
M$1494 VDD WECLK \$3291 VDD pfet_03v3 L=0.28U W=0.36U AS=0.0567P AD=0.1584P
+ PS=0.675U PD=1.6U
M$1495 \$3059 \$3058 VDD VDD pfet_03v3 L=0.28U W=0.36U AS=0.1764P AD=0.1584P
+ PS=1.26U PD=1.6U
M$1496 \$3036 \$3058 VDD VDD pfet_03v3 L=0.28U W=0.72U AS=0.1764P AD=0.36P
+ PS=1.26U PD=2.44U
M$1497 \$3161 RA VDD VDD pfet_03v3 L=0.28U W=0.72U AS=0.3312P AD=0.3888P
+ PS=2.36U PD=2.52U
M$1498 \$3036 \$3161 QAb VDD pfet_03v3 L=0.28U W=0.36U AS=0.1584P AD=0.1152P
+ PS=1.6U PD=1U
M$1499 QBb \$3162 \$3036 VDD pfet_03v3 L=0.28U W=0.36U AS=0.1152P AD=0.1584P
+ PS=1U PD=1.6U
M$1500 VDD RB \$3162 VDD pfet_03v3 L=0.28U W=0.72U AS=0.3708P AD=0.3168P
+ PS=2.47U PD=2.32U
M$1501 \$3060 D|Q VDD VDD pfet_03v3 L=0.28U W=0.72U AS=0.3168P AD=0.2097P
+ PS=2.32U PD=1.38U
M$1502 \$3061 WECLKb \$3060 VDD pfet_03v3 L=0.28U W=0.36U AS=0.2097P AD=0.1278P
+ PS=1.38U PD=1.07U
M$1503 \$3299 \$3062 \$3061 VDD pfet_03v3 L=0.28U W=0.36U AS=0.1278P AD=0.0567P
+ PS=1.07U PD=0.675U
M$1504 VDD WECLK \$3299 VDD pfet_03v3 L=0.28U W=0.36U AS=0.0567P AD=0.1584P
+ PS=0.675U PD=1.6U
M$1505 \$3062 \$3061 VDD VDD pfet_03v3 L=0.28U W=0.36U AS=0.1764P AD=0.1584P
+ PS=1.26U PD=1.6U
M$1506 \$3037 \$3061 VDD VDD pfet_03v3 L=0.28U W=0.72U AS=0.1764P AD=0.36P
+ PS=1.26U PD=2.44U
M$1507 \$3163 RA VDD VDD pfet_03v3 L=0.28U W=0.72U AS=0.3312P AD=0.3888P
+ PS=2.36U PD=2.52U
M$1508 \$3037 \$3163 QAb VDD pfet_03v3 L=0.28U W=0.36U AS=0.1584P AD=0.1152P
+ PS=1.6U PD=1U
M$1509 QBb \$3164 \$3037 VDD pfet_03v3 L=0.28U W=0.36U AS=0.1152P AD=0.1584P
+ PS=1U PD=1.6U
M$1510 VDD RB \$3164 VDD pfet_03v3 L=0.28U W=0.72U AS=0.3708P AD=0.3168P
+ PS=2.47U PD=2.32U
M$1511 \$3063 D|Q VDD VDD pfet_03v3 L=0.28U W=0.72U AS=0.3168P AD=0.2097P
+ PS=2.32U PD=1.38U
M$1512 \$3064 WECLKb \$3063 VDD pfet_03v3 L=0.28U W=0.36U AS=0.2097P AD=0.1278P
+ PS=1.38U PD=1.07U
M$1513 \$3308 \$3065 \$3064 VDD pfet_03v3 L=0.28U W=0.36U AS=0.1278P AD=0.0567P
+ PS=1.07U PD=0.675U
M$1514 VDD WECLK \$3308 VDD pfet_03v3 L=0.28U W=0.36U AS=0.0567P AD=0.1584P
+ PS=0.675U PD=1.6U
M$1515 \$3065 \$3064 VDD VDD pfet_03v3 L=0.28U W=0.36U AS=0.1764P AD=0.1584P
+ PS=1.26U PD=1.6U
M$1516 \$3038 \$3064 VDD VDD pfet_03v3 L=0.28U W=0.72U AS=0.1764P AD=0.36P
+ PS=1.26U PD=2.44U
M$1517 \$3165 RA VDD VDD pfet_03v3 L=0.28U W=0.72U AS=0.3312P AD=0.3888P
+ PS=2.36U PD=2.52U
M$1518 \$3038 \$3165 QAb VDD pfet_03v3 L=0.28U W=0.36U AS=0.1584P AD=0.1152P
+ PS=1.6U PD=1U
M$1519 QBb \$3166 \$3038 VDD pfet_03v3 L=0.28U W=0.36U AS=0.1152P AD=0.1584P
+ PS=1U PD=1.6U
M$1520 VDD RB \$3166 VDD pfet_03v3 L=0.28U W=0.72U AS=0.3708P AD=0.3168P
+ PS=2.47U PD=2.32U
M$1521 \$3066 D|Q VDD VDD pfet_03v3 L=0.28U W=0.72U AS=0.3168P AD=0.2097P
+ PS=2.32U PD=1.38U
M$1522 \$3067 WECLKb \$3066 VDD pfet_03v3 L=0.28U W=0.36U AS=0.2097P AD=0.1278P
+ PS=1.38U PD=1.07U
M$1523 \$3319 \$3068 \$3067 VDD pfet_03v3 L=0.28U W=0.36U AS=0.1278P AD=0.0567P
+ PS=1.07U PD=0.675U
M$1524 VDD WECLK \$3319 VDD pfet_03v3 L=0.28U W=0.36U AS=0.0567P AD=0.1584P
+ PS=0.675U PD=1.6U
M$1525 \$3068 \$3067 VDD VDD pfet_03v3 L=0.28U W=0.36U AS=0.1764P AD=0.1584P
+ PS=1.26U PD=1.6U
M$1526 \$3039 \$3067 VDD VDD pfet_03v3 L=0.28U W=0.72U AS=0.1764P AD=0.36P
+ PS=1.26U PD=2.44U
M$1527 \$3167 RA VDD VDD pfet_03v3 L=0.28U W=0.72U AS=0.3312P AD=0.3888P
+ PS=2.36U PD=2.52U
M$1528 \$3039 \$3167 QAb VDD pfet_03v3 L=0.28U W=0.36U AS=0.1584P AD=0.1152P
+ PS=1.6U PD=1U
M$1529 QBb \$3168 \$3039 VDD pfet_03v3 L=0.28U W=0.36U AS=0.1152P AD=0.1584P
+ PS=1U PD=1.6U
M$1530 VDD RB \$3168 VDD pfet_03v3 L=0.28U W=0.72U AS=0.3708P AD=0.3168P
+ PS=2.47U PD=2.32U
M$1531 \$3069 D|Q VDD VDD pfet_03v3 L=0.28U W=0.72U AS=0.3168P AD=0.2097P
+ PS=2.32U PD=1.38U
M$1532 \$3070 WECLKb \$3069 VDD pfet_03v3 L=0.28U W=0.36U AS=0.2097P AD=0.1278P
+ PS=1.38U PD=1.07U
M$1533 \$3328 \$3071 \$3070 VDD pfet_03v3 L=0.28U W=0.36U AS=0.1278P AD=0.0567P
+ PS=1.07U PD=0.675U
M$1534 VDD WECLK \$3328 VDD pfet_03v3 L=0.28U W=0.36U AS=0.0567P AD=0.1584P
+ PS=0.675U PD=1.6U
M$1535 \$3071 \$3070 VDD VDD pfet_03v3 L=0.28U W=0.36U AS=0.1764P AD=0.1584P
+ PS=1.26U PD=1.6U
M$1536 \$3040 \$3070 VDD VDD pfet_03v3 L=0.28U W=0.72U AS=0.1764P AD=0.36P
+ PS=1.26U PD=2.44U
M$1537 \$3169 RA VDD VDD pfet_03v3 L=0.28U W=0.72U AS=0.3312P AD=0.3888P
+ PS=2.36U PD=2.52U
M$1538 \$3040 \$3169 QAb VDD pfet_03v3 L=0.28U W=0.36U AS=0.1584P AD=0.1152P
+ PS=1.6U PD=1U
M$1539 QBb \$3170 \$3040 VDD pfet_03v3 L=0.28U W=0.36U AS=0.1152P AD=0.1584P
+ PS=1U PD=1.6U
M$1540 VDD RB \$3170 VDD pfet_03v3 L=0.28U W=0.72U AS=0.3708P AD=0.3168P
+ PS=2.47U PD=2.32U
M$1541 \$3072 D|Q VDD VDD pfet_03v3 L=0.28U W=0.72U AS=0.3168P AD=0.2097P
+ PS=2.32U PD=1.38U
M$1542 \$3073 WECLKb \$3072 VDD pfet_03v3 L=0.28U W=0.36U AS=0.2097P AD=0.1278P
+ PS=1.38U PD=1.07U
M$1543 \$3335 \$3074 \$3073 VDD pfet_03v3 L=0.28U W=0.36U AS=0.1278P AD=0.0567P
+ PS=1.07U PD=0.675U
M$1544 VDD WECLK \$3335 VDD pfet_03v3 L=0.28U W=0.36U AS=0.0567P AD=0.1584P
+ PS=0.675U PD=1.6U
M$1545 \$3074 \$3073 VDD VDD pfet_03v3 L=0.28U W=0.36U AS=0.1764P AD=0.1584P
+ PS=1.26U PD=1.6U
M$1546 \$3041 \$3073 VDD VDD pfet_03v3 L=0.28U W=0.72U AS=0.1764P AD=0.36P
+ PS=1.26U PD=2.44U
M$1547 \$3171 RA VDD VDD pfet_03v3 L=0.28U W=0.72U AS=0.3312P AD=0.3888P
+ PS=2.36U PD=2.52U
M$1548 \$3041 \$3171 QAb VDD pfet_03v3 L=0.28U W=0.36U AS=0.1584P AD=0.1152P
+ PS=1.6U PD=1U
M$1549 QBb \$3172 \$3041 VDD pfet_03v3 L=0.28U W=0.36U AS=0.1152P AD=0.1584P
+ PS=1U PD=1.6U
M$1550 VDD RB \$3172 VDD pfet_03v3 L=0.28U W=0.72U AS=0.3708P AD=0.3168P
+ PS=2.47U PD=2.32U
M$1551 \$3075 D|Q VDD VDD pfet_03v3 L=0.28U W=0.72U AS=0.3168P AD=0.2097P
+ PS=2.32U PD=1.38U
M$1552 \$3076 WECLKb \$3075 VDD pfet_03v3 L=0.28U W=0.36U AS=0.2097P AD=0.1278P
+ PS=1.38U PD=1.07U
M$1553 \$3344 \$3077 \$3076 VDD pfet_03v3 L=0.28U W=0.36U AS=0.1278P AD=0.0567P
+ PS=1.07U PD=0.675U
M$1554 VDD WECLK \$3344 VDD pfet_03v3 L=0.28U W=0.36U AS=0.0567P AD=0.1584P
+ PS=0.675U PD=1.6U
M$1555 \$3077 \$3076 VDD VDD pfet_03v3 L=0.28U W=0.36U AS=0.1764P AD=0.1584P
+ PS=1.26U PD=1.6U
M$1556 \$3042 \$3076 VDD VDD pfet_03v3 L=0.28U W=0.72U AS=0.1764P AD=0.36P
+ PS=1.26U PD=2.44U
M$1557 \$3173 RA VDD VDD pfet_03v3 L=0.28U W=0.72U AS=0.3312P AD=0.3888P
+ PS=2.36U PD=2.52U
M$1558 \$3042 \$3173 QAb VDD pfet_03v3 L=0.28U W=0.36U AS=0.1584P AD=0.1152P
+ PS=1.6U PD=1U
M$1559 QBb \$3174 \$3042 VDD pfet_03v3 L=0.28U W=0.36U AS=0.1152P AD=0.1584P
+ PS=1U PD=1.6U
M$1560 VDD RB \$3174 VDD pfet_03v3 L=0.28U W=0.72U AS=0.3708P AD=0.3168P
+ PS=2.47U PD=2.32U
M$1561 \$3078 D|Q VDD VDD pfet_03v3 L=0.28U W=0.72U AS=0.3168P AD=0.2097P
+ PS=2.32U PD=1.38U
M$1562 \$3079 WECLKb \$3078 VDD pfet_03v3 L=0.28U W=0.36U AS=0.2097P AD=0.1278P
+ PS=1.38U PD=1.07U
M$1563 \$3353 \$3080 \$3079 VDD pfet_03v3 L=0.28U W=0.36U AS=0.1278P AD=0.0567P
+ PS=1.07U PD=0.675U
M$1564 VDD WECLK \$3353 VDD pfet_03v3 L=0.28U W=0.36U AS=0.0567P AD=0.1584P
+ PS=0.675U PD=1.6U
M$1565 \$3080 \$3079 VDD VDD pfet_03v3 L=0.28U W=0.36U AS=0.1764P AD=0.1584P
+ PS=1.26U PD=1.6U
M$1566 \$3043 \$3079 VDD VDD pfet_03v3 L=0.28U W=0.72U AS=0.1764P AD=0.36P
+ PS=1.26U PD=2.44U
M$1567 \$3175 RA VDD VDD pfet_03v3 L=0.28U W=0.72U AS=0.3312P AD=0.3888P
+ PS=2.36U PD=2.52U
M$1568 \$3043 \$3175 QAb VDD pfet_03v3 L=0.28U W=0.36U AS=0.1584P AD=0.1152P
+ PS=1.6U PD=1U
M$1569 QBb \$3176 \$3043 VDD pfet_03v3 L=0.28U W=0.36U AS=0.1152P AD=0.1584P
+ PS=1U PD=1.6U
M$1570 VDD RB \$3176 VDD pfet_03v3 L=0.28U W=0.72U AS=0.3708P AD=0.3168P
+ PS=2.47U PD=2.32U
M$1571 \$3081 D|Q VDD VDD pfet_03v3 L=0.28U W=0.72U AS=0.3168P AD=0.2097P
+ PS=2.32U PD=1.38U
M$1572 \$3082 WECLKb \$3081 VDD pfet_03v3 L=0.28U W=0.36U AS=0.2097P AD=0.1278P
+ PS=1.38U PD=1.07U
M$1573 \$3362 \$3083 \$3082 VDD pfet_03v3 L=0.28U W=0.36U AS=0.1278P AD=0.0567P
+ PS=1.07U PD=0.675U
M$1574 VDD WECLK \$3362 VDD pfet_03v3 L=0.28U W=0.36U AS=0.0567P AD=0.1584P
+ PS=0.675U PD=1.6U
M$1575 \$3083 \$3082 VDD VDD pfet_03v3 L=0.28U W=0.36U AS=0.1764P AD=0.1584P
+ PS=1.26U PD=1.6U
M$1576 \$3044 \$3082 VDD VDD pfet_03v3 L=0.28U W=0.72U AS=0.1764P AD=0.36P
+ PS=1.26U PD=2.44U
M$1577 \$3177 RA VDD VDD pfet_03v3 L=0.28U W=0.72U AS=0.3312P AD=0.3888P
+ PS=2.36U PD=2.52U
M$1578 \$3044 \$3177 QAb VDD pfet_03v3 L=0.28U W=0.36U AS=0.1584P AD=0.1152P
+ PS=1.6U PD=1U
M$1579 QBb \$3178 \$3044 VDD pfet_03v3 L=0.28U W=0.36U AS=0.1152P AD=0.1584P
+ PS=1U PD=1.6U
M$1580 VDD RB \$3178 VDD pfet_03v3 L=0.28U W=0.72U AS=0.3708P AD=0.3168P
+ PS=2.47U PD=2.32U
M$1581 \$3084 D|Q VDD VDD pfet_03v3 L=0.28U W=0.72U AS=0.3168P AD=0.2097P
+ PS=2.32U PD=1.38U
M$1582 \$3085 WECLKb \$3084 VDD pfet_03v3 L=0.28U W=0.36U AS=0.2097P AD=0.1278P
+ PS=1.38U PD=1.07U
M$1583 \$3371 \$3086 \$3085 VDD pfet_03v3 L=0.28U W=0.36U AS=0.1278P AD=0.0567P
+ PS=1.07U PD=0.675U
M$1584 VDD WECLK \$3371 VDD pfet_03v3 L=0.28U W=0.36U AS=0.0567P AD=0.1584P
+ PS=0.675U PD=1.6U
M$1585 \$3086 \$3085 VDD VDD pfet_03v3 L=0.28U W=0.36U AS=0.1764P AD=0.1584P
+ PS=1.26U PD=1.6U
M$1586 \$3045 \$3085 VDD VDD pfet_03v3 L=0.28U W=0.72U AS=0.1764P AD=0.36P
+ PS=1.26U PD=2.44U
M$1587 \$3179 RA VDD VDD pfet_03v3 L=0.28U W=0.72U AS=0.3312P AD=0.3888P
+ PS=2.36U PD=2.52U
M$1588 \$3045 \$3179 QAb VDD pfet_03v3 L=0.28U W=0.36U AS=0.1584P AD=0.1152P
+ PS=1.6U PD=1U
M$1589 QBb \$3180 \$3045 VDD pfet_03v3 L=0.28U W=0.36U AS=0.1152P AD=0.1584P
+ PS=1U PD=1.6U
M$1590 VDD RB \$3180 VDD pfet_03v3 L=0.28U W=0.72U AS=0.3708P AD=0.3168P
+ PS=2.47U PD=2.32U
M$1591 \$3087 D|Q VDD VDD pfet_03v3 L=0.28U W=0.72U AS=0.3168P AD=0.2097P
+ PS=2.32U PD=1.38U
M$1592 \$3088 WECLKb \$3087 VDD pfet_03v3 L=0.28U W=0.36U AS=0.2097P AD=0.1278P
+ PS=1.38U PD=1.07U
M$1593 \$3378 \$3089 \$3088 VDD pfet_03v3 L=0.28U W=0.36U AS=0.1278P AD=0.0567P
+ PS=1.07U PD=0.675U
M$1594 VDD WECLK \$3378 VDD pfet_03v3 L=0.28U W=0.36U AS=0.0567P AD=0.1584P
+ PS=0.675U PD=1.6U
M$1595 \$3089 \$3088 VDD VDD pfet_03v3 L=0.28U W=0.36U AS=0.1764P AD=0.1584P
+ PS=1.26U PD=1.6U
M$1596 \$3046 \$3088 VDD VDD pfet_03v3 L=0.28U W=0.72U AS=0.1764P AD=0.36P
+ PS=1.26U PD=2.44U
M$1597 \$3181 RA VDD VDD pfet_03v3 L=0.28U W=0.72U AS=0.3312P AD=0.3888P
+ PS=2.36U PD=2.52U
M$1598 \$3046 \$3181 QAb VDD pfet_03v3 L=0.28U W=0.36U AS=0.1584P AD=0.1152P
+ PS=1.6U PD=1U
M$1599 QBb \$3182 \$3046 VDD pfet_03v3 L=0.28U W=0.36U AS=0.1152P AD=0.1584P
+ PS=1U PD=1.6U
M$1600 VDD RB \$3182 VDD pfet_03v3 L=0.28U W=0.72U AS=0.3708P AD=0.3168P
+ PS=2.47U PD=2.32U
M$1601 \$3090 D|Q VDD VDD pfet_03v3 L=0.28U W=0.72U AS=0.3168P AD=0.2097P
+ PS=2.32U PD=1.38U
M$1602 \$3091 WECLKb \$3090 VDD pfet_03v3 L=0.28U W=0.36U AS=0.2097P AD=0.1278P
+ PS=1.38U PD=1.07U
M$1603 \$3366 \$3092 \$3091 VDD pfet_03v3 L=0.28U W=0.36U AS=0.1278P AD=0.0567P
+ PS=1.07U PD=0.675U
M$1604 VDD WECLK \$3366 VDD pfet_03v3 L=0.28U W=0.36U AS=0.0567P AD=0.1584P
+ PS=0.675U PD=1.6U
M$1605 \$3092 \$3091 VDD VDD pfet_03v3 L=0.28U W=0.36U AS=0.1764P AD=0.1584P
+ PS=1.26U PD=1.6U
M$1606 \$3047 \$3091 VDD VDD pfet_03v3 L=0.28U W=0.72U AS=0.1764P AD=0.36P
+ PS=1.26U PD=2.44U
M$1607 \$3183 RA VDD VDD pfet_03v3 L=0.28U W=0.72U AS=0.3312P AD=0.3888P
+ PS=2.36U PD=2.52U
M$1608 \$3047 \$3183 QAb VDD pfet_03v3 L=0.28U W=0.36U AS=0.1584P AD=0.1152P
+ PS=1.6U PD=1U
M$1609 QBb \$3184 \$3047 VDD pfet_03v3 L=0.28U W=0.36U AS=0.1152P AD=0.1584P
+ PS=1U PD=1.6U
M$1610 VDD RB \$3184 VDD pfet_03v3 L=0.28U W=0.72U AS=0.3708P AD=0.3168P
+ PS=2.47U PD=2.32U
M$1611 \$3093 D|Q VDD VDD pfet_03v3 L=0.28U W=0.72U AS=0.3168P AD=0.2097P
+ PS=2.32U PD=1.38U
M$1612 \$3094 WECLKb \$3093 VDD pfet_03v3 L=0.28U W=0.36U AS=0.2097P AD=0.1278P
+ PS=1.38U PD=1.07U
M$1613 \$3340 \$3095 \$3094 VDD pfet_03v3 L=0.28U W=0.36U AS=0.1278P AD=0.0567P
+ PS=1.07U PD=0.675U
M$1614 VDD WECLK \$3340 VDD pfet_03v3 L=0.28U W=0.36U AS=0.0567P AD=0.1584P
+ PS=0.675U PD=1.6U
M$1615 \$3095 \$3094 VDD VDD pfet_03v3 L=0.28U W=0.36U AS=0.1764P AD=0.1584P
+ PS=1.26U PD=1.6U
M$1616 \$3048 \$3094 VDD VDD pfet_03v3 L=0.28U W=0.72U AS=0.1764P AD=0.36P
+ PS=1.26U PD=2.44U
M$1617 \$3185 RA VDD VDD pfet_03v3 L=0.28U W=0.72U AS=0.3312P AD=0.3888P
+ PS=2.36U PD=2.52U
M$1618 \$3048 \$3185 QAb VDD pfet_03v3 L=0.28U W=0.36U AS=0.1584P AD=0.1152P
+ PS=1.6U PD=1U
M$1619 QBb \$3186 \$3048 VDD pfet_03v3 L=0.28U W=0.36U AS=0.1152P AD=0.1584P
+ PS=1U PD=1.6U
M$1620 VDD RB \$3186 VDD pfet_03v3 L=0.28U W=0.72U AS=0.3708P AD=0.3168P
+ PS=2.47U PD=2.32U
M$1621 \$3096 D|Q VDD VDD pfet_03v3 L=0.28U W=0.72U AS=0.3168P AD=0.2097P
+ PS=2.32U PD=1.38U
M$1622 \$3097 WECLKb \$3096 VDD pfet_03v3 L=0.28U W=0.36U AS=0.2097P AD=0.1278P
+ PS=1.38U PD=1.07U
M$1623 \$3320 \$3098 \$3097 VDD pfet_03v3 L=0.28U W=0.36U AS=0.1278P AD=0.0567P
+ PS=1.07U PD=0.675U
M$1624 VDD WECLK \$3320 VDD pfet_03v3 L=0.28U W=0.36U AS=0.0567P AD=0.1584P
+ PS=0.675U PD=1.6U
M$1625 \$3098 \$3097 VDD VDD pfet_03v3 L=0.28U W=0.36U AS=0.1764P AD=0.1584P
+ PS=1.26U PD=1.6U
M$1626 \$3049 \$3097 VDD VDD pfet_03v3 L=0.28U W=0.72U AS=0.1764P AD=0.36P
+ PS=1.26U PD=2.44U
M$1627 \$3187 RA VDD VDD pfet_03v3 L=0.28U W=0.72U AS=0.3312P AD=0.3888P
+ PS=2.36U PD=2.52U
M$1628 \$3049 \$3187 QAb VDD pfet_03v3 L=0.28U W=0.36U AS=0.1584P AD=0.1152P
+ PS=1.6U PD=1U
M$1629 QBb \$3188 \$3049 VDD pfet_03v3 L=0.28U W=0.36U AS=0.1152P AD=0.1584P
+ PS=1U PD=1.6U
M$1630 VDD RB \$3188 VDD pfet_03v3 L=0.28U W=0.72U AS=0.3708P AD=0.3168P
+ PS=2.47U PD=2.32U
M$1631 \$3099 D|Q VDD VDD pfet_03v3 L=0.28U W=0.72U AS=0.3168P AD=0.2097P
+ PS=2.32U PD=1.38U
M$1632 \$3100 WECLKb \$3099 VDD pfet_03v3 L=0.28U W=0.36U AS=0.2097P AD=0.1278P
+ PS=1.38U PD=1.07U
M$1633 \$3292 \$3101 \$3100 VDD pfet_03v3 L=0.28U W=0.36U AS=0.1278P AD=0.0567P
+ PS=1.07U PD=0.675U
M$1634 VDD WECLK \$3292 VDD pfet_03v3 L=0.28U W=0.36U AS=0.0567P AD=0.1584P
+ PS=0.675U PD=1.6U
M$1635 \$3101 \$3100 VDD VDD pfet_03v3 L=0.28U W=0.36U AS=0.1764P AD=0.1584P
+ PS=1.26U PD=1.6U
M$1636 \$3050 \$3100 VDD VDD pfet_03v3 L=0.28U W=0.72U AS=0.1764P AD=0.36P
+ PS=1.26U PD=2.44U
M$1637 \$3189 RA VDD VDD pfet_03v3 L=0.28U W=0.72U AS=0.3312P AD=0.3888P
+ PS=2.36U PD=2.52U
M$1638 \$3050 \$3189 QAb VDD pfet_03v3 L=0.28U W=0.36U AS=0.1584P AD=0.1152P
+ PS=1.6U PD=1U
M$1639 QBb \$3190 \$3050 VDD pfet_03v3 L=0.28U W=0.36U AS=0.1152P AD=0.1584P
+ PS=1U PD=1.6U
M$1640 VDD RB \$3190 VDD pfet_03v3 L=0.28U W=0.72U AS=0.3708P AD=0.3168P
+ PS=2.47U PD=2.32U
M$1641 \$3383 WE VDD VDD pfet_03v3 L=0.28U W=0.72U AS=0.3168P AD=0.1872P
+ PS=2.32U PD=1.24U
M$1642 VDD CLK \$3383 VDD pfet_03v3 L=0.28U W=0.72U AS=0.1872P AD=0.3168P
+ PS=1.24U PD=2.32U
M$1643 WECLK \$3383 VDD VDD pfet_03v3 L=0.28U W=2.54U AS=0.889P AD=0.6688P
+ PS=5.21U PD=3.65U
M$1647 \$3389 WECLKb \$3388 VDD pfet_03v3 L=0.28U W=0.36U AS=0.2097P AD=0.1278P
+ PS=1.38U PD=1.07U
M$1648 \$3491 \$3390 \$3389 VDD pfet_03v3 L=0.28U W=0.36U AS=0.1278P AD=0.0567P
+ PS=1.07U PD=0.675U
M$1649 VDD WECLK \$3491 VDD pfet_03v3 L=0.28U W=0.36U AS=0.0567P AD=0.1584P
+ PS=0.675U PD=1.6U
M$1650 \$3388 D|Q VDD VDD pfet_03v3 L=0.28U W=0.72U AS=0.3168P AD=0.2097P
+ PS=2.32U PD=1.38U
M$1651 VDD \$3389 \$3390 VDD pfet_03v3 L=0.28U W=0.36U AS=0.1584P AD=0.1764P
+ PS=1.6U PD=1.26U
M$1652 \$3391 \$3389 VDD VDD pfet_03v3 L=0.28U W=0.72U AS=0.1764P AD=0.36P
+ PS=1.26U PD=2.44U
M$1653 \$3392 RA VDD VDD pfet_03v3 L=0.28U W=0.72U AS=0.3312P AD=0.3888P
+ PS=2.36U PD=2.52U
M$1654 \$3391 \$3392 QAb VDD pfet_03v3 L=0.28U W=0.36U AS=0.1584P AD=0.1152P
+ PS=1.6U PD=1U
M$1655 QBb \$3393 \$3391 VDD pfet_03v3 L=0.28U W=0.36U AS=0.1152P AD=0.1584P
+ PS=1U PD=1.6U
M$1656 VDD RB \$3393 VDD pfet_03v3 L=0.28U W=0.72U AS=0.3708P AD=0.3168P
+ PS=2.47U PD=2.32U
M$1657 \$3396 WECLKb \$3395 VDD pfet_03v3 L=0.28U W=0.36U AS=0.2097P AD=0.1278P
+ PS=1.38U PD=1.07U
M$1658 \$3500 \$3397 \$3396 VDD pfet_03v3 L=0.28U W=0.36U AS=0.1278P AD=0.0567P
+ PS=1.07U PD=0.675U
M$1659 VDD WECLK \$3500 VDD pfet_03v3 L=0.28U W=0.36U AS=0.0567P AD=0.1584P
+ PS=0.675U PD=1.6U
M$1660 \$3395 D|Q VDD VDD pfet_03v3 L=0.28U W=0.72U AS=0.3168P AD=0.2097P
+ PS=2.32U PD=1.38U
M$1661 VDD \$3396 \$3397 VDD pfet_03v3 L=0.28U W=0.36U AS=0.1584P AD=0.1764P
+ PS=1.6U PD=1.26U
M$1662 \$3398 \$3396 VDD VDD pfet_03v3 L=0.28U W=0.72U AS=0.1764P AD=0.36P
+ PS=1.26U PD=2.44U
M$1663 \$3399 RA VDD VDD pfet_03v3 L=0.28U W=0.72U AS=0.3312P AD=0.3888P
+ PS=2.36U PD=2.52U
M$1664 \$3398 \$3399 QAb VDD pfet_03v3 L=0.28U W=0.36U AS=0.1584P AD=0.1152P
+ PS=1.6U PD=1U
M$1665 QBb \$3400 \$3398 VDD pfet_03v3 L=0.28U W=0.36U AS=0.1152P AD=0.1584P
+ PS=1U PD=1.6U
M$1666 VDD RB \$3400 VDD pfet_03v3 L=0.28U W=0.72U AS=0.3708P AD=0.3168P
+ PS=2.47U PD=2.32U
M$1667 \$3402 WECLKb \$3401 VDD pfet_03v3 L=0.28U W=0.36U AS=0.2097P AD=0.1278P
+ PS=1.38U PD=1.07U
M$1668 \$3510 \$3403 \$3402 VDD pfet_03v3 L=0.28U W=0.36U AS=0.1278P AD=0.0567P
+ PS=1.07U PD=0.675U
M$1669 VDD WECLK \$3510 VDD pfet_03v3 L=0.28U W=0.36U AS=0.0567P AD=0.1584P
+ PS=0.675U PD=1.6U
M$1670 \$3401 D|Q VDD VDD pfet_03v3 L=0.28U W=0.72U AS=0.3168P AD=0.2097P
+ PS=2.32U PD=1.38U
M$1671 VDD \$3402 \$3403 VDD pfet_03v3 L=0.28U W=0.36U AS=0.1584P AD=0.1764P
+ PS=1.6U PD=1.26U
M$1672 \$3404 \$3402 VDD VDD pfet_03v3 L=0.28U W=0.72U AS=0.1764P AD=0.36P
+ PS=1.26U PD=2.44U
M$1673 \$3405 RA VDD VDD pfet_03v3 L=0.28U W=0.72U AS=0.3312P AD=0.3888P
+ PS=2.36U PD=2.52U
M$1674 \$3404 \$3405 QAb VDD pfet_03v3 L=0.28U W=0.36U AS=0.1584P AD=0.1152P
+ PS=1.6U PD=1U
M$1675 QBb \$3406 \$3404 VDD pfet_03v3 L=0.28U W=0.36U AS=0.1152P AD=0.1584P
+ PS=1U PD=1.6U
M$1676 VDD RB \$3406 VDD pfet_03v3 L=0.28U W=0.72U AS=0.3708P AD=0.3168P
+ PS=2.47U PD=2.32U
M$1677 \$3408 WECLKb \$3407 VDD pfet_03v3 L=0.28U W=0.36U AS=0.2097P AD=0.1278P
+ PS=1.38U PD=1.07U
M$1678 \$3521 \$3409 \$3408 VDD pfet_03v3 L=0.28U W=0.36U AS=0.1278P AD=0.0567P
+ PS=1.07U PD=0.675U
M$1679 VDD WECLK \$3521 VDD pfet_03v3 L=0.28U W=0.36U AS=0.0567P AD=0.1584P
+ PS=0.675U PD=1.6U
M$1680 \$3407 D|Q VDD VDD pfet_03v3 L=0.28U W=0.72U AS=0.3168P AD=0.2097P
+ PS=2.32U PD=1.38U
M$1681 VDD \$3408 \$3409 VDD pfet_03v3 L=0.28U W=0.36U AS=0.1584P AD=0.1764P
+ PS=1.6U PD=1.26U
M$1682 \$3410 \$3408 VDD VDD pfet_03v3 L=0.28U W=0.72U AS=0.1764P AD=0.36P
+ PS=1.26U PD=2.44U
M$1683 \$3411 RA VDD VDD pfet_03v3 L=0.28U W=0.72U AS=0.3312P AD=0.3888P
+ PS=2.36U PD=2.52U
M$1684 \$3410 \$3411 QAb VDD pfet_03v3 L=0.28U W=0.36U AS=0.1584P AD=0.1152P
+ PS=1.6U PD=1U
M$1685 QBb \$3412 \$3410 VDD pfet_03v3 L=0.28U W=0.36U AS=0.1152P AD=0.1584P
+ PS=1U PD=1.6U
M$1686 VDD RB \$3412 VDD pfet_03v3 L=0.28U W=0.72U AS=0.3708P AD=0.3168P
+ PS=2.47U PD=2.32U
M$1687 \$3414 WECLKb \$3413 VDD pfet_03v3 L=0.28U W=0.36U AS=0.2097P AD=0.1278P
+ PS=1.38U PD=1.07U
M$1688 \$3533 \$3415 \$3414 VDD pfet_03v3 L=0.28U W=0.36U AS=0.1278P AD=0.0567P
+ PS=1.07U PD=0.675U
M$1689 VDD WECLK \$3533 VDD pfet_03v3 L=0.28U W=0.36U AS=0.0567P AD=0.1584P
+ PS=0.675U PD=1.6U
M$1690 \$3413 D|Q VDD VDD pfet_03v3 L=0.28U W=0.72U AS=0.3168P AD=0.2097P
+ PS=2.32U PD=1.38U
M$1691 VDD \$3414 \$3415 VDD pfet_03v3 L=0.28U W=0.36U AS=0.1584P AD=0.1764P
+ PS=1.6U PD=1.26U
M$1692 \$3416 \$3414 VDD VDD pfet_03v3 L=0.28U W=0.72U AS=0.1764P AD=0.36P
+ PS=1.26U PD=2.44U
M$1693 \$3417 RA VDD VDD pfet_03v3 L=0.28U W=0.72U AS=0.3312P AD=0.3888P
+ PS=2.36U PD=2.52U
M$1694 \$3416 \$3417 QAb VDD pfet_03v3 L=0.28U W=0.36U AS=0.1584P AD=0.1152P
+ PS=1.6U PD=1U
M$1695 QBb \$3418 \$3416 VDD pfet_03v3 L=0.28U W=0.36U AS=0.1152P AD=0.1584P
+ PS=1U PD=1.6U
M$1696 VDD RB \$3418 VDD pfet_03v3 L=0.28U W=0.72U AS=0.3708P AD=0.3168P
+ PS=2.47U PD=2.32U
M$1697 \$3420 WECLKb \$3419 VDD pfet_03v3 L=0.28U W=0.36U AS=0.2097P AD=0.1278P
+ PS=1.38U PD=1.07U
M$1698 \$3542 \$3421 \$3420 VDD pfet_03v3 L=0.28U W=0.36U AS=0.1278P AD=0.0567P
+ PS=1.07U PD=0.675U
M$1699 VDD WECLK \$3542 VDD pfet_03v3 L=0.28U W=0.36U AS=0.0567P AD=0.1584P
+ PS=0.675U PD=1.6U
M$1700 \$3419 D|Q VDD VDD pfet_03v3 L=0.28U W=0.72U AS=0.3168P AD=0.2097P
+ PS=2.32U PD=1.38U
M$1701 VDD \$3420 \$3421 VDD pfet_03v3 L=0.28U W=0.36U AS=0.1584P AD=0.1764P
+ PS=1.6U PD=1.26U
M$1702 \$3422 \$3420 VDD VDD pfet_03v3 L=0.28U W=0.72U AS=0.1764P AD=0.36P
+ PS=1.26U PD=2.44U
M$1703 \$3423 RA VDD VDD pfet_03v3 L=0.28U W=0.72U AS=0.3312P AD=0.3888P
+ PS=2.36U PD=2.52U
M$1704 \$3422 \$3423 QAb VDD pfet_03v3 L=0.28U W=0.36U AS=0.1584P AD=0.1152P
+ PS=1.6U PD=1U
M$1705 QBb \$3424 \$3422 VDD pfet_03v3 L=0.28U W=0.36U AS=0.1152P AD=0.1584P
+ PS=1U PD=1.6U
M$1706 VDD RB \$3424 VDD pfet_03v3 L=0.28U W=0.72U AS=0.3708P AD=0.3168P
+ PS=2.47U PD=2.32U
M$1707 \$3426 WECLKb \$3425 VDD pfet_03v3 L=0.28U W=0.36U AS=0.2097P AD=0.1278P
+ PS=1.38U PD=1.07U
M$1708 \$3551 \$3427 \$3426 VDD pfet_03v3 L=0.28U W=0.36U AS=0.1278P AD=0.0567P
+ PS=1.07U PD=0.675U
M$1709 VDD WECLK \$3551 VDD pfet_03v3 L=0.28U W=0.36U AS=0.0567P AD=0.1584P
+ PS=0.675U PD=1.6U
M$1710 \$3425 D|Q VDD VDD pfet_03v3 L=0.28U W=0.72U AS=0.3168P AD=0.2097P
+ PS=2.32U PD=1.38U
M$1711 VDD \$3426 \$3427 VDD pfet_03v3 L=0.28U W=0.36U AS=0.1584P AD=0.1764P
+ PS=1.6U PD=1.26U
M$1712 \$3428 \$3426 VDD VDD pfet_03v3 L=0.28U W=0.72U AS=0.1764P AD=0.36P
+ PS=1.26U PD=2.44U
M$1713 \$3429 RA VDD VDD pfet_03v3 L=0.28U W=0.72U AS=0.3312P AD=0.3888P
+ PS=2.36U PD=2.52U
M$1714 \$3428 \$3429 QAb VDD pfet_03v3 L=0.28U W=0.36U AS=0.1584P AD=0.1152P
+ PS=1.6U PD=1U
M$1715 QBb \$3430 \$3428 VDD pfet_03v3 L=0.28U W=0.36U AS=0.1152P AD=0.1584P
+ PS=1U PD=1.6U
M$1716 VDD RB \$3430 VDD pfet_03v3 L=0.28U W=0.72U AS=0.3708P AD=0.3168P
+ PS=2.47U PD=2.32U
M$1717 \$3432 WECLKb \$3431 VDD pfet_03v3 L=0.28U W=0.36U AS=0.2097P AD=0.1278P
+ PS=1.38U PD=1.07U
M$1718 \$3563 \$3433 \$3432 VDD pfet_03v3 L=0.28U W=0.36U AS=0.1278P AD=0.0567P
+ PS=1.07U PD=0.675U
M$1719 VDD WECLK \$3563 VDD pfet_03v3 L=0.28U W=0.36U AS=0.0567P AD=0.1584P
+ PS=0.675U PD=1.6U
M$1720 \$3431 D|Q VDD VDD pfet_03v3 L=0.28U W=0.72U AS=0.3168P AD=0.2097P
+ PS=2.32U PD=1.38U
M$1721 VDD \$3432 \$3433 VDD pfet_03v3 L=0.28U W=0.36U AS=0.1584P AD=0.1764P
+ PS=1.6U PD=1.26U
M$1722 \$3434 \$3432 VDD VDD pfet_03v3 L=0.28U W=0.72U AS=0.1764P AD=0.36P
+ PS=1.26U PD=2.44U
M$1723 \$3435 RA VDD VDD pfet_03v3 L=0.28U W=0.72U AS=0.3312P AD=0.3888P
+ PS=2.36U PD=2.52U
M$1724 \$3434 \$3435 QAb VDD pfet_03v3 L=0.28U W=0.36U AS=0.1584P AD=0.1152P
+ PS=1.6U PD=1U
M$1725 QBb \$3436 \$3434 VDD pfet_03v3 L=0.28U W=0.36U AS=0.1152P AD=0.1584P
+ PS=1U PD=1.6U
M$1726 VDD RB \$3436 VDD pfet_03v3 L=0.28U W=0.72U AS=0.3708P AD=0.3168P
+ PS=2.47U PD=2.32U
M$1727 \$3438 WECLKb \$3437 VDD pfet_03v3 L=0.28U W=0.36U AS=0.2097P AD=0.1278P
+ PS=1.38U PD=1.07U
M$1728 \$3574 \$3439 \$3438 VDD pfet_03v3 L=0.28U W=0.36U AS=0.1278P AD=0.0567P
+ PS=1.07U PD=0.675U
M$1729 VDD WECLK \$3574 VDD pfet_03v3 L=0.28U W=0.36U AS=0.0567P AD=0.1584P
+ PS=0.675U PD=1.6U
M$1730 \$3437 D|Q VDD VDD pfet_03v3 L=0.28U W=0.72U AS=0.3168P AD=0.2097P
+ PS=2.32U PD=1.38U
M$1731 VDD \$3438 \$3439 VDD pfet_03v3 L=0.28U W=0.36U AS=0.1584P AD=0.1764P
+ PS=1.6U PD=1.26U
M$1732 \$3440 \$3438 VDD VDD pfet_03v3 L=0.28U W=0.72U AS=0.1764P AD=0.36P
+ PS=1.26U PD=2.44U
M$1733 \$3441 RA VDD VDD pfet_03v3 L=0.28U W=0.72U AS=0.3312P AD=0.3888P
+ PS=2.36U PD=2.52U
M$1734 \$3440 \$3441 QAb VDD pfet_03v3 L=0.28U W=0.36U AS=0.1584P AD=0.1152P
+ PS=1.6U PD=1U
M$1735 QBb \$3442 \$3440 VDD pfet_03v3 L=0.28U W=0.36U AS=0.1152P AD=0.1584P
+ PS=1U PD=1.6U
M$1736 VDD RB \$3442 VDD pfet_03v3 L=0.28U W=0.72U AS=0.3708P AD=0.3168P
+ PS=2.47U PD=2.32U
M$1737 \$3444 WECLKb \$3443 VDD pfet_03v3 L=0.28U W=0.36U AS=0.2097P AD=0.1278P
+ PS=1.38U PD=1.07U
M$1738 \$3584 \$3445 \$3444 VDD pfet_03v3 L=0.28U W=0.36U AS=0.1278P AD=0.0567P
+ PS=1.07U PD=0.675U
M$1739 VDD WECLK \$3584 VDD pfet_03v3 L=0.28U W=0.36U AS=0.0567P AD=0.1584P
+ PS=0.675U PD=1.6U
M$1740 \$3443 D|Q VDD VDD pfet_03v3 L=0.28U W=0.72U AS=0.3168P AD=0.2097P
+ PS=2.32U PD=1.38U
M$1741 VDD \$3444 \$3445 VDD pfet_03v3 L=0.28U W=0.36U AS=0.1584P AD=0.1764P
+ PS=1.6U PD=1.26U
M$1742 \$3446 \$3444 VDD VDD pfet_03v3 L=0.28U W=0.72U AS=0.1764P AD=0.36P
+ PS=1.26U PD=2.44U
M$1743 \$3447 RA VDD VDD pfet_03v3 L=0.28U W=0.72U AS=0.3312P AD=0.3888P
+ PS=2.36U PD=2.52U
M$1744 \$3446 \$3447 QAb VDD pfet_03v3 L=0.28U W=0.36U AS=0.1584P AD=0.1152P
+ PS=1.6U PD=1U
M$1745 QBb \$3448 \$3446 VDD pfet_03v3 L=0.28U W=0.36U AS=0.1152P AD=0.1584P
+ PS=1U PD=1.6U
M$1746 VDD RB \$3448 VDD pfet_03v3 L=0.28U W=0.72U AS=0.3708P AD=0.3168P
+ PS=2.47U PD=2.32U
M$1747 \$3450 WECLKb \$3449 VDD pfet_03v3 L=0.28U W=0.36U AS=0.2097P AD=0.1278P
+ PS=1.38U PD=1.07U
M$1748 \$3593 \$3451 \$3450 VDD pfet_03v3 L=0.28U W=0.36U AS=0.1278P AD=0.0567P
+ PS=1.07U PD=0.675U
M$1749 VDD WECLK \$3593 VDD pfet_03v3 L=0.28U W=0.36U AS=0.0567P AD=0.1584P
+ PS=0.675U PD=1.6U
M$1750 \$3449 D|Q VDD VDD pfet_03v3 L=0.28U W=0.72U AS=0.3168P AD=0.2097P
+ PS=2.32U PD=1.38U
M$1751 VDD \$3450 \$3451 VDD pfet_03v3 L=0.28U W=0.36U AS=0.1584P AD=0.1764P
+ PS=1.6U PD=1.26U
M$1752 \$3452 \$3450 VDD VDD pfet_03v3 L=0.28U W=0.72U AS=0.1764P AD=0.36P
+ PS=1.26U PD=2.44U
M$1753 \$3453 RA VDD VDD pfet_03v3 L=0.28U W=0.72U AS=0.3312P AD=0.3888P
+ PS=2.36U PD=2.52U
M$1754 \$3452 \$3453 QAb VDD pfet_03v3 L=0.28U W=0.36U AS=0.1584P AD=0.1152P
+ PS=1.6U PD=1U
M$1755 QBb \$3454 \$3452 VDD pfet_03v3 L=0.28U W=0.36U AS=0.1152P AD=0.1584P
+ PS=1U PD=1.6U
M$1756 VDD RB \$3454 VDD pfet_03v3 L=0.28U W=0.72U AS=0.3708P AD=0.3168P
+ PS=2.47U PD=2.32U
M$1757 \$3456 WECLKb \$3455 VDD pfet_03v3 L=0.28U W=0.36U AS=0.2097P AD=0.1278P
+ PS=1.38U PD=1.07U
M$1758 \$3605 \$3457 \$3456 VDD pfet_03v3 L=0.28U W=0.36U AS=0.1278P AD=0.0567P
+ PS=1.07U PD=0.675U
M$1759 VDD WECLK \$3605 VDD pfet_03v3 L=0.28U W=0.36U AS=0.0567P AD=0.1584P
+ PS=0.675U PD=1.6U
M$1760 \$3455 D|Q VDD VDD pfet_03v3 L=0.28U W=0.72U AS=0.3168P AD=0.2097P
+ PS=2.32U PD=1.38U
M$1761 VDD \$3456 \$3457 VDD pfet_03v3 L=0.28U W=0.36U AS=0.1584P AD=0.1764P
+ PS=1.6U PD=1.26U
M$1762 \$3458 \$3456 VDD VDD pfet_03v3 L=0.28U W=0.72U AS=0.1764P AD=0.36P
+ PS=1.26U PD=2.44U
M$1763 \$3459 RA VDD VDD pfet_03v3 L=0.28U W=0.72U AS=0.3312P AD=0.3888P
+ PS=2.36U PD=2.52U
M$1764 \$3458 \$3459 QAb VDD pfet_03v3 L=0.28U W=0.36U AS=0.1584P AD=0.1152P
+ PS=1.6U PD=1U
M$1765 QBb \$3460 \$3458 VDD pfet_03v3 L=0.28U W=0.36U AS=0.1152P AD=0.1584P
+ PS=1U PD=1.6U
M$1766 VDD RB \$3460 VDD pfet_03v3 L=0.28U W=0.72U AS=0.3708P AD=0.3168P
+ PS=2.47U PD=2.32U
M$1767 \$3462 WECLKb \$3461 VDD pfet_03v3 L=0.28U W=0.36U AS=0.2097P AD=0.1278P
+ PS=1.38U PD=1.07U
M$1768 \$3613 \$3463 \$3462 VDD pfet_03v3 L=0.28U W=0.36U AS=0.1278P AD=0.0567P
+ PS=1.07U PD=0.675U
M$1769 VDD WECLK \$3613 VDD pfet_03v3 L=0.28U W=0.36U AS=0.0567P AD=0.1584P
+ PS=0.675U PD=1.6U
M$1770 \$3461 D|Q VDD VDD pfet_03v3 L=0.28U W=0.72U AS=0.3168P AD=0.2097P
+ PS=2.32U PD=1.38U
M$1771 VDD \$3462 \$3463 VDD pfet_03v3 L=0.28U W=0.36U AS=0.1584P AD=0.1764P
+ PS=1.6U PD=1.26U
M$1772 \$3464 \$3462 VDD VDD pfet_03v3 L=0.28U W=0.72U AS=0.1764P AD=0.36P
+ PS=1.26U PD=2.44U
M$1773 \$3465 RA VDD VDD pfet_03v3 L=0.28U W=0.72U AS=0.3312P AD=0.3888P
+ PS=2.36U PD=2.52U
M$1774 \$3464 \$3465 QAb VDD pfet_03v3 L=0.28U W=0.36U AS=0.1584P AD=0.1152P
+ PS=1.6U PD=1U
M$1775 QBb \$3466 \$3464 VDD pfet_03v3 L=0.28U W=0.36U AS=0.1152P AD=0.1584P
+ PS=1U PD=1.6U
M$1776 VDD RB \$3466 VDD pfet_03v3 L=0.28U W=0.72U AS=0.3708P AD=0.3168P
+ PS=2.47U PD=2.32U
M$1777 \$3468 WECLKb \$3467 VDD pfet_03v3 L=0.28U W=0.36U AS=0.2097P AD=0.1278P
+ PS=1.38U PD=1.07U
M$1778 \$3576 \$3469 \$3468 VDD pfet_03v3 L=0.28U W=0.36U AS=0.1278P AD=0.0567P
+ PS=1.07U PD=0.675U
M$1779 VDD WECLK \$3576 VDD pfet_03v3 L=0.28U W=0.36U AS=0.0567P AD=0.1584P
+ PS=0.675U PD=1.6U
M$1780 \$3467 D|Q VDD VDD pfet_03v3 L=0.28U W=0.72U AS=0.3168P AD=0.2097P
+ PS=2.32U PD=1.38U
M$1781 VDD \$3468 \$3469 VDD pfet_03v3 L=0.28U W=0.36U AS=0.1584P AD=0.1764P
+ PS=1.6U PD=1.26U
M$1782 \$3470 \$3468 VDD VDD pfet_03v3 L=0.28U W=0.72U AS=0.1764P AD=0.36P
+ PS=1.26U PD=2.44U
M$1783 \$3471 RA VDD VDD pfet_03v3 L=0.28U W=0.72U AS=0.3312P AD=0.3888P
+ PS=2.36U PD=2.52U
M$1784 \$3470 \$3471 QAb VDD pfet_03v3 L=0.28U W=0.36U AS=0.1584P AD=0.1152P
+ PS=1.6U PD=1U
M$1785 QBb \$3472 \$3470 VDD pfet_03v3 L=0.28U W=0.36U AS=0.1152P AD=0.1584P
+ PS=1U PD=1.6U
M$1786 VDD RB \$3472 VDD pfet_03v3 L=0.28U W=0.72U AS=0.3708P AD=0.3168P
+ PS=2.47U PD=2.32U
M$1787 \$3474 WECLKb \$3473 VDD pfet_03v3 L=0.28U W=0.36U AS=0.2097P AD=0.1278P
+ PS=1.38U PD=1.07U
M$1788 \$3547 \$3475 \$3474 VDD pfet_03v3 L=0.28U W=0.36U AS=0.1278P AD=0.0567P
+ PS=1.07U PD=0.675U
M$1789 VDD WECLK \$3547 VDD pfet_03v3 L=0.28U W=0.36U AS=0.0567P AD=0.1584P
+ PS=0.675U PD=1.6U
M$1790 \$3473 D|Q VDD VDD pfet_03v3 L=0.28U W=0.72U AS=0.3168P AD=0.2097P
+ PS=2.32U PD=1.38U
M$1791 VDD \$3474 \$3475 VDD pfet_03v3 L=0.28U W=0.36U AS=0.1584P AD=0.1764P
+ PS=1.6U PD=1.26U
M$1792 \$3476 \$3474 VDD VDD pfet_03v3 L=0.28U W=0.72U AS=0.1764P AD=0.36P
+ PS=1.26U PD=2.44U
M$1793 \$3477 RA VDD VDD pfet_03v3 L=0.28U W=0.72U AS=0.3312P AD=0.3888P
+ PS=2.36U PD=2.52U
M$1794 \$3476 \$3477 QAb VDD pfet_03v3 L=0.28U W=0.36U AS=0.1584P AD=0.1152P
+ PS=1.6U PD=1U
M$1795 QBb \$3478 \$3476 VDD pfet_03v3 L=0.28U W=0.36U AS=0.1152P AD=0.1584P
+ PS=1U PD=1.6U
M$1796 VDD RB \$3478 VDD pfet_03v3 L=0.28U W=0.72U AS=0.3708P AD=0.3168P
+ PS=2.47U PD=2.32U
M$1797 \$3480 WECLKb \$3479 VDD pfet_03v3 L=0.28U W=0.36U AS=0.2097P AD=0.1278P
+ PS=1.38U PD=1.07U
M$1798 \$3512 \$3481 \$3480 VDD pfet_03v3 L=0.28U W=0.36U AS=0.1278P AD=0.0567P
+ PS=1.07U PD=0.675U
M$1799 VDD WECLK \$3512 VDD pfet_03v3 L=0.28U W=0.36U AS=0.0567P AD=0.1584P
+ PS=0.675U PD=1.6U
M$1800 \$3479 D|Q VDD VDD pfet_03v3 L=0.28U W=0.72U AS=0.3168P AD=0.2097P
+ PS=2.32U PD=1.38U
M$1801 VDD \$3480 \$3481 VDD pfet_03v3 L=0.28U W=0.36U AS=0.1584P AD=0.1764P
+ PS=1.6U PD=1.26U
M$1802 \$3482 \$3480 VDD VDD pfet_03v3 L=0.28U W=0.72U AS=0.1764P AD=0.36P
+ PS=1.26U PD=2.44U
M$1803 \$3483 RA VDD VDD pfet_03v3 L=0.28U W=0.72U AS=0.3312P AD=0.3888P
+ PS=2.36U PD=2.52U
M$1804 \$3482 \$3483 QAb VDD pfet_03v3 L=0.28U W=0.36U AS=0.1584P AD=0.1152P
+ PS=1.6U PD=1U
M$1805 QBb \$3484 \$3482 VDD pfet_03v3 L=0.28U W=0.36U AS=0.1152P AD=0.1584P
+ PS=1U PD=1.6U
M$1806 VDD RB \$3484 VDD pfet_03v3 L=0.28U W=0.72U AS=0.3708P AD=0.3168P
+ PS=2.47U PD=2.32U
M$1807 \$3734 WE VDD VDD pfet_03v3 L=0.28U W=0.72U AS=0.3168P AD=0.1872P
+ PS=2.32U PD=1.24U
M$1808 VDD CLK \$3734 VDD pfet_03v3 L=0.28U W=0.72U AS=0.1872P AD=0.3168P
+ PS=1.24U PD=2.32U
M$1809 WECLK \$3734 VDD VDD pfet_03v3 L=0.28U W=2.54U AS=0.8974P AD=0.6604P
+ PS=5.28U PD=3.58U
M$1813 \$3737 D|Q VDD VDD pfet_03v3 L=0.28U W=0.72U AS=0.3168P AD=0.2097P
+ PS=2.32U PD=1.38U
M$1814 \$3738 WECLKb \$3737 VDD pfet_03v3 L=0.28U W=0.36U AS=0.2097P AD=0.1278P
+ PS=1.38U PD=1.07U
M$1815 \$3959 \$3739 \$3738 VDD pfet_03v3 L=0.28U W=0.36U AS=0.1278P AD=0.0567P
+ PS=1.07U PD=0.675U
M$1816 VDD WECLK \$3959 VDD pfet_03v3 L=0.28U W=0.36U AS=0.0567P AD=0.1584P
+ PS=0.675U PD=1.6U
M$1817 \$3739 \$3738 VDD VDD pfet_03v3 L=0.28U W=0.36U AS=0.1764P AD=0.1584P
+ PS=1.26U PD=1.6U
M$1818 \$3718 \$3738 VDD VDD pfet_03v3 L=0.28U W=0.72U AS=0.1764P AD=0.36P
+ PS=1.26U PD=2.44U
M$1819 \$3836 RA VDD VDD pfet_03v3 L=0.28U W=0.72U AS=0.3312P AD=0.3888P
+ PS=2.36U PD=2.52U
M$1820 \$3718 \$3836 QAb VDD pfet_03v3 L=0.28U W=0.36U AS=0.1584P AD=0.1152P
+ PS=1.6U PD=1U
M$1821 QBb \$3837 \$3718 VDD pfet_03v3 L=0.28U W=0.36U AS=0.1152P AD=0.1584P
+ PS=1U PD=1.6U
M$1822 VDD RB \$3837 VDD pfet_03v3 L=0.28U W=0.72U AS=0.3708P AD=0.3168P
+ PS=2.47U PD=2.32U
M$1823 \$3740 D|Q VDD VDD pfet_03v3 L=0.28U W=0.72U AS=0.3168P AD=0.2097P
+ PS=2.32U PD=1.38U
M$1824 \$3741 WECLKb \$3740 VDD pfet_03v3 L=0.28U W=0.36U AS=0.2097P AD=0.1278P
+ PS=1.38U PD=1.07U
M$1825 \$3968 \$3742 \$3741 VDD pfet_03v3 L=0.28U W=0.36U AS=0.1278P AD=0.0567P
+ PS=1.07U PD=0.675U
M$1826 VDD WECLK \$3968 VDD pfet_03v3 L=0.28U W=0.36U AS=0.0567P AD=0.1584P
+ PS=0.675U PD=1.6U
M$1827 \$3742 \$3741 VDD VDD pfet_03v3 L=0.28U W=0.36U AS=0.1764P AD=0.1584P
+ PS=1.26U PD=1.6U
M$1828 \$3719 \$3741 VDD VDD pfet_03v3 L=0.28U W=0.72U AS=0.1764P AD=0.36P
+ PS=1.26U PD=2.44U
M$1829 \$3838 RA VDD VDD pfet_03v3 L=0.28U W=0.72U AS=0.3312P AD=0.3888P
+ PS=2.36U PD=2.52U
M$1830 \$3719 \$3838 QAb VDD pfet_03v3 L=0.28U W=0.36U AS=0.1584P AD=0.1152P
+ PS=1.6U PD=1U
M$1831 QBb \$3839 \$3719 VDD pfet_03v3 L=0.28U W=0.36U AS=0.1152P AD=0.1584P
+ PS=1U PD=1.6U
M$1832 VDD RB \$3839 VDD pfet_03v3 L=0.28U W=0.72U AS=0.3708P AD=0.3168P
+ PS=2.47U PD=2.32U
M$1833 \$3743 D|Q VDD VDD pfet_03v3 L=0.28U W=0.72U AS=0.3168P AD=0.2097P
+ PS=2.32U PD=1.38U
M$1834 \$3744 WECLKb \$3743 VDD pfet_03v3 L=0.28U W=0.36U AS=0.2097P AD=0.1278P
+ PS=1.38U PD=1.07U
M$1835 \$3976 \$3745 \$3744 VDD pfet_03v3 L=0.28U W=0.36U AS=0.1278P AD=0.0567P
+ PS=1.07U PD=0.675U
M$1836 VDD WECLK \$3976 VDD pfet_03v3 L=0.28U W=0.36U AS=0.0567P AD=0.1584P
+ PS=0.675U PD=1.6U
M$1837 \$3745 \$3744 VDD VDD pfet_03v3 L=0.28U W=0.36U AS=0.1764P AD=0.1584P
+ PS=1.26U PD=1.6U
M$1838 \$3720 \$3744 VDD VDD pfet_03v3 L=0.28U W=0.72U AS=0.1764P AD=0.36P
+ PS=1.26U PD=2.44U
M$1839 \$3840 RA VDD VDD pfet_03v3 L=0.28U W=0.72U AS=0.3312P AD=0.3888P
+ PS=2.36U PD=2.52U
M$1840 \$3720 \$3840 QAb VDD pfet_03v3 L=0.28U W=0.36U AS=0.1584P AD=0.1152P
+ PS=1.6U PD=1U
M$1841 QBb \$3841 \$3720 VDD pfet_03v3 L=0.28U W=0.36U AS=0.1152P AD=0.1584P
+ PS=1U PD=1.6U
M$1842 VDD RB \$3841 VDD pfet_03v3 L=0.28U W=0.72U AS=0.3708P AD=0.3168P
+ PS=2.47U PD=2.32U
M$1843 \$3746 D|Q VDD VDD pfet_03v3 L=0.28U W=0.72U AS=0.3168P AD=0.2097P
+ PS=2.32U PD=1.38U
M$1844 \$3747 WECLKb \$3746 VDD pfet_03v3 L=0.28U W=0.36U AS=0.2097P AD=0.1278P
+ PS=1.38U PD=1.07U
M$1845 \$3985 \$3748 \$3747 VDD pfet_03v3 L=0.28U W=0.36U AS=0.1278P AD=0.0567P
+ PS=1.07U PD=0.675U
M$1846 VDD WECLK \$3985 VDD pfet_03v3 L=0.28U W=0.36U AS=0.0567P AD=0.1584P
+ PS=0.675U PD=1.6U
M$1847 \$3748 \$3747 VDD VDD pfet_03v3 L=0.28U W=0.36U AS=0.1764P AD=0.1584P
+ PS=1.26U PD=1.6U
M$1848 \$3721 \$3747 VDD VDD pfet_03v3 L=0.28U W=0.72U AS=0.1764P AD=0.36P
+ PS=1.26U PD=2.44U
M$1849 \$3842 RA VDD VDD pfet_03v3 L=0.28U W=0.72U AS=0.3312P AD=0.3888P
+ PS=2.36U PD=2.52U
M$1850 \$3721 \$3842 QAb VDD pfet_03v3 L=0.28U W=0.36U AS=0.1584P AD=0.1152P
+ PS=1.6U PD=1U
M$1851 QBb \$3843 \$3721 VDD pfet_03v3 L=0.28U W=0.36U AS=0.1152P AD=0.1584P
+ PS=1U PD=1.6U
M$1852 VDD RB \$3843 VDD pfet_03v3 L=0.28U W=0.72U AS=0.3708P AD=0.3168P
+ PS=2.47U PD=2.32U
M$1853 \$3749 D|Q VDD VDD pfet_03v3 L=0.28U W=0.72U AS=0.3168P AD=0.2097P
+ PS=2.32U PD=1.38U
M$1854 \$3750 WECLKb \$3749 VDD pfet_03v3 L=0.28U W=0.36U AS=0.2097P AD=0.1278P
+ PS=1.38U PD=1.07U
M$1855 \$3996 \$3751 \$3750 VDD pfet_03v3 L=0.28U W=0.36U AS=0.1278P AD=0.0567P
+ PS=1.07U PD=0.675U
M$1856 VDD WECLK \$3996 VDD pfet_03v3 L=0.28U W=0.36U AS=0.0567P AD=0.1584P
+ PS=0.675U PD=1.6U
M$1857 \$3751 \$3750 VDD VDD pfet_03v3 L=0.28U W=0.36U AS=0.1764P AD=0.1584P
+ PS=1.26U PD=1.6U
M$1858 \$3722 \$3750 VDD VDD pfet_03v3 L=0.28U W=0.72U AS=0.1764P AD=0.36P
+ PS=1.26U PD=2.44U
M$1859 \$3844 RA VDD VDD pfet_03v3 L=0.28U W=0.72U AS=0.3312P AD=0.3888P
+ PS=2.36U PD=2.52U
M$1860 \$3722 \$3844 QAb VDD pfet_03v3 L=0.28U W=0.36U AS=0.1584P AD=0.1152P
+ PS=1.6U PD=1U
M$1861 QBb \$3845 \$3722 VDD pfet_03v3 L=0.28U W=0.36U AS=0.1152P AD=0.1584P
+ PS=1U PD=1.6U
M$1862 VDD RB \$3845 VDD pfet_03v3 L=0.28U W=0.72U AS=0.3708P AD=0.3168P
+ PS=2.47U PD=2.32U
M$1863 \$3752 D|Q VDD VDD pfet_03v3 L=0.28U W=0.72U AS=0.3168P AD=0.2097P
+ PS=2.32U PD=1.38U
M$1864 \$3753 WECLKb \$3752 VDD pfet_03v3 L=0.28U W=0.36U AS=0.2097P AD=0.1278P
+ PS=1.38U PD=1.07U
M$1865 \$4004 \$3754 \$3753 VDD pfet_03v3 L=0.28U W=0.36U AS=0.1278P AD=0.0567P
+ PS=1.07U PD=0.675U
M$1866 VDD WECLK \$4004 VDD pfet_03v3 L=0.28U W=0.36U AS=0.0567P AD=0.1584P
+ PS=0.675U PD=1.6U
M$1867 \$3754 \$3753 VDD VDD pfet_03v3 L=0.28U W=0.36U AS=0.1764P AD=0.1584P
+ PS=1.26U PD=1.6U
M$1868 \$3723 \$3753 VDD VDD pfet_03v3 L=0.28U W=0.72U AS=0.1764P AD=0.36P
+ PS=1.26U PD=2.44U
M$1869 \$3846 RA VDD VDD pfet_03v3 L=0.28U W=0.72U AS=0.3312P AD=0.3888P
+ PS=2.36U PD=2.52U
M$1870 \$3723 \$3846 QAb VDD pfet_03v3 L=0.28U W=0.36U AS=0.1584P AD=0.1152P
+ PS=1.6U PD=1U
M$1871 QBb \$3847 \$3723 VDD pfet_03v3 L=0.28U W=0.36U AS=0.1152P AD=0.1584P
+ PS=1U PD=1.6U
M$1872 VDD RB \$3847 VDD pfet_03v3 L=0.28U W=0.72U AS=0.3708P AD=0.3168P
+ PS=2.47U PD=2.32U
M$1873 \$3755 D|Q VDD VDD pfet_03v3 L=0.28U W=0.72U AS=0.3168P AD=0.2097P
+ PS=2.32U PD=1.38U
M$1874 \$3756 WECLKb \$3755 VDD pfet_03v3 L=0.28U W=0.36U AS=0.2097P AD=0.1278P
+ PS=1.38U PD=1.07U
M$1875 \$4012 \$3757 \$3756 VDD pfet_03v3 L=0.28U W=0.36U AS=0.1278P AD=0.0567P
+ PS=1.07U PD=0.675U
M$1876 VDD WECLK \$4012 VDD pfet_03v3 L=0.28U W=0.36U AS=0.0567P AD=0.1584P
+ PS=0.675U PD=1.6U
M$1877 \$3757 \$3756 VDD VDD pfet_03v3 L=0.28U W=0.36U AS=0.1764P AD=0.1584P
+ PS=1.26U PD=1.6U
M$1878 \$3724 \$3756 VDD VDD pfet_03v3 L=0.28U W=0.72U AS=0.1764P AD=0.36P
+ PS=1.26U PD=2.44U
M$1879 \$3848 RA VDD VDD pfet_03v3 L=0.28U W=0.72U AS=0.3312P AD=0.3888P
+ PS=2.36U PD=2.52U
M$1880 \$3724 \$3848 QAb VDD pfet_03v3 L=0.28U W=0.36U AS=0.1584P AD=0.1152P
+ PS=1.6U PD=1U
M$1881 QBb \$3849 \$3724 VDD pfet_03v3 L=0.28U W=0.36U AS=0.1152P AD=0.1584P
+ PS=1U PD=1.6U
M$1882 VDD RB \$3849 VDD pfet_03v3 L=0.28U W=0.72U AS=0.3708P AD=0.3168P
+ PS=2.47U PD=2.32U
M$1883 \$3758 D|Q VDD VDD pfet_03v3 L=0.28U W=0.72U AS=0.3168P AD=0.2097P
+ PS=2.32U PD=1.38U
M$1884 \$3759 WECLKb \$3758 VDD pfet_03v3 L=0.28U W=0.36U AS=0.2097P AD=0.1278P
+ PS=1.38U PD=1.07U
M$1885 \$4021 \$3760 \$3759 VDD pfet_03v3 L=0.28U W=0.36U AS=0.1278P AD=0.0567P
+ PS=1.07U PD=0.675U
M$1886 VDD WECLK \$4021 VDD pfet_03v3 L=0.28U W=0.36U AS=0.0567P AD=0.1584P
+ PS=0.675U PD=1.6U
M$1887 \$3760 \$3759 VDD VDD pfet_03v3 L=0.28U W=0.36U AS=0.1764P AD=0.1584P
+ PS=1.26U PD=1.6U
M$1888 \$3725 \$3759 VDD VDD pfet_03v3 L=0.28U W=0.72U AS=0.1764P AD=0.36P
+ PS=1.26U PD=2.44U
M$1889 \$3850 RA VDD VDD pfet_03v3 L=0.28U W=0.72U AS=0.3312P AD=0.3888P
+ PS=2.36U PD=2.52U
M$1890 \$3725 \$3850 QAb VDD pfet_03v3 L=0.28U W=0.36U AS=0.1584P AD=0.1152P
+ PS=1.6U PD=1U
M$1891 QBb \$3851 \$3725 VDD pfet_03v3 L=0.28U W=0.36U AS=0.1152P AD=0.1584P
+ PS=1U PD=1.6U
M$1892 VDD RB \$3851 VDD pfet_03v3 L=0.28U W=0.72U AS=0.3708P AD=0.3168P
+ PS=2.47U PD=2.32U
M$1893 \$3761 D|Q VDD VDD pfet_03v3 L=0.28U W=0.72U AS=0.3168P AD=0.2097P
+ PS=2.32U PD=1.38U
M$1894 \$3762 WECLKb \$3761 VDD pfet_03v3 L=0.28U W=0.36U AS=0.2097P AD=0.1278P
+ PS=1.38U PD=1.07U
M$1895 \$4030 \$3763 \$3762 VDD pfet_03v3 L=0.28U W=0.36U AS=0.1278P AD=0.0567P
+ PS=1.07U PD=0.675U
M$1896 VDD WECLK \$4030 VDD pfet_03v3 L=0.28U W=0.36U AS=0.0567P AD=0.1584P
+ PS=0.675U PD=1.6U
M$1897 \$3763 \$3762 VDD VDD pfet_03v3 L=0.28U W=0.36U AS=0.1764P AD=0.1584P
+ PS=1.26U PD=1.6U
M$1898 \$3726 \$3762 VDD VDD pfet_03v3 L=0.28U W=0.72U AS=0.1764P AD=0.36P
+ PS=1.26U PD=2.44U
M$1899 \$3852 RA VDD VDD pfet_03v3 L=0.28U W=0.72U AS=0.3312P AD=0.3888P
+ PS=2.36U PD=2.52U
M$1900 \$3726 \$3852 QAb VDD pfet_03v3 L=0.28U W=0.36U AS=0.1584P AD=0.1152P
+ PS=1.6U PD=1U
M$1901 QBb \$3853 \$3726 VDD pfet_03v3 L=0.28U W=0.36U AS=0.1152P AD=0.1584P
+ PS=1U PD=1.6U
M$1902 VDD RB \$3853 VDD pfet_03v3 L=0.28U W=0.72U AS=0.3708P AD=0.3168P
+ PS=2.47U PD=2.32U
M$1903 \$3764 D|Q VDD VDD pfet_03v3 L=0.28U W=0.72U AS=0.3168P AD=0.2097P
+ PS=2.32U PD=1.38U
M$1904 \$3765 WECLKb \$3764 VDD pfet_03v3 L=0.28U W=0.36U AS=0.2097P AD=0.1278P
+ PS=1.38U PD=1.07U
M$1905 \$4039 \$3766 \$3765 VDD pfet_03v3 L=0.28U W=0.36U AS=0.1278P AD=0.0567P
+ PS=1.07U PD=0.675U
M$1906 VDD WECLK \$4039 VDD pfet_03v3 L=0.28U W=0.36U AS=0.0567P AD=0.1584P
+ PS=0.675U PD=1.6U
M$1907 \$3766 \$3765 VDD VDD pfet_03v3 L=0.28U W=0.36U AS=0.1764P AD=0.1584P
+ PS=1.26U PD=1.6U
M$1908 \$3727 \$3765 VDD VDD pfet_03v3 L=0.28U W=0.72U AS=0.1764P AD=0.36P
+ PS=1.26U PD=2.44U
M$1909 \$3854 RA VDD VDD pfet_03v3 L=0.28U W=0.72U AS=0.3312P AD=0.3888P
+ PS=2.36U PD=2.52U
M$1910 \$3727 \$3854 QAb VDD pfet_03v3 L=0.28U W=0.36U AS=0.1584P AD=0.1152P
+ PS=1.6U PD=1U
M$1911 QBb \$3855 \$3727 VDD pfet_03v3 L=0.28U W=0.36U AS=0.1152P AD=0.1584P
+ PS=1U PD=1.6U
M$1912 VDD RB \$3855 VDD pfet_03v3 L=0.28U W=0.72U AS=0.3708P AD=0.3168P
+ PS=2.47U PD=2.32U
M$1913 \$3767 D|Q VDD VDD pfet_03v3 L=0.28U W=0.72U AS=0.3168P AD=0.2097P
+ PS=2.32U PD=1.38U
M$1914 \$3768 WECLKb \$3767 VDD pfet_03v3 L=0.28U W=0.36U AS=0.2097P AD=0.1278P
+ PS=1.38U PD=1.07U
M$1915 \$4048 \$3769 \$3768 VDD pfet_03v3 L=0.28U W=0.36U AS=0.1278P AD=0.0567P
+ PS=1.07U PD=0.675U
M$1916 VDD WECLK \$4048 VDD pfet_03v3 L=0.28U W=0.36U AS=0.0567P AD=0.1584P
+ PS=0.675U PD=1.6U
M$1917 \$3769 \$3768 VDD VDD pfet_03v3 L=0.28U W=0.36U AS=0.1764P AD=0.1584P
+ PS=1.26U PD=1.6U
M$1918 \$3728 \$3768 VDD VDD pfet_03v3 L=0.28U W=0.72U AS=0.1764P AD=0.36P
+ PS=1.26U PD=2.44U
M$1919 \$3856 RA VDD VDD pfet_03v3 L=0.28U W=0.72U AS=0.3312P AD=0.3888P
+ PS=2.36U PD=2.52U
M$1920 \$3728 \$3856 QAb VDD pfet_03v3 L=0.28U W=0.36U AS=0.1584P AD=0.1152P
+ PS=1.6U PD=1U
M$1921 QBb \$3857 \$3728 VDD pfet_03v3 L=0.28U W=0.36U AS=0.1152P AD=0.1584P
+ PS=1U PD=1.6U
M$1922 VDD RB \$3857 VDD pfet_03v3 L=0.28U W=0.72U AS=0.3708P AD=0.3168P
+ PS=2.47U PD=2.32U
M$1923 \$3770 D|Q VDD VDD pfet_03v3 L=0.28U W=0.72U AS=0.3168P AD=0.2097P
+ PS=2.32U PD=1.38U
M$1924 \$3771 WECLKb \$3770 VDD pfet_03v3 L=0.28U W=0.36U AS=0.2097P AD=0.1278P
+ PS=1.38U PD=1.07U
M$1925 \$4055 \$3772 \$3771 VDD pfet_03v3 L=0.28U W=0.36U AS=0.1278P AD=0.0567P
+ PS=1.07U PD=0.675U
M$1926 VDD WECLK \$4055 VDD pfet_03v3 L=0.28U W=0.36U AS=0.0567P AD=0.1584P
+ PS=0.675U PD=1.6U
M$1927 \$3772 \$3771 VDD VDD pfet_03v3 L=0.28U W=0.36U AS=0.1764P AD=0.1584P
+ PS=1.26U PD=1.6U
M$1928 \$3729 \$3771 VDD VDD pfet_03v3 L=0.28U W=0.72U AS=0.1764P AD=0.36P
+ PS=1.26U PD=2.44U
M$1929 \$3858 RA VDD VDD pfet_03v3 L=0.28U W=0.72U AS=0.3312P AD=0.3888P
+ PS=2.36U PD=2.52U
M$1930 \$3729 \$3858 QAb VDD pfet_03v3 L=0.28U W=0.36U AS=0.1584P AD=0.1152P
+ PS=1.6U PD=1U
M$1931 QBb \$3859 \$3729 VDD pfet_03v3 L=0.28U W=0.36U AS=0.1152P AD=0.1584P
+ PS=1U PD=1.6U
M$1932 VDD RB \$3859 VDD pfet_03v3 L=0.28U W=0.72U AS=0.3708P AD=0.3168P
+ PS=2.47U PD=2.32U
M$1933 \$3773 D|Q VDD VDD pfet_03v3 L=0.28U W=0.72U AS=0.3168P AD=0.2097P
+ PS=2.32U PD=1.38U
M$1934 \$3774 WECLKb \$3773 VDD pfet_03v3 L=0.28U W=0.36U AS=0.2097P AD=0.1278P
+ PS=1.38U PD=1.07U
M$1935 \$4043 \$3775 \$3774 VDD pfet_03v3 L=0.28U W=0.36U AS=0.1278P AD=0.0567P
+ PS=1.07U PD=0.675U
M$1936 VDD WECLK \$4043 VDD pfet_03v3 L=0.28U W=0.36U AS=0.0567P AD=0.1584P
+ PS=0.675U PD=1.6U
M$1937 \$3775 \$3774 VDD VDD pfet_03v3 L=0.28U W=0.36U AS=0.1764P AD=0.1584P
+ PS=1.26U PD=1.6U
M$1938 \$3730 \$3774 VDD VDD pfet_03v3 L=0.28U W=0.72U AS=0.1764P AD=0.36P
+ PS=1.26U PD=2.44U
M$1939 \$3860 RA VDD VDD pfet_03v3 L=0.28U W=0.72U AS=0.3312P AD=0.3888P
+ PS=2.36U PD=2.52U
M$1940 \$3730 \$3860 QAb VDD pfet_03v3 L=0.28U W=0.36U AS=0.1584P AD=0.1152P
+ PS=1.6U PD=1U
M$1941 QBb \$3861 \$3730 VDD pfet_03v3 L=0.28U W=0.36U AS=0.1152P AD=0.1584P
+ PS=1U PD=1.6U
M$1942 VDD RB \$3861 VDD pfet_03v3 L=0.28U W=0.72U AS=0.3708P AD=0.3168P
+ PS=2.47U PD=2.32U
M$1943 \$3776 D|Q VDD VDD pfet_03v3 L=0.28U W=0.72U AS=0.3168P AD=0.2097P
+ PS=2.32U PD=1.38U
M$1944 \$3777 WECLKb \$3776 VDD pfet_03v3 L=0.28U W=0.36U AS=0.2097P AD=0.1278P
+ PS=1.38U PD=1.07U
M$1945 \$4017 \$3778 \$3777 VDD pfet_03v3 L=0.28U W=0.36U AS=0.1278P AD=0.0567P
+ PS=1.07U PD=0.675U
M$1946 VDD WECLK \$4017 VDD pfet_03v3 L=0.28U W=0.36U AS=0.0567P AD=0.1584P
+ PS=0.675U PD=1.6U
M$1947 \$3778 \$3777 VDD VDD pfet_03v3 L=0.28U W=0.36U AS=0.1764P AD=0.1584P
+ PS=1.26U PD=1.6U
M$1948 \$3731 \$3777 VDD VDD pfet_03v3 L=0.28U W=0.72U AS=0.1764P AD=0.36P
+ PS=1.26U PD=2.44U
M$1949 \$3862 RA VDD VDD pfet_03v3 L=0.28U W=0.72U AS=0.3312P AD=0.3888P
+ PS=2.36U PD=2.52U
M$1950 \$3731 \$3862 QAb VDD pfet_03v3 L=0.28U W=0.36U AS=0.1584P AD=0.1152P
+ PS=1.6U PD=1U
M$1951 QBb \$3863 \$3731 VDD pfet_03v3 L=0.28U W=0.36U AS=0.1152P AD=0.1584P
+ PS=1U PD=1.6U
M$1952 VDD RB \$3863 VDD pfet_03v3 L=0.28U W=0.72U AS=0.3708P AD=0.3168P
+ PS=2.47U PD=2.32U
M$1953 \$3779 D|Q VDD VDD pfet_03v3 L=0.28U W=0.72U AS=0.3168P AD=0.2097P
+ PS=2.32U PD=1.38U
M$1954 \$3780 WECLKb \$3779 VDD pfet_03v3 L=0.28U W=0.36U AS=0.2097P AD=0.1278P
+ PS=1.38U PD=1.07U
M$1955 \$3997 \$3781 \$3780 VDD pfet_03v3 L=0.28U W=0.36U AS=0.1278P AD=0.0567P
+ PS=1.07U PD=0.675U
M$1956 VDD WECLK \$3997 VDD pfet_03v3 L=0.28U W=0.36U AS=0.0567P AD=0.1584P
+ PS=0.675U PD=1.6U
M$1957 \$3781 \$3780 VDD VDD pfet_03v3 L=0.28U W=0.36U AS=0.1764P AD=0.1584P
+ PS=1.26U PD=1.6U
M$1958 \$3732 \$3780 VDD VDD pfet_03v3 L=0.28U W=0.72U AS=0.1764P AD=0.36P
+ PS=1.26U PD=2.44U
M$1959 \$3864 RA VDD VDD pfet_03v3 L=0.28U W=0.72U AS=0.3312P AD=0.3888P
+ PS=2.36U PD=2.52U
M$1960 \$3732 \$3864 QAb VDD pfet_03v3 L=0.28U W=0.36U AS=0.1584P AD=0.1152P
+ PS=1.6U PD=1U
M$1961 QBb \$3865 \$3732 VDD pfet_03v3 L=0.28U W=0.36U AS=0.1152P AD=0.1584P
+ PS=1U PD=1.6U
M$1962 VDD RB \$3865 VDD pfet_03v3 L=0.28U W=0.72U AS=0.3708P AD=0.3168P
+ PS=2.47U PD=2.32U
M$1963 \$3782 D|Q VDD VDD pfet_03v3 L=0.28U W=0.72U AS=0.3168P AD=0.2097P
+ PS=2.32U PD=1.38U
M$1964 \$3783 WECLKb \$3782 VDD pfet_03v3 L=0.28U W=0.36U AS=0.2097P AD=0.1278P
+ PS=1.38U PD=1.07U
M$1965 \$3969 \$3784 \$3783 VDD pfet_03v3 L=0.28U W=0.36U AS=0.1278P AD=0.0567P
+ PS=1.07U PD=0.675U
M$1966 VDD WECLK \$3969 VDD pfet_03v3 L=0.28U W=0.36U AS=0.0567P AD=0.1584P
+ PS=0.675U PD=1.6U
M$1967 \$3784 \$3783 VDD VDD pfet_03v3 L=0.28U W=0.36U AS=0.1764P AD=0.1584P
+ PS=1.26U PD=1.6U
M$1968 \$3733 \$3783 VDD VDD pfet_03v3 L=0.28U W=0.72U AS=0.1764P AD=0.36P
+ PS=1.26U PD=2.44U
M$1969 \$3866 RA VDD VDD pfet_03v3 L=0.28U W=0.72U AS=0.3312P AD=0.3888P
+ PS=2.36U PD=2.52U
M$1970 \$3733 \$3866 QAb VDD pfet_03v3 L=0.28U W=0.36U AS=0.1584P AD=0.1152P
+ PS=1.6U PD=1U
M$1971 QBb \$3867 \$3733 VDD pfet_03v3 L=0.28U W=0.36U AS=0.1152P AD=0.1584P
+ PS=1U PD=1.6U
M$1972 VDD RB \$3867 VDD pfet_03v3 L=0.28U W=0.72U AS=0.3708P AD=0.3168P
+ PS=2.47U PD=2.32U
M$1973 \$4060 WE VDD VDD pfet_03v3 L=0.28U W=0.72U AS=0.3168P AD=0.1872P
+ PS=2.32U PD=1.24U
M$1974 VDD CLK \$4060 VDD pfet_03v3 L=0.28U W=0.72U AS=0.1872P AD=0.3168P
+ PS=1.24U PD=2.32U
M$1975 WECLK \$4060 VDD VDD pfet_03v3 L=0.28U W=2.54U AS=0.889P AD=0.6688P
+ PS=5.21U PD=3.65U
M$1979 \$4066 WECLKb \$4065 VDD pfet_03v3 L=0.28U W=0.36U AS=0.2097P AD=0.1278P
+ PS=1.38U PD=1.07U
M$1980 \$4168 \$4067 \$4066 VDD pfet_03v3 L=0.28U W=0.36U AS=0.1278P AD=0.0567P
+ PS=1.07U PD=0.675U
M$1981 VDD WECLK \$4168 VDD pfet_03v3 L=0.28U W=0.36U AS=0.0567P AD=0.1584P
+ PS=0.675U PD=1.6U
M$1982 \$4065 D|Q VDD VDD pfet_03v3 L=0.28U W=0.72U AS=0.3168P AD=0.2097P
+ PS=2.32U PD=1.38U
M$1983 VDD \$4066 \$4067 VDD pfet_03v3 L=0.28U W=0.36U AS=0.1584P AD=0.1764P
+ PS=1.6U PD=1.26U
M$1984 \$4068 \$4066 VDD VDD pfet_03v3 L=0.28U W=0.72U AS=0.1764P AD=0.36P
+ PS=1.26U PD=2.44U
M$1985 \$4069 RA VDD VDD pfet_03v3 L=0.28U W=0.72U AS=0.3312P AD=0.3888P
+ PS=2.36U PD=2.52U
M$1986 \$4068 \$4069 QAb VDD pfet_03v3 L=0.28U W=0.36U AS=0.1584P AD=0.1152P
+ PS=1.6U PD=1U
M$1987 QBb \$4070 \$4068 VDD pfet_03v3 L=0.28U W=0.36U AS=0.1152P AD=0.1584P
+ PS=1U PD=1.6U
M$1988 VDD RB \$4070 VDD pfet_03v3 L=0.28U W=0.72U AS=0.3708P AD=0.3168P
+ PS=2.47U PD=2.32U
M$1989 \$4073 WECLKb \$4072 VDD pfet_03v3 L=0.28U W=0.36U AS=0.2097P AD=0.1278P
+ PS=1.38U PD=1.07U
M$1990 \$4177 \$4074 \$4073 VDD pfet_03v3 L=0.28U W=0.36U AS=0.1278P AD=0.0567P
+ PS=1.07U PD=0.675U
M$1991 VDD WECLK \$4177 VDD pfet_03v3 L=0.28U W=0.36U AS=0.0567P AD=0.1584P
+ PS=0.675U PD=1.6U
M$1992 \$4072 D|Q VDD VDD pfet_03v3 L=0.28U W=0.72U AS=0.3168P AD=0.2097P
+ PS=2.32U PD=1.38U
M$1993 VDD \$4073 \$4074 VDD pfet_03v3 L=0.28U W=0.36U AS=0.1584P AD=0.1764P
+ PS=1.6U PD=1.26U
M$1994 \$4075 \$4073 VDD VDD pfet_03v3 L=0.28U W=0.72U AS=0.1764P AD=0.36P
+ PS=1.26U PD=2.44U
M$1995 \$4076 RA VDD VDD pfet_03v3 L=0.28U W=0.72U AS=0.3312P AD=0.3888P
+ PS=2.36U PD=2.52U
M$1996 \$4075 \$4076 QAb VDD pfet_03v3 L=0.28U W=0.36U AS=0.1584P AD=0.1152P
+ PS=1.6U PD=1U
M$1997 QBb \$4077 \$4075 VDD pfet_03v3 L=0.28U W=0.36U AS=0.1152P AD=0.1584P
+ PS=1U PD=1.6U
M$1998 VDD RB \$4077 VDD pfet_03v3 L=0.28U W=0.72U AS=0.3708P AD=0.3168P
+ PS=2.47U PD=2.32U
M$1999 \$4079 WECLKb \$4078 VDD pfet_03v3 L=0.28U W=0.36U AS=0.2097P AD=0.1278P
+ PS=1.38U PD=1.07U
M$2000 \$4187 \$4080 \$4079 VDD pfet_03v3 L=0.28U W=0.36U AS=0.1278P AD=0.0567P
+ PS=1.07U PD=0.675U
M$2001 VDD WECLK \$4187 VDD pfet_03v3 L=0.28U W=0.36U AS=0.0567P AD=0.1584P
+ PS=0.675U PD=1.6U
M$2002 \$4078 D|Q VDD VDD pfet_03v3 L=0.28U W=0.72U AS=0.3168P AD=0.2097P
+ PS=2.32U PD=1.38U
M$2003 VDD \$4079 \$4080 VDD pfet_03v3 L=0.28U W=0.36U AS=0.1584P AD=0.1764P
+ PS=1.6U PD=1.26U
M$2004 \$4081 \$4079 VDD VDD pfet_03v3 L=0.28U W=0.72U AS=0.1764P AD=0.36P
+ PS=1.26U PD=2.44U
M$2005 \$4082 RA VDD VDD pfet_03v3 L=0.28U W=0.72U AS=0.3312P AD=0.3888P
+ PS=2.36U PD=2.52U
M$2006 \$4081 \$4082 QAb VDD pfet_03v3 L=0.28U W=0.36U AS=0.1584P AD=0.1152P
+ PS=1.6U PD=1U
M$2007 QBb \$4083 \$4081 VDD pfet_03v3 L=0.28U W=0.36U AS=0.1152P AD=0.1584P
+ PS=1U PD=1.6U
M$2008 VDD RB \$4083 VDD pfet_03v3 L=0.28U W=0.72U AS=0.3708P AD=0.3168P
+ PS=2.47U PD=2.32U
M$2009 \$4085 WECLKb \$4084 VDD pfet_03v3 L=0.28U W=0.36U AS=0.2097P AD=0.1278P
+ PS=1.38U PD=1.07U
M$2010 \$4198 \$4086 \$4085 VDD pfet_03v3 L=0.28U W=0.36U AS=0.1278P AD=0.0567P
+ PS=1.07U PD=0.675U
M$2011 VDD WECLK \$4198 VDD pfet_03v3 L=0.28U W=0.36U AS=0.0567P AD=0.1584P
+ PS=0.675U PD=1.6U
M$2012 \$4084 D|Q VDD VDD pfet_03v3 L=0.28U W=0.72U AS=0.3168P AD=0.2097P
+ PS=2.32U PD=1.38U
M$2013 VDD \$4085 \$4086 VDD pfet_03v3 L=0.28U W=0.36U AS=0.1584P AD=0.1764P
+ PS=1.6U PD=1.26U
M$2014 \$4087 \$4085 VDD VDD pfet_03v3 L=0.28U W=0.72U AS=0.1764P AD=0.36P
+ PS=1.26U PD=2.44U
M$2015 \$4088 RA VDD VDD pfet_03v3 L=0.28U W=0.72U AS=0.3312P AD=0.3888P
+ PS=2.36U PD=2.52U
M$2016 \$4087 \$4088 QAb VDD pfet_03v3 L=0.28U W=0.36U AS=0.1584P AD=0.1152P
+ PS=1.6U PD=1U
M$2017 QBb \$4089 \$4087 VDD pfet_03v3 L=0.28U W=0.36U AS=0.1152P AD=0.1584P
+ PS=1U PD=1.6U
M$2018 VDD RB \$4089 VDD pfet_03v3 L=0.28U W=0.72U AS=0.3708P AD=0.3168P
+ PS=2.47U PD=2.32U
M$2019 \$4091 WECLKb \$4090 VDD pfet_03v3 L=0.28U W=0.36U AS=0.2097P AD=0.1278P
+ PS=1.38U PD=1.07U
M$2020 \$4210 \$4092 \$4091 VDD pfet_03v3 L=0.28U W=0.36U AS=0.1278P AD=0.0567P
+ PS=1.07U PD=0.675U
M$2021 VDD WECLK \$4210 VDD pfet_03v3 L=0.28U W=0.36U AS=0.0567P AD=0.1584P
+ PS=0.675U PD=1.6U
M$2022 \$4090 D|Q VDD VDD pfet_03v3 L=0.28U W=0.72U AS=0.3168P AD=0.2097P
+ PS=2.32U PD=1.38U
M$2023 VDD \$4091 \$4092 VDD pfet_03v3 L=0.28U W=0.36U AS=0.1584P AD=0.1764P
+ PS=1.6U PD=1.26U
M$2024 \$4093 \$4091 VDD VDD pfet_03v3 L=0.28U W=0.72U AS=0.1764P AD=0.36P
+ PS=1.26U PD=2.44U
M$2025 \$4094 RA VDD VDD pfet_03v3 L=0.28U W=0.72U AS=0.3312P AD=0.3888P
+ PS=2.36U PD=2.52U
M$2026 \$4093 \$4094 QAb VDD pfet_03v3 L=0.28U W=0.36U AS=0.1584P AD=0.1152P
+ PS=1.6U PD=1U
M$2027 QBb \$4095 \$4093 VDD pfet_03v3 L=0.28U W=0.36U AS=0.1152P AD=0.1584P
+ PS=1U PD=1.6U
M$2028 VDD RB \$4095 VDD pfet_03v3 L=0.28U W=0.72U AS=0.3708P AD=0.3168P
+ PS=2.47U PD=2.32U
M$2029 \$4097 WECLKb \$4096 VDD pfet_03v3 L=0.28U W=0.36U AS=0.2097P AD=0.1278P
+ PS=1.38U PD=1.07U
M$2030 \$4219 \$4098 \$4097 VDD pfet_03v3 L=0.28U W=0.36U AS=0.1278P AD=0.0567P
+ PS=1.07U PD=0.675U
M$2031 VDD WECLK \$4219 VDD pfet_03v3 L=0.28U W=0.36U AS=0.0567P AD=0.1584P
+ PS=0.675U PD=1.6U
M$2032 \$4096 D|Q VDD VDD pfet_03v3 L=0.28U W=0.72U AS=0.3168P AD=0.2097P
+ PS=2.32U PD=1.38U
M$2033 VDD \$4097 \$4098 VDD pfet_03v3 L=0.28U W=0.36U AS=0.1584P AD=0.1764P
+ PS=1.6U PD=1.26U
M$2034 \$4099 \$4097 VDD VDD pfet_03v3 L=0.28U W=0.72U AS=0.1764P AD=0.36P
+ PS=1.26U PD=2.44U
M$2035 \$4100 RA VDD VDD pfet_03v3 L=0.28U W=0.72U AS=0.3312P AD=0.3888P
+ PS=2.36U PD=2.52U
M$2036 \$4099 \$4100 QAb VDD pfet_03v3 L=0.28U W=0.36U AS=0.1584P AD=0.1152P
+ PS=1.6U PD=1U
M$2037 QBb \$4101 \$4099 VDD pfet_03v3 L=0.28U W=0.36U AS=0.1152P AD=0.1584P
+ PS=1U PD=1.6U
M$2038 VDD RB \$4101 VDD pfet_03v3 L=0.28U W=0.72U AS=0.3708P AD=0.3168P
+ PS=2.47U PD=2.32U
M$2039 \$4103 WECLKb \$4102 VDD pfet_03v3 L=0.28U W=0.36U AS=0.2097P AD=0.1278P
+ PS=1.38U PD=1.07U
M$2040 \$4228 \$4104 \$4103 VDD pfet_03v3 L=0.28U W=0.36U AS=0.1278P AD=0.0567P
+ PS=1.07U PD=0.675U
M$2041 VDD WECLK \$4228 VDD pfet_03v3 L=0.28U W=0.36U AS=0.0567P AD=0.1584P
+ PS=0.675U PD=1.6U
M$2042 \$4102 D|Q VDD VDD pfet_03v3 L=0.28U W=0.72U AS=0.3168P AD=0.2097P
+ PS=2.32U PD=1.38U
M$2043 VDD \$4103 \$4104 VDD pfet_03v3 L=0.28U W=0.36U AS=0.1584P AD=0.1764P
+ PS=1.6U PD=1.26U
M$2044 \$4105 \$4103 VDD VDD pfet_03v3 L=0.28U W=0.72U AS=0.1764P AD=0.36P
+ PS=1.26U PD=2.44U
M$2045 \$4106 RA VDD VDD pfet_03v3 L=0.28U W=0.72U AS=0.3312P AD=0.3888P
+ PS=2.36U PD=2.52U
M$2046 \$4105 \$4106 QAb VDD pfet_03v3 L=0.28U W=0.36U AS=0.1584P AD=0.1152P
+ PS=1.6U PD=1U
M$2047 QBb \$4107 \$4105 VDD pfet_03v3 L=0.28U W=0.36U AS=0.1152P AD=0.1584P
+ PS=1U PD=1.6U
M$2048 VDD RB \$4107 VDD pfet_03v3 L=0.28U W=0.72U AS=0.3708P AD=0.3168P
+ PS=2.47U PD=2.32U
M$2049 \$4109 WECLKb \$4108 VDD pfet_03v3 L=0.28U W=0.36U AS=0.2097P AD=0.1278P
+ PS=1.38U PD=1.07U
M$2050 \$4240 \$4110 \$4109 VDD pfet_03v3 L=0.28U W=0.36U AS=0.1278P AD=0.0567P
+ PS=1.07U PD=0.675U
M$2051 VDD WECLK \$4240 VDD pfet_03v3 L=0.28U W=0.36U AS=0.0567P AD=0.1584P
+ PS=0.675U PD=1.6U
M$2052 \$4108 D|Q VDD VDD pfet_03v3 L=0.28U W=0.72U AS=0.3168P AD=0.2097P
+ PS=2.32U PD=1.38U
M$2053 VDD \$4109 \$4110 VDD pfet_03v3 L=0.28U W=0.36U AS=0.1584P AD=0.1764P
+ PS=1.6U PD=1.26U
M$2054 \$4111 \$4109 VDD VDD pfet_03v3 L=0.28U W=0.72U AS=0.1764P AD=0.36P
+ PS=1.26U PD=2.44U
M$2055 \$4112 RA VDD VDD pfet_03v3 L=0.28U W=0.72U AS=0.3312P AD=0.3888P
+ PS=2.36U PD=2.52U
M$2056 \$4111 \$4112 QAb VDD pfet_03v3 L=0.28U W=0.36U AS=0.1584P AD=0.1152P
+ PS=1.6U PD=1U
M$2057 QBb \$4113 \$4111 VDD pfet_03v3 L=0.28U W=0.36U AS=0.1152P AD=0.1584P
+ PS=1U PD=1.6U
M$2058 VDD RB \$4113 VDD pfet_03v3 L=0.28U W=0.72U AS=0.3708P AD=0.3168P
+ PS=2.47U PD=2.32U
M$2059 \$4115 WECLKb \$4114 VDD pfet_03v3 L=0.28U W=0.36U AS=0.2097P AD=0.1278P
+ PS=1.38U PD=1.07U
M$2060 \$4251 \$4116 \$4115 VDD pfet_03v3 L=0.28U W=0.36U AS=0.1278P AD=0.0567P
+ PS=1.07U PD=0.675U
M$2061 VDD WECLK \$4251 VDD pfet_03v3 L=0.28U W=0.36U AS=0.0567P AD=0.1584P
+ PS=0.675U PD=1.6U
M$2062 \$4114 D|Q VDD VDD pfet_03v3 L=0.28U W=0.72U AS=0.3168P AD=0.2097P
+ PS=2.32U PD=1.38U
M$2063 VDD \$4115 \$4116 VDD pfet_03v3 L=0.28U W=0.36U AS=0.1584P AD=0.1764P
+ PS=1.6U PD=1.26U
M$2064 \$4117 \$4115 VDD VDD pfet_03v3 L=0.28U W=0.72U AS=0.1764P AD=0.36P
+ PS=1.26U PD=2.44U
M$2065 \$4118 RA VDD VDD pfet_03v3 L=0.28U W=0.72U AS=0.3312P AD=0.3888P
+ PS=2.36U PD=2.52U
M$2066 \$4117 \$4118 QAb VDD pfet_03v3 L=0.28U W=0.36U AS=0.1584P AD=0.1152P
+ PS=1.6U PD=1U
M$2067 QBb \$4119 \$4117 VDD pfet_03v3 L=0.28U W=0.36U AS=0.1152P AD=0.1584P
+ PS=1U PD=1.6U
M$2068 VDD RB \$4119 VDD pfet_03v3 L=0.28U W=0.72U AS=0.3708P AD=0.3168P
+ PS=2.47U PD=2.32U
M$2069 \$4121 WECLKb \$4120 VDD pfet_03v3 L=0.28U W=0.36U AS=0.2097P AD=0.1278P
+ PS=1.38U PD=1.07U
M$2070 \$4261 \$4122 \$4121 VDD pfet_03v3 L=0.28U W=0.36U AS=0.1278P AD=0.0567P
+ PS=1.07U PD=0.675U
M$2071 VDD WECLK \$4261 VDD pfet_03v3 L=0.28U W=0.36U AS=0.0567P AD=0.1584P
+ PS=0.675U PD=1.6U
M$2072 \$4120 D|Q VDD VDD pfet_03v3 L=0.28U W=0.72U AS=0.3168P AD=0.2097P
+ PS=2.32U PD=1.38U
M$2073 VDD \$4121 \$4122 VDD pfet_03v3 L=0.28U W=0.36U AS=0.1584P AD=0.1764P
+ PS=1.6U PD=1.26U
M$2074 \$4123 \$4121 VDD VDD pfet_03v3 L=0.28U W=0.72U AS=0.1764P AD=0.36P
+ PS=1.26U PD=2.44U
M$2075 \$4124 RA VDD VDD pfet_03v3 L=0.28U W=0.72U AS=0.3312P AD=0.3888P
+ PS=2.36U PD=2.52U
M$2076 \$4123 \$4124 QAb VDD pfet_03v3 L=0.28U W=0.36U AS=0.1584P AD=0.1152P
+ PS=1.6U PD=1U
M$2077 QBb \$4125 \$4123 VDD pfet_03v3 L=0.28U W=0.36U AS=0.1152P AD=0.1584P
+ PS=1U PD=1.6U
M$2078 VDD RB \$4125 VDD pfet_03v3 L=0.28U W=0.72U AS=0.3708P AD=0.3168P
+ PS=2.47U PD=2.32U
M$2079 \$4127 WECLKb \$4126 VDD pfet_03v3 L=0.28U W=0.36U AS=0.2097P AD=0.1278P
+ PS=1.38U PD=1.07U
M$2080 \$4270 \$4128 \$4127 VDD pfet_03v3 L=0.28U W=0.36U AS=0.1278P AD=0.0567P
+ PS=1.07U PD=0.675U
M$2081 VDD WECLK \$4270 VDD pfet_03v3 L=0.28U W=0.36U AS=0.0567P AD=0.1584P
+ PS=0.675U PD=1.6U
M$2082 \$4126 D|Q VDD VDD pfet_03v3 L=0.28U W=0.72U AS=0.3168P AD=0.2097P
+ PS=2.32U PD=1.38U
M$2083 VDD \$4127 \$4128 VDD pfet_03v3 L=0.28U W=0.36U AS=0.1584P AD=0.1764P
+ PS=1.6U PD=1.26U
M$2084 \$4129 \$4127 VDD VDD pfet_03v3 L=0.28U W=0.72U AS=0.1764P AD=0.36P
+ PS=1.26U PD=2.44U
M$2085 \$4130 RA VDD VDD pfet_03v3 L=0.28U W=0.72U AS=0.3312P AD=0.3888P
+ PS=2.36U PD=2.52U
M$2086 \$4129 \$4130 QAb VDD pfet_03v3 L=0.28U W=0.36U AS=0.1584P AD=0.1152P
+ PS=1.6U PD=1U
M$2087 QBb \$4131 \$4129 VDD pfet_03v3 L=0.28U W=0.36U AS=0.1152P AD=0.1584P
+ PS=1U PD=1.6U
M$2088 VDD RB \$4131 VDD pfet_03v3 L=0.28U W=0.72U AS=0.3708P AD=0.3168P
+ PS=2.47U PD=2.32U
M$2089 \$4133 WECLKb \$4132 VDD pfet_03v3 L=0.28U W=0.36U AS=0.2097P AD=0.1278P
+ PS=1.38U PD=1.07U
M$2090 \$4282 \$4134 \$4133 VDD pfet_03v3 L=0.28U W=0.36U AS=0.1278P AD=0.0567P
+ PS=1.07U PD=0.675U
M$2091 VDD WECLK \$4282 VDD pfet_03v3 L=0.28U W=0.36U AS=0.0567P AD=0.1584P
+ PS=0.675U PD=1.6U
M$2092 \$4132 D|Q VDD VDD pfet_03v3 L=0.28U W=0.72U AS=0.3168P AD=0.2097P
+ PS=2.32U PD=1.38U
M$2093 VDD \$4133 \$4134 VDD pfet_03v3 L=0.28U W=0.36U AS=0.1584P AD=0.1764P
+ PS=1.6U PD=1.26U
M$2094 \$4135 \$4133 VDD VDD pfet_03v3 L=0.28U W=0.72U AS=0.1764P AD=0.36P
+ PS=1.26U PD=2.44U
M$2095 \$4136 RA VDD VDD pfet_03v3 L=0.28U W=0.72U AS=0.3312P AD=0.3888P
+ PS=2.36U PD=2.52U
M$2096 \$4135 \$4136 QAb VDD pfet_03v3 L=0.28U W=0.36U AS=0.1584P AD=0.1152P
+ PS=1.6U PD=1U
M$2097 QBb \$4137 \$4135 VDD pfet_03v3 L=0.28U W=0.36U AS=0.1152P AD=0.1584P
+ PS=1U PD=1.6U
M$2098 VDD RB \$4137 VDD pfet_03v3 L=0.28U W=0.72U AS=0.3708P AD=0.3168P
+ PS=2.47U PD=2.32U
M$2099 \$4139 WECLKb \$4138 VDD pfet_03v3 L=0.28U W=0.36U AS=0.2097P AD=0.1278P
+ PS=1.38U PD=1.07U
M$2100 \$4290 \$4140 \$4139 VDD pfet_03v3 L=0.28U W=0.36U AS=0.1278P AD=0.0567P
+ PS=1.07U PD=0.675U
M$2101 VDD WECLK \$4290 VDD pfet_03v3 L=0.28U W=0.36U AS=0.0567P AD=0.1584P
+ PS=0.675U PD=1.6U
M$2102 \$4138 D|Q VDD VDD pfet_03v3 L=0.28U W=0.72U AS=0.3168P AD=0.2097P
+ PS=2.32U PD=1.38U
M$2103 VDD \$4139 \$4140 VDD pfet_03v3 L=0.28U W=0.36U AS=0.1584P AD=0.1764P
+ PS=1.6U PD=1.26U
M$2104 \$4141 \$4139 VDD VDD pfet_03v3 L=0.28U W=0.72U AS=0.1764P AD=0.36P
+ PS=1.26U PD=2.44U
M$2105 \$4142 RA VDD VDD pfet_03v3 L=0.28U W=0.72U AS=0.3312P AD=0.3888P
+ PS=2.36U PD=2.52U
M$2106 \$4141 \$4142 QAb VDD pfet_03v3 L=0.28U W=0.36U AS=0.1584P AD=0.1152P
+ PS=1.6U PD=1U
M$2107 QBb \$4143 \$4141 VDD pfet_03v3 L=0.28U W=0.36U AS=0.1152P AD=0.1584P
+ PS=1U PD=1.6U
M$2108 VDD RB \$4143 VDD pfet_03v3 L=0.28U W=0.72U AS=0.3708P AD=0.3168P
+ PS=2.47U PD=2.32U
M$2109 \$4145 WECLKb \$4144 VDD pfet_03v3 L=0.28U W=0.36U AS=0.2097P AD=0.1278P
+ PS=1.38U PD=1.07U
M$2110 \$4253 \$4146 \$4145 VDD pfet_03v3 L=0.28U W=0.36U AS=0.1278P AD=0.0567P
+ PS=1.07U PD=0.675U
M$2111 VDD WECLK \$4253 VDD pfet_03v3 L=0.28U W=0.36U AS=0.0567P AD=0.1584P
+ PS=0.675U PD=1.6U
M$2112 \$4144 D|Q VDD VDD pfet_03v3 L=0.28U W=0.72U AS=0.3168P AD=0.2097P
+ PS=2.32U PD=1.38U
M$2113 VDD \$4145 \$4146 VDD pfet_03v3 L=0.28U W=0.36U AS=0.1584P AD=0.1764P
+ PS=1.6U PD=1.26U
M$2114 \$4147 \$4145 VDD VDD pfet_03v3 L=0.28U W=0.72U AS=0.1764P AD=0.36P
+ PS=1.26U PD=2.44U
M$2115 \$4148 RA VDD VDD pfet_03v3 L=0.28U W=0.72U AS=0.3312P AD=0.3888P
+ PS=2.36U PD=2.52U
M$2116 \$4147 \$4148 QAb VDD pfet_03v3 L=0.28U W=0.36U AS=0.1584P AD=0.1152P
+ PS=1.6U PD=1U
M$2117 QBb \$4149 \$4147 VDD pfet_03v3 L=0.28U W=0.36U AS=0.1152P AD=0.1584P
+ PS=1U PD=1.6U
M$2118 VDD RB \$4149 VDD pfet_03v3 L=0.28U W=0.72U AS=0.3708P AD=0.3168P
+ PS=2.47U PD=2.32U
M$2119 \$4151 WECLKb \$4150 VDD pfet_03v3 L=0.28U W=0.36U AS=0.2097P AD=0.1278P
+ PS=1.38U PD=1.07U
M$2120 \$4224 \$4152 \$4151 VDD pfet_03v3 L=0.28U W=0.36U AS=0.1278P AD=0.0567P
+ PS=1.07U PD=0.675U
M$2121 VDD WECLK \$4224 VDD pfet_03v3 L=0.28U W=0.36U AS=0.0567P AD=0.1584P
+ PS=0.675U PD=1.6U
M$2122 \$4150 D|Q VDD VDD pfet_03v3 L=0.28U W=0.72U AS=0.3168P AD=0.2097P
+ PS=2.32U PD=1.38U
M$2123 VDD \$4151 \$4152 VDD pfet_03v3 L=0.28U W=0.36U AS=0.1584P AD=0.1764P
+ PS=1.6U PD=1.26U
M$2124 \$4153 \$4151 VDD VDD pfet_03v3 L=0.28U W=0.72U AS=0.1764P AD=0.36P
+ PS=1.26U PD=2.44U
M$2125 \$4154 RA VDD VDD pfet_03v3 L=0.28U W=0.72U AS=0.3312P AD=0.3888P
+ PS=2.36U PD=2.52U
M$2126 \$4153 \$4154 QAb VDD pfet_03v3 L=0.28U W=0.36U AS=0.1584P AD=0.1152P
+ PS=1.6U PD=1U
M$2127 QBb \$4155 \$4153 VDD pfet_03v3 L=0.28U W=0.36U AS=0.1152P AD=0.1584P
+ PS=1U PD=1.6U
M$2128 VDD RB \$4155 VDD pfet_03v3 L=0.28U W=0.72U AS=0.3708P AD=0.3168P
+ PS=2.47U PD=2.32U
M$2129 \$4157 WECLKb \$4156 VDD pfet_03v3 L=0.28U W=0.36U AS=0.2097P AD=0.1278P
+ PS=1.38U PD=1.07U
M$2130 \$4189 \$4158 \$4157 VDD pfet_03v3 L=0.28U W=0.36U AS=0.1278P AD=0.0567P
+ PS=1.07U PD=0.675U
M$2131 VDD WECLK \$4189 VDD pfet_03v3 L=0.28U W=0.36U AS=0.0567P AD=0.1584P
+ PS=0.675U PD=1.6U
M$2132 \$4156 D|Q VDD VDD pfet_03v3 L=0.28U W=0.72U AS=0.3168P AD=0.2097P
+ PS=2.32U PD=1.38U
M$2133 VDD \$4157 \$4158 VDD pfet_03v3 L=0.28U W=0.36U AS=0.1584P AD=0.1764P
+ PS=1.6U PD=1.26U
M$2134 \$4159 \$4157 VDD VDD pfet_03v3 L=0.28U W=0.72U AS=0.1764P AD=0.36P
+ PS=1.26U PD=2.44U
M$2135 \$4160 RA VDD VDD pfet_03v3 L=0.28U W=0.72U AS=0.3312P AD=0.3888P
+ PS=2.36U PD=2.52U
M$2136 \$4159 \$4160 QAb VDD pfet_03v3 L=0.28U W=0.36U AS=0.1584P AD=0.1152P
+ PS=1.6U PD=1U
M$2137 QBb \$4161 \$4159 VDD pfet_03v3 L=0.28U W=0.36U AS=0.1152P AD=0.1584P
+ PS=1U PD=1.6U
M$2138 VDD RB \$4161 VDD pfet_03v3 L=0.28U W=0.72U AS=0.3708P AD=0.3168P
+ PS=2.47U PD=2.32U
M$2139 \$4411 WE VDD VDD pfet_03v3 L=0.28U W=0.72U AS=0.3168P AD=0.1872P
+ PS=2.32U PD=1.24U
M$2140 VDD CLK \$4411 VDD pfet_03v3 L=0.28U W=0.72U AS=0.1872P AD=0.3168P
+ PS=1.24U PD=2.32U
M$2141 WECLK \$4411 VDD VDD pfet_03v3 L=0.28U W=2.54U AS=0.8974P AD=0.6604P
+ PS=5.28U PD=3.58U
M$2145 \$4414 D|Q VDD VDD pfet_03v3 L=0.28U W=0.72U AS=0.3168P AD=0.2097P
+ PS=2.32U PD=1.38U
M$2146 \$4415 WECLKb \$4414 VDD pfet_03v3 L=0.28U W=0.36U AS=0.2097P AD=0.1278P
+ PS=1.38U PD=1.07U
M$2147 \$4637 \$4416 \$4415 VDD pfet_03v3 L=0.28U W=0.36U AS=0.1278P AD=0.0567P
+ PS=1.07U PD=0.675U
M$2148 VDD WECLK \$4637 VDD pfet_03v3 L=0.28U W=0.36U AS=0.0567P AD=0.1584P
+ PS=0.675U PD=1.6U
M$2149 \$4416 \$4415 VDD VDD pfet_03v3 L=0.28U W=0.36U AS=0.1764P AD=0.1584P
+ PS=1.26U PD=1.6U
M$2150 \$4395 \$4415 VDD VDD pfet_03v3 L=0.28U W=0.72U AS=0.1764P AD=0.36P
+ PS=1.26U PD=2.44U
M$2151 \$4514 RA VDD VDD pfet_03v3 L=0.28U W=0.72U AS=0.3312P AD=0.3888P
+ PS=2.36U PD=2.52U
M$2152 \$4395 \$4514 QAb VDD pfet_03v3 L=0.28U W=0.36U AS=0.1584P AD=0.1152P
+ PS=1.6U PD=1U
M$2153 QBb \$4515 \$4395 VDD pfet_03v3 L=0.28U W=0.36U AS=0.1152P AD=0.1584P
+ PS=1U PD=1.6U
M$2154 VDD RB \$4515 VDD pfet_03v3 L=0.28U W=0.72U AS=0.3708P AD=0.3168P
+ PS=2.47U PD=2.32U
M$2155 \$4417 D|Q VDD VDD pfet_03v3 L=0.28U W=0.72U AS=0.3168P AD=0.2097P
+ PS=2.32U PD=1.38U
M$2156 \$4418 WECLKb \$4417 VDD pfet_03v3 L=0.28U W=0.36U AS=0.2097P AD=0.1278P
+ PS=1.38U PD=1.07U
M$2157 \$4646 \$4419 \$4418 VDD pfet_03v3 L=0.28U W=0.36U AS=0.1278P AD=0.0567P
+ PS=1.07U PD=0.675U
M$2158 VDD WECLK \$4646 VDD pfet_03v3 L=0.28U W=0.36U AS=0.0567P AD=0.1584P
+ PS=0.675U PD=1.6U
M$2159 \$4419 \$4418 VDD VDD pfet_03v3 L=0.28U W=0.36U AS=0.1764P AD=0.1584P
+ PS=1.26U PD=1.6U
M$2160 \$4396 \$4418 VDD VDD pfet_03v3 L=0.28U W=0.72U AS=0.1764P AD=0.36P
+ PS=1.26U PD=2.44U
M$2161 \$4516 RA VDD VDD pfet_03v3 L=0.28U W=0.72U AS=0.3312P AD=0.3888P
+ PS=2.36U PD=2.52U
M$2162 \$4396 \$4516 QAb VDD pfet_03v3 L=0.28U W=0.36U AS=0.1584P AD=0.1152P
+ PS=1.6U PD=1U
M$2163 QBb \$4517 \$4396 VDD pfet_03v3 L=0.28U W=0.36U AS=0.1152P AD=0.1584P
+ PS=1U PD=1.6U
M$2164 VDD RB \$4517 VDD pfet_03v3 L=0.28U W=0.72U AS=0.3708P AD=0.3168P
+ PS=2.47U PD=2.32U
M$2165 \$4420 D|Q VDD VDD pfet_03v3 L=0.28U W=0.72U AS=0.3168P AD=0.2097P
+ PS=2.32U PD=1.38U
M$2166 \$4421 WECLKb \$4420 VDD pfet_03v3 L=0.28U W=0.36U AS=0.2097P AD=0.1278P
+ PS=1.38U PD=1.07U
M$2167 \$4654 \$4422 \$4421 VDD pfet_03v3 L=0.28U W=0.36U AS=0.1278P AD=0.0567P
+ PS=1.07U PD=0.675U
M$2168 VDD WECLK \$4654 VDD pfet_03v3 L=0.28U W=0.36U AS=0.0567P AD=0.1584P
+ PS=0.675U PD=1.6U
M$2169 \$4422 \$4421 VDD VDD pfet_03v3 L=0.28U W=0.36U AS=0.1764P AD=0.1584P
+ PS=1.26U PD=1.6U
M$2170 \$4397 \$4421 VDD VDD pfet_03v3 L=0.28U W=0.72U AS=0.1764P AD=0.36P
+ PS=1.26U PD=2.44U
M$2171 \$4518 RA VDD VDD pfet_03v3 L=0.28U W=0.72U AS=0.3312P AD=0.3888P
+ PS=2.36U PD=2.52U
M$2172 \$4397 \$4518 QAb VDD pfet_03v3 L=0.28U W=0.36U AS=0.1584P AD=0.1152P
+ PS=1.6U PD=1U
M$2173 QBb \$4519 \$4397 VDD pfet_03v3 L=0.28U W=0.36U AS=0.1152P AD=0.1584P
+ PS=1U PD=1.6U
M$2174 VDD RB \$4519 VDD pfet_03v3 L=0.28U W=0.72U AS=0.3708P AD=0.3168P
+ PS=2.47U PD=2.32U
M$2175 \$4423 D|Q VDD VDD pfet_03v3 L=0.28U W=0.72U AS=0.3168P AD=0.2097P
+ PS=2.32U PD=1.38U
M$2176 \$4424 WECLKb \$4423 VDD pfet_03v3 L=0.28U W=0.36U AS=0.2097P AD=0.1278P
+ PS=1.38U PD=1.07U
M$2177 \$4663 \$4425 \$4424 VDD pfet_03v3 L=0.28U W=0.36U AS=0.1278P AD=0.0567P
+ PS=1.07U PD=0.675U
M$2178 VDD WECLK \$4663 VDD pfet_03v3 L=0.28U W=0.36U AS=0.0567P AD=0.1584P
+ PS=0.675U PD=1.6U
M$2179 \$4425 \$4424 VDD VDD pfet_03v3 L=0.28U W=0.36U AS=0.1764P AD=0.1584P
+ PS=1.26U PD=1.6U
M$2180 \$4398 \$4424 VDD VDD pfet_03v3 L=0.28U W=0.72U AS=0.1764P AD=0.36P
+ PS=1.26U PD=2.44U
M$2181 \$4520 RA VDD VDD pfet_03v3 L=0.28U W=0.72U AS=0.3312P AD=0.3888P
+ PS=2.36U PD=2.52U
M$2182 \$4398 \$4520 QAb VDD pfet_03v3 L=0.28U W=0.36U AS=0.1584P AD=0.1152P
+ PS=1.6U PD=1U
M$2183 QBb \$4521 \$4398 VDD pfet_03v3 L=0.28U W=0.36U AS=0.1152P AD=0.1584P
+ PS=1U PD=1.6U
M$2184 VDD RB \$4521 VDD pfet_03v3 L=0.28U W=0.72U AS=0.3708P AD=0.3168P
+ PS=2.47U PD=2.32U
M$2185 \$4426 D|Q VDD VDD pfet_03v3 L=0.28U W=0.72U AS=0.3168P AD=0.2097P
+ PS=2.32U PD=1.38U
M$2186 \$4427 WECLKb \$4426 VDD pfet_03v3 L=0.28U W=0.36U AS=0.2097P AD=0.1278P
+ PS=1.38U PD=1.07U
M$2187 \$4674 \$4428 \$4427 VDD pfet_03v3 L=0.28U W=0.36U AS=0.1278P AD=0.0567P
+ PS=1.07U PD=0.675U
M$2188 VDD WECLK \$4674 VDD pfet_03v3 L=0.28U W=0.36U AS=0.0567P AD=0.1584P
+ PS=0.675U PD=1.6U
M$2189 \$4428 \$4427 VDD VDD pfet_03v3 L=0.28U W=0.36U AS=0.1764P AD=0.1584P
+ PS=1.26U PD=1.6U
M$2190 \$4399 \$4427 VDD VDD pfet_03v3 L=0.28U W=0.72U AS=0.1764P AD=0.36P
+ PS=1.26U PD=2.44U
M$2191 \$4522 RA VDD VDD pfet_03v3 L=0.28U W=0.72U AS=0.3312P AD=0.3888P
+ PS=2.36U PD=2.52U
M$2192 \$4399 \$4522 QAb VDD pfet_03v3 L=0.28U W=0.36U AS=0.1584P AD=0.1152P
+ PS=1.6U PD=1U
M$2193 QBb \$4523 \$4399 VDD pfet_03v3 L=0.28U W=0.36U AS=0.1152P AD=0.1584P
+ PS=1U PD=1.6U
M$2194 VDD RB \$4523 VDD pfet_03v3 L=0.28U W=0.72U AS=0.3708P AD=0.3168P
+ PS=2.47U PD=2.32U
M$2195 \$4429 D|Q VDD VDD pfet_03v3 L=0.28U W=0.72U AS=0.3168P AD=0.2097P
+ PS=2.32U PD=1.38U
M$2196 \$4430 WECLKb \$4429 VDD pfet_03v3 L=0.28U W=0.36U AS=0.2097P AD=0.1278P
+ PS=1.38U PD=1.07U
M$2197 \$4683 \$4431 \$4430 VDD pfet_03v3 L=0.28U W=0.36U AS=0.1278P AD=0.0567P
+ PS=1.07U PD=0.675U
M$2198 VDD WECLK \$4683 VDD pfet_03v3 L=0.28U W=0.36U AS=0.0567P AD=0.1584P
+ PS=0.675U PD=1.6U
M$2199 \$4431 \$4430 VDD VDD pfet_03v3 L=0.28U W=0.36U AS=0.1764P AD=0.1584P
+ PS=1.26U PD=1.6U
M$2200 \$4400 \$4430 VDD VDD pfet_03v3 L=0.28U W=0.72U AS=0.1764P AD=0.36P
+ PS=1.26U PD=2.44U
M$2201 \$4524 RA VDD VDD pfet_03v3 L=0.28U W=0.72U AS=0.3312P AD=0.3888P
+ PS=2.36U PD=2.52U
M$2202 \$4400 \$4524 QAb VDD pfet_03v3 L=0.28U W=0.36U AS=0.1584P AD=0.1152P
+ PS=1.6U PD=1U
M$2203 QBb \$4525 \$4400 VDD pfet_03v3 L=0.28U W=0.36U AS=0.1152P AD=0.1584P
+ PS=1U PD=1.6U
M$2204 VDD RB \$4525 VDD pfet_03v3 L=0.28U W=0.72U AS=0.3708P AD=0.3168P
+ PS=2.47U PD=2.32U
M$2205 \$4432 D|Q VDD VDD pfet_03v3 L=0.28U W=0.72U AS=0.3168P AD=0.2097P
+ PS=2.32U PD=1.38U
M$2206 \$4433 WECLKb \$4432 VDD pfet_03v3 L=0.28U W=0.36U AS=0.2097P AD=0.1278P
+ PS=1.38U PD=1.07U
M$2207 \$4690 \$4434 \$4433 VDD pfet_03v3 L=0.28U W=0.36U AS=0.1278P AD=0.0567P
+ PS=1.07U PD=0.675U
M$2208 VDD WECLK \$4690 VDD pfet_03v3 L=0.28U W=0.36U AS=0.0567P AD=0.1584P
+ PS=0.675U PD=1.6U
M$2209 \$4434 \$4433 VDD VDD pfet_03v3 L=0.28U W=0.36U AS=0.1764P AD=0.1584P
+ PS=1.26U PD=1.6U
M$2210 \$4401 \$4433 VDD VDD pfet_03v3 L=0.28U W=0.72U AS=0.1764P AD=0.36P
+ PS=1.26U PD=2.44U
M$2211 \$4526 RA VDD VDD pfet_03v3 L=0.28U W=0.72U AS=0.3312P AD=0.3888P
+ PS=2.36U PD=2.52U
M$2212 \$4401 \$4526 QAb VDD pfet_03v3 L=0.28U W=0.36U AS=0.1584P AD=0.1152P
+ PS=1.6U PD=1U
M$2213 QBb \$4527 \$4401 VDD pfet_03v3 L=0.28U W=0.36U AS=0.1152P AD=0.1584P
+ PS=1U PD=1.6U
M$2214 VDD RB \$4527 VDD pfet_03v3 L=0.28U W=0.72U AS=0.3708P AD=0.3168P
+ PS=2.47U PD=2.32U
M$2215 \$4435 D|Q VDD VDD pfet_03v3 L=0.28U W=0.72U AS=0.3168P AD=0.2097P
+ PS=2.32U PD=1.38U
M$2216 \$4436 WECLKb \$4435 VDD pfet_03v3 L=0.28U W=0.36U AS=0.2097P AD=0.1278P
+ PS=1.38U PD=1.07U
M$2217 \$4699 \$4437 \$4436 VDD pfet_03v3 L=0.28U W=0.36U AS=0.1278P AD=0.0567P
+ PS=1.07U PD=0.675U
M$2218 VDD WECLK \$4699 VDD pfet_03v3 L=0.28U W=0.36U AS=0.0567P AD=0.1584P
+ PS=0.675U PD=1.6U
M$2219 \$4437 \$4436 VDD VDD pfet_03v3 L=0.28U W=0.36U AS=0.1764P AD=0.1584P
+ PS=1.26U PD=1.6U
M$2220 \$4402 \$4436 VDD VDD pfet_03v3 L=0.28U W=0.72U AS=0.1764P AD=0.36P
+ PS=1.26U PD=2.44U
M$2221 \$4528 RA VDD VDD pfet_03v3 L=0.28U W=0.72U AS=0.3312P AD=0.3888P
+ PS=2.36U PD=2.52U
M$2222 \$4402 \$4528 QAb VDD pfet_03v3 L=0.28U W=0.36U AS=0.1584P AD=0.1152P
+ PS=1.6U PD=1U
M$2223 QBb \$4529 \$4402 VDD pfet_03v3 L=0.28U W=0.36U AS=0.1152P AD=0.1584P
+ PS=1U PD=1.6U
M$2224 VDD RB \$4529 VDD pfet_03v3 L=0.28U W=0.72U AS=0.3708P AD=0.3168P
+ PS=2.47U PD=2.32U
M$2225 \$4438 D|Q VDD VDD pfet_03v3 L=0.28U W=0.72U AS=0.3168P AD=0.2097P
+ PS=2.32U PD=1.38U
M$2226 \$4439 WECLKb \$4438 VDD pfet_03v3 L=0.28U W=0.36U AS=0.2097P AD=0.1278P
+ PS=1.38U PD=1.07U
M$2227 \$4708 \$4440 \$4439 VDD pfet_03v3 L=0.28U W=0.36U AS=0.1278P AD=0.0567P
+ PS=1.07U PD=0.675U
M$2228 VDD WECLK \$4708 VDD pfet_03v3 L=0.28U W=0.36U AS=0.0567P AD=0.1584P
+ PS=0.675U PD=1.6U
M$2229 \$4440 \$4439 VDD VDD pfet_03v3 L=0.28U W=0.36U AS=0.1764P AD=0.1584P
+ PS=1.26U PD=1.6U
M$2230 \$4403 \$4439 VDD VDD pfet_03v3 L=0.28U W=0.72U AS=0.1764P AD=0.36P
+ PS=1.26U PD=2.44U
M$2231 \$4530 RA VDD VDD pfet_03v3 L=0.28U W=0.72U AS=0.3312P AD=0.3888P
+ PS=2.36U PD=2.52U
M$2232 \$4403 \$4530 QAb VDD pfet_03v3 L=0.28U W=0.36U AS=0.1584P AD=0.1152P
+ PS=1.6U PD=1U
M$2233 QBb \$4531 \$4403 VDD pfet_03v3 L=0.28U W=0.36U AS=0.1152P AD=0.1584P
+ PS=1U PD=1.6U
M$2234 VDD RB \$4531 VDD pfet_03v3 L=0.28U W=0.72U AS=0.3708P AD=0.3168P
+ PS=2.47U PD=2.32U
M$2235 \$4441 D|Q VDD VDD pfet_03v3 L=0.28U W=0.72U AS=0.3168P AD=0.2097P
+ PS=2.32U PD=1.38U
M$2236 \$4442 WECLKb \$4441 VDD pfet_03v3 L=0.28U W=0.36U AS=0.2097P AD=0.1278P
+ PS=1.38U PD=1.07U
M$2237 \$4717 \$4443 \$4442 VDD pfet_03v3 L=0.28U W=0.36U AS=0.1278P AD=0.0567P
+ PS=1.07U PD=0.675U
M$2238 VDD WECLK \$4717 VDD pfet_03v3 L=0.28U W=0.36U AS=0.0567P AD=0.1584P
+ PS=0.675U PD=1.6U
M$2239 \$4443 \$4442 VDD VDD pfet_03v3 L=0.28U W=0.36U AS=0.1764P AD=0.1584P
+ PS=1.26U PD=1.6U
M$2240 \$4404 \$4442 VDD VDD pfet_03v3 L=0.28U W=0.72U AS=0.1764P AD=0.36P
+ PS=1.26U PD=2.44U
M$2241 \$4532 RA VDD VDD pfet_03v3 L=0.28U W=0.72U AS=0.3312P AD=0.3888P
+ PS=2.36U PD=2.52U
M$2242 \$4404 \$4532 QAb VDD pfet_03v3 L=0.28U W=0.36U AS=0.1584P AD=0.1152P
+ PS=1.6U PD=1U
M$2243 QBb \$4533 \$4404 VDD pfet_03v3 L=0.28U W=0.36U AS=0.1152P AD=0.1584P
+ PS=1U PD=1.6U
M$2244 VDD RB \$4533 VDD pfet_03v3 L=0.28U W=0.72U AS=0.3708P AD=0.3168P
+ PS=2.47U PD=2.32U
M$2245 \$4444 D|Q VDD VDD pfet_03v3 L=0.28U W=0.72U AS=0.3168P AD=0.2097P
+ PS=2.32U PD=1.38U
M$2246 \$4445 WECLKb \$4444 VDD pfet_03v3 L=0.28U W=0.36U AS=0.2097P AD=0.1278P
+ PS=1.38U PD=1.07U
M$2247 \$4726 \$4446 \$4445 VDD pfet_03v3 L=0.28U W=0.36U AS=0.1278P AD=0.0567P
+ PS=1.07U PD=0.675U
M$2248 VDD WECLK \$4726 VDD pfet_03v3 L=0.28U W=0.36U AS=0.0567P AD=0.1584P
+ PS=0.675U PD=1.6U
M$2249 \$4446 \$4445 VDD VDD pfet_03v3 L=0.28U W=0.36U AS=0.1764P AD=0.1584P
+ PS=1.26U PD=1.6U
M$2250 \$4405 \$4445 VDD VDD pfet_03v3 L=0.28U W=0.72U AS=0.1764P AD=0.36P
+ PS=1.26U PD=2.44U
M$2251 \$4534 RA VDD VDD pfet_03v3 L=0.28U W=0.72U AS=0.3312P AD=0.3888P
+ PS=2.36U PD=2.52U
M$2252 \$4405 \$4534 QAb VDD pfet_03v3 L=0.28U W=0.36U AS=0.1584P AD=0.1152P
+ PS=1.6U PD=1U
M$2253 QBb \$4535 \$4405 VDD pfet_03v3 L=0.28U W=0.36U AS=0.1152P AD=0.1584P
+ PS=1U PD=1.6U
M$2254 VDD RB \$4535 VDD pfet_03v3 L=0.28U W=0.72U AS=0.3708P AD=0.3168P
+ PS=2.47U PD=2.32U
M$2255 \$4447 D|Q VDD VDD pfet_03v3 L=0.28U W=0.72U AS=0.3168P AD=0.2097P
+ PS=2.32U PD=1.38U
M$2256 \$4448 WECLKb \$4447 VDD pfet_03v3 L=0.28U W=0.36U AS=0.2097P AD=0.1278P
+ PS=1.38U PD=1.07U
M$2257 \$4733 \$4449 \$4448 VDD pfet_03v3 L=0.28U W=0.36U AS=0.1278P AD=0.0567P
+ PS=1.07U PD=0.675U
M$2258 VDD WECLK \$4733 VDD pfet_03v3 L=0.28U W=0.36U AS=0.0567P AD=0.1584P
+ PS=0.675U PD=1.6U
M$2259 \$4449 \$4448 VDD VDD pfet_03v3 L=0.28U W=0.36U AS=0.1764P AD=0.1584P
+ PS=1.26U PD=1.6U
M$2260 \$4406 \$4448 VDD VDD pfet_03v3 L=0.28U W=0.72U AS=0.1764P AD=0.36P
+ PS=1.26U PD=2.44U
M$2261 \$4536 RA VDD VDD pfet_03v3 L=0.28U W=0.72U AS=0.3312P AD=0.3888P
+ PS=2.36U PD=2.52U
M$2262 \$4406 \$4536 QAb VDD pfet_03v3 L=0.28U W=0.36U AS=0.1584P AD=0.1152P
+ PS=1.6U PD=1U
M$2263 QBb \$4537 \$4406 VDD pfet_03v3 L=0.28U W=0.36U AS=0.1152P AD=0.1584P
+ PS=1U PD=1.6U
M$2264 VDD RB \$4537 VDD pfet_03v3 L=0.28U W=0.72U AS=0.3708P AD=0.3168P
+ PS=2.47U PD=2.32U
M$2265 \$4450 D|Q VDD VDD pfet_03v3 L=0.28U W=0.72U AS=0.3168P AD=0.2097P
+ PS=2.32U PD=1.38U
M$2266 \$4451 WECLKb \$4450 VDD pfet_03v3 L=0.28U W=0.36U AS=0.2097P AD=0.1278P
+ PS=1.38U PD=1.07U
M$2267 \$4721 \$4452 \$4451 VDD pfet_03v3 L=0.28U W=0.36U AS=0.1278P AD=0.0567P
+ PS=1.07U PD=0.675U
M$2268 VDD WECLK \$4721 VDD pfet_03v3 L=0.28U W=0.36U AS=0.0567P AD=0.1584P
+ PS=0.675U PD=1.6U
M$2269 \$4452 \$4451 VDD VDD pfet_03v3 L=0.28U W=0.36U AS=0.1764P AD=0.1584P
+ PS=1.26U PD=1.6U
M$2270 \$4407 \$4451 VDD VDD pfet_03v3 L=0.28U W=0.72U AS=0.1764P AD=0.36P
+ PS=1.26U PD=2.44U
M$2271 \$4538 RA VDD VDD pfet_03v3 L=0.28U W=0.72U AS=0.3312P AD=0.3888P
+ PS=2.36U PD=2.52U
M$2272 \$4407 \$4538 QAb VDD pfet_03v3 L=0.28U W=0.36U AS=0.1584P AD=0.1152P
+ PS=1.6U PD=1U
M$2273 QBb \$4539 \$4407 VDD pfet_03v3 L=0.28U W=0.36U AS=0.1152P AD=0.1584P
+ PS=1U PD=1.6U
M$2274 VDD RB \$4539 VDD pfet_03v3 L=0.28U W=0.72U AS=0.3708P AD=0.3168P
+ PS=2.47U PD=2.32U
M$2275 \$4453 D|Q VDD VDD pfet_03v3 L=0.28U W=0.72U AS=0.3168P AD=0.2097P
+ PS=2.32U PD=1.38U
M$2276 \$4454 WECLKb \$4453 VDD pfet_03v3 L=0.28U W=0.36U AS=0.2097P AD=0.1278P
+ PS=1.38U PD=1.07U
M$2277 \$4695 \$4455 \$4454 VDD pfet_03v3 L=0.28U W=0.36U AS=0.1278P AD=0.0567P
+ PS=1.07U PD=0.675U
M$2278 VDD WECLK \$4695 VDD pfet_03v3 L=0.28U W=0.36U AS=0.0567P AD=0.1584P
+ PS=0.675U PD=1.6U
M$2279 \$4455 \$4454 VDD VDD pfet_03v3 L=0.28U W=0.36U AS=0.1764P AD=0.1584P
+ PS=1.26U PD=1.6U
M$2280 \$4408 \$4454 VDD VDD pfet_03v3 L=0.28U W=0.72U AS=0.1764P AD=0.36P
+ PS=1.26U PD=2.44U
M$2281 \$4540 RA VDD VDD pfet_03v3 L=0.28U W=0.72U AS=0.3312P AD=0.3888P
+ PS=2.36U PD=2.52U
M$2282 \$4408 \$4540 QAb VDD pfet_03v3 L=0.28U W=0.36U AS=0.1584P AD=0.1152P
+ PS=1.6U PD=1U
M$2283 QBb \$4541 \$4408 VDD pfet_03v3 L=0.28U W=0.36U AS=0.1152P AD=0.1584P
+ PS=1U PD=1.6U
M$2284 VDD RB \$4541 VDD pfet_03v3 L=0.28U W=0.72U AS=0.3708P AD=0.3168P
+ PS=2.47U PD=2.32U
M$2285 \$4456 D|Q VDD VDD pfet_03v3 L=0.28U W=0.72U AS=0.3168P AD=0.2097P
+ PS=2.32U PD=1.38U
M$2286 \$4457 WECLKb \$4456 VDD pfet_03v3 L=0.28U W=0.36U AS=0.2097P AD=0.1278P
+ PS=1.38U PD=1.07U
M$2287 \$4675 \$4458 \$4457 VDD pfet_03v3 L=0.28U W=0.36U AS=0.1278P AD=0.0567P
+ PS=1.07U PD=0.675U
M$2288 VDD WECLK \$4675 VDD pfet_03v3 L=0.28U W=0.36U AS=0.0567P AD=0.1584P
+ PS=0.675U PD=1.6U
M$2289 \$4458 \$4457 VDD VDD pfet_03v3 L=0.28U W=0.36U AS=0.1764P AD=0.1584P
+ PS=1.26U PD=1.6U
M$2290 \$4409 \$4457 VDD VDD pfet_03v3 L=0.28U W=0.72U AS=0.1764P AD=0.36P
+ PS=1.26U PD=2.44U
M$2291 \$4542 RA VDD VDD pfet_03v3 L=0.28U W=0.72U AS=0.3312P AD=0.3888P
+ PS=2.36U PD=2.52U
M$2292 \$4409 \$4542 QAb VDD pfet_03v3 L=0.28U W=0.36U AS=0.1584P AD=0.1152P
+ PS=1.6U PD=1U
M$2293 QBb \$4543 \$4409 VDD pfet_03v3 L=0.28U W=0.36U AS=0.1152P AD=0.1584P
+ PS=1U PD=1.6U
M$2294 VDD RB \$4543 VDD pfet_03v3 L=0.28U W=0.72U AS=0.3708P AD=0.3168P
+ PS=2.47U PD=2.32U
M$2295 \$4459 D|Q VDD VDD pfet_03v3 L=0.28U W=0.72U AS=0.3168P AD=0.2097P
+ PS=2.32U PD=1.38U
M$2296 \$4460 WECLKb \$4459 VDD pfet_03v3 L=0.28U W=0.36U AS=0.2097P AD=0.1278P
+ PS=1.38U PD=1.07U
M$2297 \$4647 \$4461 \$4460 VDD pfet_03v3 L=0.28U W=0.36U AS=0.1278P AD=0.0567P
+ PS=1.07U PD=0.675U
M$2298 VDD WECLK \$4647 VDD pfet_03v3 L=0.28U W=0.36U AS=0.0567P AD=0.1584P
+ PS=0.675U PD=1.6U
M$2299 \$4461 \$4460 VDD VDD pfet_03v3 L=0.28U W=0.36U AS=0.1764P AD=0.1584P
+ PS=1.26U PD=1.6U
M$2300 \$4410 \$4460 VDD VDD pfet_03v3 L=0.28U W=0.72U AS=0.1764P AD=0.36P
+ PS=1.26U PD=2.44U
M$2301 \$4544 RA VDD VDD pfet_03v3 L=0.28U W=0.72U AS=0.3312P AD=0.3888P
+ PS=2.36U PD=2.52U
M$2302 \$4410 \$4544 QAb VDD pfet_03v3 L=0.28U W=0.36U AS=0.1584P AD=0.1152P
+ PS=1.6U PD=1U
M$2303 QBb \$4545 \$4410 VDD pfet_03v3 L=0.28U W=0.36U AS=0.1152P AD=0.1584P
+ PS=1U PD=1.6U
M$2304 VDD RB \$4545 VDD pfet_03v3 L=0.28U W=0.72U AS=0.3708P AD=0.3168P
+ PS=2.47U PD=2.32U
M$2305 \$4738 WE VDD VDD pfet_03v3 L=0.28U W=0.72U AS=0.3168P AD=0.1872P
+ PS=2.32U PD=1.24U
M$2306 VDD CLK \$4738 VDD pfet_03v3 L=0.28U W=0.72U AS=0.1872P AD=0.3168P
+ PS=1.24U PD=2.32U
M$2307 WECLK \$4738 VDD VDD pfet_03v3 L=0.28U W=2.54U AS=0.889P AD=0.6688P
+ PS=5.21U PD=3.65U
M$2311 \$4744 WECLKb \$4743 VDD pfet_03v3 L=0.28U W=0.36U AS=0.2097P AD=0.1278P
+ PS=1.38U PD=1.07U
M$2312 \$4846 \$4745 \$4744 VDD pfet_03v3 L=0.28U W=0.36U AS=0.1278P AD=0.0567P
+ PS=1.07U PD=0.675U
M$2313 VDD WECLK \$4846 VDD pfet_03v3 L=0.28U W=0.36U AS=0.0567P AD=0.1584P
+ PS=0.675U PD=1.6U
M$2314 \$4743 D|Q VDD VDD pfet_03v3 L=0.28U W=0.72U AS=0.3168P AD=0.2097P
+ PS=2.32U PD=1.38U
M$2315 VDD \$4744 \$4745 VDD pfet_03v3 L=0.28U W=0.36U AS=0.1584P AD=0.1764P
+ PS=1.6U PD=1.26U
M$2316 \$4746 \$4744 VDD VDD pfet_03v3 L=0.28U W=0.72U AS=0.1764P AD=0.36P
+ PS=1.26U PD=2.44U
M$2317 \$4747 RA VDD VDD pfet_03v3 L=0.28U W=0.72U AS=0.3312P AD=0.3888P
+ PS=2.36U PD=2.52U
M$2318 \$4746 \$4747 QAb VDD pfet_03v3 L=0.28U W=0.36U AS=0.1584P AD=0.1152P
+ PS=1.6U PD=1U
M$2319 QBb \$4748 \$4746 VDD pfet_03v3 L=0.28U W=0.36U AS=0.1152P AD=0.1584P
+ PS=1U PD=1.6U
M$2320 VDD RB \$4748 VDD pfet_03v3 L=0.28U W=0.72U AS=0.3708P AD=0.3168P
+ PS=2.47U PD=2.32U
M$2321 \$4751 WECLKb \$4750 VDD pfet_03v3 L=0.28U W=0.36U AS=0.2097P AD=0.1278P
+ PS=1.38U PD=1.07U
M$2322 \$4855 \$4752 \$4751 VDD pfet_03v3 L=0.28U W=0.36U AS=0.1278P AD=0.0567P
+ PS=1.07U PD=0.675U
M$2323 VDD WECLK \$4855 VDD pfet_03v3 L=0.28U W=0.36U AS=0.0567P AD=0.1584P
+ PS=0.675U PD=1.6U
M$2324 \$4750 D|Q VDD VDD pfet_03v3 L=0.28U W=0.72U AS=0.3168P AD=0.2097P
+ PS=2.32U PD=1.38U
M$2325 VDD \$4751 \$4752 VDD pfet_03v3 L=0.28U W=0.36U AS=0.1584P AD=0.1764P
+ PS=1.6U PD=1.26U
M$2326 \$4753 \$4751 VDD VDD pfet_03v3 L=0.28U W=0.72U AS=0.1764P AD=0.36P
+ PS=1.26U PD=2.44U
M$2327 \$4754 RA VDD VDD pfet_03v3 L=0.28U W=0.72U AS=0.3312P AD=0.3888P
+ PS=2.36U PD=2.52U
M$2328 \$4753 \$4754 QAb VDD pfet_03v3 L=0.28U W=0.36U AS=0.1584P AD=0.1152P
+ PS=1.6U PD=1U
M$2329 QBb \$4755 \$4753 VDD pfet_03v3 L=0.28U W=0.36U AS=0.1152P AD=0.1584P
+ PS=1U PD=1.6U
M$2330 VDD RB \$4755 VDD pfet_03v3 L=0.28U W=0.72U AS=0.3708P AD=0.3168P
+ PS=2.47U PD=2.32U
M$2331 \$4757 WECLKb \$4756 VDD pfet_03v3 L=0.28U W=0.36U AS=0.2097P AD=0.1278P
+ PS=1.38U PD=1.07U
M$2332 \$4865 \$4758 \$4757 VDD pfet_03v3 L=0.28U W=0.36U AS=0.1278P AD=0.0567P
+ PS=1.07U PD=0.675U
M$2333 VDD WECLK \$4865 VDD pfet_03v3 L=0.28U W=0.36U AS=0.0567P AD=0.1584P
+ PS=0.675U PD=1.6U
M$2334 \$4756 D|Q VDD VDD pfet_03v3 L=0.28U W=0.72U AS=0.3168P AD=0.2097P
+ PS=2.32U PD=1.38U
M$2335 VDD \$4757 \$4758 VDD pfet_03v3 L=0.28U W=0.36U AS=0.1584P AD=0.1764P
+ PS=1.6U PD=1.26U
M$2336 \$4759 \$4757 VDD VDD pfet_03v3 L=0.28U W=0.72U AS=0.1764P AD=0.36P
+ PS=1.26U PD=2.44U
M$2337 \$4760 RA VDD VDD pfet_03v3 L=0.28U W=0.72U AS=0.3312P AD=0.3888P
+ PS=2.36U PD=2.52U
M$2338 \$4759 \$4760 QAb VDD pfet_03v3 L=0.28U W=0.36U AS=0.1584P AD=0.1152P
+ PS=1.6U PD=1U
M$2339 QBb \$4761 \$4759 VDD pfet_03v3 L=0.28U W=0.36U AS=0.1152P AD=0.1584P
+ PS=1U PD=1.6U
M$2340 VDD RB \$4761 VDD pfet_03v3 L=0.28U W=0.72U AS=0.3708P AD=0.3168P
+ PS=2.47U PD=2.32U
M$2341 \$4763 WECLKb \$4762 VDD pfet_03v3 L=0.28U W=0.36U AS=0.2097P AD=0.1278P
+ PS=1.38U PD=1.07U
M$2342 \$4876 \$4764 \$4763 VDD pfet_03v3 L=0.28U W=0.36U AS=0.1278P AD=0.0567P
+ PS=1.07U PD=0.675U
M$2343 VDD WECLK \$4876 VDD pfet_03v3 L=0.28U W=0.36U AS=0.0567P AD=0.1584P
+ PS=0.675U PD=1.6U
M$2344 \$4762 D|Q VDD VDD pfet_03v3 L=0.28U W=0.72U AS=0.3168P AD=0.2097P
+ PS=2.32U PD=1.38U
M$2345 VDD \$4763 \$4764 VDD pfet_03v3 L=0.28U W=0.36U AS=0.1584P AD=0.1764P
+ PS=1.6U PD=1.26U
M$2346 \$4765 \$4763 VDD VDD pfet_03v3 L=0.28U W=0.72U AS=0.1764P AD=0.36P
+ PS=1.26U PD=2.44U
M$2347 \$4766 RA VDD VDD pfet_03v3 L=0.28U W=0.72U AS=0.3312P AD=0.3888P
+ PS=2.36U PD=2.52U
M$2348 \$4765 \$4766 QAb VDD pfet_03v3 L=0.28U W=0.36U AS=0.1584P AD=0.1152P
+ PS=1.6U PD=1U
M$2349 QBb \$4767 \$4765 VDD pfet_03v3 L=0.28U W=0.36U AS=0.1152P AD=0.1584P
+ PS=1U PD=1.6U
M$2350 VDD RB \$4767 VDD pfet_03v3 L=0.28U W=0.72U AS=0.3708P AD=0.3168P
+ PS=2.47U PD=2.32U
M$2351 \$4769 WECLKb \$4768 VDD pfet_03v3 L=0.28U W=0.36U AS=0.2097P AD=0.1278P
+ PS=1.38U PD=1.07U
M$2352 \$4888 \$4770 \$4769 VDD pfet_03v3 L=0.28U W=0.36U AS=0.1278P AD=0.0567P
+ PS=1.07U PD=0.675U
M$2353 VDD WECLK \$4888 VDD pfet_03v3 L=0.28U W=0.36U AS=0.0567P AD=0.1584P
+ PS=0.675U PD=1.6U
M$2354 \$4768 D|Q VDD VDD pfet_03v3 L=0.28U W=0.72U AS=0.3168P AD=0.2097P
+ PS=2.32U PD=1.38U
M$2355 VDD \$4769 \$4770 VDD pfet_03v3 L=0.28U W=0.36U AS=0.1584P AD=0.1764P
+ PS=1.6U PD=1.26U
M$2356 \$4771 \$4769 VDD VDD pfet_03v3 L=0.28U W=0.72U AS=0.1764P AD=0.36P
+ PS=1.26U PD=2.44U
M$2357 \$4772 RA VDD VDD pfet_03v3 L=0.28U W=0.72U AS=0.3312P AD=0.3888P
+ PS=2.36U PD=2.52U
M$2358 \$4771 \$4772 QAb VDD pfet_03v3 L=0.28U W=0.36U AS=0.1584P AD=0.1152P
+ PS=1.6U PD=1U
M$2359 QBb \$4773 \$4771 VDD pfet_03v3 L=0.28U W=0.36U AS=0.1152P AD=0.1584P
+ PS=1U PD=1.6U
M$2360 VDD RB \$4773 VDD pfet_03v3 L=0.28U W=0.72U AS=0.3708P AD=0.3168P
+ PS=2.47U PD=2.32U
M$2361 \$4775 WECLKb \$4774 VDD pfet_03v3 L=0.28U W=0.36U AS=0.2097P AD=0.1278P
+ PS=1.38U PD=1.07U
M$2362 \$4897 \$4776 \$4775 VDD pfet_03v3 L=0.28U W=0.36U AS=0.1278P AD=0.0567P
+ PS=1.07U PD=0.675U
M$2363 VDD WECLK \$4897 VDD pfet_03v3 L=0.28U W=0.36U AS=0.0567P AD=0.1584P
+ PS=0.675U PD=1.6U
M$2364 \$4774 D|Q VDD VDD pfet_03v3 L=0.28U W=0.72U AS=0.3168P AD=0.2097P
+ PS=2.32U PD=1.38U
M$2365 VDD \$4775 \$4776 VDD pfet_03v3 L=0.28U W=0.36U AS=0.1584P AD=0.1764P
+ PS=1.6U PD=1.26U
M$2366 \$4777 \$4775 VDD VDD pfet_03v3 L=0.28U W=0.72U AS=0.1764P AD=0.36P
+ PS=1.26U PD=2.44U
M$2367 \$4778 RA VDD VDD pfet_03v3 L=0.28U W=0.72U AS=0.3312P AD=0.3888P
+ PS=2.36U PD=2.52U
M$2368 \$4777 \$4778 QAb VDD pfet_03v3 L=0.28U W=0.36U AS=0.1584P AD=0.1152P
+ PS=1.6U PD=1U
M$2369 QBb \$4779 \$4777 VDD pfet_03v3 L=0.28U W=0.36U AS=0.1152P AD=0.1584P
+ PS=1U PD=1.6U
M$2370 VDD RB \$4779 VDD pfet_03v3 L=0.28U W=0.72U AS=0.3708P AD=0.3168P
+ PS=2.47U PD=2.32U
M$2371 \$4781 WECLKb \$4780 VDD pfet_03v3 L=0.28U W=0.36U AS=0.2097P AD=0.1278P
+ PS=1.38U PD=1.07U
M$2372 \$4906 \$4782 \$4781 VDD pfet_03v3 L=0.28U W=0.36U AS=0.1278P AD=0.0567P
+ PS=1.07U PD=0.675U
M$2373 VDD WECLK \$4906 VDD pfet_03v3 L=0.28U W=0.36U AS=0.0567P AD=0.1584P
+ PS=0.675U PD=1.6U
M$2374 \$4780 D|Q VDD VDD pfet_03v3 L=0.28U W=0.72U AS=0.3168P AD=0.2097P
+ PS=2.32U PD=1.38U
M$2375 VDD \$4781 \$4782 VDD pfet_03v3 L=0.28U W=0.36U AS=0.1584P AD=0.1764P
+ PS=1.6U PD=1.26U
M$2376 \$4783 \$4781 VDD VDD pfet_03v3 L=0.28U W=0.72U AS=0.1764P AD=0.36P
+ PS=1.26U PD=2.44U
M$2377 \$4784 RA VDD VDD pfet_03v3 L=0.28U W=0.72U AS=0.3312P AD=0.3888P
+ PS=2.36U PD=2.52U
M$2378 \$4783 \$4784 QAb VDD pfet_03v3 L=0.28U W=0.36U AS=0.1584P AD=0.1152P
+ PS=1.6U PD=1U
M$2379 QBb \$4785 \$4783 VDD pfet_03v3 L=0.28U W=0.36U AS=0.1152P AD=0.1584P
+ PS=1U PD=1.6U
M$2380 VDD RB \$4785 VDD pfet_03v3 L=0.28U W=0.72U AS=0.3708P AD=0.3168P
+ PS=2.47U PD=2.32U
M$2381 \$4787 WECLKb \$4786 VDD pfet_03v3 L=0.28U W=0.36U AS=0.2097P AD=0.1278P
+ PS=1.38U PD=1.07U
M$2382 \$4918 \$4788 \$4787 VDD pfet_03v3 L=0.28U W=0.36U AS=0.1278P AD=0.0567P
+ PS=1.07U PD=0.675U
M$2383 VDD WECLK \$4918 VDD pfet_03v3 L=0.28U W=0.36U AS=0.0567P AD=0.1584P
+ PS=0.675U PD=1.6U
M$2384 \$4786 D|Q VDD VDD pfet_03v3 L=0.28U W=0.72U AS=0.3168P AD=0.2097P
+ PS=2.32U PD=1.38U
M$2385 VDD \$4787 \$4788 VDD pfet_03v3 L=0.28U W=0.36U AS=0.1584P AD=0.1764P
+ PS=1.6U PD=1.26U
M$2386 \$4789 \$4787 VDD VDD pfet_03v3 L=0.28U W=0.72U AS=0.1764P AD=0.36P
+ PS=1.26U PD=2.44U
M$2387 \$4790 RA VDD VDD pfet_03v3 L=0.28U W=0.72U AS=0.3312P AD=0.3888P
+ PS=2.36U PD=2.52U
M$2388 \$4789 \$4790 QAb VDD pfet_03v3 L=0.28U W=0.36U AS=0.1584P AD=0.1152P
+ PS=1.6U PD=1U
M$2389 QBb \$4791 \$4789 VDD pfet_03v3 L=0.28U W=0.36U AS=0.1152P AD=0.1584P
+ PS=1U PD=1.6U
M$2390 VDD RB \$4791 VDD pfet_03v3 L=0.28U W=0.72U AS=0.3708P AD=0.3168P
+ PS=2.47U PD=2.32U
M$2391 \$4793 WECLKb \$4792 VDD pfet_03v3 L=0.28U W=0.36U AS=0.2097P AD=0.1278P
+ PS=1.38U PD=1.07U
M$2392 \$4929 \$4794 \$4793 VDD pfet_03v3 L=0.28U W=0.36U AS=0.1278P AD=0.0567P
+ PS=1.07U PD=0.675U
M$2393 VDD WECLK \$4929 VDD pfet_03v3 L=0.28U W=0.36U AS=0.0567P AD=0.1584P
+ PS=0.675U PD=1.6U
M$2394 \$4792 D|Q VDD VDD pfet_03v3 L=0.28U W=0.72U AS=0.3168P AD=0.2097P
+ PS=2.32U PD=1.38U
M$2395 VDD \$4793 \$4794 VDD pfet_03v3 L=0.28U W=0.36U AS=0.1584P AD=0.1764P
+ PS=1.6U PD=1.26U
M$2396 \$4795 \$4793 VDD VDD pfet_03v3 L=0.28U W=0.72U AS=0.1764P AD=0.36P
+ PS=1.26U PD=2.44U
M$2397 \$4796 RA VDD VDD pfet_03v3 L=0.28U W=0.72U AS=0.3312P AD=0.3888P
+ PS=2.36U PD=2.52U
M$2398 \$4795 \$4796 QAb VDD pfet_03v3 L=0.28U W=0.36U AS=0.1584P AD=0.1152P
+ PS=1.6U PD=1U
M$2399 QBb \$4797 \$4795 VDD pfet_03v3 L=0.28U W=0.36U AS=0.1152P AD=0.1584P
+ PS=1U PD=1.6U
M$2400 VDD RB \$4797 VDD pfet_03v3 L=0.28U W=0.72U AS=0.3708P AD=0.3168P
+ PS=2.47U PD=2.32U
M$2401 \$4799 WECLKb \$4798 VDD pfet_03v3 L=0.28U W=0.36U AS=0.2097P AD=0.1278P
+ PS=1.38U PD=1.07U
M$2402 \$4939 \$4800 \$4799 VDD pfet_03v3 L=0.28U W=0.36U AS=0.1278P AD=0.0567P
+ PS=1.07U PD=0.675U
M$2403 VDD WECLK \$4939 VDD pfet_03v3 L=0.28U W=0.36U AS=0.0567P AD=0.1584P
+ PS=0.675U PD=1.6U
M$2404 \$4798 D|Q VDD VDD pfet_03v3 L=0.28U W=0.72U AS=0.3168P AD=0.2097P
+ PS=2.32U PD=1.38U
M$2405 VDD \$4799 \$4800 VDD pfet_03v3 L=0.28U W=0.36U AS=0.1584P AD=0.1764P
+ PS=1.6U PD=1.26U
M$2406 \$4801 \$4799 VDD VDD pfet_03v3 L=0.28U W=0.72U AS=0.1764P AD=0.36P
+ PS=1.26U PD=2.44U
M$2407 \$4802 RA VDD VDD pfet_03v3 L=0.28U W=0.72U AS=0.3312P AD=0.3888P
+ PS=2.36U PD=2.52U
M$2408 \$4801 \$4802 QAb VDD pfet_03v3 L=0.28U W=0.36U AS=0.1584P AD=0.1152P
+ PS=1.6U PD=1U
M$2409 QBb \$4803 \$4801 VDD pfet_03v3 L=0.28U W=0.36U AS=0.1152P AD=0.1584P
+ PS=1U PD=1.6U
M$2410 VDD RB \$4803 VDD pfet_03v3 L=0.28U W=0.72U AS=0.3708P AD=0.3168P
+ PS=2.47U PD=2.32U
M$2411 \$4805 WECLKb \$4804 VDD pfet_03v3 L=0.28U W=0.36U AS=0.2097P AD=0.1278P
+ PS=1.38U PD=1.07U
M$2412 \$4948 \$4806 \$4805 VDD pfet_03v3 L=0.28U W=0.36U AS=0.1278P AD=0.0567P
+ PS=1.07U PD=0.675U
M$2413 VDD WECLK \$4948 VDD pfet_03v3 L=0.28U W=0.36U AS=0.0567P AD=0.1584P
+ PS=0.675U PD=1.6U
M$2414 \$4804 D|Q VDD VDD pfet_03v3 L=0.28U W=0.72U AS=0.3168P AD=0.2097P
+ PS=2.32U PD=1.38U
M$2415 VDD \$4805 \$4806 VDD pfet_03v3 L=0.28U W=0.36U AS=0.1584P AD=0.1764P
+ PS=1.6U PD=1.26U
M$2416 \$4807 \$4805 VDD VDD pfet_03v3 L=0.28U W=0.72U AS=0.1764P AD=0.36P
+ PS=1.26U PD=2.44U
M$2417 \$4808 RA VDD VDD pfet_03v3 L=0.28U W=0.72U AS=0.3312P AD=0.3888P
+ PS=2.36U PD=2.52U
M$2418 \$4807 \$4808 QAb VDD pfet_03v3 L=0.28U W=0.36U AS=0.1584P AD=0.1152P
+ PS=1.6U PD=1U
M$2419 QBb \$4809 \$4807 VDD pfet_03v3 L=0.28U W=0.36U AS=0.1152P AD=0.1584P
+ PS=1U PD=1.6U
M$2420 VDD RB \$4809 VDD pfet_03v3 L=0.28U W=0.72U AS=0.3708P AD=0.3168P
+ PS=2.47U PD=2.32U
M$2421 \$4811 WECLKb \$4810 VDD pfet_03v3 L=0.28U W=0.36U AS=0.2097P AD=0.1278P
+ PS=1.38U PD=1.07U
M$2422 \$4960 \$4812 \$4811 VDD pfet_03v3 L=0.28U W=0.36U AS=0.1278P AD=0.0567P
+ PS=1.07U PD=0.675U
M$2423 VDD WECLK \$4960 VDD pfet_03v3 L=0.28U W=0.36U AS=0.0567P AD=0.1584P
+ PS=0.675U PD=1.6U
M$2424 \$4810 D|Q VDD VDD pfet_03v3 L=0.28U W=0.72U AS=0.3168P AD=0.2097P
+ PS=2.32U PD=1.38U
M$2425 VDD \$4811 \$4812 VDD pfet_03v3 L=0.28U W=0.36U AS=0.1584P AD=0.1764P
+ PS=1.6U PD=1.26U
M$2426 \$4813 \$4811 VDD VDD pfet_03v3 L=0.28U W=0.72U AS=0.1764P AD=0.36P
+ PS=1.26U PD=2.44U
M$2427 \$4814 RA VDD VDD pfet_03v3 L=0.28U W=0.72U AS=0.3312P AD=0.3888P
+ PS=2.36U PD=2.52U
M$2428 \$4813 \$4814 QAb VDD pfet_03v3 L=0.28U W=0.36U AS=0.1584P AD=0.1152P
+ PS=1.6U PD=1U
M$2429 QBb \$4815 \$4813 VDD pfet_03v3 L=0.28U W=0.36U AS=0.1152P AD=0.1584P
+ PS=1U PD=1.6U
M$2430 VDD RB \$4815 VDD pfet_03v3 L=0.28U W=0.72U AS=0.3708P AD=0.3168P
+ PS=2.47U PD=2.32U
M$2431 \$4817 WECLKb \$4816 VDD pfet_03v3 L=0.28U W=0.36U AS=0.2097P AD=0.1278P
+ PS=1.38U PD=1.07U
M$2432 \$4968 \$4818 \$4817 VDD pfet_03v3 L=0.28U W=0.36U AS=0.1278P AD=0.0567P
+ PS=1.07U PD=0.675U
M$2433 VDD WECLK \$4968 VDD pfet_03v3 L=0.28U W=0.36U AS=0.0567P AD=0.1584P
+ PS=0.675U PD=1.6U
M$2434 \$4816 D|Q VDD VDD pfet_03v3 L=0.28U W=0.72U AS=0.3168P AD=0.2097P
+ PS=2.32U PD=1.38U
M$2435 VDD \$4817 \$4818 VDD pfet_03v3 L=0.28U W=0.36U AS=0.1584P AD=0.1764P
+ PS=1.6U PD=1.26U
M$2436 \$4819 \$4817 VDD VDD pfet_03v3 L=0.28U W=0.72U AS=0.1764P AD=0.36P
+ PS=1.26U PD=2.44U
M$2437 \$4820 RA VDD VDD pfet_03v3 L=0.28U W=0.72U AS=0.3312P AD=0.3888P
+ PS=2.36U PD=2.52U
M$2438 \$4819 \$4820 QAb VDD pfet_03v3 L=0.28U W=0.36U AS=0.1584P AD=0.1152P
+ PS=1.6U PD=1U
M$2439 QBb \$4821 \$4819 VDD pfet_03v3 L=0.28U W=0.36U AS=0.1152P AD=0.1584P
+ PS=1U PD=1.6U
M$2440 VDD RB \$4821 VDD pfet_03v3 L=0.28U W=0.72U AS=0.3708P AD=0.3168P
+ PS=2.47U PD=2.32U
M$2441 \$4823 WECLKb \$4822 VDD pfet_03v3 L=0.28U W=0.36U AS=0.2097P AD=0.1278P
+ PS=1.38U PD=1.07U
M$2442 \$4931 \$4824 \$4823 VDD pfet_03v3 L=0.28U W=0.36U AS=0.1278P AD=0.0567P
+ PS=1.07U PD=0.675U
M$2443 VDD WECLK \$4931 VDD pfet_03v3 L=0.28U W=0.36U AS=0.0567P AD=0.1584P
+ PS=0.675U PD=1.6U
M$2444 \$4822 D|Q VDD VDD pfet_03v3 L=0.28U W=0.72U AS=0.3168P AD=0.2097P
+ PS=2.32U PD=1.38U
M$2445 VDD \$4823 \$4824 VDD pfet_03v3 L=0.28U W=0.36U AS=0.1584P AD=0.1764P
+ PS=1.6U PD=1.26U
M$2446 \$4825 \$4823 VDD VDD pfet_03v3 L=0.28U W=0.72U AS=0.1764P AD=0.36P
+ PS=1.26U PD=2.44U
M$2447 \$4826 RA VDD VDD pfet_03v3 L=0.28U W=0.72U AS=0.3312P AD=0.3888P
+ PS=2.36U PD=2.52U
M$2448 \$4825 \$4826 QAb VDD pfet_03v3 L=0.28U W=0.36U AS=0.1584P AD=0.1152P
+ PS=1.6U PD=1U
M$2449 QBb \$4827 \$4825 VDD pfet_03v3 L=0.28U W=0.36U AS=0.1152P AD=0.1584P
+ PS=1U PD=1.6U
M$2450 VDD RB \$4827 VDD pfet_03v3 L=0.28U W=0.72U AS=0.3708P AD=0.3168P
+ PS=2.47U PD=2.32U
M$2451 \$4829 WECLKb \$4828 VDD pfet_03v3 L=0.28U W=0.36U AS=0.2097P AD=0.1278P
+ PS=1.38U PD=1.07U
M$2452 \$4902 \$4830 \$4829 VDD pfet_03v3 L=0.28U W=0.36U AS=0.1278P AD=0.0567P
+ PS=1.07U PD=0.675U
M$2453 VDD WECLK \$4902 VDD pfet_03v3 L=0.28U W=0.36U AS=0.0567P AD=0.1584P
+ PS=0.675U PD=1.6U
M$2454 \$4828 D|Q VDD VDD pfet_03v3 L=0.28U W=0.72U AS=0.3168P AD=0.2097P
+ PS=2.32U PD=1.38U
M$2455 VDD \$4829 \$4830 VDD pfet_03v3 L=0.28U W=0.36U AS=0.1584P AD=0.1764P
+ PS=1.6U PD=1.26U
M$2456 \$4831 \$4829 VDD VDD pfet_03v3 L=0.28U W=0.72U AS=0.1764P AD=0.36P
+ PS=1.26U PD=2.44U
M$2457 \$4832 RA VDD VDD pfet_03v3 L=0.28U W=0.72U AS=0.3312P AD=0.3888P
+ PS=2.36U PD=2.52U
M$2458 \$4831 \$4832 QAb VDD pfet_03v3 L=0.28U W=0.36U AS=0.1584P AD=0.1152P
+ PS=1.6U PD=1U
M$2459 QBb \$4833 \$4831 VDD pfet_03v3 L=0.28U W=0.36U AS=0.1152P AD=0.1584P
+ PS=1U PD=1.6U
M$2460 VDD RB \$4833 VDD pfet_03v3 L=0.28U W=0.72U AS=0.3708P AD=0.3168P
+ PS=2.47U PD=2.32U
M$2461 \$4835 WECLKb \$4834 VDD pfet_03v3 L=0.28U W=0.36U AS=0.2097P AD=0.1278P
+ PS=1.38U PD=1.07U
M$2462 \$4867 \$4836 \$4835 VDD pfet_03v3 L=0.28U W=0.36U AS=0.1278P AD=0.0567P
+ PS=1.07U PD=0.675U
M$2463 VDD WECLK \$4867 VDD pfet_03v3 L=0.28U W=0.36U AS=0.0567P AD=0.1584P
+ PS=0.675U PD=1.6U
M$2464 \$4834 D|Q VDD VDD pfet_03v3 L=0.28U W=0.72U AS=0.3168P AD=0.2097P
+ PS=2.32U PD=1.38U
M$2465 VDD \$4835 \$4836 VDD pfet_03v3 L=0.28U W=0.36U AS=0.1584P AD=0.1764P
+ PS=1.6U PD=1.26U
M$2466 \$4837 \$4835 VDD VDD pfet_03v3 L=0.28U W=0.72U AS=0.1764P AD=0.36P
+ PS=1.26U PD=2.44U
M$2467 \$4838 RA VDD VDD pfet_03v3 L=0.28U W=0.72U AS=0.3312P AD=0.3888P
+ PS=2.36U PD=2.52U
M$2468 \$4837 \$4838 QAb VDD pfet_03v3 L=0.28U W=0.36U AS=0.1584P AD=0.1152P
+ PS=1.6U PD=1U
M$2469 QBb \$4839 \$4837 VDD pfet_03v3 L=0.28U W=0.36U AS=0.1152P AD=0.1584P
+ PS=1U PD=1.6U
M$2470 VDD RB \$4839 VDD pfet_03v3 L=0.28U W=0.72U AS=0.3708P AD=0.3168P
+ PS=2.47U PD=2.32U
M$2471 \$5089 WE VDD VDD pfet_03v3 L=0.28U W=0.72U AS=0.3168P AD=0.1872P
+ PS=2.32U PD=1.24U
M$2472 VDD CLK \$5089 VDD pfet_03v3 L=0.28U W=0.72U AS=0.1872P AD=0.3168P
+ PS=1.24U PD=2.32U
M$2473 WECLK \$5089 VDD VDD pfet_03v3 L=0.28U W=2.54U AS=0.8974P AD=0.6604P
+ PS=5.28U PD=3.58U
M$2477 \$5092 D|Q VDD VDD pfet_03v3 L=0.28U W=0.72U AS=0.3168P AD=0.2097P
+ PS=2.32U PD=1.38U
M$2478 \$5093 WECLKb \$5092 VDD pfet_03v3 L=0.28U W=0.36U AS=0.2097P AD=0.1278P
+ PS=1.38U PD=1.07U
M$2479 \$5319 \$5094 \$5093 VDD pfet_03v3 L=0.28U W=0.36U AS=0.1278P AD=0.0567P
+ PS=1.07U PD=0.675U
M$2480 VDD WECLK \$5319 VDD pfet_03v3 L=0.28U W=0.36U AS=0.0567P AD=0.1584P
+ PS=0.675U PD=1.6U
M$2481 \$5094 \$5093 VDD VDD pfet_03v3 L=0.28U W=0.36U AS=0.1764P AD=0.1584P
+ PS=1.26U PD=1.6U
M$2482 \$5073 \$5093 VDD VDD pfet_03v3 L=0.28U W=0.72U AS=0.1764P AD=0.36P
+ PS=1.26U PD=2.44U
M$2483 \$5196 RA VDD VDD pfet_03v3 L=0.28U W=0.72U AS=0.3312P AD=0.3888P
+ PS=2.36U PD=2.52U
M$2484 \$5073 \$5196 QAb VDD pfet_03v3 L=0.28U W=0.36U AS=0.1584P AD=0.1152P
+ PS=1.6U PD=1U
M$2485 QBb \$5197 \$5073 VDD pfet_03v3 L=0.28U W=0.36U AS=0.1152P AD=0.1584P
+ PS=1U PD=1.6U
M$2486 VDD RB \$5197 VDD pfet_03v3 L=0.28U W=0.72U AS=0.3708P AD=0.3168P
+ PS=2.47U PD=2.32U
M$2487 \$5095 D|Q VDD VDD pfet_03v3 L=0.28U W=0.72U AS=0.3168P AD=0.2097P
+ PS=2.32U PD=1.38U
M$2488 \$5096 WECLKb \$5095 VDD pfet_03v3 L=0.28U W=0.36U AS=0.2097P AD=0.1278P
+ PS=1.38U PD=1.07U
M$2489 \$5328 \$5097 \$5096 VDD pfet_03v3 L=0.28U W=0.36U AS=0.1278P AD=0.0567P
+ PS=1.07U PD=0.675U
M$2490 VDD WECLK \$5328 VDD pfet_03v3 L=0.28U W=0.36U AS=0.0567P AD=0.1584P
+ PS=0.675U PD=1.6U
M$2491 \$5097 \$5096 VDD VDD pfet_03v3 L=0.28U W=0.36U AS=0.1764P AD=0.1584P
+ PS=1.26U PD=1.6U
M$2492 \$5074 \$5096 VDD VDD pfet_03v3 L=0.28U W=0.72U AS=0.1764P AD=0.36P
+ PS=1.26U PD=2.44U
M$2493 \$5198 RA VDD VDD pfet_03v3 L=0.28U W=0.72U AS=0.3312P AD=0.3888P
+ PS=2.36U PD=2.52U
M$2494 \$5074 \$5198 QAb VDD pfet_03v3 L=0.28U W=0.36U AS=0.1584P AD=0.1152P
+ PS=1.6U PD=1U
M$2495 QBb \$5199 \$5074 VDD pfet_03v3 L=0.28U W=0.36U AS=0.1152P AD=0.1584P
+ PS=1U PD=1.6U
M$2496 VDD RB \$5199 VDD pfet_03v3 L=0.28U W=0.72U AS=0.3708P AD=0.3168P
+ PS=2.47U PD=2.32U
M$2497 \$5098 D|Q VDD VDD pfet_03v3 L=0.28U W=0.72U AS=0.3168P AD=0.2097P
+ PS=2.32U PD=1.38U
M$2498 \$5099 WECLKb \$5098 VDD pfet_03v3 L=0.28U W=0.36U AS=0.2097P AD=0.1278P
+ PS=1.38U PD=1.07U
M$2499 \$5336 \$5100 \$5099 VDD pfet_03v3 L=0.28U W=0.36U AS=0.1278P AD=0.0567P
+ PS=1.07U PD=0.675U
M$2500 VDD WECLK \$5336 VDD pfet_03v3 L=0.28U W=0.36U AS=0.0567P AD=0.1584P
+ PS=0.675U PD=1.6U
M$2501 \$5100 \$5099 VDD VDD pfet_03v3 L=0.28U W=0.36U AS=0.1764P AD=0.1584P
+ PS=1.26U PD=1.6U
M$2502 \$5075 \$5099 VDD VDD pfet_03v3 L=0.28U W=0.72U AS=0.1764P AD=0.36P
+ PS=1.26U PD=2.44U
M$2503 \$5200 RA VDD VDD pfet_03v3 L=0.28U W=0.72U AS=0.3312P AD=0.3888P
+ PS=2.36U PD=2.52U
M$2504 \$5075 \$5200 QAb VDD pfet_03v3 L=0.28U W=0.36U AS=0.1584P AD=0.1152P
+ PS=1.6U PD=1U
M$2505 QBb \$5201 \$5075 VDD pfet_03v3 L=0.28U W=0.36U AS=0.1152P AD=0.1584P
+ PS=1U PD=1.6U
M$2506 VDD RB \$5201 VDD pfet_03v3 L=0.28U W=0.72U AS=0.3708P AD=0.3168P
+ PS=2.47U PD=2.32U
M$2507 \$5101 D|Q VDD VDD pfet_03v3 L=0.28U W=0.72U AS=0.3168P AD=0.2097P
+ PS=2.32U PD=1.38U
M$2508 \$5102 WECLKb \$5101 VDD pfet_03v3 L=0.28U W=0.36U AS=0.2097P AD=0.1278P
+ PS=1.38U PD=1.07U
M$2509 \$5345 \$5103 \$5102 VDD pfet_03v3 L=0.28U W=0.36U AS=0.1278P AD=0.0567P
+ PS=1.07U PD=0.675U
M$2510 VDD WECLK \$5345 VDD pfet_03v3 L=0.28U W=0.36U AS=0.0567P AD=0.1584P
+ PS=0.675U PD=1.6U
M$2511 \$5103 \$5102 VDD VDD pfet_03v3 L=0.28U W=0.36U AS=0.1764P AD=0.1584P
+ PS=1.26U PD=1.6U
M$2512 \$5076 \$5102 VDD VDD pfet_03v3 L=0.28U W=0.72U AS=0.1764P AD=0.36P
+ PS=1.26U PD=2.44U
M$2513 \$5202 RA VDD VDD pfet_03v3 L=0.28U W=0.72U AS=0.3312P AD=0.3888P
+ PS=2.36U PD=2.52U
M$2514 \$5076 \$5202 QAb VDD pfet_03v3 L=0.28U W=0.36U AS=0.1584P AD=0.1152P
+ PS=1.6U PD=1U
M$2515 QBb \$5203 \$5076 VDD pfet_03v3 L=0.28U W=0.36U AS=0.1152P AD=0.1584P
+ PS=1U PD=1.6U
M$2516 VDD RB \$5203 VDD pfet_03v3 L=0.28U W=0.72U AS=0.3708P AD=0.3168P
+ PS=2.47U PD=2.32U
M$2517 \$5104 D|Q VDD VDD pfet_03v3 L=0.28U W=0.72U AS=0.3168P AD=0.2097P
+ PS=2.32U PD=1.38U
M$2518 \$5105 WECLKb \$5104 VDD pfet_03v3 L=0.28U W=0.36U AS=0.2097P AD=0.1278P
+ PS=1.38U PD=1.07U
M$2519 \$5356 \$5106 \$5105 VDD pfet_03v3 L=0.28U W=0.36U AS=0.1278P AD=0.0567P
+ PS=1.07U PD=0.675U
M$2520 VDD WECLK \$5356 VDD pfet_03v3 L=0.28U W=0.36U AS=0.0567P AD=0.1584P
+ PS=0.675U PD=1.6U
M$2521 \$5106 \$5105 VDD VDD pfet_03v3 L=0.28U W=0.36U AS=0.1764P AD=0.1584P
+ PS=1.26U PD=1.6U
M$2522 \$5077 \$5105 VDD VDD pfet_03v3 L=0.28U W=0.72U AS=0.1764P AD=0.36P
+ PS=1.26U PD=2.44U
M$2523 \$5204 RA VDD VDD pfet_03v3 L=0.28U W=0.72U AS=0.3312P AD=0.3888P
+ PS=2.36U PD=2.52U
M$2524 \$5077 \$5204 QAb VDD pfet_03v3 L=0.28U W=0.36U AS=0.1584P AD=0.1152P
+ PS=1.6U PD=1U
M$2525 QBb \$5205 \$5077 VDD pfet_03v3 L=0.28U W=0.36U AS=0.1152P AD=0.1584P
+ PS=1U PD=1.6U
M$2526 VDD RB \$5205 VDD pfet_03v3 L=0.28U W=0.72U AS=0.3708P AD=0.3168P
+ PS=2.47U PD=2.32U
M$2527 \$5107 D|Q VDD VDD pfet_03v3 L=0.28U W=0.72U AS=0.3168P AD=0.2097P
+ PS=2.32U PD=1.38U
M$2528 \$5108 WECLKb \$5107 VDD pfet_03v3 L=0.28U W=0.36U AS=0.2097P AD=0.1278P
+ PS=1.38U PD=1.07U
M$2529 \$5365 \$5109 \$5108 VDD pfet_03v3 L=0.28U W=0.36U AS=0.1278P AD=0.0567P
+ PS=1.07U PD=0.675U
M$2530 VDD WECLK \$5365 VDD pfet_03v3 L=0.28U W=0.36U AS=0.0567P AD=0.1584P
+ PS=0.675U PD=1.6U
M$2531 \$5109 \$5108 VDD VDD pfet_03v3 L=0.28U W=0.36U AS=0.1764P AD=0.1584P
+ PS=1.26U PD=1.6U
M$2532 \$5078 \$5108 VDD VDD pfet_03v3 L=0.28U W=0.72U AS=0.1764P AD=0.36P
+ PS=1.26U PD=2.44U
M$2533 \$5206 RA VDD VDD pfet_03v3 L=0.28U W=0.72U AS=0.3312P AD=0.3888P
+ PS=2.36U PD=2.52U
M$2534 \$5078 \$5206 QAb VDD pfet_03v3 L=0.28U W=0.36U AS=0.1584P AD=0.1152P
+ PS=1.6U PD=1U
M$2535 QBb \$5207 \$5078 VDD pfet_03v3 L=0.28U W=0.36U AS=0.1152P AD=0.1584P
+ PS=1U PD=1.6U
M$2536 VDD RB \$5207 VDD pfet_03v3 L=0.28U W=0.72U AS=0.3708P AD=0.3168P
+ PS=2.47U PD=2.32U
M$2537 \$5110 D|Q VDD VDD pfet_03v3 L=0.28U W=0.72U AS=0.3168P AD=0.2097P
+ PS=2.32U PD=1.38U
M$2538 \$5111 WECLKb \$5110 VDD pfet_03v3 L=0.28U W=0.36U AS=0.2097P AD=0.1278P
+ PS=1.38U PD=1.07U
M$2539 \$5372 \$5112 \$5111 VDD pfet_03v3 L=0.28U W=0.36U AS=0.1278P AD=0.0567P
+ PS=1.07U PD=0.675U
M$2540 VDD WECLK \$5372 VDD pfet_03v3 L=0.28U W=0.36U AS=0.0567P AD=0.1584P
+ PS=0.675U PD=1.6U
M$2541 \$5112 \$5111 VDD VDD pfet_03v3 L=0.28U W=0.36U AS=0.1764P AD=0.1584P
+ PS=1.26U PD=1.6U
M$2542 \$5079 \$5111 VDD VDD pfet_03v3 L=0.28U W=0.72U AS=0.1764P AD=0.36P
+ PS=1.26U PD=2.44U
M$2543 \$5208 RA VDD VDD pfet_03v3 L=0.28U W=0.72U AS=0.3312P AD=0.3888P
+ PS=2.36U PD=2.52U
M$2544 \$5079 \$5208 QAb VDD pfet_03v3 L=0.28U W=0.36U AS=0.1584P AD=0.1152P
+ PS=1.6U PD=1U
M$2545 QBb \$5209 \$5079 VDD pfet_03v3 L=0.28U W=0.36U AS=0.1152P AD=0.1584P
+ PS=1U PD=1.6U
M$2546 VDD RB \$5209 VDD pfet_03v3 L=0.28U W=0.72U AS=0.3708P AD=0.3168P
+ PS=2.47U PD=2.32U
M$2547 \$5113 D|Q VDD VDD pfet_03v3 L=0.28U W=0.72U AS=0.3168P AD=0.2097P
+ PS=2.32U PD=1.38U
M$2548 \$5114 WECLKb \$5113 VDD pfet_03v3 L=0.28U W=0.36U AS=0.2097P AD=0.1278P
+ PS=1.38U PD=1.07U
M$2549 \$5381 \$5115 \$5114 VDD pfet_03v3 L=0.28U W=0.36U AS=0.1278P AD=0.0567P
+ PS=1.07U PD=0.675U
M$2550 VDD WECLK \$5381 VDD pfet_03v3 L=0.28U W=0.36U AS=0.0567P AD=0.1584P
+ PS=0.675U PD=1.6U
M$2551 \$5115 \$5114 VDD VDD pfet_03v3 L=0.28U W=0.36U AS=0.1764P AD=0.1584P
+ PS=1.26U PD=1.6U
M$2552 \$5080 \$5114 VDD VDD pfet_03v3 L=0.28U W=0.72U AS=0.1764P AD=0.36P
+ PS=1.26U PD=2.44U
M$2553 \$5210 RA VDD VDD pfet_03v3 L=0.28U W=0.72U AS=0.3312P AD=0.3888P
+ PS=2.36U PD=2.52U
M$2554 \$5080 \$5210 QAb VDD pfet_03v3 L=0.28U W=0.36U AS=0.1584P AD=0.1152P
+ PS=1.6U PD=1U
M$2555 QBb \$5211 \$5080 VDD pfet_03v3 L=0.28U W=0.36U AS=0.1152P AD=0.1584P
+ PS=1U PD=1.6U
M$2556 VDD RB \$5211 VDD pfet_03v3 L=0.28U W=0.72U AS=0.3708P AD=0.3168P
+ PS=2.47U PD=2.32U
M$2557 \$5116 D|Q VDD VDD pfet_03v3 L=0.28U W=0.72U AS=0.3168P AD=0.2097P
+ PS=2.32U PD=1.38U
M$2558 \$5117 WECLKb \$5116 VDD pfet_03v3 L=0.28U W=0.36U AS=0.2097P AD=0.1278P
+ PS=1.38U PD=1.07U
M$2559 \$5390 \$5118 \$5117 VDD pfet_03v3 L=0.28U W=0.36U AS=0.1278P AD=0.0567P
+ PS=1.07U PD=0.675U
M$2560 VDD WECLK \$5390 VDD pfet_03v3 L=0.28U W=0.36U AS=0.0567P AD=0.1584P
+ PS=0.675U PD=1.6U
M$2561 \$5118 \$5117 VDD VDD pfet_03v3 L=0.28U W=0.36U AS=0.1764P AD=0.1584P
+ PS=1.26U PD=1.6U
M$2562 \$5081 \$5117 VDD VDD pfet_03v3 L=0.28U W=0.72U AS=0.1764P AD=0.36P
+ PS=1.26U PD=2.44U
M$2563 \$5212 RA VDD VDD pfet_03v3 L=0.28U W=0.72U AS=0.3312P AD=0.3888P
+ PS=2.36U PD=2.52U
M$2564 \$5081 \$5212 QAb VDD pfet_03v3 L=0.28U W=0.36U AS=0.1584P AD=0.1152P
+ PS=1.6U PD=1U
M$2565 QBb \$5213 \$5081 VDD pfet_03v3 L=0.28U W=0.36U AS=0.1152P AD=0.1584P
+ PS=1U PD=1.6U
M$2566 VDD RB \$5213 VDD pfet_03v3 L=0.28U W=0.72U AS=0.3708P AD=0.3168P
+ PS=2.47U PD=2.32U
M$2567 \$5119 D|Q VDD VDD pfet_03v3 L=0.28U W=0.72U AS=0.3168P AD=0.2097P
+ PS=2.32U PD=1.38U
M$2568 \$5120 WECLKb \$5119 VDD pfet_03v3 L=0.28U W=0.36U AS=0.2097P AD=0.1278P
+ PS=1.38U PD=1.07U
M$2569 \$5399 \$5121 \$5120 VDD pfet_03v3 L=0.28U W=0.36U AS=0.1278P AD=0.0567P
+ PS=1.07U PD=0.675U
M$2570 VDD WECLK \$5399 VDD pfet_03v3 L=0.28U W=0.36U AS=0.0567P AD=0.1584P
+ PS=0.675U PD=1.6U
M$2571 \$5121 \$5120 VDD VDD pfet_03v3 L=0.28U W=0.36U AS=0.1764P AD=0.1584P
+ PS=1.26U PD=1.6U
M$2572 \$5082 \$5120 VDD VDD pfet_03v3 L=0.28U W=0.72U AS=0.1764P AD=0.36P
+ PS=1.26U PD=2.44U
M$2573 \$5214 RA VDD VDD pfet_03v3 L=0.28U W=0.72U AS=0.3312P AD=0.3888P
+ PS=2.36U PD=2.52U
M$2574 \$5082 \$5214 QAb VDD pfet_03v3 L=0.28U W=0.36U AS=0.1584P AD=0.1152P
+ PS=1.6U PD=1U
M$2575 QBb \$5215 \$5082 VDD pfet_03v3 L=0.28U W=0.36U AS=0.1152P AD=0.1584P
+ PS=1U PD=1.6U
M$2576 VDD RB \$5215 VDD pfet_03v3 L=0.28U W=0.72U AS=0.3708P AD=0.3168P
+ PS=2.47U PD=2.32U
M$2577 \$5122 D|Q VDD VDD pfet_03v3 L=0.28U W=0.72U AS=0.3168P AD=0.2097P
+ PS=2.32U PD=1.38U
M$2578 \$5123 WECLKb \$5122 VDD pfet_03v3 L=0.28U W=0.36U AS=0.2097P AD=0.1278P
+ PS=1.38U PD=1.07U
M$2579 \$5408 \$5124 \$5123 VDD pfet_03v3 L=0.28U W=0.36U AS=0.1278P AD=0.0567P
+ PS=1.07U PD=0.675U
M$2580 VDD WECLK \$5408 VDD pfet_03v3 L=0.28U W=0.36U AS=0.0567P AD=0.1584P
+ PS=0.675U PD=1.6U
M$2581 \$5124 \$5123 VDD VDD pfet_03v3 L=0.28U W=0.36U AS=0.1764P AD=0.1584P
+ PS=1.26U PD=1.6U
M$2582 \$5083 \$5123 VDD VDD pfet_03v3 L=0.28U W=0.72U AS=0.1764P AD=0.36P
+ PS=1.26U PD=2.44U
M$2583 \$5216 RA VDD VDD pfet_03v3 L=0.28U W=0.72U AS=0.3312P AD=0.3888P
+ PS=2.36U PD=2.52U
M$2584 \$5083 \$5216 QAb VDD pfet_03v3 L=0.28U W=0.36U AS=0.1584P AD=0.1152P
+ PS=1.6U PD=1U
M$2585 QBb \$5217 \$5083 VDD pfet_03v3 L=0.28U W=0.36U AS=0.1152P AD=0.1584P
+ PS=1U PD=1.6U
M$2586 VDD RB \$5217 VDD pfet_03v3 L=0.28U W=0.72U AS=0.3708P AD=0.3168P
+ PS=2.47U PD=2.32U
M$2587 \$5125 D|Q VDD VDD pfet_03v3 L=0.28U W=0.72U AS=0.3168P AD=0.2097P
+ PS=2.32U PD=1.38U
M$2588 \$5126 WECLKb \$5125 VDD pfet_03v3 L=0.28U W=0.36U AS=0.2097P AD=0.1278P
+ PS=1.38U PD=1.07U
M$2589 \$5415 \$5127 \$5126 VDD pfet_03v3 L=0.28U W=0.36U AS=0.1278P AD=0.0567P
+ PS=1.07U PD=0.675U
M$2590 VDD WECLK \$5415 VDD pfet_03v3 L=0.28U W=0.36U AS=0.0567P AD=0.1584P
+ PS=0.675U PD=1.6U
M$2591 \$5127 \$5126 VDD VDD pfet_03v3 L=0.28U W=0.36U AS=0.1764P AD=0.1584P
+ PS=1.26U PD=1.6U
M$2592 \$5084 \$5126 VDD VDD pfet_03v3 L=0.28U W=0.72U AS=0.1764P AD=0.36P
+ PS=1.26U PD=2.44U
M$2593 \$5218 RA VDD VDD pfet_03v3 L=0.28U W=0.72U AS=0.3312P AD=0.3888P
+ PS=2.36U PD=2.52U
M$2594 \$5084 \$5218 QAb VDD pfet_03v3 L=0.28U W=0.36U AS=0.1584P AD=0.1152P
+ PS=1.6U PD=1U
M$2595 QBb \$5219 \$5084 VDD pfet_03v3 L=0.28U W=0.36U AS=0.1152P AD=0.1584P
+ PS=1U PD=1.6U
M$2596 VDD RB \$5219 VDD pfet_03v3 L=0.28U W=0.72U AS=0.3708P AD=0.3168P
+ PS=2.47U PD=2.32U
M$2597 \$5128 D|Q VDD VDD pfet_03v3 L=0.28U W=0.72U AS=0.3168P AD=0.2097P
+ PS=2.32U PD=1.38U
M$2598 \$5129 WECLKb \$5128 VDD pfet_03v3 L=0.28U W=0.36U AS=0.2097P AD=0.1278P
+ PS=1.38U PD=1.07U
M$2599 \$5403 \$5130 \$5129 VDD pfet_03v3 L=0.28U W=0.36U AS=0.1278P AD=0.0567P
+ PS=1.07U PD=0.675U
M$2600 VDD WECLK \$5403 VDD pfet_03v3 L=0.28U W=0.36U AS=0.0567P AD=0.1584P
+ PS=0.675U PD=1.6U
M$2601 \$5130 \$5129 VDD VDD pfet_03v3 L=0.28U W=0.36U AS=0.1764P AD=0.1584P
+ PS=1.26U PD=1.6U
M$2602 \$5085 \$5129 VDD VDD pfet_03v3 L=0.28U W=0.72U AS=0.1764P AD=0.36P
+ PS=1.26U PD=2.44U
M$2603 \$5220 RA VDD VDD pfet_03v3 L=0.28U W=0.72U AS=0.3312P AD=0.3888P
+ PS=2.36U PD=2.52U
M$2604 \$5085 \$5220 QAb VDD pfet_03v3 L=0.28U W=0.36U AS=0.1584P AD=0.1152P
+ PS=1.6U PD=1U
M$2605 QBb \$5221 \$5085 VDD pfet_03v3 L=0.28U W=0.36U AS=0.1152P AD=0.1584P
+ PS=1U PD=1.6U
M$2606 VDD RB \$5221 VDD pfet_03v3 L=0.28U W=0.72U AS=0.3708P AD=0.3168P
+ PS=2.47U PD=2.32U
M$2607 \$5131 D|Q VDD VDD pfet_03v3 L=0.28U W=0.72U AS=0.3168P AD=0.2097P
+ PS=2.32U PD=1.38U
M$2608 \$5132 WECLKb \$5131 VDD pfet_03v3 L=0.28U W=0.36U AS=0.2097P AD=0.1278P
+ PS=1.38U PD=1.07U
M$2609 \$5377 \$5133 \$5132 VDD pfet_03v3 L=0.28U W=0.36U AS=0.1278P AD=0.0567P
+ PS=1.07U PD=0.675U
M$2610 VDD WECLK \$5377 VDD pfet_03v3 L=0.28U W=0.36U AS=0.0567P AD=0.1584P
+ PS=0.675U PD=1.6U
M$2611 \$5133 \$5132 VDD VDD pfet_03v3 L=0.28U W=0.36U AS=0.1764P AD=0.1584P
+ PS=1.26U PD=1.6U
M$2612 \$5086 \$5132 VDD VDD pfet_03v3 L=0.28U W=0.72U AS=0.1764P AD=0.36P
+ PS=1.26U PD=2.44U
M$2613 \$5222 RA VDD VDD pfet_03v3 L=0.28U W=0.72U AS=0.3312P AD=0.3888P
+ PS=2.36U PD=2.52U
M$2614 \$5086 \$5222 QAb VDD pfet_03v3 L=0.28U W=0.36U AS=0.1584P AD=0.1152P
+ PS=1.6U PD=1U
M$2615 QBb \$5223 \$5086 VDD pfet_03v3 L=0.28U W=0.36U AS=0.1152P AD=0.1584P
+ PS=1U PD=1.6U
M$2616 VDD RB \$5223 VDD pfet_03v3 L=0.28U W=0.72U AS=0.3708P AD=0.3168P
+ PS=2.47U PD=2.32U
M$2617 \$5134 D|Q VDD VDD pfet_03v3 L=0.28U W=0.72U AS=0.3168P AD=0.2097P
+ PS=2.32U PD=1.38U
M$2618 \$5135 WECLKb \$5134 VDD pfet_03v3 L=0.28U W=0.36U AS=0.2097P AD=0.1278P
+ PS=1.38U PD=1.07U
M$2619 \$5357 \$5136 \$5135 VDD pfet_03v3 L=0.28U W=0.36U AS=0.1278P AD=0.0567P
+ PS=1.07U PD=0.675U
M$2620 VDD WECLK \$5357 VDD pfet_03v3 L=0.28U W=0.36U AS=0.0567P AD=0.1584P
+ PS=0.675U PD=1.6U
M$2621 \$5136 \$5135 VDD VDD pfet_03v3 L=0.28U W=0.36U AS=0.1764P AD=0.1584P
+ PS=1.26U PD=1.6U
M$2622 \$5087 \$5135 VDD VDD pfet_03v3 L=0.28U W=0.72U AS=0.1764P AD=0.36P
+ PS=1.26U PD=2.44U
M$2623 \$5224 RA VDD VDD pfet_03v3 L=0.28U W=0.72U AS=0.3312P AD=0.3888P
+ PS=2.36U PD=2.52U
M$2624 \$5087 \$5224 QAb VDD pfet_03v3 L=0.28U W=0.36U AS=0.1584P AD=0.1152P
+ PS=1.6U PD=1U
M$2625 QBb \$5225 \$5087 VDD pfet_03v3 L=0.28U W=0.36U AS=0.1152P AD=0.1584P
+ PS=1U PD=1.6U
M$2626 VDD RB \$5225 VDD pfet_03v3 L=0.28U W=0.72U AS=0.3708P AD=0.3168P
+ PS=2.47U PD=2.32U
M$2627 \$5137 D|Q VDD VDD pfet_03v3 L=0.28U W=0.72U AS=0.3168P AD=0.2097P
+ PS=2.32U PD=1.38U
M$2628 \$5138 WECLKb \$5137 VDD pfet_03v3 L=0.28U W=0.36U AS=0.2097P AD=0.1278P
+ PS=1.38U PD=1.07U
M$2629 \$5329 \$5139 \$5138 VDD pfet_03v3 L=0.28U W=0.36U AS=0.1278P AD=0.0567P
+ PS=1.07U PD=0.675U
M$2630 VDD WECLK \$5329 VDD pfet_03v3 L=0.28U W=0.36U AS=0.0567P AD=0.1584P
+ PS=0.675U PD=1.6U
M$2631 \$5139 \$5138 VDD VDD pfet_03v3 L=0.28U W=0.36U AS=0.1764P AD=0.1584P
+ PS=1.26U PD=1.6U
M$2632 \$5088 \$5138 VDD VDD pfet_03v3 L=0.28U W=0.72U AS=0.1764P AD=0.36P
+ PS=1.26U PD=2.44U
M$2633 \$5226 RA VDD VDD pfet_03v3 L=0.28U W=0.72U AS=0.3312P AD=0.3888P
+ PS=2.36U PD=2.52U
M$2634 \$5088 \$5226 QAb VDD pfet_03v3 L=0.28U W=0.36U AS=0.1584P AD=0.1152P
+ PS=1.6U PD=1U
M$2635 QBb \$5227 \$5088 VDD pfet_03v3 L=0.28U W=0.36U AS=0.1152P AD=0.1584P
+ PS=1U PD=1.6U
M$2636 VDD RB \$5227 VDD pfet_03v3 L=0.28U W=0.72U AS=0.3708P AD=0.3168P
+ PS=2.47U PD=2.32U
M$2637 \$5420 WE VDD VDD pfet_03v3 L=0.28U W=0.72U AS=0.3168P AD=0.1872P
+ PS=2.32U PD=1.24U
M$2638 VDD CLK \$5420 VDD pfet_03v3 L=0.28U W=0.72U AS=0.1872P AD=0.3168P
+ PS=1.24U PD=2.32U
M$2639 WECLK \$5420 VDD VDD pfet_03v3 L=0.28U W=2.54U AS=0.889P AD=0.6688P
+ PS=5.21U PD=3.65U
M$2643 \$5426 WECLKb \$5425 VDD pfet_03v3 L=0.28U W=0.36U AS=0.2097P AD=0.1278P
+ PS=1.38U PD=1.07U
M$2644 \$5528 \$5427 \$5426 VDD pfet_03v3 L=0.28U W=0.36U AS=0.1278P AD=0.0567P
+ PS=1.07U PD=0.675U
M$2645 VDD WECLK \$5528 VDD pfet_03v3 L=0.28U W=0.36U AS=0.0567P AD=0.1584P
+ PS=0.675U PD=1.6U
M$2646 \$5425 D|Q VDD VDD pfet_03v3 L=0.28U W=0.72U AS=0.3168P AD=0.2097P
+ PS=2.32U PD=1.38U
M$2647 VDD \$5426 \$5427 VDD pfet_03v3 L=0.28U W=0.36U AS=0.1584P AD=0.1764P
+ PS=1.6U PD=1.26U
M$2648 \$5428 \$5426 VDD VDD pfet_03v3 L=0.28U W=0.72U AS=0.1764P AD=0.36P
+ PS=1.26U PD=2.44U
M$2649 \$5429 RA VDD VDD pfet_03v3 L=0.28U W=0.72U AS=0.3312P AD=0.3888P
+ PS=2.36U PD=2.52U
M$2650 \$5428 \$5429 QAb VDD pfet_03v3 L=0.28U W=0.36U AS=0.1584P AD=0.1152P
+ PS=1.6U PD=1U
M$2651 QBb \$5430 \$5428 VDD pfet_03v3 L=0.28U W=0.36U AS=0.1152P AD=0.1584P
+ PS=1U PD=1.6U
M$2652 VDD RB \$5430 VDD pfet_03v3 L=0.28U W=0.72U AS=0.3708P AD=0.3168P
+ PS=2.47U PD=2.32U
M$2653 \$5433 WECLKb \$5432 VDD pfet_03v3 L=0.28U W=0.36U AS=0.2097P AD=0.1278P
+ PS=1.38U PD=1.07U
M$2654 \$5537 \$5434 \$5433 VDD pfet_03v3 L=0.28U W=0.36U AS=0.1278P AD=0.0567P
+ PS=1.07U PD=0.675U
M$2655 VDD WECLK \$5537 VDD pfet_03v3 L=0.28U W=0.36U AS=0.0567P AD=0.1584P
+ PS=0.675U PD=1.6U
M$2656 \$5432 D|Q VDD VDD pfet_03v3 L=0.28U W=0.72U AS=0.3168P AD=0.2097P
+ PS=2.32U PD=1.38U
M$2657 VDD \$5433 \$5434 VDD pfet_03v3 L=0.28U W=0.36U AS=0.1584P AD=0.1764P
+ PS=1.6U PD=1.26U
M$2658 \$5435 \$5433 VDD VDD pfet_03v3 L=0.28U W=0.72U AS=0.1764P AD=0.36P
+ PS=1.26U PD=2.44U
M$2659 \$5436 RA VDD VDD pfet_03v3 L=0.28U W=0.72U AS=0.3312P AD=0.3888P
+ PS=2.36U PD=2.52U
M$2660 \$5435 \$5436 QAb VDD pfet_03v3 L=0.28U W=0.36U AS=0.1584P AD=0.1152P
+ PS=1.6U PD=1U
M$2661 QBb \$5437 \$5435 VDD pfet_03v3 L=0.28U W=0.36U AS=0.1152P AD=0.1584P
+ PS=1U PD=1.6U
M$2662 VDD RB \$5437 VDD pfet_03v3 L=0.28U W=0.72U AS=0.3708P AD=0.3168P
+ PS=2.47U PD=2.32U
M$2663 \$5439 WECLKb \$5438 VDD pfet_03v3 L=0.28U W=0.36U AS=0.2097P AD=0.1278P
+ PS=1.38U PD=1.07U
M$2664 \$5547 \$5440 \$5439 VDD pfet_03v3 L=0.28U W=0.36U AS=0.1278P AD=0.0567P
+ PS=1.07U PD=0.675U
M$2665 VDD WECLK \$5547 VDD pfet_03v3 L=0.28U W=0.36U AS=0.0567P AD=0.1584P
+ PS=0.675U PD=1.6U
M$2666 \$5438 D|Q VDD VDD pfet_03v3 L=0.28U W=0.72U AS=0.3168P AD=0.2097P
+ PS=2.32U PD=1.38U
M$2667 VDD \$5439 \$5440 VDD pfet_03v3 L=0.28U W=0.36U AS=0.1584P AD=0.1764P
+ PS=1.6U PD=1.26U
M$2668 \$5441 \$5439 VDD VDD pfet_03v3 L=0.28U W=0.72U AS=0.1764P AD=0.36P
+ PS=1.26U PD=2.44U
M$2669 \$5442 RA VDD VDD pfet_03v3 L=0.28U W=0.72U AS=0.3312P AD=0.3888P
+ PS=2.36U PD=2.52U
M$2670 \$5441 \$5442 QAb VDD pfet_03v3 L=0.28U W=0.36U AS=0.1584P AD=0.1152P
+ PS=1.6U PD=1U
M$2671 QBb \$5443 \$5441 VDD pfet_03v3 L=0.28U W=0.36U AS=0.1152P AD=0.1584P
+ PS=1U PD=1.6U
M$2672 VDD RB \$5443 VDD pfet_03v3 L=0.28U W=0.72U AS=0.3708P AD=0.3168P
+ PS=2.47U PD=2.32U
M$2673 \$5445 WECLKb \$5444 VDD pfet_03v3 L=0.28U W=0.36U AS=0.2097P AD=0.1278P
+ PS=1.38U PD=1.07U
M$2674 \$5558 \$5446 \$5445 VDD pfet_03v3 L=0.28U W=0.36U AS=0.1278P AD=0.0567P
+ PS=1.07U PD=0.675U
M$2675 VDD WECLK \$5558 VDD pfet_03v3 L=0.28U W=0.36U AS=0.0567P AD=0.1584P
+ PS=0.675U PD=1.6U
M$2676 \$5444 D|Q VDD VDD pfet_03v3 L=0.28U W=0.72U AS=0.3168P AD=0.2097P
+ PS=2.32U PD=1.38U
M$2677 VDD \$5445 \$5446 VDD pfet_03v3 L=0.28U W=0.36U AS=0.1584P AD=0.1764P
+ PS=1.6U PD=1.26U
M$2678 \$5447 \$5445 VDD VDD pfet_03v3 L=0.28U W=0.72U AS=0.1764P AD=0.36P
+ PS=1.26U PD=2.44U
M$2679 \$5448 RA VDD VDD pfet_03v3 L=0.28U W=0.72U AS=0.3312P AD=0.3888P
+ PS=2.36U PD=2.52U
M$2680 \$5447 \$5448 QAb VDD pfet_03v3 L=0.28U W=0.36U AS=0.1584P AD=0.1152P
+ PS=1.6U PD=1U
M$2681 QBb \$5449 \$5447 VDD pfet_03v3 L=0.28U W=0.36U AS=0.1152P AD=0.1584P
+ PS=1U PD=1.6U
M$2682 VDD RB \$5449 VDD pfet_03v3 L=0.28U W=0.72U AS=0.3708P AD=0.3168P
+ PS=2.47U PD=2.32U
M$2683 \$5451 WECLKb \$5450 VDD pfet_03v3 L=0.28U W=0.36U AS=0.2097P AD=0.1278P
+ PS=1.38U PD=1.07U
M$2684 \$5570 \$5452 \$5451 VDD pfet_03v3 L=0.28U W=0.36U AS=0.1278P AD=0.0567P
+ PS=1.07U PD=0.675U
M$2685 VDD WECLK \$5570 VDD pfet_03v3 L=0.28U W=0.36U AS=0.0567P AD=0.1584P
+ PS=0.675U PD=1.6U
M$2686 \$5450 D|Q VDD VDD pfet_03v3 L=0.28U W=0.72U AS=0.3168P AD=0.2097P
+ PS=2.32U PD=1.38U
M$2687 VDD \$5451 \$5452 VDD pfet_03v3 L=0.28U W=0.36U AS=0.1584P AD=0.1764P
+ PS=1.6U PD=1.26U
M$2688 \$5453 \$5451 VDD VDD pfet_03v3 L=0.28U W=0.72U AS=0.1764P AD=0.36P
+ PS=1.26U PD=2.44U
M$2689 \$5454 RA VDD VDD pfet_03v3 L=0.28U W=0.72U AS=0.3312P AD=0.3888P
+ PS=2.36U PD=2.52U
M$2690 \$5453 \$5454 QAb VDD pfet_03v3 L=0.28U W=0.36U AS=0.1584P AD=0.1152P
+ PS=1.6U PD=1U
M$2691 QBb \$5455 \$5453 VDD pfet_03v3 L=0.28U W=0.36U AS=0.1152P AD=0.1584P
+ PS=1U PD=1.6U
M$2692 VDD RB \$5455 VDD pfet_03v3 L=0.28U W=0.72U AS=0.3708P AD=0.3168P
+ PS=2.47U PD=2.32U
M$2693 \$5457 WECLKb \$5456 VDD pfet_03v3 L=0.28U W=0.36U AS=0.2097P AD=0.1278P
+ PS=1.38U PD=1.07U
M$2694 \$5579 \$5458 \$5457 VDD pfet_03v3 L=0.28U W=0.36U AS=0.1278P AD=0.0567P
+ PS=1.07U PD=0.675U
M$2695 VDD WECLK \$5579 VDD pfet_03v3 L=0.28U W=0.36U AS=0.0567P AD=0.1584P
+ PS=0.675U PD=1.6U
M$2696 \$5456 D|Q VDD VDD pfet_03v3 L=0.28U W=0.72U AS=0.3168P AD=0.2097P
+ PS=2.32U PD=1.38U
M$2697 VDD \$5457 \$5458 VDD pfet_03v3 L=0.28U W=0.36U AS=0.1584P AD=0.1764P
+ PS=1.6U PD=1.26U
M$2698 \$5459 \$5457 VDD VDD pfet_03v3 L=0.28U W=0.72U AS=0.1764P AD=0.36P
+ PS=1.26U PD=2.44U
M$2699 \$5460 RA VDD VDD pfet_03v3 L=0.28U W=0.72U AS=0.3312P AD=0.3888P
+ PS=2.36U PD=2.52U
M$2700 \$5459 \$5460 QAb VDD pfet_03v3 L=0.28U W=0.36U AS=0.1584P AD=0.1152P
+ PS=1.6U PD=1U
M$2701 QBb \$5461 \$5459 VDD pfet_03v3 L=0.28U W=0.36U AS=0.1152P AD=0.1584P
+ PS=1U PD=1.6U
M$2702 VDD RB \$5461 VDD pfet_03v3 L=0.28U W=0.72U AS=0.3708P AD=0.3168P
+ PS=2.47U PD=2.32U
M$2703 \$5463 WECLKb \$5462 VDD pfet_03v3 L=0.28U W=0.36U AS=0.2097P AD=0.1278P
+ PS=1.38U PD=1.07U
M$2704 \$5588 \$5464 \$5463 VDD pfet_03v3 L=0.28U W=0.36U AS=0.1278P AD=0.0567P
+ PS=1.07U PD=0.675U
M$2705 VDD WECLK \$5588 VDD pfet_03v3 L=0.28U W=0.36U AS=0.0567P AD=0.1584P
+ PS=0.675U PD=1.6U
M$2706 \$5462 D|Q VDD VDD pfet_03v3 L=0.28U W=0.72U AS=0.3168P AD=0.2097P
+ PS=2.32U PD=1.38U
M$2707 VDD \$5463 \$5464 VDD pfet_03v3 L=0.28U W=0.36U AS=0.1584P AD=0.1764P
+ PS=1.6U PD=1.26U
M$2708 \$5465 \$5463 VDD VDD pfet_03v3 L=0.28U W=0.72U AS=0.1764P AD=0.36P
+ PS=1.26U PD=2.44U
M$2709 \$5466 RA VDD VDD pfet_03v3 L=0.28U W=0.72U AS=0.3312P AD=0.3888P
+ PS=2.36U PD=2.52U
M$2710 \$5465 \$5466 QAb VDD pfet_03v3 L=0.28U W=0.36U AS=0.1584P AD=0.1152P
+ PS=1.6U PD=1U
M$2711 QBb \$5467 \$5465 VDD pfet_03v3 L=0.28U W=0.36U AS=0.1152P AD=0.1584P
+ PS=1U PD=1.6U
M$2712 VDD RB \$5467 VDD pfet_03v3 L=0.28U W=0.72U AS=0.3708P AD=0.3168P
+ PS=2.47U PD=2.32U
M$2713 \$5469 WECLKb \$5468 VDD pfet_03v3 L=0.28U W=0.36U AS=0.2097P AD=0.1278P
+ PS=1.38U PD=1.07U
M$2714 \$5600 \$5470 \$5469 VDD pfet_03v3 L=0.28U W=0.36U AS=0.1278P AD=0.0567P
+ PS=1.07U PD=0.675U
M$2715 VDD WECLK \$5600 VDD pfet_03v3 L=0.28U W=0.36U AS=0.0567P AD=0.1584P
+ PS=0.675U PD=1.6U
M$2716 \$5468 D|Q VDD VDD pfet_03v3 L=0.28U W=0.72U AS=0.3168P AD=0.2097P
+ PS=2.32U PD=1.38U
M$2717 VDD \$5469 \$5470 VDD pfet_03v3 L=0.28U W=0.36U AS=0.1584P AD=0.1764P
+ PS=1.6U PD=1.26U
M$2718 \$5471 \$5469 VDD VDD pfet_03v3 L=0.28U W=0.72U AS=0.1764P AD=0.36P
+ PS=1.26U PD=2.44U
M$2719 \$5472 RA VDD VDD pfet_03v3 L=0.28U W=0.72U AS=0.3312P AD=0.3888P
+ PS=2.36U PD=2.52U
M$2720 \$5471 \$5472 QAb VDD pfet_03v3 L=0.28U W=0.36U AS=0.1584P AD=0.1152P
+ PS=1.6U PD=1U
M$2721 QBb \$5473 \$5471 VDD pfet_03v3 L=0.28U W=0.36U AS=0.1152P AD=0.1584P
+ PS=1U PD=1.6U
M$2722 VDD RB \$5473 VDD pfet_03v3 L=0.28U W=0.72U AS=0.3708P AD=0.3168P
+ PS=2.47U PD=2.32U
M$2723 \$5475 WECLKb \$5474 VDD pfet_03v3 L=0.28U W=0.36U AS=0.2097P AD=0.1278P
+ PS=1.38U PD=1.07U
M$2724 \$5611 \$5476 \$5475 VDD pfet_03v3 L=0.28U W=0.36U AS=0.1278P AD=0.0567P
+ PS=1.07U PD=0.675U
M$2725 VDD WECLK \$5611 VDD pfet_03v3 L=0.28U W=0.36U AS=0.0567P AD=0.1584P
+ PS=0.675U PD=1.6U
M$2726 \$5474 D|Q VDD VDD pfet_03v3 L=0.28U W=0.72U AS=0.3168P AD=0.2097P
+ PS=2.32U PD=1.38U
M$2727 VDD \$5475 \$5476 VDD pfet_03v3 L=0.28U W=0.36U AS=0.1584P AD=0.1764P
+ PS=1.6U PD=1.26U
M$2728 \$5477 \$5475 VDD VDD pfet_03v3 L=0.28U W=0.72U AS=0.1764P AD=0.36P
+ PS=1.26U PD=2.44U
M$2729 \$5478 RA VDD VDD pfet_03v3 L=0.28U W=0.72U AS=0.3312P AD=0.3888P
+ PS=2.36U PD=2.52U
M$2730 \$5477 \$5478 QAb VDD pfet_03v3 L=0.28U W=0.36U AS=0.1584P AD=0.1152P
+ PS=1.6U PD=1U
M$2731 QBb \$5479 \$5477 VDD pfet_03v3 L=0.28U W=0.36U AS=0.1152P AD=0.1584P
+ PS=1U PD=1.6U
M$2732 VDD RB \$5479 VDD pfet_03v3 L=0.28U W=0.72U AS=0.3708P AD=0.3168P
+ PS=2.47U PD=2.32U
M$2733 \$5481 WECLKb \$5480 VDD pfet_03v3 L=0.28U W=0.36U AS=0.2097P AD=0.1278P
+ PS=1.38U PD=1.07U
M$2734 \$5621 \$5482 \$5481 VDD pfet_03v3 L=0.28U W=0.36U AS=0.1278P AD=0.0567P
+ PS=1.07U PD=0.675U
M$2735 VDD WECLK \$5621 VDD pfet_03v3 L=0.28U W=0.36U AS=0.0567P AD=0.1584P
+ PS=0.675U PD=1.6U
M$2736 \$5480 D|Q VDD VDD pfet_03v3 L=0.28U W=0.72U AS=0.3168P AD=0.2097P
+ PS=2.32U PD=1.38U
M$2737 VDD \$5481 \$5482 VDD pfet_03v3 L=0.28U W=0.36U AS=0.1584P AD=0.1764P
+ PS=1.6U PD=1.26U
M$2738 \$5483 \$5481 VDD VDD pfet_03v3 L=0.28U W=0.72U AS=0.1764P AD=0.36P
+ PS=1.26U PD=2.44U
M$2739 \$5484 RA VDD VDD pfet_03v3 L=0.28U W=0.72U AS=0.3312P AD=0.3888P
+ PS=2.36U PD=2.52U
M$2740 \$5483 \$5484 QAb VDD pfet_03v3 L=0.28U W=0.36U AS=0.1584P AD=0.1152P
+ PS=1.6U PD=1U
M$2741 QBb \$5485 \$5483 VDD pfet_03v3 L=0.28U W=0.36U AS=0.1152P AD=0.1584P
+ PS=1U PD=1.6U
M$2742 VDD RB \$5485 VDD pfet_03v3 L=0.28U W=0.72U AS=0.3708P AD=0.3168P
+ PS=2.47U PD=2.32U
M$2743 \$5487 WECLKb \$5486 VDD pfet_03v3 L=0.28U W=0.36U AS=0.2097P AD=0.1278P
+ PS=1.38U PD=1.07U
M$2744 \$5630 \$5488 \$5487 VDD pfet_03v3 L=0.28U W=0.36U AS=0.1278P AD=0.0567P
+ PS=1.07U PD=0.675U
M$2745 VDD WECLK \$5630 VDD pfet_03v3 L=0.28U W=0.36U AS=0.0567P AD=0.1584P
+ PS=0.675U PD=1.6U
M$2746 \$5486 D|Q VDD VDD pfet_03v3 L=0.28U W=0.72U AS=0.3168P AD=0.2097P
+ PS=2.32U PD=1.38U
M$2747 VDD \$5487 \$5488 VDD pfet_03v3 L=0.28U W=0.36U AS=0.1584P AD=0.1764P
+ PS=1.6U PD=1.26U
M$2748 \$5489 \$5487 VDD VDD pfet_03v3 L=0.28U W=0.72U AS=0.1764P AD=0.36P
+ PS=1.26U PD=2.44U
M$2749 \$5490 RA VDD VDD pfet_03v3 L=0.28U W=0.72U AS=0.3312P AD=0.3888P
+ PS=2.36U PD=2.52U
M$2750 \$5489 \$5490 QAb VDD pfet_03v3 L=0.28U W=0.36U AS=0.1584P AD=0.1152P
+ PS=1.6U PD=1U
M$2751 QBb \$5491 \$5489 VDD pfet_03v3 L=0.28U W=0.36U AS=0.1152P AD=0.1584P
+ PS=1U PD=1.6U
M$2752 VDD RB \$5491 VDD pfet_03v3 L=0.28U W=0.72U AS=0.3708P AD=0.3168P
+ PS=2.47U PD=2.32U
M$2753 \$5493 WECLKb \$5492 VDD pfet_03v3 L=0.28U W=0.36U AS=0.2097P AD=0.1278P
+ PS=1.38U PD=1.07U
M$2754 \$5642 \$5494 \$5493 VDD pfet_03v3 L=0.28U W=0.36U AS=0.1278P AD=0.0567P
+ PS=1.07U PD=0.675U
M$2755 VDD WECLK \$5642 VDD pfet_03v3 L=0.28U W=0.36U AS=0.0567P AD=0.1584P
+ PS=0.675U PD=1.6U
M$2756 \$5492 D|Q VDD VDD pfet_03v3 L=0.28U W=0.72U AS=0.3168P AD=0.2097P
+ PS=2.32U PD=1.38U
M$2757 VDD \$5493 \$5494 VDD pfet_03v3 L=0.28U W=0.36U AS=0.1584P AD=0.1764P
+ PS=1.6U PD=1.26U
M$2758 \$5495 \$5493 VDD VDD pfet_03v3 L=0.28U W=0.72U AS=0.1764P AD=0.36P
+ PS=1.26U PD=2.44U
M$2759 \$5496 RA VDD VDD pfet_03v3 L=0.28U W=0.72U AS=0.3312P AD=0.3888P
+ PS=2.36U PD=2.52U
M$2760 \$5495 \$5496 QAb VDD pfet_03v3 L=0.28U W=0.36U AS=0.1584P AD=0.1152P
+ PS=1.6U PD=1U
M$2761 QBb \$5497 \$5495 VDD pfet_03v3 L=0.28U W=0.36U AS=0.1152P AD=0.1584P
+ PS=1U PD=1.6U
M$2762 VDD RB \$5497 VDD pfet_03v3 L=0.28U W=0.72U AS=0.3708P AD=0.3168P
+ PS=2.47U PD=2.32U
M$2763 \$5499 WECLKb \$5498 VDD pfet_03v3 L=0.28U W=0.36U AS=0.2097P AD=0.1278P
+ PS=1.38U PD=1.07U
M$2764 \$5650 \$5500 \$5499 VDD pfet_03v3 L=0.28U W=0.36U AS=0.1278P AD=0.0567P
+ PS=1.07U PD=0.675U
M$2765 VDD WECLK \$5650 VDD pfet_03v3 L=0.28U W=0.36U AS=0.0567P AD=0.1584P
+ PS=0.675U PD=1.6U
M$2766 \$5498 D|Q VDD VDD pfet_03v3 L=0.28U W=0.72U AS=0.3168P AD=0.2097P
+ PS=2.32U PD=1.38U
M$2767 VDD \$5499 \$5500 VDD pfet_03v3 L=0.28U W=0.36U AS=0.1584P AD=0.1764P
+ PS=1.6U PD=1.26U
M$2768 \$5501 \$5499 VDD VDD pfet_03v3 L=0.28U W=0.72U AS=0.1764P AD=0.36P
+ PS=1.26U PD=2.44U
M$2769 \$5502 RA VDD VDD pfet_03v3 L=0.28U W=0.72U AS=0.3312P AD=0.3888P
+ PS=2.36U PD=2.52U
M$2770 \$5501 \$5502 QAb VDD pfet_03v3 L=0.28U W=0.36U AS=0.1584P AD=0.1152P
+ PS=1.6U PD=1U
M$2771 QBb \$5503 \$5501 VDD pfet_03v3 L=0.28U W=0.36U AS=0.1152P AD=0.1584P
+ PS=1U PD=1.6U
M$2772 VDD RB \$5503 VDD pfet_03v3 L=0.28U W=0.72U AS=0.3708P AD=0.3168P
+ PS=2.47U PD=2.32U
M$2773 \$5505 WECLKb \$5504 VDD pfet_03v3 L=0.28U W=0.36U AS=0.2097P AD=0.1278P
+ PS=1.38U PD=1.07U
M$2774 \$5613 \$5506 \$5505 VDD pfet_03v3 L=0.28U W=0.36U AS=0.1278P AD=0.0567P
+ PS=1.07U PD=0.675U
M$2775 VDD WECLK \$5613 VDD pfet_03v3 L=0.28U W=0.36U AS=0.0567P AD=0.1584P
+ PS=0.675U PD=1.6U
M$2776 \$5504 D|Q VDD VDD pfet_03v3 L=0.28U W=0.72U AS=0.3168P AD=0.2097P
+ PS=2.32U PD=1.38U
M$2777 VDD \$5505 \$5506 VDD pfet_03v3 L=0.28U W=0.36U AS=0.1584P AD=0.1764P
+ PS=1.6U PD=1.26U
M$2778 \$5507 \$5505 VDD VDD pfet_03v3 L=0.28U W=0.72U AS=0.1764P AD=0.36P
+ PS=1.26U PD=2.44U
M$2779 \$5508 RA VDD VDD pfet_03v3 L=0.28U W=0.72U AS=0.3312P AD=0.3888P
+ PS=2.36U PD=2.52U
M$2780 \$5507 \$5508 QAb VDD pfet_03v3 L=0.28U W=0.36U AS=0.1584P AD=0.1152P
+ PS=1.6U PD=1U
M$2781 QBb \$5509 \$5507 VDD pfet_03v3 L=0.28U W=0.36U AS=0.1152P AD=0.1584P
+ PS=1U PD=1.6U
M$2782 VDD RB \$5509 VDD pfet_03v3 L=0.28U W=0.72U AS=0.3708P AD=0.3168P
+ PS=2.47U PD=2.32U
M$2783 \$5511 WECLKb \$5510 VDD pfet_03v3 L=0.28U W=0.36U AS=0.2097P AD=0.1278P
+ PS=1.38U PD=1.07U
M$2784 \$5584 \$5512 \$5511 VDD pfet_03v3 L=0.28U W=0.36U AS=0.1278P AD=0.0567P
+ PS=1.07U PD=0.675U
M$2785 VDD WECLK \$5584 VDD pfet_03v3 L=0.28U W=0.36U AS=0.0567P AD=0.1584P
+ PS=0.675U PD=1.6U
M$2786 \$5510 D|Q VDD VDD pfet_03v3 L=0.28U W=0.72U AS=0.3168P AD=0.2097P
+ PS=2.32U PD=1.38U
M$2787 VDD \$5511 \$5512 VDD pfet_03v3 L=0.28U W=0.36U AS=0.1584P AD=0.1764P
+ PS=1.6U PD=1.26U
M$2788 \$5513 \$5511 VDD VDD pfet_03v3 L=0.28U W=0.72U AS=0.1764P AD=0.36P
+ PS=1.26U PD=2.44U
M$2789 \$5514 RA VDD VDD pfet_03v3 L=0.28U W=0.72U AS=0.3312P AD=0.3888P
+ PS=2.36U PD=2.52U
M$2790 \$5513 \$5514 QAb VDD pfet_03v3 L=0.28U W=0.36U AS=0.1584P AD=0.1152P
+ PS=1.6U PD=1U
M$2791 QBb \$5515 \$5513 VDD pfet_03v3 L=0.28U W=0.36U AS=0.1152P AD=0.1584P
+ PS=1U PD=1.6U
M$2792 VDD RB \$5515 VDD pfet_03v3 L=0.28U W=0.72U AS=0.3708P AD=0.3168P
+ PS=2.47U PD=2.32U
M$2793 \$5517 WECLKb \$5516 VDD pfet_03v3 L=0.28U W=0.36U AS=0.2097P AD=0.1278P
+ PS=1.38U PD=1.07U
M$2794 \$5549 \$5518 \$5517 VDD pfet_03v3 L=0.28U W=0.36U AS=0.1278P AD=0.0567P
+ PS=1.07U PD=0.675U
M$2795 VDD WECLK \$5549 VDD pfet_03v3 L=0.28U W=0.36U AS=0.0567P AD=0.1584P
+ PS=0.675U PD=1.6U
M$2796 \$5516 D|Q VDD VDD pfet_03v3 L=0.28U W=0.72U AS=0.3168P AD=0.2097P
+ PS=2.32U PD=1.38U
M$2797 VDD \$5517 \$5518 VDD pfet_03v3 L=0.28U W=0.36U AS=0.1584P AD=0.1764P
+ PS=1.6U PD=1.26U
M$2798 \$5519 \$5517 VDD VDD pfet_03v3 L=0.28U W=0.72U AS=0.1764P AD=0.36P
+ PS=1.26U PD=2.44U
M$2799 \$5520 RA VDD VDD pfet_03v3 L=0.28U W=0.72U AS=0.3312P AD=0.3888P
+ PS=2.36U PD=2.52U
M$2800 \$5519 \$5520 QAb VDD pfet_03v3 L=0.28U W=0.36U AS=0.1584P AD=0.1152P
+ PS=1.6U PD=1U
M$2801 QBb \$5521 \$5519 VDD pfet_03v3 L=0.28U W=0.36U AS=0.1152P AD=0.1584P
+ PS=1U PD=1.6U
M$2802 VDD RB \$5521 VDD pfet_03v3 L=0.28U W=0.72U AS=0.3708P AD=0.3168P
+ PS=2.47U PD=2.32U
M$2803 VSS QAb QA VSS nfet_03v3 L=0.28U W=5.76U AS=3.2832P AD=1.9872P PS=29.76U
+ PD=16.8U
M$2804 QB QBb VSS VSS nfet_03v3 L=0.28U W=5.76U AS=1.9872P AD=3.2832P PS=16.8U
+ PD=29.76U
M$2835 WEMb \$256 VSS VSS nfet_03v3 L=0.28U W=1.26U AS=0.441P AD=0.441P
+ PS=3.29U PD=3.29U
M$2837 D|Q \$203 VSS VSS nfet_03v3 L=0.28U W=1.24U AS=0.434P AD=0.434P PS=3.26U
+ PD=3.26U
M$2839 D|Q \$205 VSS VSS nfet_03v3 L=0.28U W=1.24U AS=0.434P AD=0.434P PS=3.26U
+ PD=3.26U
M$2841 D|Q \$207 VSS VSS nfet_03v3 L=0.28U W=1.24U AS=0.434P AD=0.434P PS=3.26U
+ PD=3.26U
M$2843 D|Q \$209 VSS VSS nfet_03v3 L=0.28U W=1.24U AS=0.434P AD=0.434P PS=3.26U
+ PD=3.26U
M$2845 D|Q \$211 VSS VSS nfet_03v3 L=0.28U W=1.24U AS=0.434P AD=0.434P PS=3.26U
+ PD=3.26U
M$2847 D|Q \$213 VSS VSS nfet_03v3 L=0.28U W=1.24U AS=0.434P AD=0.434P PS=3.26U
+ PD=3.26U
M$2849 D|Q \$215 VSS VSS nfet_03v3 L=0.28U W=1.24U AS=0.434P AD=0.434P PS=3.26U
+ PD=3.26U
M$2851 D|Q \$217 VSS VSS nfet_03v3 L=0.28U W=1.24U AS=0.434P AD=0.434P PS=3.26U
+ PD=3.26U
M$2853 D|Q \$219 VSS VSS nfet_03v3 L=0.28U W=1.24U AS=0.434P AD=0.434P PS=3.26U
+ PD=3.26U
M$2855 D|Q \$221 VSS VSS nfet_03v3 L=0.28U W=1.24U AS=0.434P AD=0.434P PS=3.26U
+ PD=3.26U
M$2857 D|Q \$223 VSS VSS nfet_03v3 L=0.28U W=1.24U AS=0.434P AD=0.434P PS=3.26U
+ PD=3.26U
M$2859 D|Q \$225 VSS VSS nfet_03v3 L=0.28U W=1.24U AS=0.434P AD=0.434P PS=3.26U
+ PD=3.26U
M$2861 D|Q \$227 VSS VSS nfet_03v3 L=0.28U W=1.24U AS=0.434P AD=0.434P PS=3.26U
+ PD=3.26U
M$2863 D|Q \$229 VSS VSS nfet_03v3 L=0.28U W=1.24U AS=0.434P AD=0.434P PS=3.26U
+ PD=3.26U
M$2865 D|Q \$231 VSS VSS nfet_03v3 L=0.28U W=1.24U AS=0.434P AD=0.434P PS=3.26U
+ PD=3.26U
M$2867 D|Q \$233 VSS VSS nfet_03v3 L=0.28U W=1.24U AS=0.434P AD=0.434P PS=3.26U
+ PD=3.26U
M$2869 \$107 \$203 VSS VSS nfet_03v3 L=0.28U W=0.36U AS=0.1584P AD=0.1584P
+ PS=1.6U PD=1.6U
M$2870 \$260 WEMb VSS VSS nfet_03v3 L=0.28U W=0.36U AS=0.1584P AD=0.0567P
+ PS=1.6U PD=0.675U
M$2871 \$203 \$107 \$260 VSS nfet_03v3 L=0.28U W=0.36U AS=0.0567P AD=0.1278P
+ PS=0.675U PD=1.07U
M$2872 \$109 WEM \$203 VSS nfet_03v3 L=0.28U W=0.36U AS=0.1278P AD=0.1188P
+ PS=1.07U PD=1.02U
M$2873 VSS D \$109 VSS nfet_03v3 L=0.28U W=0.36U AS=0.1188P AD=0.1584P PS=1.02U
+ PD=1.6U
M$2874 \$111 \$205 VSS VSS nfet_03v3 L=0.28U W=0.36U AS=0.1584P AD=0.1584P
+ PS=1.6U PD=1.6U
M$2875 \$265 WEMb VSS VSS nfet_03v3 L=0.28U W=0.36U AS=0.1584P AD=0.0567P
+ PS=1.6U PD=0.675U
M$2876 \$205 \$111 \$265 VSS nfet_03v3 L=0.28U W=0.36U AS=0.0567P AD=0.1278P
+ PS=0.675U PD=1.07U
M$2877 \$112 WEM \$205 VSS nfet_03v3 L=0.28U W=0.36U AS=0.1278P AD=0.1188P
+ PS=1.07U PD=1.02U
M$2878 VSS D \$112 VSS nfet_03v3 L=0.28U W=0.36U AS=0.1188P AD=0.1584P PS=1.02U
+ PD=1.6U
M$2879 \$114 \$207 VSS VSS nfet_03v3 L=0.28U W=0.36U AS=0.1584P AD=0.1584P
+ PS=1.6U PD=1.6U
M$2880 \$271 WEMb VSS VSS nfet_03v3 L=0.28U W=0.36U AS=0.1584P AD=0.0567P
+ PS=1.6U PD=0.675U
M$2881 \$207 \$114 \$271 VSS nfet_03v3 L=0.28U W=0.36U AS=0.0567P AD=0.1278P
+ PS=0.675U PD=1.07U
M$2882 \$115 WEM \$207 VSS nfet_03v3 L=0.28U W=0.36U AS=0.1278P AD=0.1188P
+ PS=1.07U PD=1.02U
M$2883 VSS D \$115 VSS nfet_03v3 L=0.28U W=0.36U AS=0.1188P AD=0.1584P PS=1.02U
+ PD=1.6U
M$2884 \$117 \$209 VSS VSS nfet_03v3 L=0.28U W=0.36U AS=0.1584P AD=0.1584P
+ PS=1.6U PD=1.6U
M$2885 \$276 WEMb VSS VSS nfet_03v3 L=0.28U W=0.36U AS=0.1584P AD=0.0567P
+ PS=1.6U PD=0.675U
M$2886 \$209 \$117 \$276 VSS nfet_03v3 L=0.28U W=0.36U AS=0.0567P AD=0.1278P
+ PS=0.675U PD=1.07U
M$2887 \$118 WEM \$209 VSS nfet_03v3 L=0.28U W=0.36U AS=0.1278P AD=0.1188P
+ PS=1.07U PD=1.02U
M$2888 VSS D \$118 VSS nfet_03v3 L=0.28U W=0.36U AS=0.1188P AD=0.1584P PS=1.02U
+ PD=1.6U
M$2889 \$120 \$211 VSS VSS nfet_03v3 L=0.28U W=0.36U AS=0.1584P AD=0.1584P
+ PS=1.6U PD=1.6U
M$2890 \$281 WEMb VSS VSS nfet_03v3 L=0.28U W=0.36U AS=0.1584P AD=0.0567P
+ PS=1.6U PD=0.675U
M$2891 \$211 \$120 \$281 VSS nfet_03v3 L=0.28U W=0.36U AS=0.0567P AD=0.1278P
+ PS=0.675U PD=1.07U
M$2892 \$121 WEM \$211 VSS nfet_03v3 L=0.28U W=0.36U AS=0.1278P AD=0.1188P
+ PS=1.07U PD=1.02U
M$2893 VSS D \$121 VSS nfet_03v3 L=0.28U W=0.36U AS=0.1188P AD=0.1584P PS=1.02U
+ PD=1.6U
M$2894 \$123 \$213 VSS VSS nfet_03v3 L=0.28U W=0.36U AS=0.1584P AD=0.1584P
+ PS=1.6U PD=1.6U
M$2895 \$286 WEMb VSS VSS nfet_03v3 L=0.28U W=0.36U AS=0.1584P AD=0.0567P
+ PS=1.6U PD=0.675U
M$2896 \$213 \$123 \$286 VSS nfet_03v3 L=0.28U W=0.36U AS=0.0567P AD=0.1278P
+ PS=0.675U PD=1.07U
M$2897 \$124 WEM \$213 VSS nfet_03v3 L=0.28U W=0.36U AS=0.1278P AD=0.1188P
+ PS=1.07U PD=1.02U
M$2898 VSS D \$124 VSS nfet_03v3 L=0.28U W=0.36U AS=0.1188P AD=0.1584P PS=1.02U
+ PD=1.6U
M$2899 \$126 \$215 VSS VSS nfet_03v3 L=0.28U W=0.36U AS=0.1584P AD=0.1584P
+ PS=1.6U PD=1.6U
M$2900 \$292 WEMb VSS VSS nfet_03v3 L=0.28U W=0.36U AS=0.1584P AD=0.0567P
+ PS=1.6U PD=0.675U
M$2901 \$215 \$126 \$292 VSS nfet_03v3 L=0.28U W=0.36U AS=0.0567P AD=0.1278P
+ PS=0.675U PD=1.07U
M$2902 \$127 WEM \$215 VSS nfet_03v3 L=0.28U W=0.36U AS=0.1278P AD=0.1188P
+ PS=1.07U PD=1.02U
M$2903 VSS D \$127 VSS nfet_03v3 L=0.28U W=0.36U AS=0.1188P AD=0.1584P PS=1.02U
+ PD=1.6U
M$2904 \$129 \$217 VSS VSS nfet_03v3 L=0.28U W=0.36U AS=0.1584P AD=0.1584P
+ PS=1.6U PD=1.6U
M$2905 \$297 WEMb VSS VSS nfet_03v3 L=0.28U W=0.36U AS=0.1584P AD=0.0567P
+ PS=1.6U PD=0.675U
M$2906 \$217 \$129 \$297 VSS nfet_03v3 L=0.28U W=0.36U AS=0.0567P AD=0.1278P
+ PS=0.675U PD=1.07U
M$2907 \$130 WEM \$217 VSS nfet_03v3 L=0.28U W=0.36U AS=0.1278P AD=0.1188P
+ PS=1.07U PD=1.02U
M$2908 VSS D \$130 VSS nfet_03v3 L=0.28U W=0.36U AS=0.1188P AD=0.1584P PS=1.02U
+ PD=1.6U
M$2909 \$132 \$219 VSS VSS nfet_03v3 L=0.28U W=0.36U AS=0.1584P AD=0.1584P
+ PS=1.6U PD=1.6U
M$2910 \$302 WEMb VSS VSS nfet_03v3 L=0.28U W=0.36U AS=0.1584P AD=0.0567P
+ PS=1.6U PD=0.675U
M$2911 \$219 \$132 \$302 VSS nfet_03v3 L=0.28U W=0.36U AS=0.0567P AD=0.1278P
+ PS=0.675U PD=1.07U
M$2912 \$133 WEM \$219 VSS nfet_03v3 L=0.28U W=0.36U AS=0.1278P AD=0.1188P
+ PS=1.07U PD=1.02U
M$2913 VSS D \$133 VSS nfet_03v3 L=0.28U W=0.36U AS=0.1188P AD=0.1584P PS=1.02U
+ PD=1.6U
M$2914 \$135 \$221 VSS VSS nfet_03v3 L=0.28U W=0.36U AS=0.1584P AD=0.1584P
+ PS=1.6U PD=1.6U
M$2915 \$307 WEMb VSS VSS nfet_03v3 L=0.28U W=0.36U AS=0.1584P AD=0.0567P
+ PS=1.6U PD=0.675U
M$2916 \$221 \$135 \$307 VSS nfet_03v3 L=0.28U W=0.36U AS=0.0567P AD=0.1278P
+ PS=0.675U PD=1.07U
M$2917 \$136 WEM \$221 VSS nfet_03v3 L=0.28U W=0.36U AS=0.1278P AD=0.1188P
+ PS=1.07U PD=1.02U
M$2918 VSS D \$136 VSS nfet_03v3 L=0.28U W=0.36U AS=0.1188P AD=0.1584P PS=1.02U
+ PD=1.6U
M$2919 \$138 \$223 VSS VSS nfet_03v3 L=0.28U W=0.36U AS=0.1584P AD=0.1584P
+ PS=1.6U PD=1.6U
M$2920 \$312 WEMb VSS VSS nfet_03v3 L=0.28U W=0.36U AS=0.1584P AD=0.0567P
+ PS=1.6U PD=0.675U
M$2921 \$223 \$138 \$312 VSS nfet_03v3 L=0.28U W=0.36U AS=0.0567P AD=0.1278P
+ PS=0.675U PD=1.07U
M$2922 \$139 WEM \$223 VSS nfet_03v3 L=0.28U W=0.36U AS=0.1278P AD=0.1188P
+ PS=1.07U PD=1.02U
M$2923 VSS D \$139 VSS nfet_03v3 L=0.28U W=0.36U AS=0.1188P AD=0.1584P PS=1.02U
+ PD=1.6U
M$2924 \$141 \$225 VSS VSS nfet_03v3 L=0.28U W=0.36U AS=0.1584P AD=0.1584P
+ PS=1.6U PD=1.6U
M$2925 \$318 WEMb VSS VSS nfet_03v3 L=0.28U W=0.36U AS=0.1584P AD=0.0567P
+ PS=1.6U PD=0.675U
M$2926 \$225 \$141 \$318 VSS nfet_03v3 L=0.28U W=0.36U AS=0.0567P AD=0.1278P
+ PS=0.675U PD=1.07U
M$2927 \$142 WEM \$225 VSS nfet_03v3 L=0.28U W=0.36U AS=0.1278P AD=0.1188P
+ PS=1.07U PD=1.02U
M$2928 VSS D \$142 VSS nfet_03v3 L=0.28U W=0.36U AS=0.1188P AD=0.1584P PS=1.02U
+ PD=1.6U
M$2929 \$144 \$227 VSS VSS nfet_03v3 L=0.28U W=0.36U AS=0.1584P AD=0.1584P
+ PS=1.6U PD=1.6U
M$2930 \$314 WEMb VSS VSS nfet_03v3 L=0.28U W=0.36U AS=0.1584P AD=0.0567P
+ PS=1.6U PD=0.675U
M$2931 \$227 \$144 \$314 VSS nfet_03v3 L=0.28U W=0.36U AS=0.0567P AD=0.1278P
+ PS=0.675U PD=1.07U
M$2932 \$145 WEM \$227 VSS nfet_03v3 L=0.28U W=0.36U AS=0.1278P AD=0.1188P
+ PS=1.07U PD=1.02U
M$2933 VSS D \$145 VSS nfet_03v3 L=0.28U W=0.36U AS=0.1188P AD=0.1584P PS=1.02U
+ PD=1.6U
M$2934 \$147 \$229 VSS VSS nfet_03v3 L=0.28U W=0.36U AS=0.1584P AD=0.1584P
+ PS=1.6U PD=1.6U
M$2935 \$296 WEMb VSS VSS nfet_03v3 L=0.28U W=0.36U AS=0.1584P AD=0.0567P
+ PS=1.6U PD=0.675U
M$2936 \$229 \$147 \$296 VSS nfet_03v3 L=0.28U W=0.36U AS=0.0567P AD=0.1278P
+ PS=0.675U PD=1.07U
M$2937 \$148 WEM \$229 VSS nfet_03v3 L=0.28U W=0.36U AS=0.1278P AD=0.1188P
+ PS=1.07U PD=1.02U
M$2938 VSS D \$148 VSS nfet_03v3 L=0.28U W=0.36U AS=0.1188P AD=0.1584P PS=1.02U
+ PD=1.6U
M$2939 \$150 \$231 VSS VSS nfet_03v3 L=0.28U W=0.36U AS=0.1584P AD=0.1584P
+ PS=1.6U PD=1.6U
M$2940 \$279 WEMb VSS VSS nfet_03v3 L=0.28U W=0.36U AS=0.1584P AD=0.0567P
+ PS=1.6U PD=0.675U
M$2941 \$231 \$150 \$279 VSS nfet_03v3 L=0.28U W=0.36U AS=0.0567P AD=0.1278P
+ PS=0.675U PD=1.07U
M$2942 \$151 WEM \$231 VSS nfet_03v3 L=0.28U W=0.36U AS=0.1278P AD=0.1188P
+ PS=1.07U PD=1.02U
M$2943 VSS D \$151 VSS nfet_03v3 L=0.28U W=0.36U AS=0.1188P AD=0.1584P PS=1.02U
+ PD=1.6U
M$2944 \$153 \$233 VSS VSS nfet_03v3 L=0.28U W=0.36U AS=0.1584P AD=0.1584P
+ PS=1.6U PD=1.6U
M$2945 \$261 WEMb VSS VSS nfet_03v3 L=0.28U W=0.36U AS=0.1584P AD=0.0567P
+ PS=1.6U PD=0.675U
M$2946 \$233 \$153 \$261 VSS nfet_03v3 L=0.28U W=0.36U AS=0.0567P AD=0.1278P
+ PS=0.675U PD=1.07U
M$2947 \$154 WEM \$233 VSS nfet_03v3 L=0.28U W=0.36U AS=0.1278P AD=0.1188P
+ PS=1.07U PD=1.02U
M$2948 VSS D \$154 VSS nfet_03v3 L=0.28U W=0.36U AS=0.1188P AD=0.1584P PS=1.02U
+ PD=1.6U
M$2949 \$471 WE VSS VSS nfet_03v3 L=0.28U W=0.72U AS=0.3168P AD=0.1872P
+ PS=2.32U PD=1.24U
M$2950 \$337 CLK \$471 VSS nfet_03v3 L=0.28U W=0.72U AS=0.1872P AD=0.3168P
+ PS=1.24U PD=2.32U
M$2951 WECLK \$337 VSS VSS nfet_03v3 L=0.28U W=1.27U AS=0.4445P AD=0.3344P
+ PS=3.305U PD=2.345U
M$2953 WECLKb WECLK VSS VSS nfet_03v3 L=0.28U W=21.44U AS=5.8176P AD=7.8256P
+ PS=39.04U PD=55.52U
M$2955 \$340 D|Q VSS VSS nfet_03v3 L=0.28U W=0.36U AS=0.1584P AD=0.1188P
+ PS=1.6U PD=1.02U
M$2956 \$341 WECLK \$340 VSS nfet_03v3 L=0.28U W=0.36U AS=0.1188P AD=0.1278P
+ PS=1.02U PD=1.07U
M$2957 \$393 \$342 \$341 VSS nfet_03v3 L=0.28U W=0.36U AS=0.1278P AD=0.0567P
+ PS=1.07U PD=0.675U
M$2958 VSS WECLKb \$393 VSS nfet_03v3 L=0.28U W=0.36U AS=0.0567P AD=0.1584P
+ PS=0.675U PD=1.6U
M$2959 VSS \$341 \$342 VSS nfet_03v3 L=0.28U W=0.36U AS=0.1584P AD=0.0972P
+ PS=1.6U PD=0.9U
M$2960 \$321 \$341 VSS VSS nfet_03v3 L=0.28U W=0.36U AS=0.0972P AD=0.18P
+ PS=0.9U PD=1.72U
M$2961 \$439 RA VSS VSS nfet_03v3 L=0.28U W=0.36U AS=0.1656P AD=0.1944P
+ PS=1.64U PD=1.8U
M$2962 \$321 RA QAb VSS nfet_03v3 L=0.28U W=0.36U AS=0.1584P AD=0.1152P PS=1.6U
+ PD=1U
M$2963 QBb RB \$321 VSS nfet_03v3 L=0.28U W=0.36U AS=0.1152P AD=0.1584P PS=1U
+ PD=1.6U
M$2964 VSS RB \$440 VSS nfet_03v3 L=0.28U W=0.36U AS=0.1854P AD=0.1584P
+ PS=1.75U PD=1.6U
M$2965 \$343 D|Q VSS VSS nfet_03v3 L=0.28U W=0.36U AS=0.1584P AD=0.1188P
+ PS=1.6U PD=1.02U
M$2966 \$344 WECLK \$343 VSS nfet_03v3 L=0.28U W=0.36U AS=0.1188P AD=0.1278P
+ PS=1.02U PD=1.07U
M$2967 \$402 \$345 \$344 VSS nfet_03v3 L=0.28U W=0.36U AS=0.1278P AD=0.0567P
+ PS=1.07U PD=0.675U
M$2968 VSS WECLKb \$402 VSS nfet_03v3 L=0.28U W=0.36U AS=0.0567P AD=0.1584P
+ PS=0.675U PD=1.6U
M$2969 VSS \$344 \$345 VSS nfet_03v3 L=0.28U W=0.36U AS=0.1584P AD=0.0972P
+ PS=1.6U PD=0.9U
M$2970 \$322 \$344 VSS VSS nfet_03v3 L=0.28U W=0.36U AS=0.0972P AD=0.18P
+ PS=0.9U PD=1.72U
M$2971 \$441 RA VSS VSS nfet_03v3 L=0.28U W=0.36U AS=0.1656P AD=0.1944P
+ PS=1.64U PD=1.8U
M$2972 \$322 RA QAb VSS nfet_03v3 L=0.28U W=0.36U AS=0.1584P AD=0.1152P PS=1.6U
+ PD=1U
M$2973 QBb RB \$322 VSS nfet_03v3 L=0.28U W=0.36U AS=0.1152P AD=0.1584P PS=1U
+ PD=1.6U
M$2974 VSS RB \$442 VSS nfet_03v3 L=0.28U W=0.36U AS=0.1854P AD=0.1584P
+ PS=1.75U PD=1.6U
M$2975 \$346 D|Q VSS VSS nfet_03v3 L=0.28U W=0.36U AS=0.1584P AD=0.1188P
+ PS=1.6U PD=1.02U
M$2976 \$347 WECLK \$346 VSS nfet_03v3 L=0.28U W=0.36U AS=0.1188P AD=0.1278P
+ PS=1.02U PD=1.07U
M$2977 \$410 \$348 \$347 VSS nfet_03v3 L=0.28U W=0.36U AS=0.1278P AD=0.0567P
+ PS=1.07U PD=0.675U
M$2978 VSS WECLKb \$410 VSS nfet_03v3 L=0.28U W=0.36U AS=0.0567P AD=0.1584P
+ PS=0.675U PD=1.6U
M$2979 VSS \$347 \$348 VSS nfet_03v3 L=0.28U W=0.36U AS=0.1584P AD=0.0972P
+ PS=1.6U PD=0.9U
M$2980 \$323 \$347 VSS VSS nfet_03v3 L=0.28U W=0.36U AS=0.0972P AD=0.18P
+ PS=0.9U PD=1.72U
M$2981 \$443 RA VSS VSS nfet_03v3 L=0.28U W=0.36U AS=0.1656P AD=0.1944P
+ PS=1.64U PD=1.8U
M$2982 \$323 RA QAb VSS nfet_03v3 L=0.28U W=0.36U AS=0.1584P AD=0.1152P PS=1.6U
+ PD=1U
M$2983 QBb RB \$323 VSS nfet_03v3 L=0.28U W=0.36U AS=0.1152P AD=0.1584P PS=1U
+ PD=1.6U
M$2984 VSS RB \$444 VSS nfet_03v3 L=0.28U W=0.36U AS=0.1854P AD=0.1584P
+ PS=1.75U PD=1.6U
M$2985 \$349 D|Q VSS VSS nfet_03v3 L=0.28U W=0.36U AS=0.1584P AD=0.1188P
+ PS=1.6U PD=1.02U
M$2986 \$350 WECLK \$349 VSS nfet_03v3 L=0.28U W=0.36U AS=0.1188P AD=0.1278P
+ PS=1.02U PD=1.07U
M$2987 \$419 \$351 \$350 VSS nfet_03v3 L=0.28U W=0.36U AS=0.1278P AD=0.0567P
+ PS=1.07U PD=0.675U
M$2988 VSS WECLKb \$419 VSS nfet_03v3 L=0.28U W=0.36U AS=0.0567P AD=0.1584P
+ PS=0.675U PD=1.6U
M$2989 VSS \$350 \$351 VSS nfet_03v3 L=0.28U W=0.36U AS=0.1584P AD=0.0972P
+ PS=1.6U PD=0.9U
M$2990 \$324 \$350 VSS VSS nfet_03v3 L=0.28U W=0.36U AS=0.0972P AD=0.18P
+ PS=0.9U PD=1.72U
M$2991 \$445 RA VSS VSS nfet_03v3 L=0.28U W=0.36U AS=0.1656P AD=0.1944P
+ PS=1.64U PD=1.8U
M$2992 \$324 RA QAb VSS nfet_03v3 L=0.28U W=0.36U AS=0.1584P AD=0.1152P PS=1.6U
+ PD=1U
M$2993 QBb RB \$324 VSS nfet_03v3 L=0.28U W=0.36U AS=0.1152P AD=0.1584P PS=1U
+ PD=1.6U
M$2994 VSS RB \$446 VSS nfet_03v3 L=0.28U W=0.36U AS=0.1854P AD=0.1584P
+ PS=1.75U PD=1.6U
M$2995 \$352 D|Q VSS VSS nfet_03v3 L=0.28U W=0.36U AS=0.1584P AD=0.1188P
+ PS=1.6U PD=1.02U
M$2996 \$353 WECLK \$352 VSS nfet_03v3 L=0.28U W=0.36U AS=0.1188P AD=0.1278P
+ PS=1.02U PD=1.07U
M$2997 \$429 \$354 \$353 VSS nfet_03v3 L=0.28U W=0.36U AS=0.1278P AD=0.0567P
+ PS=1.07U PD=0.675U
M$2998 VSS WECLKb \$429 VSS nfet_03v3 L=0.28U W=0.36U AS=0.0567P AD=0.1584P
+ PS=0.675U PD=1.6U
M$2999 VSS \$353 \$354 VSS nfet_03v3 L=0.28U W=0.36U AS=0.1584P AD=0.0972P
+ PS=1.6U PD=0.9U
M$3000 \$325 \$353 VSS VSS nfet_03v3 L=0.28U W=0.36U AS=0.0972P AD=0.18P
+ PS=0.9U PD=1.72U
M$3001 \$447 RA VSS VSS nfet_03v3 L=0.28U W=0.36U AS=0.1656P AD=0.1944P
+ PS=1.64U PD=1.8U
M$3002 \$325 RA QAb VSS nfet_03v3 L=0.28U W=0.36U AS=0.1584P AD=0.1152P PS=1.6U
+ PD=1U
M$3003 QBb RB \$325 VSS nfet_03v3 L=0.28U W=0.36U AS=0.1152P AD=0.1584P PS=1U
+ PD=1.6U
M$3004 VSS RB \$448 VSS nfet_03v3 L=0.28U W=0.36U AS=0.1854P AD=0.1584P
+ PS=1.75U PD=1.6U
M$3005 \$355 D|Q VSS VSS nfet_03v3 L=0.28U W=0.36U AS=0.1584P AD=0.1188P
+ PS=1.6U PD=1.02U
M$3006 \$356 WECLK \$355 VSS nfet_03v3 L=0.28U W=0.36U AS=0.1188P AD=0.1278P
+ PS=1.02U PD=1.07U
M$3007 \$435 \$357 \$356 VSS nfet_03v3 L=0.28U W=0.36U AS=0.1278P AD=0.0567P
+ PS=1.07U PD=0.675U
M$3008 VSS WECLKb \$435 VSS nfet_03v3 L=0.28U W=0.36U AS=0.0567P AD=0.1584P
+ PS=0.675U PD=1.6U
M$3009 VSS \$356 \$357 VSS nfet_03v3 L=0.28U W=0.36U AS=0.1584P AD=0.0972P
+ PS=1.6U PD=0.9U
M$3010 \$326 \$356 VSS VSS nfet_03v3 L=0.28U W=0.36U AS=0.0972P AD=0.18P
+ PS=0.9U PD=1.72U
M$3011 \$449 RA VSS VSS nfet_03v3 L=0.28U W=0.36U AS=0.1656P AD=0.1944P
+ PS=1.64U PD=1.8U
M$3012 \$326 RA QAb VSS nfet_03v3 L=0.28U W=0.36U AS=0.1584P AD=0.1152P PS=1.6U
+ PD=1U
M$3013 QBb RB \$326 VSS nfet_03v3 L=0.28U W=0.36U AS=0.1152P AD=0.1584P PS=1U
+ PD=1.6U
M$3014 VSS RB \$450 VSS nfet_03v3 L=0.28U W=0.36U AS=0.1854P AD=0.1584P
+ PS=1.75U PD=1.6U
M$3015 \$358 D|Q VSS VSS nfet_03v3 L=0.28U W=0.36U AS=0.1584P AD=0.1188P
+ PS=1.6U PD=1.02U
M$3016 \$359 WECLK \$358 VSS nfet_03v3 L=0.28U W=0.36U AS=0.1188P AD=0.1278P
+ PS=1.02U PD=1.07U
M$3017 \$428 \$360 \$359 VSS nfet_03v3 L=0.28U W=0.36U AS=0.1278P AD=0.0567P
+ PS=1.07U PD=0.675U
M$3018 VSS WECLKb \$428 VSS nfet_03v3 L=0.28U W=0.36U AS=0.0567P AD=0.1584P
+ PS=0.675U PD=1.6U
M$3019 VSS \$359 \$360 VSS nfet_03v3 L=0.28U W=0.36U AS=0.1584P AD=0.0972P
+ PS=1.6U PD=0.9U
M$3020 \$327 \$359 VSS VSS nfet_03v3 L=0.28U W=0.36U AS=0.0972P AD=0.18P
+ PS=0.9U PD=1.72U
M$3021 \$451 RA VSS VSS nfet_03v3 L=0.28U W=0.36U AS=0.1656P AD=0.1944P
+ PS=1.64U PD=1.8U
M$3022 \$327 RA QAb VSS nfet_03v3 L=0.28U W=0.36U AS=0.1584P AD=0.1152P PS=1.6U
+ PD=1U
M$3023 QBb RB \$327 VSS nfet_03v3 L=0.28U W=0.36U AS=0.1152P AD=0.1584P PS=1U
+ PD=1.6U
M$3024 VSS RB \$452 VSS nfet_03v3 L=0.28U W=0.36U AS=0.1854P AD=0.1584P
+ PS=1.75U PD=1.6U
M$3025 \$361 D|Q VSS VSS nfet_03v3 L=0.28U W=0.36U AS=0.1584P AD=0.1188P
+ PS=1.6U PD=1.02U
M$3026 \$362 WECLK \$361 VSS nfet_03v3 L=0.28U W=0.36U AS=0.1188P AD=0.1278P
+ PS=1.02U PD=1.07U
M$3027 \$426 \$363 \$362 VSS nfet_03v3 L=0.28U W=0.36U AS=0.1278P AD=0.0567P
+ PS=1.07U PD=0.675U
M$3028 VSS WECLKb \$426 VSS nfet_03v3 L=0.28U W=0.36U AS=0.0567P AD=0.1584P
+ PS=0.675U PD=1.6U
M$3029 VSS \$362 \$363 VSS nfet_03v3 L=0.28U W=0.36U AS=0.1584P AD=0.0972P
+ PS=1.6U PD=0.9U
M$3030 \$328 \$362 VSS VSS nfet_03v3 L=0.28U W=0.36U AS=0.0972P AD=0.18P
+ PS=0.9U PD=1.72U
M$3031 \$453 RA VSS VSS nfet_03v3 L=0.28U W=0.36U AS=0.1656P AD=0.1944P
+ PS=1.64U PD=1.8U
M$3032 \$328 RA QAb VSS nfet_03v3 L=0.28U W=0.36U AS=0.1584P AD=0.1152P PS=1.6U
+ PD=1U
M$3033 QBb RB \$328 VSS nfet_03v3 L=0.28U W=0.36U AS=0.1152P AD=0.1584P PS=1U
+ PD=1.6U
M$3034 VSS RB \$454 VSS nfet_03v3 L=0.28U W=0.36U AS=0.1854P AD=0.1584P
+ PS=1.75U PD=1.6U
M$3035 \$364 D|Q VSS VSS nfet_03v3 L=0.28U W=0.36U AS=0.1584P AD=0.1188P
+ PS=1.6U PD=1.02U
M$3036 \$365 WECLK \$364 VSS nfet_03v3 L=0.28U W=0.36U AS=0.1188P AD=0.1278P
+ PS=1.02U PD=1.07U
M$3037 \$421 \$366 \$365 VSS nfet_03v3 L=0.28U W=0.36U AS=0.1278P AD=0.0567P
+ PS=1.07U PD=0.675U
M$3038 VSS WECLKb \$421 VSS nfet_03v3 L=0.28U W=0.36U AS=0.0567P AD=0.1584P
+ PS=0.675U PD=1.6U
M$3039 VSS \$365 \$366 VSS nfet_03v3 L=0.28U W=0.36U AS=0.1584P AD=0.0972P
+ PS=1.6U PD=0.9U
M$3040 \$329 \$365 VSS VSS nfet_03v3 L=0.28U W=0.36U AS=0.0972P AD=0.18P
+ PS=0.9U PD=1.72U
M$3041 \$455 RA VSS VSS nfet_03v3 L=0.28U W=0.36U AS=0.1656P AD=0.1944P
+ PS=1.64U PD=1.8U
M$3042 \$329 RA QAb VSS nfet_03v3 L=0.28U W=0.36U AS=0.1584P AD=0.1152P PS=1.6U
+ PD=1U
M$3043 QBb RB \$329 VSS nfet_03v3 L=0.28U W=0.36U AS=0.1152P AD=0.1584P PS=1U
+ PD=1.6U
M$3044 VSS RB \$456 VSS nfet_03v3 L=0.28U W=0.36U AS=0.1854P AD=0.1584P
+ PS=1.75U PD=1.6U
M$3045 \$367 D|Q VSS VSS nfet_03v3 L=0.28U W=0.36U AS=0.1584P AD=0.1188P
+ PS=1.6U PD=1.02U
M$3046 \$368 WECLK \$367 VSS nfet_03v3 L=0.28U W=0.36U AS=0.1188P AD=0.1278P
+ PS=1.02U PD=1.07U
M$3047 \$417 \$369 \$368 VSS nfet_03v3 L=0.28U W=0.36U AS=0.1278P AD=0.0567P
+ PS=1.07U PD=0.675U
M$3048 VSS WECLKb \$417 VSS nfet_03v3 L=0.28U W=0.36U AS=0.0567P AD=0.1584P
+ PS=0.675U PD=1.6U
M$3049 VSS \$368 \$369 VSS nfet_03v3 L=0.28U W=0.36U AS=0.1584P AD=0.0972P
+ PS=1.6U PD=0.9U
M$3050 \$330 \$368 VSS VSS nfet_03v3 L=0.28U W=0.36U AS=0.0972P AD=0.18P
+ PS=0.9U PD=1.72U
M$3051 \$457 RA VSS VSS nfet_03v3 L=0.28U W=0.36U AS=0.1656P AD=0.1944P
+ PS=1.64U PD=1.8U
M$3052 \$330 RA QAb VSS nfet_03v3 L=0.28U W=0.36U AS=0.1584P AD=0.1152P PS=1.6U
+ PD=1U
M$3053 QBb RB \$330 VSS nfet_03v3 L=0.28U W=0.36U AS=0.1152P AD=0.1584P PS=1U
+ PD=1.6U
M$3054 VSS RB \$458 VSS nfet_03v3 L=0.28U W=0.36U AS=0.1854P AD=0.1584P
+ PS=1.75U PD=1.6U
M$3055 \$370 D|Q VSS VSS nfet_03v3 L=0.28U W=0.36U AS=0.1584P AD=0.1188P
+ PS=1.6U PD=1.02U
M$3056 \$371 WECLK \$370 VSS nfet_03v3 L=0.28U W=0.36U AS=0.1188P AD=0.1278P
+ PS=1.02U PD=1.07U
M$3057 \$412 \$372 \$371 VSS nfet_03v3 L=0.28U W=0.36U AS=0.1278P AD=0.0567P
+ PS=1.07U PD=0.675U
M$3058 VSS WECLKb \$412 VSS nfet_03v3 L=0.28U W=0.36U AS=0.0567P AD=0.1584P
+ PS=0.675U PD=1.6U
M$3059 VSS \$371 \$372 VSS nfet_03v3 L=0.28U W=0.36U AS=0.1584P AD=0.0972P
+ PS=1.6U PD=0.9U
M$3060 \$331 \$371 VSS VSS nfet_03v3 L=0.28U W=0.36U AS=0.0972P AD=0.18P
+ PS=0.9U PD=1.72U
M$3061 \$459 RA VSS VSS nfet_03v3 L=0.28U W=0.36U AS=0.1656P AD=0.1944P
+ PS=1.64U PD=1.8U
M$3062 \$331 RA QAb VSS nfet_03v3 L=0.28U W=0.36U AS=0.1584P AD=0.1152P PS=1.6U
+ PD=1U
M$3063 QBb RB \$331 VSS nfet_03v3 L=0.28U W=0.36U AS=0.1152P AD=0.1584P PS=1U
+ PD=1.6U
M$3064 VSS RB \$460 VSS nfet_03v3 L=0.28U W=0.36U AS=0.1854P AD=0.1584P
+ PS=1.75U PD=1.6U
M$3065 \$373 D|Q VSS VSS nfet_03v3 L=0.28U W=0.36U AS=0.1584P AD=0.1188P
+ PS=1.6U PD=1.02U
M$3066 \$374 WECLK \$373 VSS nfet_03v3 L=0.28U W=0.36U AS=0.1188P AD=0.1278P
+ PS=1.02U PD=1.07U
M$3067 \$408 \$375 \$374 VSS nfet_03v3 L=0.28U W=0.36U AS=0.1278P AD=0.0567P
+ PS=1.07U PD=0.675U
M$3068 VSS WECLKb \$408 VSS nfet_03v3 L=0.28U W=0.36U AS=0.0567P AD=0.1584P
+ PS=0.675U PD=1.6U
M$3069 VSS \$374 \$375 VSS nfet_03v3 L=0.28U W=0.36U AS=0.1584P AD=0.0972P
+ PS=1.6U PD=0.9U
M$3070 \$332 \$374 VSS VSS nfet_03v3 L=0.28U W=0.36U AS=0.0972P AD=0.18P
+ PS=0.9U PD=1.72U
M$3071 \$461 RA VSS VSS nfet_03v3 L=0.28U W=0.36U AS=0.1656P AD=0.1944P
+ PS=1.64U PD=1.8U
M$3072 \$332 RA QAb VSS nfet_03v3 L=0.28U W=0.36U AS=0.1584P AD=0.1152P PS=1.6U
+ PD=1U
M$3073 QBb RB \$332 VSS nfet_03v3 L=0.28U W=0.36U AS=0.1152P AD=0.1584P PS=1U
+ PD=1.6U
M$3074 VSS RB \$462 VSS nfet_03v3 L=0.28U W=0.36U AS=0.1854P AD=0.1584P
+ PS=1.75U PD=1.6U
M$3075 \$376 D|Q VSS VSS nfet_03v3 L=0.28U W=0.36U AS=0.1584P AD=0.1188P
+ PS=1.6U PD=1.02U
M$3076 \$377 WECLK \$376 VSS nfet_03v3 L=0.28U W=0.36U AS=0.1188P AD=0.1278P
+ PS=1.02U PD=1.07U
M$3077 \$401 \$378 \$377 VSS nfet_03v3 L=0.28U W=0.36U AS=0.1278P AD=0.0567P
+ PS=1.07U PD=0.675U
M$3078 VSS WECLKb \$401 VSS nfet_03v3 L=0.28U W=0.36U AS=0.0567P AD=0.1584P
+ PS=0.675U PD=1.6U
M$3079 VSS \$377 \$378 VSS nfet_03v3 L=0.28U W=0.36U AS=0.1584P AD=0.0972P
+ PS=1.6U PD=0.9U
M$3080 \$333 \$377 VSS VSS nfet_03v3 L=0.28U W=0.36U AS=0.0972P AD=0.18P
+ PS=0.9U PD=1.72U
M$3081 \$463 RA VSS VSS nfet_03v3 L=0.28U W=0.36U AS=0.1656P AD=0.1944P
+ PS=1.64U PD=1.8U
M$3082 \$333 RA QAb VSS nfet_03v3 L=0.28U W=0.36U AS=0.1584P AD=0.1152P PS=1.6U
+ PD=1U
M$3083 QBb RB \$333 VSS nfet_03v3 L=0.28U W=0.36U AS=0.1152P AD=0.1584P PS=1U
+ PD=1.6U
M$3084 VSS RB \$464 VSS nfet_03v3 L=0.28U W=0.36U AS=0.1854P AD=0.1584P
+ PS=1.75U PD=1.6U
M$3085 \$379 D|Q VSS VSS nfet_03v3 L=0.28U W=0.36U AS=0.1584P AD=0.1188P
+ PS=1.6U PD=1.02U
M$3086 \$380 WECLK \$379 VSS nfet_03v3 L=0.28U W=0.36U AS=0.1188P AD=0.1278P
+ PS=1.02U PD=1.07U
M$3087 \$398 \$381 \$380 VSS nfet_03v3 L=0.28U W=0.36U AS=0.1278P AD=0.0567P
+ PS=1.07U PD=0.675U
M$3088 VSS WECLKb \$398 VSS nfet_03v3 L=0.28U W=0.36U AS=0.0567P AD=0.1584P
+ PS=0.675U PD=1.6U
M$3089 VSS \$380 \$381 VSS nfet_03v3 L=0.28U W=0.36U AS=0.1584P AD=0.0972P
+ PS=1.6U PD=0.9U
M$3090 \$334 \$380 VSS VSS nfet_03v3 L=0.28U W=0.36U AS=0.0972P AD=0.18P
+ PS=0.9U PD=1.72U
M$3091 \$465 RA VSS VSS nfet_03v3 L=0.28U W=0.36U AS=0.1656P AD=0.1944P
+ PS=1.64U PD=1.8U
M$3092 \$334 RA QAb VSS nfet_03v3 L=0.28U W=0.36U AS=0.1584P AD=0.1152P PS=1.6U
+ PD=1U
M$3093 QBb RB \$334 VSS nfet_03v3 L=0.28U W=0.36U AS=0.1152P AD=0.1584P PS=1U
+ PD=1.6U
M$3094 VSS RB \$466 VSS nfet_03v3 L=0.28U W=0.36U AS=0.1854P AD=0.1584P
+ PS=1.75U PD=1.6U
M$3095 \$382 D|Q VSS VSS nfet_03v3 L=0.28U W=0.36U AS=0.1584P AD=0.1188P
+ PS=1.6U PD=1.02U
M$3096 \$383 WECLK \$382 VSS nfet_03v3 L=0.28U W=0.36U AS=0.1188P AD=0.1278P
+ PS=1.02U PD=1.07U
M$3097 \$392 \$384 \$383 VSS nfet_03v3 L=0.28U W=0.36U AS=0.1278P AD=0.0567P
+ PS=1.07U PD=0.675U
M$3098 VSS WECLKb \$392 VSS nfet_03v3 L=0.28U W=0.36U AS=0.0567P AD=0.1584P
+ PS=0.675U PD=1.6U
M$3099 VSS \$383 \$384 VSS nfet_03v3 L=0.28U W=0.36U AS=0.1584P AD=0.0972P
+ PS=1.6U PD=0.9U
M$3100 \$335 \$383 VSS VSS nfet_03v3 L=0.28U W=0.36U AS=0.0972P AD=0.18P
+ PS=0.9U PD=1.72U
M$3101 \$467 RA VSS VSS nfet_03v3 L=0.28U W=0.36U AS=0.1656P AD=0.1944P
+ PS=1.64U PD=1.8U
M$3102 \$335 RA QAb VSS nfet_03v3 L=0.28U W=0.36U AS=0.1584P AD=0.1152P PS=1.6U
+ PD=1U
M$3103 QBb RB \$335 VSS nfet_03v3 L=0.28U W=0.36U AS=0.1152P AD=0.1584P PS=1U
+ PD=1.6U
M$3104 VSS RB \$468 VSS nfet_03v3 L=0.28U W=0.36U AS=0.1854P AD=0.1584P
+ PS=1.75U PD=1.6U
M$3105 \$385 D|Q VSS VSS nfet_03v3 L=0.28U W=0.36U AS=0.1584P AD=0.1188P
+ PS=1.6U PD=1.02U
M$3106 \$386 WECLK \$385 VSS nfet_03v3 L=0.28U W=0.36U AS=0.1188P AD=0.1278P
+ PS=1.02U PD=1.07U
M$3107 \$389 \$387 \$386 VSS nfet_03v3 L=0.28U W=0.36U AS=0.1278P AD=0.0567P
+ PS=1.07U PD=0.675U
M$3108 VSS WECLKb \$389 VSS nfet_03v3 L=0.28U W=0.36U AS=0.0567P AD=0.1584P
+ PS=0.675U PD=1.6U
M$3109 VSS \$386 \$387 VSS nfet_03v3 L=0.28U W=0.36U AS=0.1584P AD=0.0972P
+ PS=1.6U PD=0.9U
M$3110 \$336 \$386 VSS VSS nfet_03v3 L=0.28U W=0.36U AS=0.0972P AD=0.18P
+ PS=0.9U PD=1.72U
M$3111 \$469 RA VSS VSS nfet_03v3 L=0.28U W=0.36U AS=0.1656P AD=0.1944P
+ PS=1.64U PD=1.8U
M$3112 \$336 RA QAb VSS nfet_03v3 L=0.28U W=0.36U AS=0.1584P AD=0.1152P PS=1.6U
+ PD=1U
M$3113 QBb RB \$336 VSS nfet_03v3 L=0.28U W=0.36U AS=0.1152P AD=0.1584P PS=1U
+ PD=1.6U
M$3114 VSS RB \$470 VSS nfet_03v3 L=0.28U W=0.36U AS=0.1854P AD=0.1584P
+ PS=1.75U PD=1.6U
M$3115 \$900 WE VSS VSS nfet_03v3 L=0.28U W=0.72U AS=0.3168P AD=0.1872P
+ PS=2.32U PD=1.24U
M$3116 \$663 CLK \$900 VSS nfet_03v3 L=0.28U W=0.72U AS=0.1872P AD=0.3168P
+ PS=1.24U PD=2.32U
M$3117 WECLK \$663 VSS VSS nfet_03v3 L=0.28U W=1.27U AS=0.4487P AD=0.3302P
+ PS=3.34U PD=2.31U
M$3121 \$672 RA VSS VSS nfet_03v3 L=0.28U W=0.36U AS=0.1656P AD=0.1944P
+ PS=1.64U PD=1.8U
M$3122 \$671 RA QAb VSS nfet_03v3 L=0.28U W=0.36U AS=0.1584P AD=0.1152P PS=1.6U
+ PD=1U
M$3123 QBb RB \$671 VSS nfet_03v3 L=0.28U W=0.36U AS=0.1152P AD=0.1584P PS=1U
+ PD=1.6U
M$3124 VSS RB \$673 VSS nfet_03v3 L=0.28U W=0.36U AS=0.1854P AD=0.1584P
+ PS=1.75U PD=1.6U
M$3125 \$679 RA VSS VSS nfet_03v3 L=0.28U W=0.36U AS=0.1656P AD=0.1944P
+ PS=1.64U PD=1.8U
M$3126 \$678 RA QAb VSS nfet_03v3 L=0.28U W=0.36U AS=0.1584P AD=0.1152P PS=1.6U
+ PD=1U
M$3127 QBb RB \$678 VSS nfet_03v3 L=0.28U W=0.36U AS=0.1152P AD=0.1584P PS=1U
+ PD=1.6U
M$3128 VSS RB \$680 VSS nfet_03v3 L=0.28U W=0.36U AS=0.1854P AD=0.1584P
+ PS=1.75U PD=1.6U
M$3129 \$685 RA VSS VSS nfet_03v3 L=0.28U W=0.36U AS=0.1656P AD=0.1944P
+ PS=1.64U PD=1.8U
M$3130 \$684 RA QAb VSS nfet_03v3 L=0.28U W=0.36U AS=0.1584P AD=0.1152P PS=1.6U
+ PD=1U
M$3131 QBb RB \$684 VSS nfet_03v3 L=0.28U W=0.36U AS=0.1152P AD=0.1584P PS=1U
+ PD=1.6U
M$3132 VSS RB \$686 VSS nfet_03v3 L=0.28U W=0.36U AS=0.1854P AD=0.1584P
+ PS=1.75U PD=1.6U
M$3133 \$691 RA VSS VSS nfet_03v3 L=0.28U W=0.36U AS=0.1656P AD=0.1944P
+ PS=1.64U PD=1.8U
M$3134 \$690 RA QAb VSS nfet_03v3 L=0.28U W=0.36U AS=0.1584P AD=0.1152P PS=1.6U
+ PD=1U
M$3135 QBb RB \$690 VSS nfet_03v3 L=0.28U W=0.36U AS=0.1152P AD=0.1584P PS=1U
+ PD=1.6U
M$3136 VSS RB \$692 VSS nfet_03v3 L=0.28U W=0.36U AS=0.1854P AD=0.1584P
+ PS=1.75U PD=1.6U
M$3137 \$697 RA VSS VSS nfet_03v3 L=0.28U W=0.36U AS=0.1656P AD=0.1944P
+ PS=1.64U PD=1.8U
M$3138 \$696 RA QAb VSS nfet_03v3 L=0.28U W=0.36U AS=0.1584P AD=0.1152P PS=1.6U
+ PD=1U
M$3139 QBb RB \$696 VSS nfet_03v3 L=0.28U W=0.36U AS=0.1152P AD=0.1584P PS=1U
+ PD=1.6U
M$3140 VSS RB \$698 VSS nfet_03v3 L=0.28U W=0.36U AS=0.1854P AD=0.1584P
+ PS=1.75U PD=1.6U
M$3141 \$703 RA VSS VSS nfet_03v3 L=0.28U W=0.36U AS=0.1656P AD=0.1944P
+ PS=1.64U PD=1.8U
M$3142 \$702 RA QAb VSS nfet_03v3 L=0.28U W=0.36U AS=0.1584P AD=0.1152P PS=1.6U
+ PD=1U
M$3143 QBb RB \$702 VSS nfet_03v3 L=0.28U W=0.36U AS=0.1152P AD=0.1584P PS=1U
+ PD=1.6U
M$3144 VSS RB \$704 VSS nfet_03v3 L=0.28U W=0.36U AS=0.1854P AD=0.1584P
+ PS=1.75U PD=1.6U
M$3145 \$709 RA VSS VSS nfet_03v3 L=0.28U W=0.36U AS=0.1656P AD=0.1944P
+ PS=1.64U PD=1.8U
M$3146 \$708 RA QAb VSS nfet_03v3 L=0.28U W=0.36U AS=0.1584P AD=0.1152P PS=1.6U
+ PD=1U
M$3147 QBb RB \$708 VSS nfet_03v3 L=0.28U W=0.36U AS=0.1152P AD=0.1584P PS=1U
+ PD=1.6U
M$3148 VSS RB \$710 VSS nfet_03v3 L=0.28U W=0.36U AS=0.1854P AD=0.1584P
+ PS=1.75U PD=1.6U
M$3149 \$715 RA VSS VSS nfet_03v3 L=0.28U W=0.36U AS=0.1656P AD=0.1944P
+ PS=1.64U PD=1.8U
M$3150 \$714 RA QAb VSS nfet_03v3 L=0.28U W=0.36U AS=0.1584P AD=0.1152P PS=1.6U
+ PD=1U
M$3151 QBb RB \$714 VSS nfet_03v3 L=0.28U W=0.36U AS=0.1152P AD=0.1584P PS=1U
+ PD=1.6U
M$3152 VSS RB \$716 VSS nfet_03v3 L=0.28U W=0.36U AS=0.1854P AD=0.1584P
+ PS=1.75U PD=1.6U
M$3153 \$721 RA VSS VSS nfet_03v3 L=0.28U W=0.36U AS=0.1656P AD=0.1944P
+ PS=1.64U PD=1.8U
M$3154 \$720 RA QAb VSS nfet_03v3 L=0.28U W=0.36U AS=0.1584P AD=0.1152P PS=1.6U
+ PD=1U
M$3155 QBb RB \$720 VSS nfet_03v3 L=0.28U W=0.36U AS=0.1152P AD=0.1584P PS=1U
+ PD=1.6U
M$3156 VSS RB \$722 VSS nfet_03v3 L=0.28U W=0.36U AS=0.1854P AD=0.1584P
+ PS=1.75U PD=1.6U
M$3157 \$727 RA VSS VSS nfet_03v3 L=0.28U W=0.36U AS=0.1656P AD=0.1944P
+ PS=1.64U PD=1.8U
M$3158 \$726 RA QAb VSS nfet_03v3 L=0.28U W=0.36U AS=0.1584P AD=0.1152P PS=1.6U
+ PD=1U
M$3159 QBb RB \$726 VSS nfet_03v3 L=0.28U W=0.36U AS=0.1152P AD=0.1584P PS=1U
+ PD=1.6U
M$3160 VSS RB \$728 VSS nfet_03v3 L=0.28U W=0.36U AS=0.1854P AD=0.1584P
+ PS=1.75U PD=1.6U
M$3161 \$733 RA VSS VSS nfet_03v3 L=0.28U W=0.36U AS=0.1656P AD=0.1944P
+ PS=1.64U PD=1.8U
M$3162 \$732 RA QAb VSS nfet_03v3 L=0.28U W=0.36U AS=0.1584P AD=0.1152P PS=1.6U
+ PD=1U
M$3163 QBb RB \$732 VSS nfet_03v3 L=0.28U W=0.36U AS=0.1152P AD=0.1584P PS=1U
+ PD=1.6U
M$3164 VSS RB \$734 VSS nfet_03v3 L=0.28U W=0.36U AS=0.1854P AD=0.1584P
+ PS=1.75U PD=1.6U
M$3165 \$739 RA VSS VSS nfet_03v3 L=0.28U W=0.36U AS=0.1656P AD=0.1944P
+ PS=1.64U PD=1.8U
M$3166 \$738 RA QAb VSS nfet_03v3 L=0.28U W=0.36U AS=0.1584P AD=0.1152P PS=1.6U
+ PD=1U
M$3167 QBb RB \$738 VSS nfet_03v3 L=0.28U W=0.36U AS=0.1152P AD=0.1584P PS=1U
+ PD=1.6U
M$3168 VSS RB \$740 VSS nfet_03v3 L=0.28U W=0.36U AS=0.1854P AD=0.1584P
+ PS=1.75U PD=1.6U
M$3169 \$745 RA VSS VSS nfet_03v3 L=0.28U W=0.36U AS=0.1656P AD=0.1944P
+ PS=1.64U PD=1.8U
M$3170 \$744 RA QAb VSS nfet_03v3 L=0.28U W=0.36U AS=0.1584P AD=0.1152P PS=1.6U
+ PD=1U
M$3171 QBb RB \$744 VSS nfet_03v3 L=0.28U W=0.36U AS=0.1152P AD=0.1584P PS=1U
+ PD=1.6U
M$3172 VSS RB \$746 VSS nfet_03v3 L=0.28U W=0.36U AS=0.1854P AD=0.1584P
+ PS=1.75U PD=1.6U
M$3173 \$751 RA VSS VSS nfet_03v3 L=0.28U W=0.36U AS=0.1656P AD=0.1944P
+ PS=1.64U PD=1.8U
M$3174 \$750 RA QAb VSS nfet_03v3 L=0.28U W=0.36U AS=0.1584P AD=0.1152P PS=1.6U
+ PD=1U
M$3175 QBb RB \$750 VSS nfet_03v3 L=0.28U W=0.36U AS=0.1152P AD=0.1584P PS=1U
+ PD=1.6U
M$3176 VSS RB \$752 VSS nfet_03v3 L=0.28U W=0.36U AS=0.1854P AD=0.1584P
+ PS=1.75U PD=1.6U
M$3177 \$757 RA VSS VSS nfet_03v3 L=0.28U W=0.36U AS=0.1656P AD=0.1944P
+ PS=1.64U PD=1.8U
M$3178 \$756 RA QAb VSS nfet_03v3 L=0.28U W=0.36U AS=0.1584P AD=0.1152P PS=1.6U
+ PD=1U
M$3179 QBb RB \$756 VSS nfet_03v3 L=0.28U W=0.36U AS=0.1152P AD=0.1584P PS=1U
+ PD=1.6U
M$3180 VSS RB \$758 VSS nfet_03v3 L=0.28U W=0.36U AS=0.1854P AD=0.1584P
+ PS=1.75U PD=1.6U
M$3181 \$763 RA VSS VSS nfet_03v3 L=0.28U W=0.36U AS=0.1656P AD=0.1944P
+ PS=1.64U PD=1.8U
M$3182 \$762 RA QAb VSS nfet_03v3 L=0.28U W=0.36U AS=0.1584P AD=0.1152P PS=1.6U
+ PD=1U
M$3183 QBb RB \$762 VSS nfet_03v3 L=0.28U W=0.36U AS=0.1152P AD=0.1584P PS=1U
+ PD=1.6U
M$3184 VSS RB \$764 VSS nfet_03v3 L=0.28U W=0.36U AS=0.1854P AD=0.1584P
+ PS=1.75U PD=1.6U
M$3185 \$668 D|Q VSS VSS nfet_03v3 L=0.28U W=0.36U AS=0.1584P AD=0.1188P
+ PS=1.6U PD=1.02U
M$3186 \$669 WECLK \$668 VSS nfet_03v3 L=0.28U W=0.36U AS=0.1188P AD=0.1278P
+ PS=1.02U PD=1.07U
M$3187 \$904 \$670 \$669 VSS nfet_03v3 L=0.28U W=0.36U AS=0.1278P AD=0.0567P
+ PS=1.07U PD=0.675U
M$3188 VSS WECLKb \$904 VSS nfet_03v3 L=0.28U W=0.36U AS=0.0567P AD=0.1584P
+ PS=0.675U PD=1.6U
M$3189 VSS \$669 \$670 VSS nfet_03v3 L=0.28U W=0.36U AS=0.1584P AD=0.0972P
+ PS=1.6U PD=0.9U
M$3190 \$671 \$669 VSS VSS nfet_03v3 L=0.28U W=0.36U AS=0.0972P AD=0.18P
+ PS=0.9U PD=1.72U
M$3191 \$675 D|Q VSS VSS nfet_03v3 L=0.28U W=0.36U AS=0.1584P AD=0.1188P
+ PS=1.6U PD=1.02U
M$3192 \$676 WECLK \$675 VSS nfet_03v3 L=0.28U W=0.36U AS=0.1188P AD=0.1278P
+ PS=1.02U PD=1.07U
M$3193 \$911 \$677 \$676 VSS nfet_03v3 L=0.28U W=0.36U AS=0.1278P AD=0.0567P
+ PS=1.07U PD=0.675U
M$3194 VSS WECLKb \$911 VSS nfet_03v3 L=0.28U W=0.36U AS=0.0567P AD=0.1584P
+ PS=0.675U PD=1.6U
M$3195 VSS \$676 \$677 VSS nfet_03v3 L=0.28U W=0.36U AS=0.1584P AD=0.0972P
+ PS=1.6U PD=0.9U
M$3196 \$678 \$676 VSS VSS nfet_03v3 L=0.28U W=0.36U AS=0.0972P AD=0.18P
+ PS=0.9U PD=1.72U
M$3197 \$681 D|Q VSS VSS nfet_03v3 L=0.28U W=0.36U AS=0.1584P AD=0.1188P
+ PS=1.6U PD=1.02U
M$3198 \$682 WECLK \$681 VSS nfet_03v3 L=0.28U W=0.36U AS=0.1188P AD=0.1278P
+ PS=1.02U PD=1.07U
M$3199 \$918 \$683 \$682 VSS nfet_03v3 L=0.28U W=0.36U AS=0.1278P AD=0.0567P
+ PS=1.07U PD=0.675U
M$3200 VSS WECLKb \$918 VSS nfet_03v3 L=0.28U W=0.36U AS=0.0567P AD=0.1584P
+ PS=0.675U PD=1.6U
M$3201 VSS \$682 \$683 VSS nfet_03v3 L=0.28U W=0.36U AS=0.1584P AD=0.0972P
+ PS=1.6U PD=0.9U
M$3202 \$684 \$682 VSS VSS nfet_03v3 L=0.28U W=0.36U AS=0.0972P AD=0.18P
+ PS=0.9U PD=1.72U
M$3203 \$687 D|Q VSS VSS nfet_03v3 L=0.28U W=0.36U AS=0.1584P AD=0.1188P
+ PS=1.6U PD=1.02U
M$3204 \$688 WECLK \$687 VSS nfet_03v3 L=0.28U W=0.36U AS=0.1188P AD=0.1278P
+ PS=1.02U PD=1.07U
M$3205 \$926 \$689 \$688 VSS nfet_03v3 L=0.28U W=0.36U AS=0.1278P AD=0.0567P
+ PS=1.07U PD=0.675U
M$3206 VSS WECLKb \$926 VSS nfet_03v3 L=0.28U W=0.36U AS=0.0567P AD=0.1584P
+ PS=0.675U PD=1.6U
M$3207 VSS \$688 \$689 VSS nfet_03v3 L=0.28U W=0.36U AS=0.1584P AD=0.0972P
+ PS=1.6U PD=0.9U
M$3208 \$690 \$688 VSS VSS nfet_03v3 L=0.28U W=0.36U AS=0.0972P AD=0.18P
+ PS=0.9U PD=1.72U
M$3209 \$693 D|Q VSS VSS nfet_03v3 L=0.28U W=0.36U AS=0.1584P AD=0.1188P
+ PS=1.6U PD=1.02U
M$3210 \$694 WECLK \$693 VSS nfet_03v3 L=0.28U W=0.36U AS=0.1188P AD=0.1278P
+ PS=1.02U PD=1.07U
M$3211 \$932 \$695 \$694 VSS nfet_03v3 L=0.28U W=0.36U AS=0.1278P AD=0.0567P
+ PS=1.07U PD=0.675U
M$3212 VSS WECLKb \$932 VSS nfet_03v3 L=0.28U W=0.36U AS=0.0567P AD=0.1584P
+ PS=0.675U PD=1.6U
M$3213 VSS \$694 \$695 VSS nfet_03v3 L=0.28U W=0.36U AS=0.1584P AD=0.0972P
+ PS=1.6U PD=0.9U
M$3214 \$696 \$694 VSS VSS nfet_03v3 L=0.28U W=0.36U AS=0.0972P AD=0.18P
+ PS=0.9U PD=1.72U
M$3215 \$699 D|Q VSS VSS nfet_03v3 L=0.28U W=0.36U AS=0.1584P AD=0.1188P
+ PS=1.6U PD=1.02U
M$3216 \$700 WECLK \$699 VSS nfet_03v3 L=0.28U W=0.36U AS=0.1188P AD=0.1278P
+ PS=1.02U PD=1.07U
M$3217 \$939 \$701 \$700 VSS nfet_03v3 L=0.28U W=0.36U AS=0.1278P AD=0.0567P
+ PS=1.07U PD=0.675U
M$3218 VSS WECLKb \$939 VSS nfet_03v3 L=0.28U W=0.36U AS=0.0567P AD=0.1584P
+ PS=0.675U PD=1.6U
M$3219 VSS \$700 \$701 VSS nfet_03v3 L=0.28U W=0.36U AS=0.1584P AD=0.0972P
+ PS=1.6U PD=0.9U
M$3220 \$702 \$700 VSS VSS nfet_03v3 L=0.28U W=0.36U AS=0.0972P AD=0.18P
+ PS=0.9U PD=1.72U
M$3221 \$705 D|Q VSS VSS nfet_03v3 L=0.28U W=0.36U AS=0.1584P AD=0.1188P
+ PS=1.6U PD=1.02U
M$3222 \$706 WECLK \$705 VSS nfet_03v3 L=0.28U W=0.36U AS=0.1188P AD=0.1278P
+ PS=1.02U PD=1.07U
M$3223 \$946 \$707 \$706 VSS nfet_03v3 L=0.28U W=0.36U AS=0.1278P AD=0.0567P
+ PS=1.07U PD=0.675U
M$3224 VSS WECLKb \$946 VSS nfet_03v3 L=0.28U W=0.36U AS=0.0567P AD=0.1584P
+ PS=0.675U PD=1.6U
M$3225 VSS \$706 \$707 VSS nfet_03v3 L=0.28U W=0.36U AS=0.1584P AD=0.0972P
+ PS=1.6U PD=0.9U
M$3226 \$708 \$706 VSS VSS nfet_03v3 L=0.28U W=0.36U AS=0.0972P AD=0.18P
+ PS=0.9U PD=1.72U
M$3227 \$711 D|Q VSS VSS nfet_03v3 L=0.28U W=0.36U AS=0.1584P AD=0.1188P
+ PS=1.6U PD=1.02U
M$3228 \$712 WECLK \$711 VSS nfet_03v3 L=0.28U W=0.36U AS=0.1188P AD=0.1278P
+ PS=1.02U PD=1.07U
M$3229 \$954 \$713 \$712 VSS nfet_03v3 L=0.28U W=0.36U AS=0.1278P AD=0.0567P
+ PS=1.07U PD=0.675U
M$3230 VSS WECLKb \$954 VSS nfet_03v3 L=0.28U W=0.36U AS=0.0567P AD=0.1584P
+ PS=0.675U PD=1.6U
M$3231 VSS \$712 \$713 VSS nfet_03v3 L=0.28U W=0.36U AS=0.1584P AD=0.0972P
+ PS=1.6U PD=0.9U
M$3232 \$714 \$712 VSS VSS nfet_03v3 L=0.28U W=0.36U AS=0.0972P AD=0.18P
+ PS=0.9U PD=1.72U
M$3233 \$717 D|Q VSS VSS nfet_03v3 L=0.28U W=0.36U AS=0.1584P AD=0.1188P
+ PS=1.6U PD=1.02U
M$3234 \$718 WECLK \$717 VSS nfet_03v3 L=0.28U W=0.36U AS=0.1188P AD=0.1278P
+ PS=1.02U PD=1.07U
M$3235 \$962 \$719 \$718 VSS nfet_03v3 L=0.28U W=0.36U AS=0.1278P AD=0.0567P
+ PS=1.07U PD=0.675U
M$3236 VSS WECLKb \$962 VSS nfet_03v3 L=0.28U W=0.36U AS=0.0567P AD=0.1584P
+ PS=0.675U PD=1.6U
M$3237 VSS \$718 \$719 VSS nfet_03v3 L=0.28U W=0.36U AS=0.1584P AD=0.0972P
+ PS=1.6U PD=0.9U
M$3238 \$720 \$718 VSS VSS nfet_03v3 L=0.28U W=0.36U AS=0.0972P AD=0.18P
+ PS=0.9U PD=1.72U
M$3239 \$723 D|Q VSS VSS nfet_03v3 L=0.28U W=0.36U AS=0.1584P AD=0.1188P
+ PS=1.6U PD=1.02U
M$3240 \$724 WECLK \$723 VSS nfet_03v3 L=0.28U W=0.36U AS=0.1188P AD=0.1278P
+ PS=1.02U PD=1.07U
M$3241 \$968 \$725 \$724 VSS nfet_03v3 L=0.28U W=0.36U AS=0.1278P AD=0.0567P
+ PS=1.07U PD=0.675U
M$3242 VSS WECLKb \$968 VSS nfet_03v3 L=0.28U W=0.36U AS=0.0567P AD=0.1584P
+ PS=0.675U PD=1.6U
M$3243 VSS \$724 \$725 VSS nfet_03v3 L=0.28U W=0.36U AS=0.1584P AD=0.0972P
+ PS=1.6U PD=0.9U
M$3244 \$726 \$724 VSS VSS nfet_03v3 L=0.28U W=0.36U AS=0.0972P AD=0.18P
+ PS=0.9U PD=1.72U
M$3245 \$729 D|Q VSS VSS nfet_03v3 L=0.28U W=0.36U AS=0.1584P AD=0.1188P
+ PS=1.6U PD=1.02U
M$3246 \$730 WECLK \$729 VSS nfet_03v3 L=0.28U W=0.36U AS=0.1188P AD=0.1278P
+ PS=1.02U PD=1.07U
M$3247 \$975 \$731 \$730 VSS nfet_03v3 L=0.28U W=0.36U AS=0.1278P AD=0.0567P
+ PS=1.07U PD=0.675U
M$3248 VSS WECLKb \$975 VSS nfet_03v3 L=0.28U W=0.36U AS=0.0567P AD=0.1584P
+ PS=0.675U PD=1.6U
M$3249 VSS \$730 \$731 VSS nfet_03v3 L=0.28U W=0.36U AS=0.1584P AD=0.0972P
+ PS=1.6U PD=0.9U
M$3250 \$732 \$730 VSS VSS nfet_03v3 L=0.28U W=0.36U AS=0.0972P AD=0.18P
+ PS=0.9U PD=1.72U
M$3251 \$735 D|Q VSS VSS nfet_03v3 L=0.28U W=0.36U AS=0.1584P AD=0.1188P
+ PS=1.6U PD=1.02U
M$3252 \$736 WECLK \$735 VSS nfet_03v3 L=0.28U W=0.36U AS=0.1188P AD=0.1278P
+ PS=1.02U PD=1.07U
M$3253 \$982 \$737 \$736 VSS nfet_03v3 L=0.28U W=0.36U AS=0.1278P AD=0.0567P
+ PS=1.07U PD=0.675U
M$3254 VSS WECLKb \$982 VSS nfet_03v3 L=0.28U W=0.36U AS=0.0567P AD=0.1584P
+ PS=0.675U PD=1.6U
M$3255 VSS \$736 \$737 VSS nfet_03v3 L=0.28U W=0.36U AS=0.1584P AD=0.0972P
+ PS=1.6U PD=0.9U
M$3256 \$738 \$736 VSS VSS nfet_03v3 L=0.28U W=0.36U AS=0.0972P AD=0.18P
+ PS=0.9U PD=1.72U
M$3257 \$741 D|Q VSS VSS nfet_03v3 L=0.28U W=0.36U AS=0.1584P AD=0.1188P
+ PS=1.6U PD=1.02U
M$3258 \$742 WECLK \$741 VSS nfet_03v3 L=0.28U W=0.36U AS=0.1188P AD=0.1278P
+ PS=1.02U PD=1.07U
M$3259 \$990 \$743 \$742 VSS nfet_03v3 L=0.28U W=0.36U AS=0.1278P AD=0.0567P
+ PS=1.07U PD=0.675U
M$3260 VSS WECLKb \$990 VSS nfet_03v3 L=0.28U W=0.36U AS=0.0567P AD=0.1584P
+ PS=0.675U PD=1.6U
M$3261 VSS \$742 \$743 VSS nfet_03v3 L=0.28U W=0.36U AS=0.1584P AD=0.0972P
+ PS=1.6U PD=0.9U
M$3262 \$744 \$742 VSS VSS nfet_03v3 L=0.28U W=0.36U AS=0.0972P AD=0.18P
+ PS=0.9U PD=1.72U
M$3263 \$747 D|Q VSS VSS nfet_03v3 L=0.28U W=0.36U AS=0.1584P AD=0.1188P
+ PS=1.6U PD=1.02U
M$3264 \$748 WECLK \$747 VSS nfet_03v3 L=0.28U W=0.36U AS=0.1188P AD=0.1278P
+ PS=1.02U PD=1.07U
M$3265 \$997 \$749 \$748 VSS nfet_03v3 L=0.28U W=0.36U AS=0.1278P AD=0.0567P
+ PS=1.07U PD=0.675U
M$3266 VSS WECLKb \$997 VSS nfet_03v3 L=0.28U W=0.36U AS=0.0567P AD=0.1584P
+ PS=0.675U PD=1.6U
M$3267 VSS \$748 \$749 VSS nfet_03v3 L=0.28U W=0.36U AS=0.1584P AD=0.0972P
+ PS=1.6U PD=0.9U
M$3268 \$750 \$748 VSS VSS nfet_03v3 L=0.28U W=0.36U AS=0.0972P AD=0.18P
+ PS=0.9U PD=1.72U
M$3269 \$753 D|Q VSS VSS nfet_03v3 L=0.28U W=0.36U AS=0.1584P AD=0.1188P
+ PS=1.6U PD=1.02U
M$3270 \$754 WECLK \$753 VSS nfet_03v3 L=0.28U W=0.36U AS=0.1188P AD=0.1278P
+ PS=1.02U PD=1.07U
M$3271 \$961 \$755 \$754 VSS nfet_03v3 L=0.28U W=0.36U AS=0.1278P AD=0.0567P
+ PS=1.07U PD=0.675U
M$3272 VSS WECLKb \$961 VSS nfet_03v3 L=0.28U W=0.36U AS=0.0567P AD=0.1584P
+ PS=0.675U PD=1.6U
M$3273 VSS \$754 \$755 VSS nfet_03v3 L=0.28U W=0.36U AS=0.1584P AD=0.0972P
+ PS=1.6U PD=0.9U
M$3274 \$756 \$754 VSS VSS nfet_03v3 L=0.28U W=0.36U AS=0.0972P AD=0.18P
+ PS=0.9U PD=1.72U
M$3275 \$759 D|Q VSS VSS nfet_03v3 L=0.28U W=0.36U AS=0.1584P AD=0.1188P
+ PS=1.6U PD=1.02U
M$3276 \$760 WECLK \$759 VSS nfet_03v3 L=0.28U W=0.36U AS=0.1188P AD=0.1278P
+ PS=1.02U PD=1.07U
M$3277 \$925 \$761 \$760 VSS nfet_03v3 L=0.28U W=0.36U AS=0.1278P AD=0.0567P
+ PS=1.07U PD=0.675U
M$3278 VSS WECLKb \$925 VSS nfet_03v3 L=0.28U W=0.36U AS=0.0567P AD=0.1584P
+ PS=0.675U PD=1.6U
M$3279 VSS \$760 \$761 VSS nfet_03v3 L=0.28U W=0.36U AS=0.1584P AD=0.0972P
+ PS=1.6U PD=0.9U
M$3280 \$762 \$760 VSS VSS nfet_03v3 L=0.28U W=0.36U AS=0.0972P AD=0.18P
+ PS=0.9U PD=1.72U
M$3281 \$1154 WE VSS VSS nfet_03v3 L=0.28U W=0.72U AS=0.3168P AD=0.1872P
+ PS=2.32U PD=1.24U
M$3282 \$1014 CLK \$1154 VSS nfet_03v3 L=0.28U W=0.72U AS=0.1872P AD=0.3168P
+ PS=1.24U PD=2.32U
M$3283 WECLK \$1014 VSS VSS nfet_03v3 L=0.28U W=1.27U AS=0.4445P AD=0.3344P
+ PS=3.305U PD=2.345U
M$3287 \$1017 D|Q VSS VSS nfet_03v3 L=0.28U W=0.36U AS=0.1584P AD=0.1188P
+ PS=1.6U PD=1.02U
M$3288 \$1018 WECLK \$1017 VSS nfet_03v3 L=0.28U W=0.36U AS=0.1188P AD=0.1278P
+ PS=1.02U PD=1.07U
M$3289 \$1071 \$1019 \$1018 VSS nfet_03v3 L=0.28U W=0.36U AS=0.1278P AD=0.0567P
+ PS=1.07U PD=0.675U
M$3290 VSS WECLKb \$1071 VSS nfet_03v3 L=0.28U W=0.36U AS=0.0567P AD=0.1584P
+ PS=0.675U PD=1.6U
M$3291 VSS \$1018 \$1019 VSS nfet_03v3 L=0.28U W=0.36U AS=0.1584P AD=0.0972P
+ PS=1.6U PD=0.9U
M$3292 \$998 \$1018 VSS VSS nfet_03v3 L=0.28U W=0.36U AS=0.0972P AD=0.18P
+ PS=0.9U PD=1.72U
M$3293 \$1020 D|Q VSS VSS nfet_03v3 L=0.28U W=0.36U AS=0.1584P AD=0.1188P
+ PS=1.6U PD=1.02U
M$3294 \$1021 WECLK \$1020 VSS nfet_03v3 L=0.28U W=0.36U AS=0.1188P AD=0.1278P
+ PS=1.02U PD=1.07U
M$3295 \$1082 \$1022 \$1021 VSS nfet_03v3 L=0.28U W=0.36U AS=0.1278P AD=0.0567P
+ PS=1.07U PD=0.675U
M$3296 VSS WECLKb \$1082 VSS nfet_03v3 L=0.28U W=0.36U AS=0.0567P AD=0.1584P
+ PS=0.675U PD=1.6U
M$3297 VSS \$1021 \$1022 VSS nfet_03v3 L=0.28U W=0.36U AS=0.1584P AD=0.0972P
+ PS=1.6U PD=0.9U
M$3298 \$999 \$1021 VSS VSS nfet_03v3 L=0.28U W=0.36U AS=0.0972P AD=0.18P
+ PS=0.9U PD=1.72U
M$3299 \$1023 D|Q VSS VSS nfet_03v3 L=0.28U W=0.36U AS=0.1584P AD=0.1188P
+ PS=1.6U PD=1.02U
M$3300 \$1024 WECLK \$1023 VSS nfet_03v3 L=0.28U W=0.36U AS=0.1188P AD=0.1278P
+ PS=1.02U PD=1.07U
M$3301 \$1091 \$1025 \$1024 VSS nfet_03v3 L=0.28U W=0.36U AS=0.1278P AD=0.0567P
+ PS=1.07U PD=0.675U
M$3302 VSS WECLKb \$1091 VSS nfet_03v3 L=0.28U W=0.36U AS=0.0567P AD=0.1584P
+ PS=0.675U PD=1.6U
M$3303 VSS \$1024 \$1025 VSS nfet_03v3 L=0.28U W=0.36U AS=0.1584P AD=0.0972P
+ PS=1.6U PD=0.9U
M$3304 \$1000 \$1024 VSS VSS nfet_03v3 L=0.28U W=0.36U AS=0.0972P AD=0.18P
+ PS=0.9U PD=1.72U
M$3305 \$1026 D|Q VSS VSS nfet_03v3 L=0.28U W=0.36U AS=0.1584P AD=0.1188P
+ PS=1.6U PD=1.02U
M$3306 \$1027 WECLK \$1026 VSS nfet_03v3 L=0.28U W=0.36U AS=0.1188P AD=0.1278P
+ PS=1.02U PD=1.07U
M$3307 \$1101 \$1028 \$1027 VSS nfet_03v3 L=0.28U W=0.36U AS=0.1278P AD=0.0567P
+ PS=1.07U PD=0.675U
M$3308 VSS WECLKb \$1101 VSS nfet_03v3 L=0.28U W=0.36U AS=0.0567P AD=0.1584P
+ PS=0.675U PD=1.6U
M$3309 VSS \$1027 \$1028 VSS nfet_03v3 L=0.28U W=0.36U AS=0.1584P AD=0.0972P
+ PS=1.6U PD=0.9U
M$3310 \$1001 \$1027 VSS VSS nfet_03v3 L=0.28U W=0.36U AS=0.0972P AD=0.18P
+ PS=0.9U PD=1.72U
M$3311 \$1029 D|Q VSS VSS nfet_03v3 L=0.28U W=0.36U AS=0.1584P AD=0.1188P
+ PS=1.6U PD=1.02U
M$3312 \$1030 WECLK \$1029 VSS nfet_03v3 L=0.28U W=0.36U AS=0.1188P AD=0.1278P
+ PS=1.02U PD=1.07U
M$3313 \$1112 \$1031 \$1030 VSS nfet_03v3 L=0.28U W=0.36U AS=0.1278P AD=0.0567P
+ PS=1.07U PD=0.675U
M$3314 VSS WECLKb \$1112 VSS nfet_03v3 L=0.28U W=0.36U AS=0.0567P AD=0.1584P
+ PS=0.675U PD=1.6U
M$3315 VSS \$1030 \$1031 VSS nfet_03v3 L=0.28U W=0.36U AS=0.1584P AD=0.0972P
+ PS=1.6U PD=0.9U
M$3316 \$1002 \$1030 VSS VSS nfet_03v3 L=0.28U W=0.36U AS=0.0972P AD=0.18P
+ PS=0.9U PD=1.72U
M$3317 \$1032 D|Q VSS VSS nfet_03v3 L=0.28U W=0.36U AS=0.1584P AD=0.1188P
+ PS=1.6U PD=1.02U
M$3318 \$1033 WECLK \$1032 VSS nfet_03v3 L=0.28U W=0.36U AS=0.1188P AD=0.1278P
+ PS=1.02U PD=1.07U
M$3319 \$1117 \$1034 \$1033 VSS nfet_03v3 L=0.28U W=0.36U AS=0.1278P AD=0.0567P
+ PS=1.07U PD=0.675U
M$3320 VSS WECLKb \$1117 VSS nfet_03v3 L=0.28U W=0.36U AS=0.0567P AD=0.1584P
+ PS=0.675U PD=1.6U
M$3321 VSS \$1033 \$1034 VSS nfet_03v3 L=0.28U W=0.36U AS=0.1584P AD=0.0972P
+ PS=1.6U PD=0.9U
M$3322 \$1003 \$1033 VSS VSS nfet_03v3 L=0.28U W=0.36U AS=0.0972P AD=0.18P
+ PS=0.9U PD=1.72U
M$3323 \$1035 D|Q VSS VSS nfet_03v3 L=0.28U W=0.36U AS=0.1584P AD=0.1188P
+ PS=1.6U PD=1.02U
M$3324 \$1036 WECLK \$1035 VSS nfet_03v3 L=0.28U W=0.36U AS=0.1188P AD=0.1278P
+ PS=1.02U PD=1.07U
M$3325 \$1113 \$1037 \$1036 VSS nfet_03v3 L=0.28U W=0.36U AS=0.1278P AD=0.0567P
+ PS=1.07U PD=0.675U
M$3326 VSS WECLKb \$1113 VSS nfet_03v3 L=0.28U W=0.36U AS=0.0567P AD=0.1584P
+ PS=0.675U PD=1.6U
M$3327 VSS \$1036 \$1037 VSS nfet_03v3 L=0.28U W=0.36U AS=0.1584P AD=0.0972P
+ PS=1.6U PD=0.9U
M$3328 \$1004 \$1036 VSS VSS nfet_03v3 L=0.28U W=0.36U AS=0.0972P AD=0.18P
+ PS=0.9U PD=1.72U
M$3329 \$1038 D|Q VSS VSS nfet_03v3 L=0.28U W=0.36U AS=0.1584P AD=0.1188P
+ PS=1.6U PD=1.02U
M$3330 \$1039 WECLK \$1038 VSS nfet_03v3 L=0.28U W=0.36U AS=0.1188P AD=0.1278P
+ PS=1.02U PD=1.07U
M$3331 \$1106 \$1040 \$1039 VSS nfet_03v3 L=0.28U W=0.36U AS=0.1278P AD=0.0567P
+ PS=1.07U PD=0.675U
M$3332 VSS WECLKb \$1106 VSS nfet_03v3 L=0.28U W=0.36U AS=0.0567P AD=0.1584P
+ PS=0.675U PD=1.6U
M$3333 VSS \$1039 \$1040 VSS nfet_03v3 L=0.28U W=0.36U AS=0.1584P AD=0.0972P
+ PS=1.6U PD=0.9U
M$3334 \$1005 \$1039 VSS VSS nfet_03v3 L=0.28U W=0.36U AS=0.0972P AD=0.18P
+ PS=0.9U PD=1.72U
M$3335 \$1041 D|Q VSS VSS nfet_03v3 L=0.28U W=0.36U AS=0.1584P AD=0.1188P
+ PS=1.6U PD=1.02U
M$3336 \$1042 WECLK \$1041 VSS nfet_03v3 L=0.28U W=0.36U AS=0.1188P AD=0.1278P
+ PS=1.02U PD=1.07U
M$3337 \$1103 \$1043 \$1042 VSS nfet_03v3 L=0.28U W=0.36U AS=0.1278P AD=0.0567P
+ PS=1.07U PD=0.675U
M$3338 VSS WECLKb \$1103 VSS nfet_03v3 L=0.28U W=0.36U AS=0.0567P AD=0.1584P
+ PS=0.675U PD=1.6U
M$3339 VSS \$1042 \$1043 VSS nfet_03v3 L=0.28U W=0.36U AS=0.1584P AD=0.0972P
+ PS=1.6U PD=0.9U
M$3340 \$1006 \$1042 VSS VSS nfet_03v3 L=0.28U W=0.36U AS=0.0972P AD=0.18P
+ PS=0.9U PD=1.72U
M$3341 \$1044 D|Q VSS VSS nfet_03v3 L=0.28U W=0.36U AS=0.1584P AD=0.1188P
+ PS=1.6U PD=1.02U
M$3342 \$1045 WECLK \$1044 VSS nfet_03v3 L=0.28U W=0.36U AS=0.1188P AD=0.1278P
+ PS=1.02U PD=1.07U
M$3343 \$1098 \$1046 \$1045 VSS nfet_03v3 L=0.28U W=0.36U AS=0.1278P AD=0.0567P
+ PS=1.07U PD=0.675U
M$3344 VSS WECLKb \$1098 VSS nfet_03v3 L=0.28U W=0.36U AS=0.0567P AD=0.1584P
+ PS=0.675U PD=1.6U
M$3345 VSS \$1045 \$1046 VSS nfet_03v3 L=0.28U W=0.36U AS=0.1584P AD=0.0972P
+ PS=1.6U PD=0.9U
M$3346 \$1007 \$1045 VSS VSS nfet_03v3 L=0.28U W=0.36U AS=0.0972P AD=0.18P
+ PS=0.9U PD=1.72U
M$3347 \$1047 D|Q VSS VSS nfet_03v3 L=0.28U W=0.36U AS=0.1584P AD=0.1188P
+ PS=1.6U PD=1.02U
M$3348 \$1048 WECLK \$1047 VSS nfet_03v3 L=0.28U W=0.36U AS=0.1188P AD=0.1278P
+ PS=1.02U PD=1.07U
M$3349 \$1092 \$1049 \$1048 VSS nfet_03v3 L=0.28U W=0.36U AS=0.1278P AD=0.0567P
+ PS=1.07U PD=0.675U
M$3350 VSS WECLKb \$1092 VSS nfet_03v3 L=0.28U W=0.36U AS=0.0567P AD=0.1584P
+ PS=0.675U PD=1.6U
M$3351 VSS \$1048 \$1049 VSS nfet_03v3 L=0.28U W=0.36U AS=0.1584P AD=0.0972P
+ PS=1.6U PD=0.9U
M$3352 \$1008 \$1048 VSS VSS nfet_03v3 L=0.28U W=0.36U AS=0.0972P AD=0.18P
+ PS=0.9U PD=1.72U
M$3353 \$1050 D|Q VSS VSS nfet_03v3 L=0.28U W=0.36U AS=0.1584P AD=0.1188P
+ PS=1.6U PD=1.02U
M$3354 \$1051 WECLK \$1050 VSS nfet_03v3 L=0.28U W=0.36U AS=0.1188P AD=0.1278P
+ PS=1.02U PD=1.07U
M$3355 \$1088 \$1052 \$1051 VSS nfet_03v3 L=0.28U W=0.36U AS=0.1278P AD=0.0567P
+ PS=1.07U PD=0.675U
M$3356 VSS WECLKb \$1088 VSS nfet_03v3 L=0.28U W=0.36U AS=0.0567P AD=0.1584P
+ PS=0.675U PD=1.6U
M$3357 VSS \$1051 \$1052 VSS nfet_03v3 L=0.28U W=0.36U AS=0.1584P AD=0.0972P
+ PS=1.6U PD=0.9U
M$3358 \$1009 \$1051 VSS VSS nfet_03v3 L=0.28U W=0.36U AS=0.0972P AD=0.18P
+ PS=0.9U PD=1.72U
M$3359 \$1053 D|Q VSS VSS nfet_03v3 L=0.28U W=0.36U AS=0.1584P AD=0.1188P
+ PS=1.6U PD=1.02U
M$3360 \$1054 WECLK \$1053 VSS nfet_03v3 L=0.28U W=0.36U AS=0.1188P AD=0.1278P
+ PS=1.02U PD=1.07U
M$3361 \$1084 \$1055 \$1054 VSS nfet_03v3 L=0.28U W=0.36U AS=0.1278P AD=0.0567P
+ PS=1.07U PD=0.675U
M$3362 VSS WECLKb \$1084 VSS nfet_03v3 L=0.28U W=0.36U AS=0.0567P AD=0.1584P
+ PS=0.675U PD=1.6U
M$3363 VSS \$1054 \$1055 VSS nfet_03v3 L=0.28U W=0.36U AS=0.1584P AD=0.0972P
+ PS=1.6U PD=0.9U
M$3364 \$1010 \$1054 VSS VSS nfet_03v3 L=0.28U W=0.36U AS=0.0972P AD=0.18P
+ PS=0.9U PD=1.72U
M$3365 \$1056 D|Q VSS VSS nfet_03v3 L=0.28U W=0.36U AS=0.1584P AD=0.1188P
+ PS=1.6U PD=1.02U
M$3366 \$1057 WECLK \$1056 VSS nfet_03v3 L=0.28U W=0.36U AS=0.1188P AD=0.1278P
+ PS=1.02U PD=1.07U
M$3367 \$1077 \$1058 \$1057 VSS nfet_03v3 L=0.28U W=0.36U AS=0.1278P AD=0.0567P
+ PS=1.07U PD=0.675U
M$3368 VSS WECLKb \$1077 VSS nfet_03v3 L=0.28U W=0.36U AS=0.0567P AD=0.1584P
+ PS=0.675U PD=1.6U
M$3369 VSS \$1057 \$1058 VSS nfet_03v3 L=0.28U W=0.36U AS=0.1584P AD=0.0972P
+ PS=1.6U PD=0.9U
M$3370 \$1011 \$1057 VSS VSS nfet_03v3 L=0.28U W=0.36U AS=0.0972P AD=0.18P
+ PS=0.9U PD=1.72U
M$3371 \$1059 D|Q VSS VSS nfet_03v3 L=0.28U W=0.36U AS=0.1584P AD=0.1188P
+ PS=1.6U PD=1.02U
M$3372 \$1060 WECLK \$1059 VSS nfet_03v3 L=0.28U W=0.36U AS=0.1188P AD=0.1278P
+ PS=1.02U PD=1.07U
M$3373 \$1072 \$1061 \$1060 VSS nfet_03v3 L=0.28U W=0.36U AS=0.1278P AD=0.0567P
+ PS=1.07U PD=0.675U
M$3374 VSS WECLKb \$1072 VSS nfet_03v3 L=0.28U W=0.36U AS=0.0567P AD=0.1584P
+ PS=0.675U PD=1.6U
M$3375 VSS \$1060 \$1061 VSS nfet_03v3 L=0.28U W=0.36U AS=0.1584P AD=0.0972P
+ PS=1.6U PD=0.9U
M$3376 \$1012 \$1060 VSS VSS nfet_03v3 L=0.28U W=0.36U AS=0.0972P AD=0.18P
+ PS=0.9U PD=1.72U
M$3377 \$1062 D|Q VSS VSS nfet_03v3 L=0.28U W=0.36U AS=0.1584P AD=0.1188P
+ PS=1.6U PD=1.02U
M$3378 \$1063 WECLK \$1062 VSS nfet_03v3 L=0.28U W=0.36U AS=0.1188P AD=0.1278P
+ PS=1.02U PD=1.07U
M$3379 \$1067 \$1064 \$1063 VSS nfet_03v3 L=0.28U W=0.36U AS=0.1278P AD=0.0567P
+ PS=1.07U PD=0.675U
M$3380 VSS WECLKb \$1067 VSS nfet_03v3 L=0.28U W=0.36U AS=0.0567P AD=0.1584P
+ PS=0.675U PD=1.6U
M$3381 VSS \$1063 \$1064 VSS nfet_03v3 L=0.28U W=0.36U AS=0.1584P AD=0.0972P
+ PS=1.6U PD=0.9U
M$3382 \$1013 \$1063 VSS VSS nfet_03v3 L=0.28U W=0.36U AS=0.0972P AD=0.18P
+ PS=0.9U PD=1.72U
M$3383 \$1355 RA VSS VSS nfet_03v3 L=0.28U W=0.36U AS=0.1656P AD=0.1944P
+ PS=1.64U PD=1.8U
M$3384 \$1122 RA VSS VSS nfet_03v3 L=0.28U W=0.36U AS=0.1656P AD=0.1944P
+ PS=1.64U PD=1.8U
M$3385 \$1354 RA QAb VSS nfet_03v3 L=0.28U W=0.36U AS=0.1584P AD=0.1152P
+ PS=1.6U PD=1U
M$3386 QBb RB \$1354 VSS nfet_03v3 L=0.28U W=0.36U AS=0.1152P AD=0.1584P PS=1U
+ PD=1.6U
M$3387 \$998 RA QAb VSS nfet_03v3 L=0.28U W=0.36U AS=0.1584P AD=0.1152P PS=1.6U
+ PD=1U
M$3388 QBb RB \$998 VSS nfet_03v3 L=0.28U W=0.36U AS=0.1152P AD=0.1584P PS=1U
+ PD=1.6U
M$3389 VSS RB \$1123 VSS nfet_03v3 L=0.28U W=0.36U AS=0.1854P AD=0.1584P
+ PS=1.75U PD=1.6U
M$3390 VSS RB \$1356 VSS nfet_03v3 L=0.28U W=0.36U AS=0.1854P AD=0.1584P
+ PS=1.75U PD=1.6U
M$3391 \$1362 RA VSS VSS nfet_03v3 L=0.28U W=0.36U AS=0.1656P AD=0.1944P
+ PS=1.64U PD=1.8U
M$3392 \$1124 RA VSS VSS nfet_03v3 L=0.28U W=0.36U AS=0.1656P AD=0.1944P
+ PS=1.64U PD=1.8U
M$3393 \$1361 RA QAb VSS nfet_03v3 L=0.28U W=0.36U AS=0.1584P AD=0.1152P
+ PS=1.6U PD=1U
M$3394 QBb RB \$1361 VSS nfet_03v3 L=0.28U W=0.36U AS=0.1152P AD=0.1584P PS=1U
+ PD=1.6U
M$3395 \$999 RA QAb VSS nfet_03v3 L=0.28U W=0.36U AS=0.1584P AD=0.1152P PS=1.6U
+ PD=1U
M$3396 QBb RB \$999 VSS nfet_03v3 L=0.28U W=0.36U AS=0.1152P AD=0.1584P PS=1U
+ PD=1.6U
M$3397 VSS RB \$1125 VSS nfet_03v3 L=0.28U W=0.36U AS=0.1854P AD=0.1584P
+ PS=1.75U PD=1.6U
M$3398 VSS RB \$1363 VSS nfet_03v3 L=0.28U W=0.36U AS=0.1854P AD=0.1584P
+ PS=1.75U PD=1.6U
M$3399 \$1126 RA VSS VSS nfet_03v3 L=0.28U W=0.36U AS=0.1656P AD=0.1944P
+ PS=1.64U PD=1.8U
M$3400 \$1368 RA VSS VSS nfet_03v3 L=0.28U W=0.36U AS=0.1656P AD=0.1944P
+ PS=1.64U PD=1.8U
M$3401 \$1367 RA QAb VSS nfet_03v3 L=0.28U W=0.36U AS=0.1584P AD=0.1152P
+ PS=1.6U PD=1U
M$3402 QBb RB \$1367 VSS nfet_03v3 L=0.28U W=0.36U AS=0.1152P AD=0.1584P PS=1U
+ PD=1.6U
M$3403 \$1000 RA QAb VSS nfet_03v3 L=0.28U W=0.36U AS=0.1584P AD=0.1152P
+ PS=1.6U PD=1U
M$3404 QBb RB \$1000 VSS nfet_03v3 L=0.28U W=0.36U AS=0.1152P AD=0.1584P PS=1U
+ PD=1.6U
M$3405 VSS RB \$1127 VSS nfet_03v3 L=0.28U W=0.36U AS=0.1854P AD=0.1584P
+ PS=1.75U PD=1.6U
M$3406 VSS RB \$1369 VSS nfet_03v3 L=0.28U W=0.36U AS=0.1854P AD=0.1584P
+ PS=1.75U PD=1.6U
M$3407 \$1374 RA VSS VSS nfet_03v3 L=0.28U W=0.36U AS=0.1656P AD=0.1944P
+ PS=1.64U PD=1.8U
M$3408 \$1128 RA VSS VSS nfet_03v3 L=0.28U W=0.36U AS=0.1656P AD=0.1944P
+ PS=1.64U PD=1.8U
M$3409 \$1001 RA QAb VSS nfet_03v3 L=0.28U W=0.36U AS=0.1584P AD=0.1152P
+ PS=1.6U PD=1U
M$3410 QBb RB \$1001 VSS nfet_03v3 L=0.28U W=0.36U AS=0.1152P AD=0.1584P PS=1U
+ PD=1.6U
M$3411 \$1373 RA QAb VSS nfet_03v3 L=0.28U W=0.36U AS=0.1584P AD=0.1152P
+ PS=1.6U PD=1U
M$3412 QBb RB \$1373 VSS nfet_03v3 L=0.28U W=0.36U AS=0.1152P AD=0.1584P PS=1U
+ PD=1.6U
M$3413 VSS RB \$1129 VSS nfet_03v3 L=0.28U W=0.36U AS=0.1854P AD=0.1584P
+ PS=1.75U PD=1.6U
M$3414 VSS RB \$1375 VSS nfet_03v3 L=0.28U W=0.36U AS=0.1854P AD=0.1584P
+ PS=1.75U PD=1.6U
M$3415 \$1130 RA VSS VSS nfet_03v3 L=0.28U W=0.36U AS=0.1656P AD=0.1944P
+ PS=1.64U PD=1.8U
M$3416 \$1380 RA VSS VSS nfet_03v3 L=0.28U W=0.36U AS=0.1656P AD=0.1944P
+ PS=1.64U PD=1.8U
M$3417 \$1002 RA QAb VSS nfet_03v3 L=0.28U W=0.36U AS=0.1584P AD=0.1152P
+ PS=1.6U PD=1U
M$3418 QBb RB \$1002 VSS nfet_03v3 L=0.28U W=0.36U AS=0.1152P AD=0.1584P PS=1U
+ PD=1.6U
M$3419 \$1379 RA QAb VSS nfet_03v3 L=0.28U W=0.36U AS=0.1584P AD=0.1152P
+ PS=1.6U PD=1U
M$3420 QBb RB \$1379 VSS nfet_03v3 L=0.28U W=0.36U AS=0.1152P AD=0.1584P PS=1U
+ PD=1.6U
M$3421 VSS RB \$1381 VSS nfet_03v3 L=0.28U W=0.36U AS=0.1854P AD=0.1584P
+ PS=1.75U PD=1.6U
M$3422 VSS RB \$1131 VSS nfet_03v3 L=0.28U W=0.36U AS=0.1854P AD=0.1584P
+ PS=1.75U PD=1.6U
M$3423 \$1132 RA VSS VSS nfet_03v3 L=0.28U W=0.36U AS=0.1656P AD=0.1944P
+ PS=1.64U PD=1.8U
M$3424 \$1386 RA VSS VSS nfet_03v3 L=0.28U W=0.36U AS=0.1656P AD=0.1944P
+ PS=1.64U PD=1.8U
M$3425 \$1003 RA QAb VSS nfet_03v3 L=0.28U W=0.36U AS=0.1584P AD=0.1152P
+ PS=1.6U PD=1U
M$3426 QBb RB \$1003 VSS nfet_03v3 L=0.28U W=0.36U AS=0.1152P AD=0.1584P PS=1U
+ PD=1.6U
M$3427 \$1385 RA QAb VSS nfet_03v3 L=0.28U W=0.36U AS=0.1584P AD=0.1152P
+ PS=1.6U PD=1U
M$3428 QBb RB \$1385 VSS nfet_03v3 L=0.28U W=0.36U AS=0.1152P AD=0.1584P PS=1U
+ PD=1.6U
M$3429 VSS RB \$1387 VSS nfet_03v3 L=0.28U W=0.36U AS=0.1854P AD=0.1584P
+ PS=1.75U PD=1.6U
M$3430 VSS RB \$1133 VSS nfet_03v3 L=0.28U W=0.36U AS=0.1854P AD=0.1584P
+ PS=1.75U PD=1.6U
M$3431 \$1392 RA VSS VSS nfet_03v3 L=0.28U W=0.36U AS=0.1656P AD=0.1944P
+ PS=1.64U PD=1.8U
M$3432 \$1134 RA VSS VSS nfet_03v3 L=0.28U W=0.36U AS=0.1656P AD=0.1944P
+ PS=1.64U PD=1.8U
M$3433 \$1391 RA QAb VSS nfet_03v3 L=0.28U W=0.36U AS=0.1584P AD=0.1152P
+ PS=1.6U PD=1U
M$3434 QBb RB \$1391 VSS nfet_03v3 L=0.28U W=0.36U AS=0.1152P AD=0.1584P PS=1U
+ PD=1.6U
M$3435 \$1004 RA QAb VSS nfet_03v3 L=0.28U W=0.36U AS=0.1584P AD=0.1152P
+ PS=1.6U PD=1U
M$3436 QBb RB \$1004 VSS nfet_03v3 L=0.28U W=0.36U AS=0.1152P AD=0.1584P PS=1U
+ PD=1.6U
M$3437 VSS RB \$1135 VSS nfet_03v3 L=0.28U W=0.36U AS=0.1854P AD=0.1584P
+ PS=1.75U PD=1.6U
M$3438 VSS RB \$1393 VSS nfet_03v3 L=0.28U W=0.36U AS=0.1854P AD=0.1584P
+ PS=1.75U PD=1.6U
M$3439 \$1398 RA VSS VSS nfet_03v3 L=0.28U W=0.36U AS=0.1656P AD=0.1944P
+ PS=1.64U PD=1.8U
M$3440 \$1136 RA VSS VSS nfet_03v3 L=0.28U W=0.36U AS=0.1656P AD=0.1944P
+ PS=1.64U PD=1.8U
M$3441 \$1005 RA QAb VSS nfet_03v3 L=0.28U W=0.36U AS=0.1584P AD=0.1152P
+ PS=1.6U PD=1U
M$3442 QBb RB \$1005 VSS nfet_03v3 L=0.28U W=0.36U AS=0.1152P AD=0.1584P PS=1U
+ PD=1.6U
M$3443 \$1397 RA QAb VSS nfet_03v3 L=0.28U W=0.36U AS=0.1584P AD=0.1152P
+ PS=1.6U PD=1U
M$3444 QBb RB \$1397 VSS nfet_03v3 L=0.28U W=0.36U AS=0.1152P AD=0.1584P PS=1U
+ PD=1.6U
M$3445 VSS RB \$1137 VSS nfet_03v3 L=0.28U W=0.36U AS=0.1854P AD=0.1584P
+ PS=1.75U PD=1.6U
M$3446 VSS RB \$1399 VSS nfet_03v3 L=0.28U W=0.36U AS=0.1854P AD=0.1584P
+ PS=1.75U PD=1.6U
M$3447 \$1404 RA VSS VSS nfet_03v3 L=0.28U W=0.36U AS=0.1656P AD=0.1944P
+ PS=1.64U PD=1.8U
M$3448 \$1138 RA VSS VSS nfet_03v3 L=0.28U W=0.36U AS=0.1656P AD=0.1944P
+ PS=1.64U PD=1.8U
M$3449 \$1006 RA QAb VSS nfet_03v3 L=0.28U W=0.36U AS=0.1584P AD=0.1152P
+ PS=1.6U PD=1U
M$3450 QBb RB \$1006 VSS nfet_03v3 L=0.28U W=0.36U AS=0.1152P AD=0.1584P PS=1U
+ PD=1.6U
M$3451 \$1403 RA QAb VSS nfet_03v3 L=0.28U W=0.36U AS=0.1584P AD=0.1152P
+ PS=1.6U PD=1U
M$3452 QBb RB \$1403 VSS nfet_03v3 L=0.28U W=0.36U AS=0.1152P AD=0.1584P PS=1U
+ PD=1.6U
M$3453 VSS RB \$1405 VSS nfet_03v3 L=0.28U W=0.36U AS=0.1854P AD=0.1584P
+ PS=1.75U PD=1.6U
M$3454 VSS RB \$1139 VSS nfet_03v3 L=0.28U W=0.36U AS=0.1854P AD=0.1584P
+ PS=1.75U PD=1.6U
M$3455 \$1140 RA VSS VSS nfet_03v3 L=0.28U W=0.36U AS=0.1656P AD=0.1944P
+ PS=1.64U PD=1.8U
M$3456 \$1410 RA VSS VSS nfet_03v3 L=0.28U W=0.36U AS=0.1656P AD=0.1944P
+ PS=1.64U PD=1.8U
M$3457 \$1409 RA QAb VSS nfet_03v3 L=0.28U W=0.36U AS=0.1584P AD=0.1152P
+ PS=1.6U PD=1U
M$3458 QBb RB \$1409 VSS nfet_03v3 L=0.28U W=0.36U AS=0.1152P AD=0.1584P PS=1U
+ PD=1.6U
M$3459 \$1007 RA QAb VSS nfet_03v3 L=0.28U W=0.36U AS=0.1584P AD=0.1152P
+ PS=1.6U PD=1U
M$3460 QBb RB \$1007 VSS nfet_03v3 L=0.28U W=0.36U AS=0.1152P AD=0.1584P PS=1U
+ PD=1.6U
M$3461 VSS RB \$1411 VSS nfet_03v3 L=0.28U W=0.36U AS=0.1854P AD=0.1584P
+ PS=1.75U PD=1.6U
M$3462 VSS RB \$1141 VSS nfet_03v3 L=0.28U W=0.36U AS=0.1854P AD=0.1584P
+ PS=1.75U PD=1.6U
M$3463 \$1142 RA VSS VSS nfet_03v3 L=0.28U W=0.36U AS=0.1656P AD=0.1944P
+ PS=1.64U PD=1.8U
M$3464 \$1416 RA VSS VSS nfet_03v3 L=0.28U W=0.36U AS=0.1656P AD=0.1944P
+ PS=1.64U PD=1.8U
M$3465 \$1008 RA QAb VSS nfet_03v3 L=0.28U W=0.36U AS=0.1584P AD=0.1152P
+ PS=1.6U PD=1U
M$3466 QBb RB \$1008 VSS nfet_03v3 L=0.28U W=0.36U AS=0.1152P AD=0.1584P PS=1U
+ PD=1.6U
M$3467 \$1415 RA QAb VSS nfet_03v3 L=0.28U W=0.36U AS=0.1584P AD=0.1152P
+ PS=1.6U PD=1U
M$3468 QBb RB \$1415 VSS nfet_03v3 L=0.28U W=0.36U AS=0.1152P AD=0.1584P PS=1U
+ PD=1.6U
M$3469 VSS RB \$1417 VSS nfet_03v3 L=0.28U W=0.36U AS=0.1854P AD=0.1584P
+ PS=1.75U PD=1.6U
M$3470 VSS RB \$1143 VSS nfet_03v3 L=0.28U W=0.36U AS=0.1854P AD=0.1584P
+ PS=1.75U PD=1.6U
M$3471 \$1144 RA VSS VSS nfet_03v3 L=0.28U W=0.36U AS=0.1656P AD=0.1944P
+ PS=1.64U PD=1.8U
M$3472 \$1422 RA VSS VSS nfet_03v3 L=0.28U W=0.36U AS=0.1656P AD=0.1944P
+ PS=1.64U PD=1.8U
M$3473 \$1009 RA QAb VSS nfet_03v3 L=0.28U W=0.36U AS=0.1584P AD=0.1152P
+ PS=1.6U PD=1U
M$3474 QBb RB \$1009 VSS nfet_03v3 L=0.28U W=0.36U AS=0.1152P AD=0.1584P PS=1U
+ PD=1.6U
M$3475 \$1421 RA QAb VSS nfet_03v3 L=0.28U W=0.36U AS=0.1584P AD=0.1152P
+ PS=1.6U PD=1U
M$3476 QBb RB \$1421 VSS nfet_03v3 L=0.28U W=0.36U AS=0.1152P AD=0.1584P PS=1U
+ PD=1.6U
M$3477 VSS RB \$1423 VSS nfet_03v3 L=0.28U W=0.36U AS=0.1854P AD=0.1584P
+ PS=1.75U PD=1.6U
M$3478 VSS RB \$1145 VSS nfet_03v3 L=0.28U W=0.36U AS=0.1854P AD=0.1584P
+ PS=1.75U PD=1.6U
M$3479 \$1146 RA VSS VSS nfet_03v3 L=0.28U W=0.36U AS=0.1656P AD=0.1944P
+ PS=1.64U PD=1.8U
M$3480 \$1428 RA VSS VSS nfet_03v3 L=0.28U W=0.36U AS=0.1656P AD=0.1944P
+ PS=1.64U PD=1.8U
M$3481 \$1010 RA QAb VSS nfet_03v3 L=0.28U W=0.36U AS=0.1584P AD=0.1152P
+ PS=1.6U PD=1U
M$3482 QBb RB \$1010 VSS nfet_03v3 L=0.28U W=0.36U AS=0.1152P AD=0.1584P PS=1U
+ PD=1.6U
M$3483 \$1427 RA QAb VSS nfet_03v3 L=0.28U W=0.36U AS=0.1584P AD=0.1152P
+ PS=1.6U PD=1U
M$3484 QBb RB \$1427 VSS nfet_03v3 L=0.28U W=0.36U AS=0.1152P AD=0.1584P PS=1U
+ PD=1.6U
M$3485 VSS RB \$1147 VSS nfet_03v3 L=0.28U W=0.36U AS=0.1854P AD=0.1584P
+ PS=1.75U PD=1.6U
M$3486 VSS RB \$1429 VSS nfet_03v3 L=0.28U W=0.36U AS=0.1854P AD=0.1584P
+ PS=1.75U PD=1.6U
M$3487 \$1434 RA VSS VSS nfet_03v3 L=0.28U W=0.36U AS=0.1656P AD=0.1944P
+ PS=1.64U PD=1.8U
M$3488 \$1148 RA VSS VSS nfet_03v3 L=0.28U W=0.36U AS=0.1656P AD=0.1944P
+ PS=1.64U PD=1.8U
M$3489 \$1433 RA QAb VSS nfet_03v3 L=0.28U W=0.36U AS=0.1584P AD=0.1152P
+ PS=1.6U PD=1U
M$3490 QBb RB \$1433 VSS nfet_03v3 L=0.28U W=0.36U AS=0.1152P AD=0.1584P PS=1U
+ PD=1.6U
M$3491 \$1011 RA QAb VSS nfet_03v3 L=0.28U W=0.36U AS=0.1584P AD=0.1152P
+ PS=1.6U PD=1U
M$3492 QBb RB \$1011 VSS nfet_03v3 L=0.28U W=0.36U AS=0.1152P AD=0.1584P PS=1U
+ PD=1.6U
M$3493 VSS RB \$1435 VSS nfet_03v3 L=0.28U W=0.36U AS=0.1854P AD=0.1584P
+ PS=1.75U PD=1.6U
M$3494 VSS RB \$1149 VSS nfet_03v3 L=0.28U W=0.36U AS=0.1854P AD=0.1584P
+ PS=1.75U PD=1.6U
M$3495 \$1440 RA VSS VSS nfet_03v3 L=0.28U W=0.36U AS=0.1656P AD=0.1944P
+ PS=1.64U PD=1.8U
M$3496 \$1150 RA VSS VSS nfet_03v3 L=0.28U W=0.36U AS=0.1656P AD=0.1944P
+ PS=1.64U PD=1.8U
M$3497 \$1439 RA QAb VSS nfet_03v3 L=0.28U W=0.36U AS=0.1584P AD=0.1152P
+ PS=1.6U PD=1U
M$3498 QBb RB \$1439 VSS nfet_03v3 L=0.28U W=0.36U AS=0.1152P AD=0.1584P PS=1U
+ PD=1.6U
M$3499 \$1012 RA QAb VSS nfet_03v3 L=0.28U W=0.36U AS=0.1584P AD=0.1152P
+ PS=1.6U PD=1U
M$3500 QBb RB \$1012 VSS nfet_03v3 L=0.28U W=0.36U AS=0.1152P AD=0.1584P PS=1U
+ PD=1.6U
M$3501 VSS RB \$1151 VSS nfet_03v3 L=0.28U W=0.36U AS=0.1854P AD=0.1584P
+ PS=1.75U PD=1.6U
M$3502 VSS RB \$1441 VSS nfet_03v3 L=0.28U W=0.36U AS=0.1854P AD=0.1584P
+ PS=1.75U PD=1.6U
M$3503 \$1152 RA VSS VSS nfet_03v3 L=0.28U W=0.36U AS=0.1656P AD=0.1944P
+ PS=1.64U PD=1.8U
M$3504 \$1446 RA VSS VSS nfet_03v3 L=0.28U W=0.36U AS=0.1656P AD=0.1944P
+ PS=1.64U PD=1.8U
M$3505 \$1013 RA QAb VSS nfet_03v3 L=0.28U W=0.36U AS=0.1584P AD=0.1152P
+ PS=1.6U PD=1U
M$3506 QBb RB \$1013 VSS nfet_03v3 L=0.28U W=0.36U AS=0.1152P AD=0.1584P PS=1U
+ PD=1.6U
M$3507 \$1445 RA QAb VSS nfet_03v3 L=0.28U W=0.36U AS=0.1584P AD=0.1152P
+ PS=1.6U PD=1U
M$3508 QBb RB \$1445 VSS nfet_03v3 L=0.28U W=0.36U AS=0.1152P AD=0.1584P PS=1U
+ PD=1.6U
M$3509 VSS RB \$1447 VSS nfet_03v3 L=0.28U W=0.36U AS=0.1854P AD=0.1584P
+ PS=1.75U PD=1.6U
M$3510 VSS RB \$1153 VSS nfet_03v3 L=0.28U W=0.36U AS=0.1854P AD=0.1584P
+ PS=1.75U PD=1.6U
M$3511 \$1583 WE VSS VSS nfet_03v3 L=0.28U W=0.72U AS=0.3168P AD=0.1872P
+ PS=2.32U PD=1.24U
M$3512 \$1346 CLK \$1583 VSS nfet_03v3 L=0.28U W=0.72U AS=0.1872P AD=0.3168P
+ PS=1.24U PD=2.32U
M$3513 WECLK \$1346 VSS VSS nfet_03v3 L=0.28U W=1.27U AS=0.4487P AD=0.3302P
+ PS=3.34U PD=2.31U
M$3517 \$1351 D|Q VSS VSS nfet_03v3 L=0.28U W=0.36U AS=0.1584P AD=0.1188P
+ PS=1.6U PD=1.02U
M$3518 \$1352 WECLK \$1351 VSS nfet_03v3 L=0.28U W=0.36U AS=0.1188P AD=0.1278P
+ PS=1.02U PD=1.07U
M$3519 \$1587 \$1353 \$1352 VSS nfet_03v3 L=0.28U W=0.36U AS=0.1278P AD=0.0567P
+ PS=1.07U PD=0.675U
M$3520 VSS WECLKb \$1587 VSS nfet_03v3 L=0.28U W=0.36U AS=0.0567P AD=0.1584P
+ PS=0.675U PD=1.6U
M$3521 VSS \$1352 \$1353 VSS nfet_03v3 L=0.28U W=0.36U AS=0.1584P AD=0.0972P
+ PS=1.6U PD=0.9U
M$3522 \$1354 \$1352 VSS VSS nfet_03v3 L=0.28U W=0.36U AS=0.0972P AD=0.18P
+ PS=0.9U PD=1.72U
M$3523 \$1358 D|Q VSS VSS nfet_03v3 L=0.28U W=0.36U AS=0.1584P AD=0.1188P
+ PS=1.6U PD=1.02U
M$3524 \$1359 WECLK \$1358 VSS nfet_03v3 L=0.28U W=0.36U AS=0.1188P AD=0.1278P
+ PS=1.02U PD=1.07U
M$3525 \$1594 \$1360 \$1359 VSS nfet_03v3 L=0.28U W=0.36U AS=0.1278P AD=0.0567P
+ PS=1.07U PD=0.675U
M$3526 VSS WECLKb \$1594 VSS nfet_03v3 L=0.28U W=0.36U AS=0.0567P AD=0.1584P
+ PS=0.675U PD=1.6U
M$3527 VSS \$1359 \$1360 VSS nfet_03v3 L=0.28U W=0.36U AS=0.1584P AD=0.0972P
+ PS=1.6U PD=0.9U
M$3528 \$1361 \$1359 VSS VSS nfet_03v3 L=0.28U W=0.36U AS=0.0972P AD=0.18P
+ PS=0.9U PD=1.72U
M$3529 \$1364 D|Q VSS VSS nfet_03v3 L=0.28U W=0.36U AS=0.1584P AD=0.1188P
+ PS=1.6U PD=1.02U
M$3530 \$1365 WECLK \$1364 VSS nfet_03v3 L=0.28U W=0.36U AS=0.1188P AD=0.1278P
+ PS=1.02U PD=1.07U
M$3531 \$1601 \$1366 \$1365 VSS nfet_03v3 L=0.28U W=0.36U AS=0.1278P AD=0.0567P
+ PS=1.07U PD=0.675U
M$3532 VSS WECLKb \$1601 VSS nfet_03v3 L=0.28U W=0.36U AS=0.0567P AD=0.1584P
+ PS=0.675U PD=1.6U
M$3533 VSS \$1365 \$1366 VSS nfet_03v3 L=0.28U W=0.36U AS=0.1584P AD=0.0972P
+ PS=1.6U PD=0.9U
M$3534 \$1367 \$1365 VSS VSS nfet_03v3 L=0.28U W=0.36U AS=0.0972P AD=0.18P
+ PS=0.9U PD=1.72U
M$3535 \$1370 D|Q VSS VSS nfet_03v3 L=0.28U W=0.36U AS=0.1584P AD=0.1188P
+ PS=1.6U PD=1.02U
M$3536 \$1371 WECLK \$1370 VSS nfet_03v3 L=0.28U W=0.36U AS=0.1188P AD=0.1278P
+ PS=1.02U PD=1.07U
M$3537 \$1609 \$1372 \$1371 VSS nfet_03v3 L=0.28U W=0.36U AS=0.1278P AD=0.0567P
+ PS=1.07U PD=0.675U
M$3538 VSS WECLKb \$1609 VSS nfet_03v3 L=0.28U W=0.36U AS=0.0567P AD=0.1584P
+ PS=0.675U PD=1.6U
M$3539 VSS \$1371 \$1372 VSS nfet_03v3 L=0.28U W=0.36U AS=0.1584P AD=0.0972P
+ PS=1.6U PD=0.9U
M$3540 \$1373 \$1371 VSS VSS nfet_03v3 L=0.28U W=0.36U AS=0.0972P AD=0.18P
+ PS=0.9U PD=1.72U
M$3541 \$1376 D|Q VSS VSS nfet_03v3 L=0.28U W=0.36U AS=0.1584P AD=0.1188P
+ PS=1.6U PD=1.02U
M$3542 \$1377 WECLK \$1376 VSS nfet_03v3 L=0.28U W=0.36U AS=0.1188P AD=0.1278P
+ PS=1.02U PD=1.07U
M$3543 \$1615 \$1378 \$1377 VSS nfet_03v3 L=0.28U W=0.36U AS=0.1278P AD=0.0567P
+ PS=1.07U PD=0.675U
M$3544 VSS WECLKb \$1615 VSS nfet_03v3 L=0.28U W=0.36U AS=0.0567P AD=0.1584P
+ PS=0.675U PD=1.6U
M$3545 VSS \$1377 \$1378 VSS nfet_03v3 L=0.28U W=0.36U AS=0.1584P AD=0.0972P
+ PS=1.6U PD=0.9U
M$3546 \$1379 \$1377 VSS VSS nfet_03v3 L=0.28U W=0.36U AS=0.0972P AD=0.18P
+ PS=0.9U PD=1.72U
M$3547 \$1382 D|Q VSS VSS nfet_03v3 L=0.28U W=0.36U AS=0.1584P AD=0.1188P
+ PS=1.6U PD=1.02U
M$3548 \$1383 WECLK \$1382 VSS nfet_03v3 L=0.28U W=0.36U AS=0.1188P AD=0.1278P
+ PS=1.02U PD=1.07U
M$3549 \$1622 \$1384 \$1383 VSS nfet_03v3 L=0.28U W=0.36U AS=0.1278P AD=0.0567P
+ PS=1.07U PD=0.675U
M$3550 VSS WECLKb \$1622 VSS nfet_03v3 L=0.28U W=0.36U AS=0.0567P AD=0.1584P
+ PS=0.675U PD=1.6U
M$3551 VSS \$1383 \$1384 VSS nfet_03v3 L=0.28U W=0.36U AS=0.1584P AD=0.0972P
+ PS=1.6U PD=0.9U
M$3552 \$1385 \$1383 VSS VSS nfet_03v3 L=0.28U W=0.36U AS=0.0972P AD=0.18P
+ PS=0.9U PD=1.72U
M$3553 \$1388 D|Q VSS VSS nfet_03v3 L=0.28U W=0.36U AS=0.1584P AD=0.1188P
+ PS=1.6U PD=1.02U
M$3554 \$1389 WECLK \$1388 VSS nfet_03v3 L=0.28U W=0.36U AS=0.1188P AD=0.1278P
+ PS=1.02U PD=1.07U
M$3555 \$1629 \$1390 \$1389 VSS nfet_03v3 L=0.28U W=0.36U AS=0.1278P AD=0.0567P
+ PS=1.07U PD=0.675U
M$3556 VSS WECLKb \$1629 VSS nfet_03v3 L=0.28U W=0.36U AS=0.0567P AD=0.1584P
+ PS=0.675U PD=1.6U
M$3557 VSS \$1389 \$1390 VSS nfet_03v3 L=0.28U W=0.36U AS=0.1584P AD=0.0972P
+ PS=1.6U PD=0.9U
M$3558 \$1391 \$1389 VSS VSS nfet_03v3 L=0.28U W=0.36U AS=0.0972P AD=0.18P
+ PS=0.9U PD=1.72U
M$3559 \$1394 D|Q VSS VSS nfet_03v3 L=0.28U W=0.36U AS=0.1584P AD=0.1188P
+ PS=1.6U PD=1.02U
M$3560 \$1395 WECLK \$1394 VSS nfet_03v3 L=0.28U W=0.36U AS=0.1188P AD=0.1278P
+ PS=1.02U PD=1.07U
M$3561 \$1637 \$1396 \$1395 VSS nfet_03v3 L=0.28U W=0.36U AS=0.1278P AD=0.0567P
+ PS=1.07U PD=0.675U
M$3562 VSS WECLKb \$1637 VSS nfet_03v3 L=0.28U W=0.36U AS=0.0567P AD=0.1584P
+ PS=0.675U PD=1.6U
M$3563 VSS \$1395 \$1396 VSS nfet_03v3 L=0.28U W=0.36U AS=0.1584P AD=0.0972P
+ PS=1.6U PD=0.9U
M$3564 \$1397 \$1395 VSS VSS nfet_03v3 L=0.28U W=0.36U AS=0.0972P AD=0.18P
+ PS=0.9U PD=1.72U
M$3565 \$1400 D|Q VSS VSS nfet_03v3 L=0.28U W=0.36U AS=0.1584P AD=0.1188P
+ PS=1.6U PD=1.02U
M$3566 \$1401 WECLK \$1400 VSS nfet_03v3 L=0.28U W=0.36U AS=0.1188P AD=0.1278P
+ PS=1.02U PD=1.07U
M$3567 \$1645 \$1402 \$1401 VSS nfet_03v3 L=0.28U W=0.36U AS=0.1278P AD=0.0567P
+ PS=1.07U PD=0.675U
M$3568 VSS WECLKb \$1645 VSS nfet_03v3 L=0.28U W=0.36U AS=0.0567P AD=0.1584P
+ PS=0.675U PD=1.6U
M$3569 VSS \$1401 \$1402 VSS nfet_03v3 L=0.28U W=0.36U AS=0.1584P AD=0.0972P
+ PS=1.6U PD=0.9U
M$3570 \$1403 \$1401 VSS VSS nfet_03v3 L=0.28U W=0.36U AS=0.0972P AD=0.18P
+ PS=0.9U PD=1.72U
M$3571 \$1406 D|Q VSS VSS nfet_03v3 L=0.28U W=0.36U AS=0.1584P AD=0.1188P
+ PS=1.6U PD=1.02U
M$3572 \$1407 WECLK \$1406 VSS nfet_03v3 L=0.28U W=0.36U AS=0.1188P AD=0.1278P
+ PS=1.02U PD=1.07U
M$3573 \$1651 \$1408 \$1407 VSS nfet_03v3 L=0.28U W=0.36U AS=0.1278P AD=0.0567P
+ PS=1.07U PD=0.675U
M$3574 VSS WECLKb \$1651 VSS nfet_03v3 L=0.28U W=0.36U AS=0.0567P AD=0.1584P
+ PS=0.675U PD=1.6U
M$3575 VSS \$1407 \$1408 VSS nfet_03v3 L=0.28U W=0.36U AS=0.1584P AD=0.0972P
+ PS=1.6U PD=0.9U
M$3576 \$1409 \$1407 VSS VSS nfet_03v3 L=0.28U W=0.36U AS=0.0972P AD=0.18P
+ PS=0.9U PD=1.72U
M$3577 \$1412 D|Q VSS VSS nfet_03v3 L=0.28U W=0.36U AS=0.1584P AD=0.1188P
+ PS=1.6U PD=1.02U
M$3578 \$1413 WECLK \$1412 VSS nfet_03v3 L=0.28U W=0.36U AS=0.1188P AD=0.1278P
+ PS=1.02U PD=1.07U
M$3579 \$1658 \$1414 \$1413 VSS nfet_03v3 L=0.28U W=0.36U AS=0.1278P AD=0.0567P
+ PS=1.07U PD=0.675U
M$3580 VSS WECLKb \$1658 VSS nfet_03v3 L=0.28U W=0.36U AS=0.0567P AD=0.1584P
+ PS=0.675U PD=1.6U
M$3581 VSS \$1413 \$1414 VSS nfet_03v3 L=0.28U W=0.36U AS=0.1584P AD=0.0972P
+ PS=1.6U PD=0.9U
M$3582 \$1415 \$1413 VSS VSS nfet_03v3 L=0.28U W=0.36U AS=0.0972P AD=0.18P
+ PS=0.9U PD=1.72U
M$3583 \$1418 D|Q VSS VSS nfet_03v3 L=0.28U W=0.36U AS=0.1584P AD=0.1188P
+ PS=1.6U PD=1.02U
M$3584 \$1419 WECLK \$1418 VSS nfet_03v3 L=0.28U W=0.36U AS=0.1188P AD=0.1278P
+ PS=1.02U PD=1.07U
M$3585 \$1665 \$1420 \$1419 VSS nfet_03v3 L=0.28U W=0.36U AS=0.1278P AD=0.0567P
+ PS=1.07U PD=0.675U
M$3586 VSS WECLKb \$1665 VSS nfet_03v3 L=0.28U W=0.36U AS=0.0567P AD=0.1584P
+ PS=0.675U PD=1.6U
M$3587 VSS \$1419 \$1420 VSS nfet_03v3 L=0.28U W=0.36U AS=0.1584P AD=0.0972P
+ PS=1.6U PD=0.9U
M$3588 \$1421 \$1419 VSS VSS nfet_03v3 L=0.28U W=0.36U AS=0.0972P AD=0.18P
+ PS=0.9U PD=1.72U
M$3589 \$1424 D|Q VSS VSS nfet_03v3 L=0.28U W=0.36U AS=0.1584P AD=0.1188P
+ PS=1.6U PD=1.02U
M$3590 \$1425 WECLK \$1424 VSS nfet_03v3 L=0.28U W=0.36U AS=0.1188P AD=0.1278P
+ PS=1.02U PD=1.07U
M$3591 \$1673 \$1426 \$1425 VSS nfet_03v3 L=0.28U W=0.36U AS=0.1278P AD=0.0567P
+ PS=1.07U PD=0.675U
M$3592 VSS WECLKb \$1673 VSS nfet_03v3 L=0.28U W=0.36U AS=0.0567P AD=0.1584P
+ PS=0.675U PD=1.6U
M$3593 VSS \$1425 \$1426 VSS nfet_03v3 L=0.28U W=0.36U AS=0.1584P AD=0.0972P
+ PS=1.6U PD=0.9U
M$3594 \$1427 \$1425 VSS VSS nfet_03v3 L=0.28U W=0.36U AS=0.0972P AD=0.18P
+ PS=0.9U PD=1.72U
M$3595 \$1430 D|Q VSS VSS nfet_03v3 L=0.28U W=0.36U AS=0.1584P AD=0.1188P
+ PS=1.6U PD=1.02U
M$3596 \$1431 WECLK \$1430 VSS nfet_03v3 L=0.28U W=0.36U AS=0.1188P AD=0.1278P
+ PS=1.02U PD=1.07U
M$3597 \$1680 \$1432 \$1431 VSS nfet_03v3 L=0.28U W=0.36U AS=0.1278P AD=0.0567P
+ PS=1.07U PD=0.675U
M$3598 VSS WECLKb \$1680 VSS nfet_03v3 L=0.28U W=0.36U AS=0.0567P AD=0.1584P
+ PS=0.675U PD=1.6U
M$3599 VSS \$1431 \$1432 VSS nfet_03v3 L=0.28U W=0.36U AS=0.1584P AD=0.0972P
+ PS=1.6U PD=0.9U
M$3600 \$1433 \$1431 VSS VSS nfet_03v3 L=0.28U W=0.36U AS=0.0972P AD=0.18P
+ PS=0.9U PD=1.72U
M$3601 \$1436 D|Q VSS VSS nfet_03v3 L=0.28U W=0.36U AS=0.1584P AD=0.1188P
+ PS=1.6U PD=1.02U
M$3602 \$1437 WECLK \$1436 VSS nfet_03v3 L=0.28U W=0.36U AS=0.1188P AD=0.1278P
+ PS=1.02U PD=1.07U
M$3603 \$1644 \$1438 \$1437 VSS nfet_03v3 L=0.28U W=0.36U AS=0.1278P AD=0.0567P
+ PS=1.07U PD=0.675U
M$3604 VSS WECLKb \$1644 VSS nfet_03v3 L=0.28U W=0.36U AS=0.0567P AD=0.1584P
+ PS=0.675U PD=1.6U
M$3605 VSS \$1437 \$1438 VSS nfet_03v3 L=0.28U W=0.36U AS=0.1584P AD=0.0972P
+ PS=1.6U PD=0.9U
M$3606 \$1439 \$1437 VSS VSS nfet_03v3 L=0.28U W=0.36U AS=0.0972P AD=0.18P
+ PS=0.9U PD=1.72U
M$3607 \$1442 D|Q VSS VSS nfet_03v3 L=0.28U W=0.36U AS=0.1584P AD=0.1188P
+ PS=1.6U PD=1.02U
M$3608 \$1443 WECLK \$1442 VSS nfet_03v3 L=0.28U W=0.36U AS=0.1188P AD=0.1278P
+ PS=1.02U PD=1.07U
M$3609 \$1608 \$1444 \$1443 VSS nfet_03v3 L=0.28U W=0.36U AS=0.1278P AD=0.0567P
+ PS=1.07U PD=0.675U
M$3610 VSS WECLKb \$1608 VSS nfet_03v3 L=0.28U W=0.36U AS=0.0567P AD=0.1584P
+ PS=0.675U PD=1.6U
M$3611 VSS \$1443 \$1444 VSS nfet_03v3 L=0.28U W=0.36U AS=0.1584P AD=0.0972P
+ PS=1.6U PD=0.9U
M$3612 \$1445 \$1443 VSS VSS nfet_03v3 L=0.28U W=0.36U AS=0.0972P AD=0.18P
+ PS=0.9U PD=1.72U
M$3613 \$1831 WE VSS VSS nfet_03v3 L=0.28U W=0.72U AS=0.3168P AD=0.1872P
+ PS=2.32U PD=1.24U
M$3614 \$1697 CLK \$1831 VSS nfet_03v3 L=0.28U W=0.72U AS=0.1872P AD=0.3168P
+ PS=1.24U PD=2.32U
M$3615 WECLK \$1697 VSS VSS nfet_03v3 L=0.28U W=1.27U AS=0.4445P AD=0.3344P
+ PS=3.305U PD=2.345U
M$3619 \$1700 D|Q VSS VSS nfet_03v3 L=0.28U W=0.36U AS=0.1584P AD=0.1188P
+ PS=1.6U PD=1.02U
M$3620 \$1701 WECLK \$1700 VSS nfet_03v3 L=0.28U W=0.36U AS=0.1188P AD=0.1278P
+ PS=1.02U PD=1.07U
M$3621 \$1755 \$1702 \$1701 VSS nfet_03v3 L=0.28U W=0.36U AS=0.1278P AD=0.0567P
+ PS=1.07U PD=0.675U
M$3622 VSS WECLKb \$1755 VSS nfet_03v3 L=0.28U W=0.36U AS=0.0567P AD=0.1584P
+ PS=0.675U PD=1.6U
M$3623 VSS \$1701 \$1702 VSS nfet_03v3 L=0.28U W=0.36U AS=0.1584P AD=0.0972P
+ PS=1.6U PD=0.9U
M$3624 \$1681 \$1701 VSS VSS nfet_03v3 L=0.28U W=0.36U AS=0.0972P AD=0.18P
+ PS=0.9U PD=1.72U
M$3625 \$1703 D|Q VSS VSS nfet_03v3 L=0.28U W=0.36U AS=0.1584P AD=0.1188P
+ PS=1.6U PD=1.02U
M$3626 \$1704 WECLK \$1703 VSS nfet_03v3 L=0.28U W=0.36U AS=0.1188P AD=0.1278P
+ PS=1.02U PD=1.07U
M$3627 \$1764 \$1705 \$1704 VSS nfet_03v3 L=0.28U W=0.36U AS=0.1278P AD=0.0567P
+ PS=1.07U PD=0.675U
M$3628 VSS WECLKb \$1764 VSS nfet_03v3 L=0.28U W=0.36U AS=0.0567P AD=0.1584P
+ PS=0.675U PD=1.6U
M$3629 VSS \$1704 \$1705 VSS nfet_03v3 L=0.28U W=0.36U AS=0.1584P AD=0.0972P
+ PS=1.6U PD=0.9U
M$3630 \$1682 \$1704 VSS VSS nfet_03v3 L=0.28U W=0.36U AS=0.0972P AD=0.18P
+ PS=0.9U PD=1.72U
M$3631 \$1706 D|Q VSS VSS nfet_03v3 L=0.28U W=0.36U AS=0.1584P AD=0.1188P
+ PS=1.6U PD=1.02U
M$3632 \$1707 WECLK \$1706 VSS nfet_03v3 L=0.28U W=0.36U AS=0.1188P AD=0.1278P
+ PS=1.02U PD=1.07U
M$3633 \$1773 \$1708 \$1707 VSS nfet_03v3 L=0.28U W=0.36U AS=0.1278P AD=0.0567P
+ PS=1.07U PD=0.675U
M$3634 VSS WECLKb \$1773 VSS nfet_03v3 L=0.28U W=0.36U AS=0.0567P AD=0.1584P
+ PS=0.675U PD=1.6U
M$3635 VSS \$1707 \$1708 VSS nfet_03v3 L=0.28U W=0.36U AS=0.1584P AD=0.0972P
+ PS=1.6U PD=0.9U
M$3636 \$1683 \$1707 VSS VSS nfet_03v3 L=0.28U W=0.36U AS=0.0972P AD=0.18P
+ PS=0.9U PD=1.72U
M$3637 \$1709 D|Q VSS VSS nfet_03v3 L=0.28U W=0.36U AS=0.1584P AD=0.1188P
+ PS=1.6U PD=1.02U
M$3638 \$1710 WECLK \$1709 VSS nfet_03v3 L=0.28U W=0.36U AS=0.1188P AD=0.1278P
+ PS=1.02U PD=1.07U
M$3639 \$1782 \$1711 \$1710 VSS nfet_03v3 L=0.28U W=0.36U AS=0.1278P AD=0.0567P
+ PS=1.07U PD=0.675U
M$3640 VSS WECLKb \$1782 VSS nfet_03v3 L=0.28U W=0.36U AS=0.0567P AD=0.1584P
+ PS=0.675U PD=1.6U
M$3641 VSS \$1710 \$1711 VSS nfet_03v3 L=0.28U W=0.36U AS=0.1584P AD=0.0972P
+ PS=1.6U PD=0.9U
M$3642 \$1684 \$1710 VSS VSS nfet_03v3 L=0.28U W=0.36U AS=0.0972P AD=0.18P
+ PS=0.9U PD=1.72U
M$3643 \$1712 D|Q VSS VSS nfet_03v3 L=0.28U W=0.36U AS=0.1584P AD=0.1188P
+ PS=1.6U PD=1.02U
M$3644 \$1713 WECLK \$1712 VSS nfet_03v3 L=0.28U W=0.36U AS=0.1188P AD=0.1278P
+ PS=1.02U PD=1.07U
M$3645 \$1791 \$1714 \$1713 VSS nfet_03v3 L=0.28U W=0.36U AS=0.1278P AD=0.0567P
+ PS=1.07U PD=0.675U
M$3646 VSS WECLKb \$1791 VSS nfet_03v3 L=0.28U W=0.36U AS=0.0567P AD=0.1584P
+ PS=0.675U PD=1.6U
M$3647 VSS \$1713 \$1714 VSS nfet_03v3 L=0.28U W=0.36U AS=0.1584P AD=0.0972P
+ PS=1.6U PD=0.9U
M$3648 \$1685 \$1713 VSS VSS nfet_03v3 L=0.28U W=0.36U AS=0.0972P AD=0.18P
+ PS=0.9U PD=1.72U
M$3649 \$1715 D|Q VSS VSS nfet_03v3 L=0.28U W=0.36U AS=0.1584P AD=0.1188P
+ PS=1.6U PD=1.02U
M$3650 \$1716 WECLK \$1715 VSS nfet_03v3 L=0.28U W=0.36U AS=0.1188P AD=0.1278P
+ PS=1.02U PD=1.07U
M$3651 \$1794 \$1717 \$1716 VSS nfet_03v3 L=0.28U W=0.36U AS=0.1278P AD=0.0567P
+ PS=1.07U PD=0.675U
M$3652 VSS WECLKb \$1794 VSS nfet_03v3 L=0.28U W=0.36U AS=0.0567P AD=0.1584P
+ PS=0.675U PD=1.6U
M$3653 VSS \$1716 \$1717 VSS nfet_03v3 L=0.28U W=0.36U AS=0.1584P AD=0.0972P
+ PS=1.6U PD=0.9U
M$3654 \$1686 \$1716 VSS VSS nfet_03v3 L=0.28U W=0.36U AS=0.0972P AD=0.18P
+ PS=0.9U PD=1.72U
M$3655 \$1718 D|Q VSS VSS nfet_03v3 L=0.28U W=0.36U AS=0.1584P AD=0.1188P
+ PS=1.6U PD=1.02U
M$3656 \$1719 WECLK \$1718 VSS nfet_03v3 L=0.28U W=0.36U AS=0.1188P AD=0.1278P
+ PS=1.02U PD=1.07U
M$3657 \$1788 \$1720 \$1719 VSS nfet_03v3 L=0.28U W=0.36U AS=0.1278P AD=0.0567P
+ PS=1.07U PD=0.675U
M$3658 VSS WECLKb \$1788 VSS nfet_03v3 L=0.28U W=0.36U AS=0.0567P AD=0.1584P
+ PS=0.675U PD=1.6U
M$3659 VSS \$1719 \$1720 VSS nfet_03v3 L=0.28U W=0.36U AS=0.1584P AD=0.0972P
+ PS=1.6U PD=0.9U
M$3660 \$1687 \$1719 VSS VSS nfet_03v3 L=0.28U W=0.36U AS=0.0972P AD=0.18P
+ PS=0.9U PD=1.72U
M$3661 \$1721 D|Q VSS VSS nfet_03v3 L=0.28U W=0.36U AS=0.1584P AD=0.1188P
+ PS=1.6U PD=1.02U
M$3662 \$1722 WECLK \$1721 VSS nfet_03v3 L=0.28U W=0.36U AS=0.1188P AD=0.1278P
+ PS=1.02U PD=1.07U
M$3663 \$1786 \$1723 \$1722 VSS nfet_03v3 L=0.28U W=0.36U AS=0.1278P AD=0.0567P
+ PS=1.07U PD=0.675U
M$3664 VSS WECLKb \$1786 VSS nfet_03v3 L=0.28U W=0.36U AS=0.0567P AD=0.1584P
+ PS=0.675U PD=1.6U
M$3665 VSS \$1722 \$1723 VSS nfet_03v3 L=0.28U W=0.36U AS=0.1584P AD=0.0972P
+ PS=1.6U PD=0.9U
M$3666 \$1688 \$1722 VSS VSS nfet_03v3 L=0.28U W=0.36U AS=0.0972P AD=0.18P
+ PS=0.9U PD=1.72U
M$3667 \$1724 D|Q VSS VSS nfet_03v3 L=0.28U W=0.36U AS=0.1584P AD=0.1188P
+ PS=1.6U PD=1.02U
M$3668 \$1725 WECLK \$1724 VSS nfet_03v3 L=0.28U W=0.36U AS=0.1188P AD=0.1278P
+ PS=1.02U PD=1.07U
M$3669 \$1780 \$1726 \$1725 VSS nfet_03v3 L=0.28U W=0.36U AS=0.1278P AD=0.0567P
+ PS=1.07U PD=0.675U
M$3670 VSS WECLKb \$1780 VSS nfet_03v3 L=0.28U W=0.36U AS=0.0567P AD=0.1584P
+ PS=0.675U PD=1.6U
M$3671 VSS \$1725 \$1726 VSS nfet_03v3 L=0.28U W=0.36U AS=0.1584P AD=0.0972P
+ PS=1.6U PD=0.9U
M$3672 \$1689 \$1725 VSS VSS nfet_03v3 L=0.28U W=0.36U AS=0.0972P AD=0.18P
+ PS=0.9U PD=1.72U
M$3673 \$1727 D|Q VSS VSS nfet_03v3 L=0.28U W=0.36U AS=0.1584P AD=0.1188P
+ PS=1.6U PD=1.02U
M$3674 \$1728 WECLK \$1727 VSS nfet_03v3 L=0.28U W=0.36U AS=0.1188P AD=0.1278P
+ PS=1.02U PD=1.07U
M$3675 \$1777 \$1729 \$1728 VSS nfet_03v3 L=0.28U W=0.36U AS=0.1278P AD=0.0567P
+ PS=1.07U PD=0.675U
M$3676 VSS WECLKb \$1777 VSS nfet_03v3 L=0.28U W=0.36U AS=0.0567P AD=0.1584P
+ PS=0.675U PD=1.6U
M$3677 VSS \$1728 \$1729 VSS nfet_03v3 L=0.28U W=0.36U AS=0.1584P AD=0.0972P
+ PS=1.6U PD=0.9U
M$3678 \$1690 \$1728 VSS VSS nfet_03v3 L=0.28U W=0.36U AS=0.0972P AD=0.18P
+ PS=0.9U PD=1.72U
M$3679 \$1730 D|Q VSS VSS nfet_03v3 L=0.28U W=0.36U AS=0.1584P AD=0.1188P
+ PS=1.6U PD=1.02U
M$3680 \$1731 WECLK \$1730 VSS nfet_03v3 L=0.28U W=0.36U AS=0.1188P AD=0.1278P
+ PS=1.02U PD=1.07U
M$3681 \$1771 \$1732 \$1731 VSS nfet_03v3 L=0.28U W=0.36U AS=0.1278P AD=0.0567P
+ PS=1.07U PD=0.675U
M$3682 VSS WECLKb \$1771 VSS nfet_03v3 L=0.28U W=0.36U AS=0.0567P AD=0.1584P
+ PS=0.675U PD=1.6U
M$3683 VSS \$1731 \$1732 VSS nfet_03v3 L=0.28U W=0.36U AS=0.1584P AD=0.0972P
+ PS=1.6U PD=0.9U
M$3684 \$1691 \$1731 VSS VSS nfet_03v3 L=0.28U W=0.36U AS=0.0972P AD=0.18P
+ PS=0.9U PD=1.72U
M$3685 \$1733 D|Q VSS VSS nfet_03v3 L=0.28U W=0.36U AS=0.1584P AD=0.1188P
+ PS=1.6U PD=1.02U
M$3686 \$1734 WECLK \$1733 VSS nfet_03v3 L=0.28U W=0.36U AS=0.1188P AD=0.1278P
+ PS=1.02U PD=1.07U
M$3687 \$1768 \$1735 \$1734 VSS nfet_03v3 L=0.28U W=0.36U AS=0.1278P AD=0.0567P
+ PS=1.07U PD=0.675U
M$3688 VSS WECLKb \$1768 VSS nfet_03v3 L=0.28U W=0.36U AS=0.0567P AD=0.1584P
+ PS=0.675U PD=1.6U
M$3689 VSS \$1734 \$1735 VSS nfet_03v3 L=0.28U W=0.36U AS=0.1584P AD=0.0972P
+ PS=1.6U PD=0.9U
M$3690 \$1692 \$1734 VSS VSS nfet_03v3 L=0.28U W=0.36U AS=0.0972P AD=0.18P
+ PS=0.9U PD=1.72U
M$3691 \$1736 D|Q VSS VSS nfet_03v3 L=0.28U W=0.36U AS=0.1584P AD=0.1188P
+ PS=1.6U PD=1.02U
M$3692 \$1737 WECLK \$1736 VSS nfet_03v3 L=0.28U W=0.36U AS=0.1188P AD=0.1278P
+ PS=1.02U PD=1.07U
M$3693 \$1762 \$1738 \$1737 VSS nfet_03v3 L=0.28U W=0.36U AS=0.1278P AD=0.0567P
+ PS=1.07U PD=0.675U
M$3694 VSS WECLKb \$1762 VSS nfet_03v3 L=0.28U W=0.36U AS=0.0567P AD=0.1584P
+ PS=0.675U PD=1.6U
M$3695 VSS \$1737 \$1738 VSS nfet_03v3 L=0.28U W=0.36U AS=0.1584P AD=0.0972P
+ PS=1.6U PD=0.9U
M$3696 \$1693 \$1737 VSS VSS nfet_03v3 L=0.28U W=0.36U AS=0.0972P AD=0.18P
+ PS=0.9U PD=1.72U
M$3697 \$1739 D|Q VSS VSS nfet_03v3 L=0.28U W=0.36U AS=0.1584P AD=0.1188P
+ PS=1.6U PD=1.02U
M$3698 \$1740 WECLK \$1739 VSS nfet_03v3 L=0.28U W=0.36U AS=0.1188P AD=0.1278P
+ PS=1.02U PD=1.07U
M$3699 \$1759 \$1741 \$1740 VSS nfet_03v3 L=0.28U W=0.36U AS=0.1278P AD=0.0567P
+ PS=1.07U PD=0.675U
M$3700 VSS WECLKb \$1759 VSS nfet_03v3 L=0.28U W=0.36U AS=0.0567P AD=0.1584P
+ PS=0.675U PD=1.6U
M$3701 VSS \$1740 \$1741 VSS nfet_03v3 L=0.28U W=0.36U AS=0.1584P AD=0.0972P
+ PS=1.6U PD=0.9U
M$3702 \$1694 \$1740 VSS VSS nfet_03v3 L=0.28U W=0.36U AS=0.0972P AD=0.18P
+ PS=0.9U PD=1.72U
M$3703 \$1742 D|Q VSS VSS nfet_03v3 L=0.28U W=0.36U AS=0.1584P AD=0.1188P
+ PS=1.6U PD=1.02U
M$3704 \$1743 WECLK \$1742 VSS nfet_03v3 L=0.28U W=0.36U AS=0.1188P AD=0.1278P
+ PS=1.02U PD=1.07U
M$3705 \$1752 \$1744 \$1743 VSS nfet_03v3 L=0.28U W=0.36U AS=0.1278P AD=0.0567P
+ PS=1.07U PD=0.675U
M$3706 VSS WECLKb \$1752 VSS nfet_03v3 L=0.28U W=0.36U AS=0.0567P AD=0.1584P
+ PS=0.675U PD=1.6U
M$3707 VSS \$1743 \$1744 VSS nfet_03v3 L=0.28U W=0.36U AS=0.1584P AD=0.0972P
+ PS=1.6U PD=0.9U
M$3708 \$1695 \$1743 VSS VSS nfet_03v3 L=0.28U W=0.36U AS=0.0972P AD=0.18P
+ PS=0.9U PD=1.72U
M$3709 \$1745 D|Q VSS VSS nfet_03v3 L=0.28U W=0.36U AS=0.1584P AD=0.1188P
+ PS=1.6U PD=1.02U
M$3710 \$1746 WECLK \$1745 VSS nfet_03v3 L=0.28U W=0.36U AS=0.1188P AD=0.1278P
+ PS=1.02U PD=1.07U
M$3711 \$1749 \$1747 \$1746 VSS nfet_03v3 L=0.28U W=0.36U AS=0.1278P AD=0.0567P
+ PS=1.07U PD=0.675U
M$3712 VSS WECLKb \$1749 VSS nfet_03v3 L=0.28U W=0.36U AS=0.0567P AD=0.1584P
+ PS=0.675U PD=1.6U
M$3713 VSS \$1746 \$1747 VSS nfet_03v3 L=0.28U W=0.36U AS=0.1584P AD=0.0972P
+ PS=1.6U PD=0.9U
M$3714 \$1696 \$1746 VSS VSS nfet_03v3 L=0.28U W=0.36U AS=0.0972P AD=0.18P
+ PS=0.9U PD=1.72U
M$3715 \$2032 RA VSS VSS nfet_03v3 L=0.28U W=0.36U AS=0.1656P AD=0.1944P
+ PS=1.64U PD=1.8U
M$3716 \$1799 RA VSS VSS nfet_03v3 L=0.28U W=0.36U AS=0.1656P AD=0.1944P
+ PS=1.64U PD=1.8U
M$3717 \$2031 RA QAb VSS nfet_03v3 L=0.28U W=0.36U AS=0.1584P AD=0.1152P
+ PS=1.6U PD=1U
M$3718 QBb RB \$2031 VSS nfet_03v3 L=0.28U W=0.36U AS=0.1152P AD=0.1584P PS=1U
+ PD=1.6U
M$3719 \$1681 RA QAb VSS nfet_03v3 L=0.28U W=0.36U AS=0.1584P AD=0.1152P
+ PS=1.6U PD=1U
M$3720 QBb RB \$1681 VSS nfet_03v3 L=0.28U W=0.36U AS=0.1152P AD=0.1584P PS=1U
+ PD=1.6U
M$3721 VSS RB \$1800 VSS nfet_03v3 L=0.28U W=0.36U AS=0.1854P AD=0.1584P
+ PS=1.75U PD=1.6U
M$3722 VSS RB \$2033 VSS nfet_03v3 L=0.28U W=0.36U AS=0.1854P AD=0.1584P
+ PS=1.75U PD=1.6U
M$3723 \$2039 RA VSS VSS nfet_03v3 L=0.28U W=0.36U AS=0.1656P AD=0.1944P
+ PS=1.64U PD=1.8U
M$3724 \$1801 RA VSS VSS nfet_03v3 L=0.28U W=0.36U AS=0.1656P AD=0.1944P
+ PS=1.64U PD=1.8U
M$3725 \$1682 RA QAb VSS nfet_03v3 L=0.28U W=0.36U AS=0.1584P AD=0.1152P
+ PS=1.6U PD=1U
M$3726 QBb RB \$1682 VSS nfet_03v3 L=0.28U W=0.36U AS=0.1152P AD=0.1584P PS=1U
+ PD=1.6U
M$3727 \$2038 RA QAb VSS nfet_03v3 L=0.28U W=0.36U AS=0.1584P AD=0.1152P
+ PS=1.6U PD=1U
M$3728 QBb RB \$2038 VSS nfet_03v3 L=0.28U W=0.36U AS=0.1152P AD=0.1584P PS=1U
+ PD=1.6U
M$3729 VSS RB \$2040 VSS nfet_03v3 L=0.28U W=0.36U AS=0.1854P AD=0.1584P
+ PS=1.75U PD=1.6U
M$3730 VSS RB \$1802 VSS nfet_03v3 L=0.28U W=0.36U AS=0.1854P AD=0.1584P
+ PS=1.75U PD=1.6U
M$3731 \$1803 RA VSS VSS nfet_03v3 L=0.28U W=0.36U AS=0.1656P AD=0.1944P
+ PS=1.64U PD=1.8U
M$3732 \$2045 RA VSS VSS nfet_03v3 L=0.28U W=0.36U AS=0.1656P AD=0.1944P
+ PS=1.64U PD=1.8U
M$3733 \$1683 RA QAb VSS nfet_03v3 L=0.28U W=0.36U AS=0.1584P AD=0.1152P
+ PS=1.6U PD=1U
M$3734 QBb RB \$1683 VSS nfet_03v3 L=0.28U W=0.36U AS=0.1152P AD=0.1584P PS=1U
+ PD=1.6U
M$3735 \$2044 RA QAb VSS nfet_03v3 L=0.28U W=0.36U AS=0.1584P AD=0.1152P
+ PS=1.6U PD=1U
M$3736 QBb RB \$2044 VSS nfet_03v3 L=0.28U W=0.36U AS=0.1152P AD=0.1584P PS=1U
+ PD=1.6U
M$3737 VSS RB \$1804 VSS nfet_03v3 L=0.28U W=0.36U AS=0.1854P AD=0.1584P
+ PS=1.75U PD=1.6U
M$3738 VSS RB \$2046 VSS nfet_03v3 L=0.28U W=0.36U AS=0.1854P AD=0.1584P
+ PS=1.75U PD=1.6U
M$3739 \$2051 RA VSS VSS nfet_03v3 L=0.28U W=0.36U AS=0.1656P AD=0.1944P
+ PS=1.64U PD=1.8U
M$3740 \$1805 RA VSS VSS nfet_03v3 L=0.28U W=0.36U AS=0.1656P AD=0.1944P
+ PS=1.64U PD=1.8U
M$3741 \$1684 RA QAb VSS nfet_03v3 L=0.28U W=0.36U AS=0.1584P AD=0.1152P
+ PS=1.6U PD=1U
M$3742 QBb RB \$1684 VSS nfet_03v3 L=0.28U W=0.36U AS=0.1152P AD=0.1584P PS=1U
+ PD=1.6U
M$3743 \$2050 RA QAb VSS nfet_03v3 L=0.28U W=0.36U AS=0.1584P AD=0.1152P
+ PS=1.6U PD=1U
M$3744 QBb RB \$2050 VSS nfet_03v3 L=0.28U W=0.36U AS=0.1152P AD=0.1584P PS=1U
+ PD=1.6U
M$3745 VSS RB \$1806 VSS nfet_03v3 L=0.28U W=0.36U AS=0.1854P AD=0.1584P
+ PS=1.75U PD=1.6U
M$3746 VSS RB \$2052 VSS nfet_03v3 L=0.28U W=0.36U AS=0.1854P AD=0.1584P
+ PS=1.75U PD=1.6U
M$3747 \$2057 RA VSS VSS nfet_03v3 L=0.28U W=0.36U AS=0.1656P AD=0.1944P
+ PS=1.64U PD=1.8U
M$3748 \$1807 RA VSS VSS nfet_03v3 L=0.28U W=0.36U AS=0.1656P AD=0.1944P
+ PS=1.64U PD=1.8U
M$3749 \$1685 RA QAb VSS nfet_03v3 L=0.28U W=0.36U AS=0.1584P AD=0.1152P
+ PS=1.6U PD=1U
M$3750 QBb RB \$1685 VSS nfet_03v3 L=0.28U W=0.36U AS=0.1152P AD=0.1584P PS=1U
+ PD=1.6U
M$3751 \$2056 RA QAb VSS nfet_03v3 L=0.28U W=0.36U AS=0.1584P AD=0.1152P
+ PS=1.6U PD=1U
M$3752 QBb RB \$2056 VSS nfet_03v3 L=0.28U W=0.36U AS=0.1152P AD=0.1584P PS=1U
+ PD=1.6U
M$3753 VSS RB \$1808 VSS nfet_03v3 L=0.28U W=0.36U AS=0.1854P AD=0.1584P
+ PS=1.75U PD=1.6U
M$3754 VSS RB \$2058 VSS nfet_03v3 L=0.28U W=0.36U AS=0.1854P AD=0.1584P
+ PS=1.75U PD=1.6U
M$3755 \$2063 RA VSS VSS nfet_03v3 L=0.28U W=0.36U AS=0.1656P AD=0.1944P
+ PS=1.64U PD=1.8U
M$3756 \$1809 RA VSS VSS nfet_03v3 L=0.28U W=0.36U AS=0.1656P AD=0.1944P
+ PS=1.64U PD=1.8U
M$3757 \$2062 RA QAb VSS nfet_03v3 L=0.28U W=0.36U AS=0.1584P AD=0.1152P
+ PS=1.6U PD=1U
M$3758 QBb RB \$2062 VSS nfet_03v3 L=0.28U W=0.36U AS=0.1152P AD=0.1584P PS=1U
+ PD=1.6U
M$3759 \$1686 RA QAb VSS nfet_03v3 L=0.28U W=0.36U AS=0.1584P AD=0.1152P
+ PS=1.6U PD=1U
M$3760 QBb RB \$1686 VSS nfet_03v3 L=0.28U W=0.36U AS=0.1152P AD=0.1584P PS=1U
+ PD=1.6U
M$3761 VSS RB \$1810 VSS nfet_03v3 L=0.28U W=0.36U AS=0.1854P AD=0.1584P
+ PS=1.75U PD=1.6U
M$3762 VSS RB \$2064 VSS nfet_03v3 L=0.28U W=0.36U AS=0.1854P AD=0.1584P
+ PS=1.75U PD=1.6U
M$3763 \$2069 RA VSS VSS nfet_03v3 L=0.28U W=0.36U AS=0.1656P AD=0.1944P
+ PS=1.64U PD=1.8U
M$3764 \$1811 RA VSS VSS nfet_03v3 L=0.28U W=0.36U AS=0.1656P AD=0.1944P
+ PS=1.64U PD=1.8U
M$3765 \$2068 RA QAb VSS nfet_03v3 L=0.28U W=0.36U AS=0.1584P AD=0.1152P
+ PS=1.6U PD=1U
M$3766 QBb RB \$2068 VSS nfet_03v3 L=0.28U W=0.36U AS=0.1152P AD=0.1584P PS=1U
+ PD=1.6U
M$3767 \$1687 RA QAb VSS nfet_03v3 L=0.28U W=0.36U AS=0.1584P AD=0.1152P
+ PS=1.6U PD=1U
M$3768 QBb RB \$1687 VSS nfet_03v3 L=0.28U W=0.36U AS=0.1152P AD=0.1584P PS=1U
+ PD=1.6U
M$3769 VSS RB \$2070 VSS nfet_03v3 L=0.28U W=0.36U AS=0.1854P AD=0.1584P
+ PS=1.75U PD=1.6U
M$3770 VSS RB \$1812 VSS nfet_03v3 L=0.28U W=0.36U AS=0.1854P AD=0.1584P
+ PS=1.75U PD=1.6U
M$3771 \$2075 RA VSS VSS nfet_03v3 L=0.28U W=0.36U AS=0.1656P AD=0.1944P
+ PS=1.64U PD=1.8U
M$3772 \$1813 RA VSS VSS nfet_03v3 L=0.28U W=0.36U AS=0.1656P AD=0.1944P
+ PS=1.64U PD=1.8U
M$3773 \$2074 RA QAb VSS nfet_03v3 L=0.28U W=0.36U AS=0.1584P AD=0.1152P
+ PS=1.6U PD=1U
M$3774 QBb RB \$2074 VSS nfet_03v3 L=0.28U W=0.36U AS=0.1152P AD=0.1584P PS=1U
+ PD=1.6U
M$3775 \$1688 RA QAb VSS nfet_03v3 L=0.28U W=0.36U AS=0.1584P AD=0.1152P
+ PS=1.6U PD=1U
M$3776 QBb RB \$1688 VSS nfet_03v3 L=0.28U W=0.36U AS=0.1152P AD=0.1584P PS=1U
+ PD=1.6U
M$3777 VSS RB \$1814 VSS nfet_03v3 L=0.28U W=0.36U AS=0.1854P AD=0.1584P
+ PS=1.75U PD=1.6U
M$3778 VSS RB \$2076 VSS nfet_03v3 L=0.28U W=0.36U AS=0.1854P AD=0.1584P
+ PS=1.75U PD=1.6U
M$3779 \$1815 RA VSS VSS nfet_03v3 L=0.28U W=0.36U AS=0.1656P AD=0.1944P
+ PS=1.64U PD=1.8U
M$3780 \$2081 RA VSS VSS nfet_03v3 L=0.28U W=0.36U AS=0.1656P AD=0.1944P
+ PS=1.64U PD=1.8U
M$3781 \$2080 RA QAb VSS nfet_03v3 L=0.28U W=0.36U AS=0.1584P AD=0.1152P
+ PS=1.6U PD=1U
M$3782 QBb RB \$2080 VSS nfet_03v3 L=0.28U W=0.36U AS=0.1152P AD=0.1584P PS=1U
+ PD=1.6U
M$3783 \$1689 RA QAb VSS nfet_03v3 L=0.28U W=0.36U AS=0.1584P AD=0.1152P
+ PS=1.6U PD=1U
M$3784 QBb RB \$1689 VSS nfet_03v3 L=0.28U W=0.36U AS=0.1152P AD=0.1584P PS=1U
+ PD=1.6U
M$3785 VSS RB \$2082 VSS nfet_03v3 L=0.28U W=0.36U AS=0.1854P AD=0.1584P
+ PS=1.75U PD=1.6U
M$3786 VSS RB \$1816 VSS nfet_03v3 L=0.28U W=0.36U AS=0.1854P AD=0.1584P
+ PS=1.75U PD=1.6U
M$3787 \$2087 RA VSS VSS nfet_03v3 L=0.28U W=0.36U AS=0.1656P AD=0.1944P
+ PS=1.64U PD=1.8U
M$3788 \$1817 RA VSS VSS nfet_03v3 L=0.28U W=0.36U AS=0.1656P AD=0.1944P
+ PS=1.64U PD=1.8U
M$3789 \$2086 RA QAb VSS nfet_03v3 L=0.28U W=0.36U AS=0.1584P AD=0.1152P
+ PS=1.6U PD=1U
M$3790 QBb RB \$2086 VSS nfet_03v3 L=0.28U W=0.36U AS=0.1152P AD=0.1584P PS=1U
+ PD=1.6U
M$3791 \$1690 RA QAb VSS nfet_03v3 L=0.28U W=0.36U AS=0.1584P AD=0.1152P
+ PS=1.6U PD=1U
M$3792 QBb RB \$1690 VSS nfet_03v3 L=0.28U W=0.36U AS=0.1152P AD=0.1584P PS=1U
+ PD=1.6U
M$3793 VSS RB \$1818 VSS nfet_03v3 L=0.28U W=0.36U AS=0.1854P AD=0.1584P
+ PS=1.75U PD=1.6U
M$3794 VSS RB \$2088 VSS nfet_03v3 L=0.28U W=0.36U AS=0.1854P AD=0.1584P
+ PS=1.75U PD=1.6U
M$3795 \$2093 RA VSS VSS nfet_03v3 L=0.28U W=0.36U AS=0.1656P AD=0.1944P
+ PS=1.64U PD=1.8U
M$3796 \$1819 RA VSS VSS nfet_03v3 L=0.28U W=0.36U AS=0.1656P AD=0.1944P
+ PS=1.64U PD=1.8U
M$3797 \$2092 RA QAb VSS nfet_03v3 L=0.28U W=0.36U AS=0.1584P AD=0.1152P
+ PS=1.6U PD=1U
M$3798 QBb RB \$2092 VSS nfet_03v3 L=0.28U W=0.36U AS=0.1152P AD=0.1584P PS=1U
+ PD=1.6U
M$3799 \$1691 RA QAb VSS nfet_03v3 L=0.28U W=0.36U AS=0.1584P AD=0.1152P
+ PS=1.6U PD=1U
M$3800 QBb RB \$1691 VSS nfet_03v3 L=0.28U W=0.36U AS=0.1152P AD=0.1584P PS=1U
+ PD=1.6U
M$3801 VSS RB \$2094 VSS nfet_03v3 L=0.28U W=0.36U AS=0.1854P AD=0.1584P
+ PS=1.75U PD=1.6U
M$3802 VSS RB \$1820 VSS nfet_03v3 L=0.28U W=0.36U AS=0.1854P AD=0.1584P
+ PS=1.75U PD=1.6U
M$3803 \$1821 RA VSS VSS nfet_03v3 L=0.28U W=0.36U AS=0.1656P AD=0.1944P
+ PS=1.64U PD=1.8U
M$3804 \$2099 RA VSS VSS nfet_03v3 L=0.28U W=0.36U AS=0.1656P AD=0.1944P
+ PS=1.64U PD=1.8U
M$3805 \$1692 RA QAb VSS nfet_03v3 L=0.28U W=0.36U AS=0.1584P AD=0.1152P
+ PS=1.6U PD=1U
M$3806 QBb RB \$1692 VSS nfet_03v3 L=0.28U W=0.36U AS=0.1152P AD=0.1584P PS=1U
+ PD=1.6U
M$3807 \$2098 RA QAb VSS nfet_03v3 L=0.28U W=0.36U AS=0.1584P AD=0.1152P
+ PS=1.6U PD=1U
M$3808 QBb RB \$2098 VSS nfet_03v3 L=0.28U W=0.36U AS=0.1152P AD=0.1584P PS=1U
+ PD=1.6U
M$3809 VSS RB \$2100 VSS nfet_03v3 L=0.28U W=0.36U AS=0.1854P AD=0.1584P
+ PS=1.75U PD=1.6U
M$3810 VSS RB \$1822 VSS nfet_03v3 L=0.28U W=0.36U AS=0.1854P AD=0.1584P
+ PS=1.75U PD=1.6U
M$3811 \$1823 RA VSS VSS nfet_03v3 L=0.28U W=0.36U AS=0.1656P AD=0.1944P
+ PS=1.64U PD=1.8U
M$3812 \$2105 RA VSS VSS nfet_03v3 L=0.28U W=0.36U AS=0.1656P AD=0.1944P
+ PS=1.64U PD=1.8U
M$3813 \$1693 RA QAb VSS nfet_03v3 L=0.28U W=0.36U AS=0.1584P AD=0.1152P
+ PS=1.6U PD=1U
M$3814 QBb RB \$1693 VSS nfet_03v3 L=0.28U W=0.36U AS=0.1152P AD=0.1584P PS=1U
+ PD=1.6U
M$3815 \$2104 RA QAb VSS nfet_03v3 L=0.28U W=0.36U AS=0.1584P AD=0.1152P
+ PS=1.6U PD=1U
M$3816 QBb RB \$2104 VSS nfet_03v3 L=0.28U W=0.36U AS=0.1152P AD=0.1584P PS=1U
+ PD=1.6U
M$3817 VSS RB \$2106 VSS nfet_03v3 L=0.28U W=0.36U AS=0.1854P AD=0.1584P
+ PS=1.75U PD=1.6U
M$3818 VSS RB \$1824 VSS nfet_03v3 L=0.28U W=0.36U AS=0.1854P AD=0.1584P
+ PS=1.75U PD=1.6U
M$3819 \$1825 RA VSS VSS nfet_03v3 L=0.28U W=0.36U AS=0.1656P AD=0.1944P
+ PS=1.64U PD=1.8U
M$3820 \$2111 RA VSS VSS nfet_03v3 L=0.28U W=0.36U AS=0.1656P AD=0.1944P
+ PS=1.64U PD=1.8U
M$3821 \$2110 RA QAb VSS nfet_03v3 L=0.28U W=0.36U AS=0.1584P AD=0.1152P
+ PS=1.6U PD=1U
M$3822 QBb RB \$2110 VSS nfet_03v3 L=0.28U W=0.36U AS=0.1152P AD=0.1584P PS=1U
+ PD=1.6U
M$3823 \$1694 RA QAb VSS nfet_03v3 L=0.28U W=0.36U AS=0.1584P AD=0.1152P
+ PS=1.6U PD=1U
M$3824 QBb RB \$1694 VSS nfet_03v3 L=0.28U W=0.36U AS=0.1152P AD=0.1584P PS=1U
+ PD=1.6U
M$3825 VSS RB \$1826 VSS nfet_03v3 L=0.28U W=0.36U AS=0.1854P AD=0.1584P
+ PS=1.75U PD=1.6U
M$3826 VSS RB \$2112 VSS nfet_03v3 L=0.28U W=0.36U AS=0.1854P AD=0.1584P
+ PS=1.75U PD=1.6U
M$3827 \$2117 RA VSS VSS nfet_03v3 L=0.28U W=0.36U AS=0.1656P AD=0.1944P
+ PS=1.64U PD=1.8U
M$3828 \$1827 RA VSS VSS nfet_03v3 L=0.28U W=0.36U AS=0.1656P AD=0.1944P
+ PS=1.64U PD=1.8U
M$3829 \$2116 RA QAb VSS nfet_03v3 L=0.28U W=0.36U AS=0.1584P AD=0.1152P
+ PS=1.6U PD=1U
M$3830 QBb RB \$2116 VSS nfet_03v3 L=0.28U W=0.36U AS=0.1152P AD=0.1584P PS=1U
+ PD=1.6U
M$3831 \$1695 RA QAb VSS nfet_03v3 L=0.28U W=0.36U AS=0.1584P AD=0.1152P
+ PS=1.6U PD=1U
M$3832 QBb RB \$1695 VSS nfet_03v3 L=0.28U W=0.36U AS=0.1152P AD=0.1584P PS=1U
+ PD=1.6U
M$3833 VSS RB \$2118 VSS nfet_03v3 L=0.28U W=0.36U AS=0.1854P AD=0.1584P
+ PS=1.75U PD=1.6U
M$3834 VSS RB \$1828 VSS nfet_03v3 L=0.28U W=0.36U AS=0.1854P AD=0.1584P
+ PS=1.75U PD=1.6U
M$3835 \$1829 RA VSS VSS nfet_03v3 L=0.28U W=0.36U AS=0.1656P AD=0.1944P
+ PS=1.64U PD=1.8U
M$3836 \$2123 RA VSS VSS nfet_03v3 L=0.28U W=0.36U AS=0.1656P AD=0.1944P
+ PS=1.64U PD=1.8U
M$3837 \$2122 RA QAb VSS nfet_03v3 L=0.28U W=0.36U AS=0.1584P AD=0.1152P
+ PS=1.6U PD=1U
M$3838 QBb RB \$2122 VSS nfet_03v3 L=0.28U W=0.36U AS=0.1152P AD=0.1584P PS=1U
+ PD=1.6U
M$3839 \$1696 RA QAb VSS nfet_03v3 L=0.28U W=0.36U AS=0.1584P AD=0.1152P
+ PS=1.6U PD=1U
M$3840 QBb RB \$1696 VSS nfet_03v3 L=0.28U W=0.36U AS=0.1152P AD=0.1584P PS=1U
+ PD=1.6U
M$3841 VSS RB \$1830 VSS nfet_03v3 L=0.28U W=0.36U AS=0.1854P AD=0.1584P
+ PS=1.75U PD=1.6U
M$3842 VSS RB \$2124 VSS nfet_03v3 L=0.28U W=0.36U AS=0.1854P AD=0.1584P
+ PS=1.75U PD=1.6U
M$3843 \$2260 WE VSS VSS nfet_03v3 L=0.28U W=0.72U AS=0.3168P AD=0.1872P
+ PS=2.32U PD=1.24U
M$3844 \$2023 CLK \$2260 VSS nfet_03v3 L=0.28U W=0.72U AS=0.1872P AD=0.3168P
+ PS=1.24U PD=2.32U
M$3845 WECLK \$2023 VSS VSS nfet_03v3 L=0.28U W=1.27U AS=0.4487P AD=0.3302P
+ PS=3.34U PD=2.31U
M$3849 \$2028 D|Q VSS VSS nfet_03v3 L=0.28U W=0.36U AS=0.1584P AD=0.1188P
+ PS=1.6U PD=1.02U
M$3850 \$2029 WECLK \$2028 VSS nfet_03v3 L=0.28U W=0.36U AS=0.1188P AD=0.1278P
+ PS=1.02U PD=1.07U
M$3851 \$2264 \$2030 \$2029 VSS nfet_03v3 L=0.28U W=0.36U AS=0.1278P AD=0.0567P
+ PS=1.07U PD=0.675U
M$3852 VSS WECLKb \$2264 VSS nfet_03v3 L=0.28U W=0.36U AS=0.0567P AD=0.1584P
+ PS=0.675U PD=1.6U
M$3853 VSS \$2029 \$2030 VSS nfet_03v3 L=0.28U W=0.36U AS=0.1584P AD=0.0972P
+ PS=1.6U PD=0.9U
M$3854 \$2031 \$2029 VSS VSS nfet_03v3 L=0.28U W=0.36U AS=0.0972P AD=0.18P
+ PS=0.9U PD=1.72U
M$3855 \$2035 D|Q VSS VSS nfet_03v3 L=0.28U W=0.36U AS=0.1584P AD=0.1188P
+ PS=1.6U PD=1.02U
M$3856 \$2036 WECLK \$2035 VSS nfet_03v3 L=0.28U W=0.36U AS=0.1188P AD=0.1278P
+ PS=1.02U PD=1.07U
M$3857 \$2271 \$2037 \$2036 VSS nfet_03v3 L=0.28U W=0.36U AS=0.1278P AD=0.0567P
+ PS=1.07U PD=0.675U
M$3858 VSS WECLKb \$2271 VSS nfet_03v3 L=0.28U W=0.36U AS=0.0567P AD=0.1584P
+ PS=0.675U PD=1.6U
M$3859 VSS \$2036 \$2037 VSS nfet_03v3 L=0.28U W=0.36U AS=0.1584P AD=0.0972P
+ PS=1.6U PD=0.9U
M$3860 \$2038 \$2036 VSS VSS nfet_03v3 L=0.28U W=0.36U AS=0.0972P AD=0.18P
+ PS=0.9U PD=1.72U
M$3861 \$2041 D|Q VSS VSS nfet_03v3 L=0.28U W=0.36U AS=0.1584P AD=0.1188P
+ PS=1.6U PD=1.02U
M$3862 \$2042 WECLK \$2041 VSS nfet_03v3 L=0.28U W=0.36U AS=0.1188P AD=0.1278P
+ PS=1.02U PD=1.07U
M$3863 \$2278 \$2043 \$2042 VSS nfet_03v3 L=0.28U W=0.36U AS=0.1278P AD=0.0567P
+ PS=1.07U PD=0.675U
M$3864 VSS WECLKb \$2278 VSS nfet_03v3 L=0.28U W=0.36U AS=0.0567P AD=0.1584P
+ PS=0.675U PD=1.6U
M$3865 VSS \$2042 \$2043 VSS nfet_03v3 L=0.28U W=0.36U AS=0.1584P AD=0.0972P
+ PS=1.6U PD=0.9U
M$3866 \$2044 \$2042 VSS VSS nfet_03v3 L=0.28U W=0.36U AS=0.0972P AD=0.18P
+ PS=0.9U PD=1.72U
M$3867 \$2047 D|Q VSS VSS nfet_03v3 L=0.28U W=0.36U AS=0.1584P AD=0.1188P
+ PS=1.6U PD=1.02U
M$3868 \$2048 WECLK \$2047 VSS nfet_03v3 L=0.28U W=0.36U AS=0.1188P AD=0.1278P
+ PS=1.02U PD=1.07U
M$3869 \$2286 \$2049 \$2048 VSS nfet_03v3 L=0.28U W=0.36U AS=0.1278P AD=0.0567P
+ PS=1.07U PD=0.675U
M$3870 VSS WECLKb \$2286 VSS nfet_03v3 L=0.28U W=0.36U AS=0.0567P AD=0.1584P
+ PS=0.675U PD=1.6U
M$3871 VSS \$2048 \$2049 VSS nfet_03v3 L=0.28U W=0.36U AS=0.1584P AD=0.0972P
+ PS=1.6U PD=0.9U
M$3872 \$2050 \$2048 VSS VSS nfet_03v3 L=0.28U W=0.36U AS=0.0972P AD=0.18P
+ PS=0.9U PD=1.72U
M$3873 \$2053 D|Q VSS VSS nfet_03v3 L=0.28U W=0.36U AS=0.1584P AD=0.1188P
+ PS=1.6U PD=1.02U
M$3874 \$2054 WECLK \$2053 VSS nfet_03v3 L=0.28U W=0.36U AS=0.1188P AD=0.1278P
+ PS=1.02U PD=1.07U
M$3875 \$2292 \$2055 \$2054 VSS nfet_03v3 L=0.28U W=0.36U AS=0.1278P AD=0.0567P
+ PS=1.07U PD=0.675U
M$3876 VSS WECLKb \$2292 VSS nfet_03v3 L=0.28U W=0.36U AS=0.0567P AD=0.1584P
+ PS=0.675U PD=1.6U
M$3877 VSS \$2054 \$2055 VSS nfet_03v3 L=0.28U W=0.36U AS=0.1584P AD=0.0972P
+ PS=1.6U PD=0.9U
M$3878 \$2056 \$2054 VSS VSS nfet_03v3 L=0.28U W=0.36U AS=0.0972P AD=0.18P
+ PS=0.9U PD=1.72U
M$3879 \$2059 D|Q VSS VSS nfet_03v3 L=0.28U W=0.36U AS=0.1584P AD=0.1188P
+ PS=1.6U PD=1.02U
M$3880 \$2060 WECLK \$2059 VSS nfet_03v3 L=0.28U W=0.36U AS=0.1188P AD=0.1278P
+ PS=1.02U PD=1.07U
M$3881 \$2299 \$2061 \$2060 VSS nfet_03v3 L=0.28U W=0.36U AS=0.1278P AD=0.0567P
+ PS=1.07U PD=0.675U
M$3882 VSS WECLKb \$2299 VSS nfet_03v3 L=0.28U W=0.36U AS=0.0567P AD=0.1584P
+ PS=0.675U PD=1.6U
M$3883 VSS \$2060 \$2061 VSS nfet_03v3 L=0.28U W=0.36U AS=0.1584P AD=0.0972P
+ PS=1.6U PD=0.9U
M$3884 \$2062 \$2060 VSS VSS nfet_03v3 L=0.28U W=0.36U AS=0.0972P AD=0.18P
+ PS=0.9U PD=1.72U
M$3885 \$2065 D|Q VSS VSS nfet_03v3 L=0.28U W=0.36U AS=0.1584P AD=0.1188P
+ PS=1.6U PD=1.02U
M$3886 \$2066 WECLK \$2065 VSS nfet_03v3 L=0.28U W=0.36U AS=0.1188P AD=0.1278P
+ PS=1.02U PD=1.07U
M$3887 \$2306 \$2067 \$2066 VSS nfet_03v3 L=0.28U W=0.36U AS=0.1278P AD=0.0567P
+ PS=1.07U PD=0.675U
M$3888 VSS WECLKb \$2306 VSS nfet_03v3 L=0.28U W=0.36U AS=0.0567P AD=0.1584P
+ PS=0.675U PD=1.6U
M$3889 VSS \$2066 \$2067 VSS nfet_03v3 L=0.28U W=0.36U AS=0.1584P AD=0.0972P
+ PS=1.6U PD=0.9U
M$3890 \$2068 \$2066 VSS VSS nfet_03v3 L=0.28U W=0.36U AS=0.0972P AD=0.18P
+ PS=0.9U PD=1.72U
M$3891 \$2071 D|Q VSS VSS nfet_03v3 L=0.28U W=0.36U AS=0.1584P AD=0.1188P
+ PS=1.6U PD=1.02U
M$3892 \$2072 WECLK \$2071 VSS nfet_03v3 L=0.28U W=0.36U AS=0.1188P AD=0.1278P
+ PS=1.02U PD=1.07U
M$3893 \$2314 \$2073 \$2072 VSS nfet_03v3 L=0.28U W=0.36U AS=0.1278P AD=0.0567P
+ PS=1.07U PD=0.675U
M$3894 VSS WECLKb \$2314 VSS nfet_03v3 L=0.28U W=0.36U AS=0.0567P AD=0.1584P
+ PS=0.675U PD=1.6U
M$3895 VSS \$2072 \$2073 VSS nfet_03v3 L=0.28U W=0.36U AS=0.1584P AD=0.0972P
+ PS=1.6U PD=0.9U
M$3896 \$2074 \$2072 VSS VSS nfet_03v3 L=0.28U W=0.36U AS=0.0972P AD=0.18P
+ PS=0.9U PD=1.72U
M$3897 \$2077 D|Q VSS VSS nfet_03v3 L=0.28U W=0.36U AS=0.1584P AD=0.1188P
+ PS=1.6U PD=1.02U
M$3898 \$2078 WECLK \$2077 VSS nfet_03v3 L=0.28U W=0.36U AS=0.1188P AD=0.1278P
+ PS=1.02U PD=1.07U
M$3899 \$2322 \$2079 \$2078 VSS nfet_03v3 L=0.28U W=0.36U AS=0.1278P AD=0.0567P
+ PS=1.07U PD=0.675U
M$3900 VSS WECLKb \$2322 VSS nfet_03v3 L=0.28U W=0.36U AS=0.0567P AD=0.1584P
+ PS=0.675U PD=1.6U
M$3901 VSS \$2078 \$2079 VSS nfet_03v3 L=0.28U W=0.36U AS=0.1584P AD=0.0972P
+ PS=1.6U PD=0.9U
M$3902 \$2080 \$2078 VSS VSS nfet_03v3 L=0.28U W=0.36U AS=0.0972P AD=0.18P
+ PS=0.9U PD=1.72U
M$3903 \$2083 D|Q VSS VSS nfet_03v3 L=0.28U W=0.36U AS=0.1584P AD=0.1188P
+ PS=1.6U PD=1.02U
M$3904 \$2084 WECLK \$2083 VSS nfet_03v3 L=0.28U W=0.36U AS=0.1188P AD=0.1278P
+ PS=1.02U PD=1.07U
M$3905 \$2328 \$2085 \$2084 VSS nfet_03v3 L=0.28U W=0.36U AS=0.1278P AD=0.0567P
+ PS=1.07U PD=0.675U
M$3906 VSS WECLKb \$2328 VSS nfet_03v3 L=0.28U W=0.36U AS=0.0567P AD=0.1584P
+ PS=0.675U PD=1.6U
M$3907 VSS \$2084 \$2085 VSS nfet_03v3 L=0.28U W=0.36U AS=0.1584P AD=0.0972P
+ PS=1.6U PD=0.9U
M$3908 \$2086 \$2084 VSS VSS nfet_03v3 L=0.28U W=0.36U AS=0.0972P AD=0.18P
+ PS=0.9U PD=1.72U
M$3909 \$2089 D|Q VSS VSS nfet_03v3 L=0.28U W=0.36U AS=0.1584P AD=0.1188P
+ PS=1.6U PD=1.02U
M$3910 \$2090 WECLK \$2089 VSS nfet_03v3 L=0.28U W=0.36U AS=0.1188P AD=0.1278P
+ PS=1.02U PD=1.07U
M$3911 \$2335 \$2091 \$2090 VSS nfet_03v3 L=0.28U W=0.36U AS=0.1278P AD=0.0567P
+ PS=1.07U PD=0.675U
M$3912 VSS WECLKb \$2335 VSS nfet_03v3 L=0.28U W=0.36U AS=0.0567P AD=0.1584P
+ PS=0.675U PD=1.6U
M$3913 VSS \$2090 \$2091 VSS nfet_03v3 L=0.28U W=0.36U AS=0.1584P AD=0.0972P
+ PS=1.6U PD=0.9U
M$3914 \$2092 \$2090 VSS VSS nfet_03v3 L=0.28U W=0.36U AS=0.0972P AD=0.18P
+ PS=0.9U PD=1.72U
M$3915 \$2095 D|Q VSS VSS nfet_03v3 L=0.28U W=0.36U AS=0.1584P AD=0.1188P
+ PS=1.6U PD=1.02U
M$3916 \$2096 WECLK \$2095 VSS nfet_03v3 L=0.28U W=0.36U AS=0.1188P AD=0.1278P
+ PS=1.02U PD=1.07U
M$3917 \$2342 \$2097 \$2096 VSS nfet_03v3 L=0.28U W=0.36U AS=0.1278P AD=0.0567P
+ PS=1.07U PD=0.675U
M$3918 VSS WECLKb \$2342 VSS nfet_03v3 L=0.28U W=0.36U AS=0.0567P AD=0.1584P
+ PS=0.675U PD=1.6U
M$3919 VSS \$2096 \$2097 VSS nfet_03v3 L=0.28U W=0.36U AS=0.1584P AD=0.0972P
+ PS=1.6U PD=0.9U
M$3920 \$2098 \$2096 VSS VSS nfet_03v3 L=0.28U W=0.36U AS=0.0972P AD=0.18P
+ PS=0.9U PD=1.72U
M$3921 \$2101 D|Q VSS VSS nfet_03v3 L=0.28U W=0.36U AS=0.1584P AD=0.1188P
+ PS=1.6U PD=1.02U
M$3922 \$2102 WECLK \$2101 VSS nfet_03v3 L=0.28U W=0.36U AS=0.1188P AD=0.1278P
+ PS=1.02U PD=1.07U
M$3923 \$2350 \$2103 \$2102 VSS nfet_03v3 L=0.28U W=0.36U AS=0.1278P AD=0.0567P
+ PS=1.07U PD=0.675U
M$3924 VSS WECLKb \$2350 VSS nfet_03v3 L=0.28U W=0.36U AS=0.0567P AD=0.1584P
+ PS=0.675U PD=1.6U
M$3925 VSS \$2102 \$2103 VSS nfet_03v3 L=0.28U W=0.36U AS=0.1584P AD=0.0972P
+ PS=1.6U PD=0.9U
M$3926 \$2104 \$2102 VSS VSS nfet_03v3 L=0.28U W=0.36U AS=0.0972P AD=0.18P
+ PS=0.9U PD=1.72U
M$3927 \$2107 D|Q VSS VSS nfet_03v3 L=0.28U W=0.36U AS=0.1584P AD=0.1188P
+ PS=1.6U PD=1.02U
M$3928 \$2108 WECLK \$2107 VSS nfet_03v3 L=0.28U W=0.36U AS=0.1188P AD=0.1278P
+ PS=1.02U PD=1.07U
M$3929 \$2357 \$2109 \$2108 VSS nfet_03v3 L=0.28U W=0.36U AS=0.1278P AD=0.0567P
+ PS=1.07U PD=0.675U
M$3930 VSS WECLKb \$2357 VSS nfet_03v3 L=0.28U W=0.36U AS=0.0567P AD=0.1584P
+ PS=0.675U PD=1.6U
M$3931 VSS \$2108 \$2109 VSS nfet_03v3 L=0.28U W=0.36U AS=0.1584P AD=0.0972P
+ PS=1.6U PD=0.9U
M$3932 \$2110 \$2108 VSS VSS nfet_03v3 L=0.28U W=0.36U AS=0.0972P AD=0.18P
+ PS=0.9U PD=1.72U
M$3933 \$2113 D|Q VSS VSS nfet_03v3 L=0.28U W=0.36U AS=0.1584P AD=0.1188P
+ PS=1.6U PD=1.02U
M$3934 \$2114 WECLK \$2113 VSS nfet_03v3 L=0.28U W=0.36U AS=0.1188P AD=0.1278P
+ PS=1.02U PD=1.07U
M$3935 \$2321 \$2115 \$2114 VSS nfet_03v3 L=0.28U W=0.36U AS=0.1278P AD=0.0567P
+ PS=1.07U PD=0.675U
M$3936 VSS WECLKb \$2321 VSS nfet_03v3 L=0.28U W=0.36U AS=0.0567P AD=0.1584P
+ PS=0.675U PD=1.6U
M$3937 VSS \$2114 \$2115 VSS nfet_03v3 L=0.28U W=0.36U AS=0.1584P AD=0.0972P
+ PS=1.6U PD=0.9U
M$3938 \$2116 \$2114 VSS VSS nfet_03v3 L=0.28U W=0.36U AS=0.0972P AD=0.18P
+ PS=0.9U PD=1.72U
M$3939 \$2119 D|Q VSS VSS nfet_03v3 L=0.28U W=0.36U AS=0.1584P AD=0.1188P
+ PS=1.6U PD=1.02U
M$3940 \$2120 WECLK \$2119 VSS nfet_03v3 L=0.28U W=0.36U AS=0.1188P AD=0.1278P
+ PS=1.02U PD=1.07U
M$3941 \$2285 \$2121 \$2120 VSS nfet_03v3 L=0.28U W=0.36U AS=0.1278P AD=0.0567P
+ PS=1.07U PD=0.675U
M$3942 VSS WECLKb \$2285 VSS nfet_03v3 L=0.28U W=0.36U AS=0.0567P AD=0.1584P
+ PS=0.675U PD=1.6U
M$3943 VSS \$2120 \$2121 VSS nfet_03v3 L=0.28U W=0.36U AS=0.1584P AD=0.0972P
+ PS=1.6U PD=0.9U
M$3944 \$2122 \$2120 VSS VSS nfet_03v3 L=0.28U W=0.36U AS=0.0972P AD=0.18P
+ PS=0.9U PD=1.72U
M$3945 \$2508 WE VSS VSS nfet_03v3 L=0.28U W=0.72U AS=0.3168P AD=0.1872P
+ PS=2.32U PD=1.24U
M$3946 \$2374 CLK \$2508 VSS nfet_03v3 L=0.28U W=0.72U AS=0.1872P AD=0.3168P
+ PS=1.24U PD=2.32U
M$3947 WECLK \$2374 VSS VSS nfet_03v3 L=0.28U W=1.27U AS=0.4445P AD=0.3344P
+ PS=3.305U PD=2.345U
M$3951 \$2377 D|Q VSS VSS nfet_03v3 L=0.28U W=0.36U AS=0.1584P AD=0.1188P
+ PS=1.6U PD=1.02U
M$3952 \$2378 WECLK \$2377 VSS nfet_03v3 L=0.28U W=0.36U AS=0.1188P AD=0.1278P
+ PS=1.02U PD=1.07U
M$3953 \$2432 \$2379 \$2378 VSS nfet_03v3 L=0.28U W=0.36U AS=0.1278P AD=0.0567P
+ PS=1.07U PD=0.675U
M$3954 VSS WECLKb \$2432 VSS nfet_03v3 L=0.28U W=0.36U AS=0.0567P AD=0.1584P
+ PS=0.675U PD=1.6U
M$3955 VSS \$2378 \$2379 VSS nfet_03v3 L=0.28U W=0.36U AS=0.1584P AD=0.0972P
+ PS=1.6U PD=0.9U
M$3956 \$2358 \$2378 VSS VSS nfet_03v3 L=0.28U W=0.36U AS=0.0972P AD=0.18P
+ PS=0.9U PD=1.72U
M$3957 \$2380 D|Q VSS VSS nfet_03v3 L=0.28U W=0.36U AS=0.1584P AD=0.1188P
+ PS=1.6U PD=1.02U
M$3958 \$2381 WECLK \$2380 VSS nfet_03v3 L=0.28U W=0.36U AS=0.1188P AD=0.1278P
+ PS=1.02U PD=1.07U
M$3959 \$2441 \$2382 \$2381 VSS nfet_03v3 L=0.28U W=0.36U AS=0.1278P AD=0.0567P
+ PS=1.07U PD=0.675U
M$3960 VSS WECLKb \$2441 VSS nfet_03v3 L=0.28U W=0.36U AS=0.0567P AD=0.1584P
+ PS=0.675U PD=1.6U
M$3961 VSS \$2381 \$2382 VSS nfet_03v3 L=0.28U W=0.36U AS=0.1584P AD=0.0972P
+ PS=1.6U PD=0.9U
M$3962 \$2359 \$2381 VSS VSS nfet_03v3 L=0.28U W=0.36U AS=0.0972P AD=0.18P
+ PS=0.9U PD=1.72U
M$3963 \$2383 D|Q VSS VSS nfet_03v3 L=0.28U W=0.36U AS=0.1584P AD=0.1188P
+ PS=1.6U PD=1.02U
M$3964 \$2384 WECLK \$2383 VSS nfet_03v3 L=0.28U W=0.36U AS=0.1188P AD=0.1278P
+ PS=1.02U PD=1.07U
M$3965 \$2450 \$2385 \$2384 VSS nfet_03v3 L=0.28U W=0.36U AS=0.1278P AD=0.0567P
+ PS=1.07U PD=0.675U
M$3966 VSS WECLKb \$2450 VSS nfet_03v3 L=0.28U W=0.36U AS=0.0567P AD=0.1584P
+ PS=0.675U PD=1.6U
M$3967 VSS \$2384 \$2385 VSS nfet_03v3 L=0.28U W=0.36U AS=0.1584P AD=0.0972P
+ PS=1.6U PD=0.9U
M$3968 \$2360 \$2384 VSS VSS nfet_03v3 L=0.28U W=0.36U AS=0.0972P AD=0.18P
+ PS=0.9U PD=1.72U
M$3969 \$2386 D|Q VSS VSS nfet_03v3 L=0.28U W=0.36U AS=0.1584P AD=0.1188P
+ PS=1.6U PD=1.02U
M$3970 \$2387 WECLK \$2386 VSS nfet_03v3 L=0.28U W=0.36U AS=0.1188P AD=0.1278P
+ PS=1.02U PD=1.07U
M$3971 \$2459 \$2388 \$2387 VSS nfet_03v3 L=0.28U W=0.36U AS=0.1278P AD=0.0567P
+ PS=1.07U PD=0.675U
M$3972 VSS WECLKb \$2459 VSS nfet_03v3 L=0.28U W=0.36U AS=0.0567P AD=0.1584P
+ PS=0.675U PD=1.6U
M$3973 VSS \$2387 \$2388 VSS nfet_03v3 L=0.28U W=0.36U AS=0.1584P AD=0.0972P
+ PS=1.6U PD=0.9U
M$3974 \$2361 \$2387 VSS VSS nfet_03v3 L=0.28U W=0.36U AS=0.0972P AD=0.18P
+ PS=0.9U PD=1.72U
M$3975 \$2389 D|Q VSS VSS nfet_03v3 L=0.28U W=0.36U AS=0.1584P AD=0.1188P
+ PS=1.6U PD=1.02U
M$3976 \$2390 WECLK \$2389 VSS nfet_03v3 L=0.28U W=0.36U AS=0.1188P AD=0.1278P
+ PS=1.02U PD=1.07U
M$3977 \$2468 \$2391 \$2390 VSS nfet_03v3 L=0.28U W=0.36U AS=0.1278P AD=0.0567P
+ PS=1.07U PD=0.675U
M$3978 VSS WECLKb \$2468 VSS nfet_03v3 L=0.28U W=0.36U AS=0.0567P AD=0.1584P
+ PS=0.675U PD=1.6U
M$3979 VSS \$2390 \$2391 VSS nfet_03v3 L=0.28U W=0.36U AS=0.1584P AD=0.0972P
+ PS=1.6U PD=0.9U
M$3980 \$2362 \$2390 VSS VSS nfet_03v3 L=0.28U W=0.36U AS=0.0972P AD=0.18P
+ PS=0.9U PD=1.72U
M$3981 \$2392 D|Q VSS VSS nfet_03v3 L=0.28U W=0.36U AS=0.1584P AD=0.1188P
+ PS=1.6U PD=1.02U
M$3982 \$2393 WECLK \$2392 VSS nfet_03v3 L=0.28U W=0.36U AS=0.1188P AD=0.1278P
+ PS=1.02U PD=1.07U
M$3983 \$2471 \$2394 \$2393 VSS nfet_03v3 L=0.28U W=0.36U AS=0.1278P AD=0.0567P
+ PS=1.07U PD=0.675U
M$3984 VSS WECLKb \$2471 VSS nfet_03v3 L=0.28U W=0.36U AS=0.0567P AD=0.1584P
+ PS=0.675U PD=1.6U
M$3985 VSS \$2393 \$2394 VSS nfet_03v3 L=0.28U W=0.36U AS=0.1584P AD=0.0972P
+ PS=1.6U PD=0.9U
M$3986 \$2363 \$2393 VSS VSS nfet_03v3 L=0.28U W=0.36U AS=0.0972P AD=0.18P
+ PS=0.9U PD=1.72U
M$3987 \$2395 D|Q VSS VSS nfet_03v3 L=0.28U W=0.36U AS=0.1584P AD=0.1188P
+ PS=1.6U PD=1.02U
M$3988 \$2396 WECLK \$2395 VSS nfet_03v3 L=0.28U W=0.36U AS=0.1188P AD=0.1278P
+ PS=1.02U PD=1.07U
M$3989 \$2465 \$2397 \$2396 VSS nfet_03v3 L=0.28U W=0.36U AS=0.1278P AD=0.0567P
+ PS=1.07U PD=0.675U
M$3990 VSS WECLKb \$2465 VSS nfet_03v3 L=0.28U W=0.36U AS=0.0567P AD=0.1584P
+ PS=0.675U PD=1.6U
M$3991 VSS \$2396 \$2397 VSS nfet_03v3 L=0.28U W=0.36U AS=0.1584P AD=0.0972P
+ PS=1.6U PD=0.9U
M$3992 \$2364 \$2396 VSS VSS nfet_03v3 L=0.28U W=0.36U AS=0.0972P AD=0.18P
+ PS=0.9U PD=1.72U
M$3993 \$2398 D|Q VSS VSS nfet_03v3 L=0.28U W=0.36U AS=0.1584P AD=0.1188P
+ PS=1.6U PD=1.02U
M$3994 \$2399 WECLK \$2398 VSS nfet_03v3 L=0.28U W=0.36U AS=0.1188P AD=0.1278P
+ PS=1.02U PD=1.07U
M$3995 \$2463 \$2400 \$2399 VSS nfet_03v3 L=0.28U W=0.36U AS=0.1278P AD=0.0567P
+ PS=1.07U PD=0.675U
M$3996 VSS WECLKb \$2463 VSS nfet_03v3 L=0.28U W=0.36U AS=0.0567P AD=0.1584P
+ PS=0.675U PD=1.6U
M$3997 VSS \$2399 \$2400 VSS nfet_03v3 L=0.28U W=0.36U AS=0.1584P AD=0.0972P
+ PS=1.6U PD=0.9U
M$3998 \$2365 \$2399 VSS VSS nfet_03v3 L=0.28U W=0.36U AS=0.0972P AD=0.18P
+ PS=0.9U PD=1.72U
M$3999 \$2401 D|Q VSS VSS nfet_03v3 L=0.28U W=0.36U AS=0.1584P AD=0.1188P
+ PS=1.6U PD=1.02U
M$4000 \$2402 WECLK \$2401 VSS nfet_03v3 L=0.28U W=0.36U AS=0.1188P AD=0.1278P
+ PS=1.02U PD=1.07U
M$4001 \$2457 \$2403 \$2402 VSS nfet_03v3 L=0.28U W=0.36U AS=0.1278P AD=0.0567P
+ PS=1.07U PD=0.675U
M$4002 VSS WECLKb \$2457 VSS nfet_03v3 L=0.28U W=0.36U AS=0.0567P AD=0.1584P
+ PS=0.675U PD=1.6U
M$4003 VSS \$2402 \$2403 VSS nfet_03v3 L=0.28U W=0.36U AS=0.1584P AD=0.0972P
+ PS=1.6U PD=0.9U
M$4004 \$2366 \$2402 VSS VSS nfet_03v3 L=0.28U W=0.36U AS=0.0972P AD=0.18P
+ PS=0.9U PD=1.72U
M$4005 \$2404 D|Q VSS VSS nfet_03v3 L=0.28U W=0.36U AS=0.1584P AD=0.1188P
+ PS=1.6U PD=1.02U
M$4006 \$2405 WECLK \$2404 VSS nfet_03v3 L=0.28U W=0.36U AS=0.1188P AD=0.1278P
+ PS=1.02U PD=1.07U
M$4007 \$2454 \$2406 \$2405 VSS nfet_03v3 L=0.28U W=0.36U AS=0.1278P AD=0.0567P
+ PS=1.07U PD=0.675U
M$4008 VSS WECLKb \$2454 VSS nfet_03v3 L=0.28U W=0.36U AS=0.0567P AD=0.1584P
+ PS=0.675U PD=1.6U
M$4009 VSS \$2405 \$2406 VSS nfet_03v3 L=0.28U W=0.36U AS=0.1584P AD=0.0972P
+ PS=1.6U PD=0.9U
M$4010 \$2367 \$2405 VSS VSS nfet_03v3 L=0.28U W=0.36U AS=0.0972P AD=0.18P
+ PS=0.9U PD=1.72U
M$4011 \$2407 D|Q VSS VSS nfet_03v3 L=0.28U W=0.36U AS=0.1584P AD=0.1188P
+ PS=1.6U PD=1.02U
M$4012 \$2408 WECLK \$2407 VSS nfet_03v3 L=0.28U W=0.36U AS=0.1188P AD=0.1278P
+ PS=1.02U PD=1.07U
M$4013 \$2448 \$2409 \$2408 VSS nfet_03v3 L=0.28U W=0.36U AS=0.1278P AD=0.0567P
+ PS=1.07U PD=0.675U
M$4014 VSS WECLKb \$2448 VSS nfet_03v3 L=0.28U W=0.36U AS=0.0567P AD=0.1584P
+ PS=0.675U PD=1.6U
M$4015 VSS \$2408 \$2409 VSS nfet_03v3 L=0.28U W=0.36U AS=0.1584P AD=0.0972P
+ PS=1.6U PD=0.9U
M$4016 \$2368 \$2408 VSS VSS nfet_03v3 L=0.28U W=0.36U AS=0.0972P AD=0.18P
+ PS=0.9U PD=1.72U
M$4017 \$2410 D|Q VSS VSS nfet_03v3 L=0.28U W=0.36U AS=0.1584P AD=0.1188P
+ PS=1.6U PD=1.02U
M$4018 \$2411 WECLK \$2410 VSS nfet_03v3 L=0.28U W=0.36U AS=0.1188P AD=0.1278P
+ PS=1.02U PD=1.07U
M$4019 \$2445 \$2412 \$2411 VSS nfet_03v3 L=0.28U W=0.36U AS=0.1278P AD=0.0567P
+ PS=1.07U PD=0.675U
M$4020 VSS WECLKb \$2445 VSS nfet_03v3 L=0.28U W=0.36U AS=0.0567P AD=0.1584P
+ PS=0.675U PD=1.6U
M$4021 VSS \$2411 \$2412 VSS nfet_03v3 L=0.28U W=0.36U AS=0.1584P AD=0.0972P
+ PS=1.6U PD=0.9U
M$4022 \$2369 \$2411 VSS VSS nfet_03v3 L=0.28U W=0.36U AS=0.0972P AD=0.18P
+ PS=0.9U PD=1.72U
M$4023 \$2413 D|Q VSS VSS nfet_03v3 L=0.28U W=0.36U AS=0.1584P AD=0.1188P
+ PS=1.6U PD=1.02U
M$4024 \$2414 WECLK \$2413 VSS nfet_03v3 L=0.28U W=0.36U AS=0.1188P AD=0.1278P
+ PS=1.02U PD=1.07U
M$4025 \$2439 \$2415 \$2414 VSS nfet_03v3 L=0.28U W=0.36U AS=0.1278P AD=0.0567P
+ PS=1.07U PD=0.675U
M$4026 VSS WECLKb \$2439 VSS nfet_03v3 L=0.28U W=0.36U AS=0.0567P AD=0.1584P
+ PS=0.675U PD=1.6U
M$4027 VSS \$2414 \$2415 VSS nfet_03v3 L=0.28U W=0.36U AS=0.1584P AD=0.0972P
+ PS=1.6U PD=0.9U
M$4028 \$2370 \$2414 VSS VSS nfet_03v3 L=0.28U W=0.36U AS=0.0972P AD=0.18P
+ PS=0.9U PD=1.72U
M$4029 \$2416 D|Q VSS VSS nfet_03v3 L=0.28U W=0.36U AS=0.1584P AD=0.1188P
+ PS=1.6U PD=1.02U
M$4030 \$2417 WECLK \$2416 VSS nfet_03v3 L=0.28U W=0.36U AS=0.1188P AD=0.1278P
+ PS=1.02U PD=1.07U
M$4031 \$2436 \$2418 \$2417 VSS nfet_03v3 L=0.28U W=0.36U AS=0.1278P AD=0.0567P
+ PS=1.07U PD=0.675U
M$4032 VSS WECLKb \$2436 VSS nfet_03v3 L=0.28U W=0.36U AS=0.0567P AD=0.1584P
+ PS=0.675U PD=1.6U
M$4033 VSS \$2417 \$2418 VSS nfet_03v3 L=0.28U W=0.36U AS=0.1584P AD=0.0972P
+ PS=1.6U PD=0.9U
M$4034 \$2371 \$2417 VSS VSS nfet_03v3 L=0.28U W=0.36U AS=0.0972P AD=0.18P
+ PS=0.9U PD=1.72U
M$4035 \$2419 D|Q VSS VSS nfet_03v3 L=0.28U W=0.36U AS=0.1584P AD=0.1188P
+ PS=1.6U PD=1.02U
M$4036 \$2420 WECLK \$2419 VSS nfet_03v3 L=0.28U W=0.36U AS=0.1188P AD=0.1278P
+ PS=1.02U PD=1.07U
M$4037 \$2429 \$2421 \$2420 VSS nfet_03v3 L=0.28U W=0.36U AS=0.1278P AD=0.0567P
+ PS=1.07U PD=0.675U
M$4038 VSS WECLKb \$2429 VSS nfet_03v3 L=0.28U W=0.36U AS=0.0567P AD=0.1584P
+ PS=0.675U PD=1.6U
M$4039 VSS \$2420 \$2421 VSS nfet_03v3 L=0.28U W=0.36U AS=0.1584P AD=0.0972P
+ PS=1.6U PD=0.9U
M$4040 \$2372 \$2420 VSS VSS nfet_03v3 L=0.28U W=0.36U AS=0.0972P AD=0.18P
+ PS=0.9U PD=1.72U
M$4041 \$2422 D|Q VSS VSS nfet_03v3 L=0.28U W=0.36U AS=0.1584P AD=0.1188P
+ PS=1.6U PD=1.02U
M$4042 \$2423 WECLK \$2422 VSS nfet_03v3 L=0.28U W=0.36U AS=0.1188P AD=0.1278P
+ PS=1.02U PD=1.07U
M$4043 \$2426 \$2424 \$2423 VSS nfet_03v3 L=0.28U W=0.36U AS=0.1278P AD=0.0567P
+ PS=1.07U PD=0.675U
M$4044 VSS WECLKb \$2426 VSS nfet_03v3 L=0.28U W=0.36U AS=0.0567P AD=0.1584P
+ PS=0.675U PD=1.6U
M$4045 VSS \$2423 \$2424 VSS nfet_03v3 L=0.28U W=0.36U AS=0.1584P AD=0.0972P
+ PS=1.6U PD=0.9U
M$4046 \$2373 \$2423 VSS VSS nfet_03v3 L=0.28U W=0.36U AS=0.0972P AD=0.18P
+ PS=0.9U PD=1.72U
M$4047 \$2709 RA VSS VSS nfet_03v3 L=0.28U W=0.36U AS=0.1656P AD=0.1944P
+ PS=1.64U PD=1.8U
M$4048 \$2476 RA VSS VSS nfet_03v3 L=0.28U W=0.36U AS=0.1656P AD=0.1944P
+ PS=1.64U PD=1.8U
M$4049 \$2708 RA QAb VSS nfet_03v3 L=0.28U W=0.36U AS=0.1584P AD=0.1152P
+ PS=1.6U PD=1U
M$4050 QBb RB \$2708 VSS nfet_03v3 L=0.28U W=0.36U AS=0.1152P AD=0.1584P PS=1U
+ PD=1.6U
M$4051 \$2358 RA QAb VSS nfet_03v3 L=0.28U W=0.36U AS=0.1584P AD=0.1152P
+ PS=1.6U PD=1U
M$4052 QBb RB \$2358 VSS nfet_03v3 L=0.28U W=0.36U AS=0.1152P AD=0.1584P PS=1U
+ PD=1.6U
M$4053 VSS RB \$2477 VSS nfet_03v3 L=0.28U W=0.36U AS=0.1854P AD=0.1584P
+ PS=1.75U PD=1.6U
M$4054 VSS RB \$2710 VSS nfet_03v3 L=0.28U W=0.36U AS=0.1854P AD=0.1584P
+ PS=1.75U PD=1.6U
M$4055 \$2478 RA VSS VSS nfet_03v3 L=0.28U W=0.36U AS=0.1656P AD=0.1944P
+ PS=1.64U PD=1.8U
M$4056 \$2716 RA VSS VSS nfet_03v3 L=0.28U W=0.36U AS=0.1656P AD=0.1944P
+ PS=1.64U PD=1.8U
M$4057 \$2715 RA QAb VSS nfet_03v3 L=0.28U W=0.36U AS=0.1584P AD=0.1152P
+ PS=1.6U PD=1U
M$4058 QBb RB \$2715 VSS nfet_03v3 L=0.28U W=0.36U AS=0.1152P AD=0.1584P PS=1U
+ PD=1.6U
M$4059 \$2359 RA QAb VSS nfet_03v3 L=0.28U W=0.36U AS=0.1584P AD=0.1152P
+ PS=1.6U PD=1U
M$4060 QBb RB \$2359 VSS nfet_03v3 L=0.28U W=0.36U AS=0.1152P AD=0.1584P PS=1U
+ PD=1.6U
M$4061 VSS RB \$2479 VSS nfet_03v3 L=0.28U W=0.36U AS=0.1854P AD=0.1584P
+ PS=1.75U PD=1.6U
M$4062 VSS RB \$2717 VSS nfet_03v3 L=0.28U W=0.36U AS=0.1854P AD=0.1584P
+ PS=1.75U PD=1.6U
M$4063 \$2480 RA VSS VSS nfet_03v3 L=0.28U W=0.36U AS=0.1656P AD=0.1944P
+ PS=1.64U PD=1.8U
M$4064 \$2722 RA VSS VSS nfet_03v3 L=0.28U W=0.36U AS=0.1656P AD=0.1944P
+ PS=1.64U PD=1.8U
M$4065 \$2721 RA QAb VSS nfet_03v3 L=0.28U W=0.36U AS=0.1584P AD=0.1152P
+ PS=1.6U PD=1U
M$4066 QBb RB \$2721 VSS nfet_03v3 L=0.28U W=0.36U AS=0.1152P AD=0.1584P PS=1U
+ PD=1.6U
M$4067 \$2360 RA QAb VSS nfet_03v3 L=0.28U W=0.36U AS=0.1584P AD=0.1152P
+ PS=1.6U PD=1U
M$4068 QBb RB \$2360 VSS nfet_03v3 L=0.28U W=0.36U AS=0.1152P AD=0.1584P PS=1U
+ PD=1.6U
M$4069 VSS RB \$2481 VSS nfet_03v3 L=0.28U W=0.36U AS=0.1854P AD=0.1584P
+ PS=1.75U PD=1.6U
M$4070 VSS RB \$2723 VSS nfet_03v3 L=0.28U W=0.36U AS=0.1854P AD=0.1584P
+ PS=1.75U PD=1.6U
M$4071 \$2482 RA VSS VSS nfet_03v3 L=0.28U W=0.36U AS=0.1656P AD=0.1944P
+ PS=1.64U PD=1.8U
M$4072 \$2728 RA VSS VSS nfet_03v3 L=0.28U W=0.36U AS=0.1656P AD=0.1944P
+ PS=1.64U PD=1.8U
M$4073 \$2727 RA QAb VSS nfet_03v3 L=0.28U W=0.36U AS=0.1584P AD=0.1152P
+ PS=1.6U PD=1U
M$4074 QBb RB \$2727 VSS nfet_03v3 L=0.28U W=0.36U AS=0.1152P AD=0.1584P PS=1U
+ PD=1.6U
M$4075 \$2361 RA QAb VSS nfet_03v3 L=0.28U W=0.36U AS=0.1584P AD=0.1152P
+ PS=1.6U PD=1U
M$4076 QBb RB \$2361 VSS nfet_03v3 L=0.28U W=0.36U AS=0.1152P AD=0.1584P PS=1U
+ PD=1.6U
M$4077 VSS RB \$2483 VSS nfet_03v3 L=0.28U W=0.36U AS=0.1854P AD=0.1584P
+ PS=1.75U PD=1.6U
M$4078 VSS RB \$2729 VSS nfet_03v3 L=0.28U W=0.36U AS=0.1854P AD=0.1584P
+ PS=1.75U PD=1.6U
M$4079 \$2484 RA VSS VSS nfet_03v3 L=0.28U W=0.36U AS=0.1656P AD=0.1944P
+ PS=1.64U PD=1.8U
M$4080 \$2734 RA VSS VSS nfet_03v3 L=0.28U W=0.36U AS=0.1656P AD=0.1944P
+ PS=1.64U PD=1.8U
M$4081 \$2733 RA QAb VSS nfet_03v3 L=0.28U W=0.36U AS=0.1584P AD=0.1152P
+ PS=1.6U PD=1U
M$4082 QBb RB \$2733 VSS nfet_03v3 L=0.28U W=0.36U AS=0.1152P AD=0.1584P PS=1U
+ PD=1.6U
M$4083 \$2362 RA QAb VSS nfet_03v3 L=0.28U W=0.36U AS=0.1584P AD=0.1152P
+ PS=1.6U PD=1U
M$4084 QBb RB \$2362 VSS nfet_03v3 L=0.28U W=0.36U AS=0.1152P AD=0.1584P PS=1U
+ PD=1.6U
M$4085 VSS RB \$2735 VSS nfet_03v3 L=0.28U W=0.36U AS=0.1854P AD=0.1584P
+ PS=1.75U PD=1.6U
M$4086 VSS RB \$2485 VSS nfet_03v3 L=0.28U W=0.36U AS=0.1854P AD=0.1584P
+ PS=1.75U PD=1.6U
M$4087 \$2740 RA VSS VSS nfet_03v3 L=0.28U W=0.36U AS=0.1656P AD=0.1944P
+ PS=1.64U PD=1.8U
M$4088 \$2486 RA VSS VSS nfet_03v3 L=0.28U W=0.36U AS=0.1656P AD=0.1944P
+ PS=1.64U PD=1.8U
M$4089 \$2739 RA QAb VSS nfet_03v3 L=0.28U W=0.36U AS=0.1584P AD=0.1152P
+ PS=1.6U PD=1U
M$4090 QBb RB \$2739 VSS nfet_03v3 L=0.28U W=0.36U AS=0.1152P AD=0.1584P PS=1U
+ PD=1.6U
M$4091 \$2363 RA QAb VSS nfet_03v3 L=0.28U W=0.36U AS=0.1584P AD=0.1152P
+ PS=1.6U PD=1U
M$4092 QBb RB \$2363 VSS nfet_03v3 L=0.28U W=0.36U AS=0.1152P AD=0.1584P PS=1U
+ PD=1.6U
M$4093 VSS RB \$2487 VSS nfet_03v3 L=0.28U W=0.36U AS=0.1854P AD=0.1584P
+ PS=1.75U PD=1.6U
M$4094 VSS RB \$2741 VSS nfet_03v3 L=0.28U W=0.36U AS=0.1854P AD=0.1584P
+ PS=1.75U PD=1.6U
M$4095 \$2488 RA VSS VSS nfet_03v3 L=0.28U W=0.36U AS=0.1656P AD=0.1944P
+ PS=1.64U PD=1.8U
M$4096 \$2746 RA VSS VSS nfet_03v3 L=0.28U W=0.36U AS=0.1656P AD=0.1944P
+ PS=1.64U PD=1.8U
M$4097 \$2745 RA QAb VSS nfet_03v3 L=0.28U W=0.36U AS=0.1584P AD=0.1152P
+ PS=1.6U PD=1U
M$4098 QBb RB \$2745 VSS nfet_03v3 L=0.28U W=0.36U AS=0.1152P AD=0.1584P PS=1U
+ PD=1.6U
M$4099 \$2364 RA QAb VSS nfet_03v3 L=0.28U W=0.36U AS=0.1584P AD=0.1152P
+ PS=1.6U PD=1U
M$4100 QBb RB \$2364 VSS nfet_03v3 L=0.28U W=0.36U AS=0.1152P AD=0.1584P PS=1U
+ PD=1.6U
M$4101 VSS RB \$2747 VSS nfet_03v3 L=0.28U W=0.36U AS=0.1854P AD=0.1584P
+ PS=1.75U PD=1.6U
M$4102 VSS RB \$2489 VSS nfet_03v3 L=0.28U W=0.36U AS=0.1854P AD=0.1584P
+ PS=1.75U PD=1.6U
M$4103 \$2490 RA VSS VSS nfet_03v3 L=0.28U W=0.36U AS=0.1656P AD=0.1944P
+ PS=1.64U PD=1.8U
M$4104 \$2752 RA VSS VSS nfet_03v3 L=0.28U W=0.36U AS=0.1656P AD=0.1944P
+ PS=1.64U PD=1.8U
M$4105 \$2751 RA QAb VSS nfet_03v3 L=0.28U W=0.36U AS=0.1584P AD=0.1152P
+ PS=1.6U PD=1U
M$4106 QBb RB \$2751 VSS nfet_03v3 L=0.28U W=0.36U AS=0.1152P AD=0.1584P PS=1U
+ PD=1.6U
M$4107 \$2365 RA QAb VSS nfet_03v3 L=0.28U W=0.36U AS=0.1584P AD=0.1152P
+ PS=1.6U PD=1U
M$4108 QBb RB \$2365 VSS nfet_03v3 L=0.28U W=0.36U AS=0.1152P AD=0.1584P PS=1U
+ PD=1.6U
M$4109 VSS RB \$2491 VSS nfet_03v3 L=0.28U W=0.36U AS=0.1854P AD=0.1584P
+ PS=1.75U PD=1.6U
M$4110 VSS RB \$2753 VSS nfet_03v3 L=0.28U W=0.36U AS=0.1854P AD=0.1584P
+ PS=1.75U PD=1.6U
M$4111 \$2758 RA VSS VSS nfet_03v3 L=0.28U W=0.36U AS=0.1656P AD=0.1944P
+ PS=1.64U PD=1.8U
M$4112 \$2492 RA VSS VSS nfet_03v3 L=0.28U W=0.36U AS=0.1656P AD=0.1944P
+ PS=1.64U PD=1.8U
M$4113 \$2757 RA QAb VSS nfet_03v3 L=0.28U W=0.36U AS=0.1584P AD=0.1152P
+ PS=1.6U PD=1U
M$4114 QBb RB \$2757 VSS nfet_03v3 L=0.28U W=0.36U AS=0.1152P AD=0.1584P PS=1U
+ PD=1.6U
M$4115 \$2366 RA QAb VSS nfet_03v3 L=0.28U W=0.36U AS=0.1584P AD=0.1152P
+ PS=1.6U PD=1U
M$4116 QBb RB \$2366 VSS nfet_03v3 L=0.28U W=0.36U AS=0.1152P AD=0.1584P PS=1U
+ PD=1.6U
M$4117 VSS RB \$2759 VSS nfet_03v3 L=0.28U W=0.36U AS=0.1854P AD=0.1584P
+ PS=1.75U PD=1.6U
M$4118 VSS RB \$2493 VSS nfet_03v3 L=0.28U W=0.36U AS=0.1854P AD=0.1584P
+ PS=1.75U PD=1.6U
M$4119 \$2764 RA VSS VSS nfet_03v3 L=0.28U W=0.36U AS=0.1656P AD=0.1944P
+ PS=1.64U PD=1.8U
M$4120 \$2494 RA VSS VSS nfet_03v3 L=0.28U W=0.36U AS=0.1656P AD=0.1944P
+ PS=1.64U PD=1.8U
M$4121 \$2763 RA QAb VSS nfet_03v3 L=0.28U W=0.36U AS=0.1584P AD=0.1152P
+ PS=1.6U PD=1U
M$4122 QBb RB \$2763 VSS nfet_03v3 L=0.28U W=0.36U AS=0.1152P AD=0.1584P PS=1U
+ PD=1.6U
M$4123 \$2367 RA QAb VSS nfet_03v3 L=0.28U W=0.36U AS=0.1584P AD=0.1152P
+ PS=1.6U PD=1U
M$4124 QBb RB \$2367 VSS nfet_03v3 L=0.28U W=0.36U AS=0.1152P AD=0.1584P PS=1U
+ PD=1.6U
M$4125 VSS RB \$2495 VSS nfet_03v3 L=0.28U W=0.36U AS=0.1854P AD=0.1584P
+ PS=1.75U PD=1.6U
M$4126 VSS RB \$2765 VSS nfet_03v3 L=0.28U W=0.36U AS=0.1854P AD=0.1584P
+ PS=1.75U PD=1.6U
M$4127 \$2770 RA VSS VSS nfet_03v3 L=0.28U W=0.36U AS=0.1656P AD=0.1944P
+ PS=1.64U PD=1.8U
M$4128 \$2496 RA VSS VSS nfet_03v3 L=0.28U W=0.36U AS=0.1656P AD=0.1944P
+ PS=1.64U PD=1.8U
M$4129 \$2368 RA QAb VSS nfet_03v3 L=0.28U W=0.36U AS=0.1584P AD=0.1152P
+ PS=1.6U PD=1U
M$4130 QBb RB \$2368 VSS nfet_03v3 L=0.28U W=0.36U AS=0.1152P AD=0.1584P PS=1U
+ PD=1.6U
M$4131 \$2769 RA QAb VSS nfet_03v3 L=0.28U W=0.36U AS=0.1584P AD=0.1152P
+ PS=1.6U PD=1U
M$4132 QBb RB \$2769 VSS nfet_03v3 L=0.28U W=0.36U AS=0.1152P AD=0.1584P PS=1U
+ PD=1.6U
M$4133 VSS RB \$2497 VSS nfet_03v3 L=0.28U W=0.36U AS=0.1854P AD=0.1584P
+ PS=1.75U PD=1.6U
M$4134 VSS RB \$2771 VSS nfet_03v3 L=0.28U W=0.36U AS=0.1854P AD=0.1584P
+ PS=1.75U PD=1.6U
M$4135 \$2776 RA VSS VSS nfet_03v3 L=0.28U W=0.36U AS=0.1656P AD=0.1944P
+ PS=1.64U PD=1.8U
M$4136 \$2498 RA VSS VSS nfet_03v3 L=0.28U W=0.36U AS=0.1656P AD=0.1944P
+ PS=1.64U PD=1.8U
M$4137 \$2369 RA QAb VSS nfet_03v3 L=0.28U W=0.36U AS=0.1584P AD=0.1152P
+ PS=1.6U PD=1U
M$4138 QBb RB \$2369 VSS nfet_03v3 L=0.28U W=0.36U AS=0.1152P AD=0.1584P PS=1U
+ PD=1.6U
M$4139 \$2775 RA QAb VSS nfet_03v3 L=0.28U W=0.36U AS=0.1584P AD=0.1152P
+ PS=1.6U PD=1U
M$4140 QBb RB \$2775 VSS nfet_03v3 L=0.28U W=0.36U AS=0.1152P AD=0.1584P PS=1U
+ PD=1.6U
M$4141 VSS RB \$2777 VSS nfet_03v3 L=0.28U W=0.36U AS=0.1854P AD=0.1584P
+ PS=1.75U PD=1.6U
M$4142 VSS RB \$2499 VSS nfet_03v3 L=0.28U W=0.36U AS=0.1854P AD=0.1584P
+ PS=1.75U PD=1.6U
M$4143 \$2500 RA VSS VSS nfet_03v3 L=0.28U W=0.36U AS=0.1656P AD=0.1944P
+ PS=1.64U PD=1.8U
M$4144 \$2782 RA VSS VSS nfet_03v3 L=0.28U W=0.36U AS=0.1656P AD=0.1944P
+ PS=1.64U PD=1.8U
M$4145 \$2370 RA QAb VSS nfet_03v3 L=0.28U W=0.36U AS=0.1584P AD=0.1152P
+ PS=1.6U PD=1U
M$4146 QBb RB \$2370 VSS nfet_03v3 L=0.28U W=0.36U AS=0.1152P AD=0.1584P PS=1U
+ PD=1.6U
M$4147 \$2781 RA QAb VSS nfet_03v3 L=0.28U W=0.36U AS=0.1584P AD=0.1152P
+ PS=1.6U PD=1U
M$4148 QBb RB \$2781 VSS nfet_03v3 L=0.28U W=0.36U AS=0.1152P AD=0.1584P PS=1U
+ PD=1.6U
M$4149 VSS RB \$2783 VSS nfet_03v3 L=0.28U W=0.36U AS=0.1854P AD=0.1584P
+ PS=1.75U PD=1.6U
M$4150 VSS RB \$2501 VSS nfet_03v3 L=0.28U W=0.36U AS=0.1854P AD=0.1584P
+ PS=1.75U PD=1.6U
M$4151 \$2502 RA VSS VSS nfet_03v3 L=0.28U W=0.36U AS=0.1656P AD=0.1944P
+ PS=1.64U PD=1.8U
M$4152 \$2788 RA VSS VSS nfet_03v3 L=0.28U W=0.36U AS=0.1656P AD=0.1944P
+ PS=1.64U PD=1.8U
M$4153 \$2787 RA QAb VSS nfet_03v3 L=0.28U W=0.36U AS=0.1584P AD=0.1152P
+ PS=1.6U PD=1U
M$4154 QBb RB \$2787 VSS nfet_03v3 L=0.28U W=0.36U AS=0.1152P AD=0.1584P PS=1U
+ PD=1.6U
M$4155 \$2371 RA QAb VSS nfet_03v3 L=0.28U W=0.36U AS=0.1584P AD=0.1152P
+ PS=1.6U PD=1U
M$4156 QBb RB \$2371 VSS nfet_03v3 L=0.28U W=0.36U AS=0.1152P AD=0.1584P PS=1U
+ PD=1.6U
M$4157 VSS RB \$2789 VSS nfet_03v3 L=0.28U W=0.36U AS=0.1854P AD=0.1584P
+ PS=1.75U PD=1.6U
M$4158 VSS RB \$2503 VSS nfet_03v3 L=0.28U W=0.36U AS=0.1854P AD=0.1584P
+ PS=1.75U PD=1.6U
M$4159 \$2794 RA VSS VSS nfet_03v3 L=0.28U W=0.36U AS=0.1656P AD=0.1944P
+ PS=1.64U PD=1.8U
M$4160 \$2504 RA VSS VSS nfet_03v3 L=0.28U W=0.36U AS=0.1656P AD=0.1944P
+ PS=1.64U PD=1.8U
M$4161 \$2372 RA QAb VSS nfet_03v3 L=0.28U W=0.36U AS=0.1584P AD=0.1152P
+ PS=1.6U PD=1U
M$4162 QBb RB \$2372 VSS nfet_03v3 L=0.28U W=0.36U AS=0.1152P AD=0.1584P PS=1U
+ PD=1.6U
M$4163 \$2793 RA QAb VSS nfet_03v3 L=0.28U W=0.36U AS=0.1584P AD=0.1152P
+ PS=1.6U PD=1U
M$4164 QBb RB \$2793 VSS nfet_03v3 L=0.28U W=0.36U AS=0.1152P AD=0.1584P PS=1U
+ PD=1.6U
M$4165 VSS RB \$2795 VSS nfet_03v3 L=0.28U W=0.36U AS=0.1854P AD=0.1584P
+ PS=1.75U PD=1.6U
M$4166 VSS RB \$2505 VSS nfet_03v3 L=0.28U W=0.36U AS=0.1854P AD=0.1584P
+ PS=1.75U PD=1.6U
M$4167 \$2800 RA VSS VSS nfet_03v3 L=0.28U W=0.36U AS=0.1656P AD=0.1944P
+ PS=1.64U PD=1.8U
M$4168 \$2506 RA VSS VSS nfet_03v3 L=0.28U W=0.36U AS=0.1656P AD=0.1944P
+ PS=1.64U PD=1.8U
M$4169 \$2799 RA QAb VSS nfet_03v3 L=0.28U W=0.36U AS=0.1584P AD=0.1152P
+ PS=1.6U PD=1U
M$4170 QBb RB \$2799 VSS nfet_03v3 L=0.28U W=0.36U AS=0.1152P AD=0.1584P PS=1U
+ PD=1.6U
M$4171 \$2373 RA QAb VSS nfet_03v3 L=0.28U W=0.36U AS=0.1584P AD=0.1152P
+ PS=1.6U PD=1U
M$4172 QBb RB \$2373 VSS nfet_03v3 L=0.28U W=0.36U AS=0.1152P AD=0.1584P PS=1U
+ PD=1.6U
M$4173 VSS RB \$2801 VSS nfet_03v3 L=0.28U W=0.36U AS=0.1854P AD=0.1584P
+ PS=1.75U PD=1.6U
M$4174 VSS RB \$2507 VSS nfet_03v3 L=0.28U W=0.36U AS=0.1854P AD=0.1584P
+ PS=1.75U PD=1.6U
M$4175 \$2937 WE VSS VSS nfet_03v3 L=0.28U W=0.72U AS=0.3168P AD=0.1872P
+ PS=2.32U PD=1.24U
M$4176 \$2700 CLK \$2937 VSS nfet_03v3 L=0.28U W=0.72U AS=0.1872P AD=0.3168P
+ PS=1.24U PD=2.32U
M$4177 WECLK \$2700 VSS VSS nfet_03v3 L=0.28U W=1.27U AS=0.4487P AD=0.3302P
+ PS=3.34U PD=2.31U
M$4181 \$2705 D|Q VSS VSS nfet_03v3 L=0.28U W=0.36U AS=0.1584P AD=0.1188P
+ PS=1.6U PD=1.02U
M$4182 \$2706 WECLK \$2705 VSS nfet_03v3 L=0.28U W=0.36U AS=0.1188P AD=0.1278P
+ PS=1.02U PD=1.07U
M$4183 \$2941 \$2707 \$2706 VSS nfet_03v3 L=0.28U W=0.36U AS=0.1278P AD=0.0567P
+ PS=1.07U PD=0.675U
M$4184 VSS WECLKb \$2941 VSS nfet_03v3 L=0.28U W=0.36U AS=0.0567P AD=0.1584P
+ PS=0.675U PD=1.6U
M$4185 VSS \$2706 \$2707 VSS nfet_03v3 L=0.28U W=0.36U AS=0.1584P AD=0.0972P
+ PS=1.6U PD=0.9U
M$4186 \$2708 \$2706 VSS VSS nfet_03v3 L=0.28U W=0.36U AS=0.0972P AD=0.18P
+ PS=0.9U PD=1.72U
M$4187 \$2712 D|Q VSS VSS nfet_03v3 L=0.28U W=0.36U AS=0.1584P AD=0.1188P
+ PS=1.6U PD=1.02U
M$4188 \$2713 WECLK \$2712 VSS nfet_03v3 L=0.28U W=0.36U AS=0.1188P AD=0.1278P
+ PS=1.02U PD=1.07U
M$4189 \$2948 \$2714 \$2713 VSS nfet_03v3 L=0.28U W=0.36U AS=0.1278P AD=0.0567P
+ PS=1.07U PD=0.675U
M$4190 VSS WECLKb \$2948 VSS nfet_03v3 L=0.28U W=0.36U AS=0.0567P AD=0.1584P
+ PS=0.675U PD=1.6U
M$4191 VSS \$2713 \$2714 VSS nfet_03v3 L=0.28U W=0.36U AS=0.1584P AD=0.0972P
+ PS=1.6U PD=0.9U
M$4192 \$2715 \$2713 VSS VSS nfet_03v3 L=0.28U W=0.36U AS=0.0972P AD=0.18P
+ PS=0.9U PD=1.72U
M$4193 \$2718 D|Q VSS VSS nfet_03v3 L=0.28U W=0.36U AS=0.1584P AD=0.1188P
+ PS=1.6U PD=1.02U
M$4194 \$2719 WECLK \$2718 VSS nfet_03v3 L=0.28U W=0.36U AS=0.1188P AD=0.1278P
+ PS=1.02U PD=1.07U
M$4195 \$2955 \$2720 \$2719 VSS nfet_03v3 L=0.28U W=0.36U AS=0.1278P AD=0.0567P
+ PS=1.07U PD=0.675U
M$4196 VSS WECLKb \$2955 VSS nfet_03v3 L=0.28U W=0.36U AS=0.0567P AD=0.1584P
+ PS=0.675U PD=1.6U
M$4197 VSS \$2719 \$2720 VSS nfet_03v3 L=0.28U W=0.36U AS=0.1584P AD=0.0972P
+ PS=1.6U PD=0.9U
M$4198 \$2721 \$2719 VSS VSS nfet_03v3 L=0.28U W=0.36U AS=0.0972P AD=0.18P
+ PS=0.9U PD=1.72U
M$4199 \$2724 D|Q VSS VSS nfet_03v3 L=0.28U W=0.36U AS=0.1584P AD=0.1188P
+ PS=1.6U PD=1.02U
M$4200 \$2725 WECLK \$2724 VSS nfet_03v3 L=0.28U W=0.36U AS=0.1188P AD=0.1278P
+ PS=1.02U PD=1.07U
M$4201 \$2963 \$2726 \$2725 VSS nfet_03v3 L=0.28U W=0.36U AS=0.1278P AD=0.0567P
+ PS=1.07U PD=0.675U
M$4202 VSS WECLKb \$2963 VSS nfet_03v3 L=0.28U W=0.36U AS=0.0567P AD=0.1584P
+ PS=0.675U PD=1.6U
M$4203 VSS \$2725 \$2726 VSS nfet_03v3 L=0.28U W=0.36U AS=0.1584P AD=0.0972P
+ PS=1.6U PD=0.9U
M$4204 \$2727 \$2725 VSS VSS nfet_03v3 L=0.28U W=0.36U AS=0.0972P AD=0.18P
+ PS=0.9U PD=1.72U
M$4205 \$2730 D|Q VSS VSS nfet_03v3 L=0.28U W=0.36U AS=0.1584P AD=0.1188P
+ PS=1.6U PD=1.02U
M$4206 \$2731 WECLK \$2730 VSS nfet_03v3 L=0.28U W=0.36U AS=0.1188P AD=0.1278P
+ PS=1.02U PD=1.07U
M$4207 \$2969 \$2732 \$2731 VSS nfet_03v3 L=0.28U W=0.36U AS=0.1278P AD=0.0567P
+ PS=1.07U PD=0.675U
M$4208 VSS WECLKb \$2969 VSS nfet_03v3 L=0.28U W=0.36U AS=0.0567P AD=0.1584P
+ PS=0.675U PD=1.6U
M$4209 VSS \$2731 \$2732 VSS nfet_03v3 L=0.28U W=0.36U AS=0.1584P AD=0.0972P
+ PS=1.6U PD=0.9U
M$4210 \$2733 \$2731 VSS VSS nfet_03v3 L=0.28U W=0.36U AS=0.0972P AD=0.18P
+ PS=0.9U PD=1.72U
M$4211 \$2736 D|Q VSS VSS nfet_03v3 L=0.28U W=0.36U AS=0.1584P AD=0.1188P
+ PS=1.6U PD=1.02U
M$4212 \$2737 WECLK \$2736 VSS nfet_03v3 L=0.28U W=0.36U AS=0.1188P AD=0.1278P
+ PS=1.02U PD=1.07U
M$4213 \$2976 \$2738 \$2737 VSS nfet_03v3 L=0.28U W=0.36U AS=0.1278P AD=0.0567P
+ PS=1.07U PD=0.675U
M$4214 VSS WECLKb \$2976 VSS nfet_03v3 L=0.28U W=0.36U AS=0.0567P AD=0.1584P
+ PS=0.675U PD=1.6U
M$4215 VSS \$2737 \$2738 VSS nfet_03v3 L=0.28U W=0.36U AS=0.1584P AD=0.0972P
+ PS=1.6U PD=0.9U
M$4216 \$2739 \$2737 VSS VSS nfet_03v3 L=0.28U W=0.36U AS=0.0972P AD=0.18P
+ PS=0.9U PD=1.72U
M$4217 \$2742 D|Q VSS VSS nfet_03v3 L=0.28U W=0.36U AS=0.1584P AD=0.1188P
+ PS=1.6U PD=1.02U
M$4218 \$2743 WECLK \$2742 VSS nfet_03v3 L=0.28U W=0.36U AS=0.1188P AD=0.1278P
+ PS=1.02U PD=1.07U
M$4219 \$2983 \$2744 \$2743 VSS nfet_03v3 L=0.28U W=0.36U AS=0.1278P AD=0.0567P
+ PS=1.07U PD=0.675U
M$4220 VSS WECLKb \$2983 VSS nfet_03v3 L=0.28U W=0.36U AS=0.0567P AD=0.1584P
+ PS=0.675U PD=1.6U
M$4221 VSS \$2743 \$2744 VSS nfet_03v3 L=0.28U W=0.36U AS=0.1584P AD=0.0972P
+ PS=1.6U PD=0.9U
M$4222 \$2745 \$2743 VSS VSS nfet_03v3 L=0.28U W=0.36U AS=0.0972P AD=0.18P
+ PS=0.9U PD=1.72U
M$4223 \$2748 D|Q VSS VSS nfet_03v3 L=0.28U W=0.36U AS=0.1584P AD=0.1188P
+ PS=1.6U PD=1.02U
M$4224 \$2749 WECLK \$2748 VSS nfet_03v3 L=0.28U W=0.36U AS=0.1188P AD=0.1278P
+ PS=1.02U PD=1.07U
M$4225 \$2991 \$2750 \$2749 VSS nfet_03v3 L=0.28U W=0.36U AS=0.1278P AD=0.0567P
+ PS=1.07U PD=0.675U
M$4226 VSS WECLKb \$2991 VSS nfet_03v3 L=0.28U W=0.36U AS=0.0567P AD=0.1584P
+ PS=0.675U PD=1.6U
M$4227 VSS \$2749 \$2750 VSS nfet_03v3 L=0.28U W=0.36U AS=0.1584P AD=0.0972P
+ PS=1.6U PD=0.9U
M$4228 \$2751 \$2749 VSS VSS nfet_03v3 L=0.28U W=0.36U AS=0.0972P AD=0.18P
+ PS=0.9U PD=1.72U
M$4229 \$2754 D|Q VSS VSS nfet_03v3 L=0.28U W=0.36U AS=0.1584P AD=0.1188P
+ PS=1.6U PD=1.02U
M$4230 \$2755 WECLK \$2754 VSS nfet_03v3 L=0.28U W=0.36U AS=0.1188P AD=0.1278P
+ PS=1.02U PD=1.07U
M$4231 \$2999 \$2756 \$2755 VSS nfet_03v3 L=0.28U W=0.36U AS=0.1278P AD=0.0567P
+ PS=1.07U PD=0.675U
M$4232 VSS WECLKb \$2999 VSS nfet_03v3 L=0.28U W=0.36U AS=0.0567P AD=0.1584P
+ PS=0.675U PD=1.6U
M$4233 VSS \$2755 \$2756 VSS nfet_03v3 L=0.28U W=0.36U AS=0.1584P AD=0.0972P
+ PS=1.6U PD=0.9U
M$4234 \$2757 \$2755 VSS VSS nfet_03v3 L=0.28U W=0.36U AS=0.0972P AD=0.18P
+ PS=0.9U PD=1.72U
M$4235 \$2760 D|Q VSS VSS nfet_03v3 L=0.28U W=0.36U AS=0.1584P AD=0.1188P
+ PS=1.6U PD=1.02U
M$4236 \$2761 WECLK \$2760 VSS nfet_03v3 L=0.28U W=0.36U AS=0.1188P AD=0.1278P
+ PS=1.02U PD=1.07U
M$4237 \$3005 \$2762 \$2761 VSS nfet_03v3 L=0.28U W=0.36U AS=0.1278P AD=0.0567P
+ PS=1.07U PD=0.675U
M$4238 VSS WECLKb \$3005 VSS nfet_03v3 L=0.28U W=0.36U AS=0.0567P AD=0.1584P
+ PS=0.675U PD=1.6U
M$4239 VSS \$2761 \$2762 VSS nfet_03v3 L=0.28U W=0.36U AS=0.1584P AD=0.0972P
+ PS=1.6U PD=0.9U
M$4240 \$2763 \$2761 VSS VSS nfet_03v3 L=0.28U W=0.36U AS=0.0972P AD=0.18P
+ PS=0.9U PD=1.72U
M$4241 \$2766 D|Q VSS VSS nfet_03v3 L=0.28U W=0.36U AS=0.1584P AD=0.1188P
+ PS=1.6U PD=1.02U
M$4242 \$2767 WECLK \$2766 VSS nfet_03v3 L=0.28U W=0.36U AS=0.1188P AD=0.1278P
+ PS=1.02U PD=1.07U
M$4243 \$3012 \$2768 \$2767 VSS nfet_03v3 L=0.28U W=0.36U AS=0.1278P AD=0.0567P
+ PS=1.07U PD=0.675U
M$4244 VSS WECLKb \$3012 VSS nfet_03v3 L=0.28U W=0.36U AS=0.0567P AD=0.1584P
+ PS=0.675U PD=1.6U
M$4245 VSS \$2767 \$2768 VSS nfet_03v3 L=0.28U W=0.36U AS=0.1584P AD=0.0972P
+ PS=1.6U PD=0.9U
M$4246 \$2769 \$2767 VSS VSS nfet_03v3 L=0.28U W=0.36U AS=0.0972P AD=0.18P
+ PS=0.9U PD=1.72U
M$4247 \$2772 D|Q VSS VSS nfet_03v3 L=0.28U W=0.36U AS=0.1584P AD=0.1188P
+ PS=1.6U PD=1.02U
M$4248 \$2773 WECLK \$2772 VSS nfet_03v3 L=0.28U W=0.36U AS=0.1188P AD=0.1278P
+ PS=1.02U PD=1.07U
M$4249 \$3019 \$2774 \$2773 VSS nfet_03v3 L=0.28U W=0.36U AS=0.1278P AD=0.0567P
+ PS=1.07U PD=0.675U
M$4250 VSS WECLKb \$3019 VSS nfet_03v3 L=0.28U W=0.36U AS=0.0567P AD=0.1584P
+ PS=0.675U PD=1.6U
M$4251 VSS \$2773 \$2774 VSS nfet_03v3 L=0.28U W=0.36U AS=0.1584P AD=0.0972P
+ PS=1.6U PD=0.9U
M$4252 \$2775 \$2773 VSS VSS nfet_03v3 L=0.28U W=0.36U AS=0.0972P AD=0.18P
+ PS=0.9U PD=1.72U
M$4253 \$2778 D|Q VSS VSS nfet_03v3 L=0.28U W=0.36U AS=0.1584P AD=0.1188P
+ PS=1.6U PD=1.02U
M$4254 \$2779 WECLK \$2778 VSS nfet_03v3 L=0.28U W=0.36U AS=0.1188P AD=0.1278P
+ PS=1.02U PD=1.07U
M$4255 \$3027 \$2780 \$2779 VSS nfet_03v3 L=0.28U W=0.36U AS=0.1278P AD=0.0567P
+ PS=1.07U PD=0.675U
M$4256 VSS WECLKb \$3027 VSS nfet_03v3 L=0.28U W=0.36U AS=0.0567P AD=0.1584P
+ PS=0.675U PD=1.6U
M$4257 VSS \$2779 \$2780 VSS nfet_03v3 L=0.28U W=0.36U AS=0.1584P AD=0.0972P
+ PS=1.6U PD=0.9U
M$4258 \$2781 \$2779 VSS VSS nfet_03v3 L=0.28U W=0.36U AS=0.0972P AD=0.18P
+ PS=0.9U PD=1.72U
M$4259 \$2784 D|Q VSS VSS nfet_03v3 L=0.28U W=0.36U AS=0.1584P AD=0.1188P
+ PS=1.6U PD=1.02U
M$4260 \$2785 WECLK \$2784 VSS nfet_03v3 L=0.28U W=0.36U AS=0.1188P AD=0.1278P
+ PS=1.02U PD=1.07U
M$4261 \$3034 \$2786 \$2785 VSS nfet_03v3 L=0.28U W=0.36U AS=0.1278P AD=0.0567P
+ PS=1.07U PD=0.675U
M$4262 VSS WECLKb \$3034 VSS nfet_03v3 L=0.28U W=0.36U AS=0.0567P AD=0.1584P
+ PS=0.675U PD=1.6U
M$4263 VSS \$2785 \$2786 VSS nfet_03v3 L=0.28U W=0.36U AS=0.1584P AD=0.0972P
+ PS=1.6U PD=0.9U
M$4264 \$2787 \$2785 VSS VSS nfet_03v3 L=0.28U W=0.36U AS=0.0972P AD=0.18P
+ PS=0.9U PD=1.72U
M$4265 \$2790 D|Q VSS VSS nfet_03v3 L=0.28U W=0.36U AS=0.1584P AD=0.1188P
+ PS=1.6U PD=1.02U
M$4266 \$2791 WECLK \$2790 VSS nfet_03v3 L=0.28U W=0.36U AS=0.1188P AD=0.1278P
+ PS=1.02U PD=1.07U
M$4267 \$2998 \$2792 \$2791 VSS nfet_03v3 L=0.28U W=0.36U AS=0.1278P AD=0.0567P
+ PS=1.07U PD=0.675U
M$4268 VSS WECLKb \$2998 VSS nfet_03v3 L=0.28U W=0.36U AS=0.0567P AD=0.1584P
+ PS=0.675U PD=1.6U
M$4269 VSS \$2791 \$2792 VSS nfet_03v3 L=0.28U W=0.36U AS=0.1584P AD=0.0972P
+ PS=1.6U PD=0.9U
M$4270 \$2793 \$2791 VSS VSS nfet_03v3 L=0.28U W=0.36U AS=0.0972P AD=0.18P
+ PS=0.9U PD=1.72U
M$4271 \$2796 D|Q VSS VSS nfet_03v3 L=0.28U W=0.36U AS=0.1584P AD=0.1188P
+ PS=1.6U PD=1.02U
M$4272 \$2797 WECLK \$2796 VSS nfet_03v3 L=0.28U W=0.36U AS=0.1188P AD=0.1278P
+ PS=1.02U PD=1.07U
M$4273 \$2962 \$2798 \$2797 VSS nfet_03v3 L=0.28U W=0.36U AS=0.1278P AD=0.0567P
+ PS=1.07U PD=0.675U
M$4274 VSS WECLKb \$2962 VSS nfet_03v3 L=0.28U W=0.36U AS=0.0567P AD=0.1584P
+ PS=0.675U PD=1.6U
M$4275 VSS \$2797 \$2798 VSS nfet_03v3 L=0.28U W=0.36U AS=0.1584P AD=0.0972P
+ PS=1.6U PD=0.9U
M$4276 \$2799 \$2797 VSS VSS nfet_03v3 L=0.28U W=0.36U AS=0.0972P AD=0.18P
+ PS=0.9U PD=1.72U
M$4277 \$3191 WE VSS VSS nfet_03v3 L=0.28U W=0.72U AS=0.3168P AD=0.1872P
+ PS=2.32U PD=1.24U
M$4278 \$3051 CLK \$3191 VSS nfet_03v3 L=0.28U W=0.72U AS=0.1872P AD=0.3168P
+ PS=1.24U PD=2.32U
M$4279 WECLK \$3051 VSS VSS nfet_03v3 L=0.28U W=1.27U AS=0.4445P AD=0.3344P
+ PS=3.305U PD=2.345U
M$4283 \$3054 D|Q VSS VSS nfet_03v3 L=0.28U W=0.36U AS=0.1584P AD=0.1188P
+ PS=1.6U PD=1.02U
M$4284 \$3055 WECLK \$3054 VSS nfet_03v3 L=0.28U W=0.36U AS=0.1188P AD=0.1278P
+ PS=1.02U PD=1.07U
M$4285 \$3108 \$3056 \$3055 VSS nfet_03v3 L=0.28U W=0.36U AS=0.1278P AD=0.0567P
+ PS=1.07U PD=0.675U
M$4286 VSS WECLKb \$3108 VSS nfet_03v3 L=0.28U W=0.36U AS=0.0567P AD=0.1584P
+ PS=0.675U PD=1.6U
M$4287 VSS \$3055 \$3056 VSS nfet_03v3 L=0.28U W=0.36U AS=0.1584P AD=0.0972P
+ PS=1.6U PD=0.9U
M$4288 \$3035 \$3055 VSS VSS nfet_03v3 L=0.28U W=0.36U AS=0.0972P AD=0.18P
+ PS=0.9U PD=1.72U
M$4289 \$3057 D|Q VSS VSS nfet_03v3 L=0.28U W=0.36U AS=0.1584P AD=0.1188P
+ PS=1.6U PD=1.02U
M$4290 \$3058 WECLK \$3057 VSS nfet_03v3 L=0.28U W=0.36U AS=0.1188P AD=0.1278P
+ PS=1.02U PD=1.07U
M$4291 \$3119 \$3059 \$3058 VSS nfet_03v3 L=0.28U W=0.36U AS=0.1278P AD=0.0567P
+ PS=1.07U PD=0.675U
M$4292 VSS WECLKb \$3119 VSS nfet_03v3 L=0.28U W=0.36U AS=0.0567P AD=0.1584P
+ PS=0.675U PD=1.6U
M$4293 VSS \$3058 \$3059 VSS nfet_03v3 L=0.28U W=0.36U AS=0.1584P AD=0.0972P
+ PS=1.6U PD=0.9U
M$4294 \$3036 \$3058 VSS VSS nfet_03v3 L=0.28U W=0.36U AS=0.0972P AD=0.18P
+ PS=0.9U PD=1.72U
M$4295 \$3060 D|Q VSS VSS nfet_03v3 L=0.28U W=0.36U AS=0.1584P AD=0.1188P
+ PS=1.6U PD=1.02U
M$4296 \$3061 WECLK \$3060 VSS nfet_03v3 L=0.28U W=0.36U AS=0.1188P AD=0.1278P
+ PS=1.02U PD=1.07U
M$4297 \$3128 \$3062 \$3061 VSS nfet_03v3 L=0.28U W=0.36U AS=0.1278P AD=0.0567P
+ PS=1.07U PD=0.675U
M$4298 VSS WECLKb \$3128 VSS nfet_03v3 L=0.28U W=0.36U AS=0.0567P AD=0.1584P
+ PS=0.675U PD=1.6U
M$4299 VSS \$3061 \$3062 VSS nfet_03v3 L=0.28U W=0.36U AS=0.1584P AD=0.0972P
+ PS=1.6U PD=0.9U
M$4300 \$3037 \$3061 VSS VSS nfet_03v3 L=0.28U W=0.36U AS=0.0972P AD=0.18P
+ PS=0.9U PD=1.72U
M$4301 \$3063 D|Q VSS VSS nfet_03v3 L=0.28U W=0.36U AS=0.1584P AD=0.1188P
+ PS=1.6U PD=1.02U
M$4302 \$3064 WECLK \$3063 VSS nfet_03v3 L=0.28U W=0.36U AS=0.1188P AD=0.1278P
+ PS=1.02U PD=1.07U
M$4303 \$3138 \$3065 \$3064 VSS nfet_03v3 L=0.28U W=0.36U AS=0.1278P AD=0.0567P
+ PS=1.07U PD=0.675U
M$4304 VSS WECLKb \$3138 VSS nfet_03v3 L=0.28U W=0.36U AS=0.0567P AD=0.1584P
+ PS=0.675U PD=1.6U
M$4305 VSS \$3064 \$3065 VSS nfet_03v3 L=0.28U W=0.36U AS=0.1584P AD=0.0972P
+ PS=1.6U PD=0.9U
M$4306 \$3038 \$3064 VSS VSS nfet_03v3 L=0.28U W=0.36U AS=0.0972P AD=0.18P
+ PS=0.9U PD=1.72U
M$4307 \$3066 D|Q VSS VSS nfet_03v3 L=0.28U W=0.36U AS=0.1584P AD=0.1188P
+ PS=1.6U PD=1.02U
M$4308 \$3067 WECLK \$3066 VSS nfet_03v3 L=0.28U W=0.36U AS=0.1188P AD=0.1278P
+ PS=1.02U PD=1.07U
M$4309 \$3149 \$3068 \$3067 VSS nfet_03v3 L=0.28U W=0.36U AS=0.1278P AD=0.0567P
+ PS=1.07U PD=0.675U
M$4310 VSS WECLKb \$3149 VSS nfet_03v3 L=0.28U W=0.36U AS=0.0567P AD=0.1584P
+ PS=0.675U PD=1.6U
M$4311 VSS \$3067 \$3068 VSS nfet_03v3 L=0.28U W=0.36U AS=0.1584P AD=0.0972P
+ PS=1.6U PD=0.9U
M$4312 \$3039 \$3067 VSS VSS nfet_03v3 L=0.28U W=0.36U AS=0.0972P AD=0.18P
+ PS=0.9U PD=1.72U
M$4313 \$3069 D|Q VSS VSS nfet_03v3 L=0.28U W=0.36U AS=0.1584P AD=0.1188P
+ PS=1.6U PD=1.02U
M$4314 \$3070 WECLK \$3069 VSS nfet_03v3 L=0.28U W=0.36U AS=0.1188P AD=0.1278P
+ PS=1.02U PD=1.07U
M$4315 \$3154 \$3071 \$3070 VSS nfet_03v3 L=0.28U W=0.36U AS=0.1278P AD=0.0567P
+ PS=1.07U PD=0.675U
M$4316 VSS WECLKb \$3154 VSS nfet_03v3 L=0.28U W=0.36U AS=0.0567P AD=0.1584P
+ PS=0.675U PD=1.6U
M$4317 VSS \$3070 \$3071 VSS nfet_03v3 L=0.28U W=0.36U AS=0.1584P AD=0.0972P
+ PS=1.6U PD=0.9U
M$4318 \$3040 \$3070 VSS VSS nfet_03v3 L=0.28U W=0.36U AS=0.0972P AD=0.18P
+ PS=0.9U PD=1.72U
M$4319 \$3072 D|Q VSS VSS nfet_03v3 L=0.28U W=0.36U AS=0.1584P AD=0.1188P
+ PS=1.6U PD=1.02U
M$4320 \$3073 WECLK \$3072 VSS nfet_03v3 L=0.28U W=0.36U AS=0.1188P AD=0.1278P
+ PS=1.02U PD=1.07U
M$4321 \$3150 \$3074 \$3073 VSS nfet_03v3 L=0.28U W=0.36U AS=0.1278P AD=0.0567P
+ PS=1.07U PD=0.675U
M$4322 VSS WECLKb \$3150 VSS nfet_03v3 L=0.28U W=0.36U AS=0.0567P AD=0.1584P
+ PS=0.675U PD=1.6U
M$4323 VSS \$3073 \$3074 VSS nfet_03v3 L=0.28U W=0.36U AS=0.1584P AD=0.0972P
+ PS=1.6U PD=0.9U
M$4324 \$3041 \$3073 VSS VSS nfet_03v3 L=0.28U W=0.36U AS=0.0972P AD=0.18P
+ PS=0.9U PD=1.72U
M$4325 \$3075 D|Q VSS VSS nfet_03v3 L=0.28U W=0.36U AS=0.1584P AD=0.1188P
+ PS=1.6U PD=1.02U
M$4326 \$3076 WECLK \$3075 VSS nfet_03v3 L=0.28U W=0.36U AS=0.1188P AD=0.1278P
+ PS=1.02U PD=1.07U
M$4327 \$3143 \$3077 \$3076 VSS nfet_03v3 L=0.28U W=0.36U AS=0.1278P AD=0.0567P
+ PS=1.07U PD=0.675U
M$4328 VSS WECLKb \$3143 VSS nfet_03v3 L=0.28U W=0.36U AS=0.0567P AD=0.1584P
+ PS=0.675U PD=1.6U
M$4329 VSS \$3076 \$3077 VSS nfet_03v3 L=0.28U W=0.36U AS=0.1584P AD=0.0972P
+ PS=1.6U PD=0.9U
M$4330 \$3042 \$3076 VSS VSS nfet_03v3 L=0.28U W=0.36U AS=0.0972P AD=0.18P
+ PS=0.9U PD=1.72U
M$4331 \$3078 D|Q VSS VSS nfet_03v3 L=0.28U W=0.36U AS=0.1584P AD=0.1188P
+ PS=1.6U PD=1.02U
M$4332 \$3079 WECLK \$3078 VSS nfet_03v3 L=0.28U W=0.36U AS=0.1188P AD=0.1278P
+ PS=1.02U PD=1.07U
M$4333 \$3140 \$3080 \$3079 VSS nfet_03v3 L=0.28U W=0.36U AS=0.1278P AD=0.0567P
+ PS=1.07U PD=0.675U
M$4334 VSS WECLKb \$3140 VSS nfet_03v3 L=0.28U W=0.36U AS=0.0567P AD=0.1584P
+ PS=0.675U PD=1.6U
M$4335 VSS \$3079 \$3080 VSS nfet_03v3 L=0.28U W=0.36U AS=0.1584P AD=0.0972P
+ PS=1.6U PD=0.9U
M$4336 \$3043 \$3079 VSS VSS nfet_03v3 L=0.28U W=0.36U AS=0.0972P AD=0.18P
+ PS=0.9U PD=1.72U
M$4337 \$3081 D|Q VSS VSS nfet_03v3 L=0.28U W=0.36U AS=0.1584P AD=0.1188P
+ PS=1.6U PD=1.02U
M$4338 \$3082 WECLK \$3081 VSS nfet_03v3 L=0.28U W=0.36U AS=0.1188P AD=0.1278P
+ PS=1.02U PD=1.07U
M$4339 \$3135 \$3083 \$3082 VSS nfet_03v3 L=0.28U W=0.36U AS=0.1278P AD=0.0567P
+ PS=1.07U PD=0.675U
M$4340 VSS WECLKb \$3135 VSS nfet_03v3 L=0.28U W=0.36U AS=0.0567P AD=0.1584P
+ PS=0.675U PD=1.6U
M$4341 VSS \$3082 \$3083 VSS nfet_03v3 L=0.28U W=0.36U AS=0.1584P AD=0.0972P
+ PS=1.6U PD=0.9U
M$4342 \$3044 \$3082 VSS VSS nfet_03v3 L=0.28U W=0.36U AS=0.0972P AD=0.18P
+ PS=0.9U PD=1.72U
M$4343 \$3084 D|Q VSS VSS nfet_03v3 L=0.28U W=0.36U AS=0.1584P AD=0.1188P
+ PS=1.6U PD=1.02U
M$4344 \$3085 WECLK \$3084 VSS nfet_03v3 L=0.28U W=0.36U AS=0.1188P AD=0.1278P
+ PS=1.02U PD=1.07U
M$4345 \$3129 \$3086 \$3085 VSS nfet_03v3 L=0.28U W=0.36U AS=0.1278P AD=0.0567P
+ PS=1.07U PD=0.675U
M$4346 VSS WECLKb \$3129 VSS nfet_03v3 L=0.28U W=0.36U AS=0.0567P AD=0.1584P
+ PS=0.675U PD=1.6U
M$4347 VSS \$3085 \$3086 VSS nfet_03v3 L=0.28U W=0.36U AS=0.1584P AD=0.0972P
+ PS=1.6U PD=0.9U
M$4348 \$3045 \$3085 VSS VSS nfet_03v3 L=0.28U W=0.36U AS=0.0972P AD=0.18P
+ PS=0.9U PD=1.72U
M$4349 \$3087 D|Q VSS VSS nfet_03v3 L=0.28U W=0.36U AS=0.1584P AD=0.1188P
+ PS=1.6U PD=1.02U
M$4350 \$3088 WECLK \$3087 VSS nfet_03v3 L=0.28U W=0.36U AS=0.1188P AD=0.1278P
+ PS=1.02U PD=1.07U
M$4351 \$3125 \$3089 \$3088 VSS nfet_03v3 L=0.28U W=0.36U AS=0.1278P AD=0.0567P
+ PS=1.07U PD=0.675U
M$4352 VSS WECLKb \$3125 VSS nfet_03v3 L=0.28U W=0.36U AS=0.0567P AD=0.1584P
+ PS=0.675U PD=1.6U
M$4353 VSS \$3088 \$3089 VSS nfet_03v3 L=0.28U W=0.36U AS=0.1584P AD=0.0972P
+ PS=1.6U PD=0.9U
M$4354 \$3046 \$3088 VSS VSS nfet_03v3 L=0.28U W=0.36U AS=0.0972P AD=0.18P
+ PS=0.9U PD=1.72U
M$4355 \$3090 D|Q VSS VSS nfet_03v3 L=0.28U W=0.36U AS=0.1584P AD=0.1188P
+ PS=1.6U PD=1.02U
M$4356 \$3091 WECLK \$3090 VSS nfet_03v3 L=0.28U W=0.36U AS=0.1188P AD=0.1278P
+ PS=1.02U PD=1.07U
M$4357 \$3121 \$3092 \$3091 VSS nfet_03v3 L=0.28U W=0.36U AS=0.1278P AD=0.0567P
+ PS=1.07U PD=0.675U
M$4358 VSS WECLKb \$3121 VSS nfet_03v3 L=0.28U W=0.36U AS=0.0567P AD=0.1584P
+ PS=0.675U PD=1.6U
M$4359 VSS \$3091 \$3092 VSS nfet_03v3 L=0.28U W=0.36U AS=0.1584P AD=0.0972P
+ PS=1.6U PD=0.9U
M$4360 \$3047 \$3091 VSS VSS nfet_03v3 L=0.28U W=0.36U AS=0.0972P AD=0.18P
+ PS=0.9U PD=1.72U
M$4361 \$3093 D|Q VSS VSS nfet_03v3 L=0.28U W=0.36U AS=0.1584P AD=0.1188P
+ PS=1.6U PD=1.02U
M$4362 \$3094 WECLK \$3093 VSS nfet_03v3 L=0.28U W=0.36U AS=0.1188P AD=0.1278P
+ PS=1.02U PD=1.07U
M$4363 \$3114 \$3095 \$3094 VSS nfet_03v3 L=0.28U W=0.36U AS=0.1278P AD=0.0567P
+ PS=1.07U PD=0.675U
M$4364 VSS WECLKb \$3114 VSS nfet_03v3 L=0.28U W=0.36U AS=0.0567P AD=0.1584P
+ PS=0.675U PD=1.6U
M$4365 VSS \$3094 \$3095 VSS nfet_03v3 L=0.28U W=0.36U AS=0.1584P AD=0.0972P
+ PS=1.6U PD=0.9U
M$4366 \$3048 \$3094 VSS VSS nfet_03v3 L=0.28U W=0.36U AS=0.0972P AD=0.18P
+ PS=0.9U PD=1.72U
M$4367 \$3096 D|Q VSS VSS nfet_03v3 L=0.28U W=0.36U AS=0.1584P AD=0.1188P
+ PS=1.6U PD=1.02U
M$4368 \$3097 WECLK \$3096 VSS nfet_03v3 L=0.28U W=0.36U AS=0.1188P AD=0.1278P
+ PS=1.02U PD=1.07U
M$4369 \$3109 \$3098 \$3097 VSS nfet_03v3 L=0.28U W=0.36U AS=0.1278P AD=0.0567P
+ PS=1.07U PD=0.675U
M$4370 VSS WECLKb \$3109 VSS nfet_03v3 L=0.28U W=0.36U AS=0.0567P AD=0.1584P
+ PS=0.675U PD=1.6U
M$4371 VSS \$3097 \$3098 VSS nfet_03v3 L=0.28U W=0.36U AS=0.1584P AD=0.0972P
+ PS=1.6U PD=0.9U
M$4372 \$3049 \$3097 VSS VSS nfet_03v3 L=0.28U W=0.36U AS=0.0972P AD=0.18P
+ PS=0.9U PD=1.72U
M$4373 \$3099 D|Q VSS VSS nfet_03v3 L=0.28U W=0.36U AS=0.1584P AD=0.1188P
+ PS=1.6U PD=1.02U
M$4374 \$3100 WECLK \$3099 VSS nfet_03v3 L=0.28U W=0.36U AS=0.1188P AD=0.1278P
+ PS=1.02U PD=1.07U
M$4375 \$3104 \$3101 \$3100 VSS nfet_03v3 L=0.28U W=0.36U AS=0.1278P AD=0.0567P
+ PS=1.07U PD=0.675U
M$4376 VSS WECLKb \$3104 VSS nfet_03v3 L=0.28U W=0.36U AS=0.0567P AD=0.1584P
+ PS=0.675U PD=1.6U
M$4377 VSS \$3100 \$3101 VSS nfet_03v3 L=0.28U W=0.36U AS=0.1584P AD=0.0972P
+ PS=1.6U PD=0.9U
M$4378 \$3050 \$3100 VSS VSS nfet_03v3 L=0.28U W=0.36U AS=0.0972P AD=0.18P
+ PS=0.9U PD=1.72U
M$4379 \$3392 RA VSS VSS nfet_03v3 L=0.28U W=0.36U AS=0.1656P AD=0.1944P
+ PS=1.64U PD=1.8U
M$4380 \$3159 RA VSS VSS nfet_03v3 L=0.28U W=0.36U AS=0.1656P AD=0.1944P
+ PS=1.64U PD=1.8U
M$4381 \$3391 RA QAb VSS nfet_03v3 L=0.28U W=0.36U AS=0.1584P AD=0.1152P
+ PS=1.6U PD=1U
M$4382 QBb RB \$3391 VSS nfet_03v3 L=0.28U W=0.36U AS=0.1152P AD=0.1584P PS=1U
+ PD=1.6U
M$4383 \$3035 RA QAb VSS nfet_03v3 L=0.28U W=0.36U AS=0.1584P AD=0.1152P
+ PS=1.6U PD=1U
M$4384 QBb RB \$3035 VSS nfet_03v3 L=0.28U W=0.36U AS=0.1152P AD=0.1584P PS=1U
+ PD=1.6U
M$4385 VSS RB \$3160 VSS nfet_03v3 L=0.28U W=0.36U AS=0.1854P AD=0.1584P
+ PS=1.75U PD=1.6U
M$4386 VSS RB \$3393 VSS nfet_03v3 L=0.28U W=0.36U AS=0.1854P AD=0.1584P
+ PS=1.75U PD=1.6U
M$4387 \$3399 RA VSS VSS nfet_03v3 L=0.28U W=0.36U AS=0.1656P AD=0.1944P
+ PS=1.64U PD=1.8U
M$4388 \$3161 RA VSS VSS nfet_03v3 L=0.28U W=0.36U AS=0.1656P AD=0.1944P
+ PS=1.64U PD=1.8U
M$4389 \$3398 RA QAb VSS nfet_03v3 L=0.28U W=0.36U AS=0.1584P AD=0.1152P
+ PS=1.6U PD=1U
M$4390 QBb RB \$3398 VSS nfet_03v3 L=0.28U W=0.36U AS=0.1152P AD=0.1584P PS=1U
+ PD=1.6U
M$4391 \$3036 RA QAb VSS nfet_03v3 L=0.28U W=0.36U AS=0.1584P AD=0.1152P
+ PS=1.6U PD=1U
M$4392 QBb RB \$3036 VSS nfet_03v3 L=0.28U W=0.36U AS=0.1152P AD=0.1584P PS=1U
+ PD=1.6U
M$4393 VSS RB \$3400 VSS nfet_03v3 L=0.28U W=0.36U AS=0.1854P AD=0.1584P
+ PS=1.75U PD=1.6U
M$4394 VSS RB \$3162 VSS nfet_03v3 L=0.28U W=0.36U AS=0.1854P AD=0.1584P
+ PS=1.75U PD=1.6U
M$4395 \$3405 RA VSS VSS nfet_03v3 L=0.28U W=0.36U AS=0.1656P AD=0.1944P
+ PS=1.64U PD=1.8U
M$4396 \$3163 RA VSS VSS nfet_03v3 L=0.28U W=0.36U AS=0.1656P AD=0.1944P
+ PS=1.64U PD=1.8U
M$4397 \$3037 RA QAb VSS nfet_03v3 L=0.28U W=0.36U AS=0.1584P AD=0.1152P
+ PS=1.6U PD=1U
M$4398 QBb RB \$3037 VSS nfet_03v3 L=0.28U W=0.36U AS=0.1152P AD=0.1584P PS=1U
+ PD=1.6U
M$4399 \$3404 RA QAb VSS nfet_03v3 L=0.28U W=0.36U AS=0.1584P AD=0.1152P
+ PS=1.6U PD=1U
M$4400 QBb RB \$3404 VSS nfet_03v3 L=0.28U W=0.36U AS=0.1152P AD=0.1584P PS=1U
+ PD=1.6U
M$4401 VSS RB \$3406 VSS nfet_03v3 L=0.28U W=0.36U AS=0.1854P AD=0.1584P
+ PS=1.75U PD=1.6U
M$4402 VSS RB \$3164 VSS nfet_03v3 L=0.28U W=0.36U AS=0.1854P AD=0.1584P
+ PS=1.75U PD=1.6U
M$4403 \$3165 RA VSS VSS nfet_03v3 L=0.28U W=0.36U AS=0.1656P AD=0.1944P
+ PS=1.64U PD=1.8U
M$4404 \$3411 RA VSS VSS nfet_03v3 L=0.28U W=0.36U AS=0.1656P AD=0.1944P
+ PS=1.64U PD=1.8U
M$4405 \$3410 RA QAb VSS nfet_03v3 L=0.28U W=0.36U AS=0.1584P AD=0.1152P
+ PS=1.6U PD=1U
M$4406 QBb RB \$3410 VSS nfet_03v3 L=0.28U W=0.36U AS=0.1152P AD=0.1584P PS=1U
+ PD=1.6U
M$4407 \$3038 RA QAb VSS nfet_03v3 L=0.28U W=0.36U AS=0.1584P AD=0.1152P
+ PS=1.6U PD=1U
M$4408 QBb RB \$3038 VSS nfet_03v3 L=0.28U W=0.36U AS=0.1152P AD=0.1584P PS=1U
+ PD=1.6U
M$4409 VSS RB \$3412 VSS nfet_03v3 L=0.28U W=0.36U AS=0.1854P AD=0.1584P
+ PS=1.75U PD=1.6U
M$4410 VSS RB \$3166 VSS nfet_03v3 L=0.28U W=0.36U AS=0.1854P AD=0.1584P
+ PS=1.75U PD=1.6U
M$4411 \$3167 RA VSS VSS nfet_03v3 L=0.28U W=0.36U AS=0.1656P AD=0.1944P
+ PS=1.64U PD=1.8U
M$4412 \$3417 RA VSS VSS nfet_03v3 L=0.28U W=0.36U AS=0.1656P AD=0.1944P
+ PS=1.64U PD=1.8U
M$4413 \$3039 RA QAb VSS nfet_03v3 L=0.28U W=0.36U AS=0.1584P AD=0.1152P
+ PS=1.6U PD=1U
M$4414 QBb RB \$3039 VSS nfet_03v3 L=0.28U W=0.36U AS=0.1152P AD=0.1584P PS=1U
+ PD=1.6U
M$4415 \$3416 RA QAb VSS nfet_03v3 L=0.28U W=0.36U AS=0.1584P AD=0.1152P
+ PS=1.6U PD=1U
M$4416 QBb RB \$3416 VSS nfet_03v3 L=0.28U W=0.36U AS=0.1152P AD=0.1584P PS=1U
+ PD=1.6U
M$4417 VSS RB \$3168 VSS nfet_03v3 L=0.28U W=0.36U AS=0.1854P AD=0.1584P
+ PS=1.75U PD=1.6U
M$4418 VSS RB \$3418 VSS nfet_03v3 L=0.28U W=0.36U AS=0.1854P AD=0.1584P
+ PS=1.75U PD=1.6U
M$4419 \$3169 RA VSS VSS nfet_03v3 L=0.28U W=0.36U AS=0.1656P AD=0.1944P
+ PS=1.64U PD=1.8U
M$4420 \$3423 RA VSS VSS nfet_03v3 L=0.28U W=0.36U AS=0.1656P AD=0.1944P
+ PS=1.64U PD=1.8U
M$4421 \$3422 RA QAb VSS nfet_03v3 L=0.28U W=0.36U AS=0.1584P AD=0.1152P
+ PS=1.6U PD=1U
M$4422 QBb RB \$3422 VSS nfet_03v3 L=0.28U W=0.36U AS=0.1152P AD=0.1584P PS=1U
+ PD=1.6U
M$4423 \$3040 RA QAb VSS nfet_03v3 L=0.28U W=0.36U AS=0.1584P AD=0.1152P
+ PS=1.6U PD=1U
M$4424 QBb RB \$3040 VSS nfet_03v3 L=0.28U W=0.36U AS=0.1152P AD=0.1584P PS=1U
+ PD=1.6U
M$4425 VSS RB \$3424 VSS nfet_03v3 L=0.28U W=0.36U AS=0.1854P AD=0.1584P
+ PS=1.75U PD=1.6U
M$4426 VSS RB \$3170 VSS nfet_03v3 L=0.28U W=0.36U AS=0.1854P AD=0.1584P
+ PS=1.75U PD=1.6U
M$4427 \$3429 RA VSS VSS nfet_03v3 L=0.28U W=0.36U AS=0.1656P AD=0.1944P
+ PS=1.64U PD=1.8U
M$4428 \$3171 RA VSS VSS nfet_03v3 L=0.28U W=0.36U AS=0.1656P AD=0.1944P
+ PS=1.64U PD=1.8U
M$4429 \$3428 RA QAb VSS nfet_03v3 L=0.28U W=0.36U AS=0.1584P AD=0.1152P
+ PS=1.6U PD=1U
M$4430 QBb RB \$3428 VSS nfet_03v3 L=0.28U W=0.36U AS=0.1152P AD=0.1584P PS=1U
+ PD=1.6U
M$4431 \$3041 RA QAb VSS nfet_03v3 L=0.28U W=0.36U AS=0.1584P AD=0.1152P
+ PS=1.6U PD=1U
M$4432 QBb RB \$3041 VSS nfet_03v3 L=0.28U W=0.36U AS=0.1152P AD=0.1584P PS=1U
+ PD=1.6U
M$4433 VSS RB \$3172 VSS nfet_03v3 L=0.28U W=0.36U AS=0.1854P AD=0.1584P
+ PS=1.75U PD=1.6U
M$4434 VSS RB \$3430 VSS nfet_03v3 L=0.28U W=0.36U AS=0.1854P AD=0.1584P
+ PS=1.75U PD=1.6U
M$4435 \$3435 RA VSS VSS nfet_03v3 L=0.28U W=0.36U AS=0.1656P AD=0.1944P
+ PS=1.64U PD=1.8U
M$4436 \$3173 RA VSS VSS nfet_03v3 L=0.28U W=0.36U AS=0.1656P AD=0.1944P
+ PS=1.64U PD=1.8U
M$4437 \$3434 RA QAb VSS nfet_03v3 L=0.28U W=0.36U AS=0.1584P AD=0.1152P
+ PS=1.6U PD=1U
M$4438 QBb RB \$3434 VSS nfet_03v3 L=0.28U W=0.36U AS=0.1152P AD=0.1584P PS=1U
+ PD=1.6U
M$4439 \$3042 RA QAb VSS nfet_03v3 L=0.28U W=0.36U AS=0.1584P AD=0.1152P
+ PS=1.6U PD=1U
M$4440 QBb RB \$3042 VSS nfet_03v3 L=0.28U W=0.36U AS=0.1152P AD=0.1584P PS=1U
+ PD=1.6U
M$4441 VSS RB \$3174 VSS nfet_03v3 L=0.28U W=0.36U AS=0.1854P AD=0.1584P
+ PS=1.75U PD=1.6U
M$4442 VSS RB \$3436 VSS nfet_03v3 L=0.28U W=0.36U AS=0.1854P AD=0.1584P
+ PS=1.75U PD=1.6U
M$4443 \$3175 RA VSS VSS nfet_03v3 L=0.28U W=0.36U AS=0.1656P AD=0.1944P
+ PS=1.64U PD=1.8U
M$4444 \$3441 RA VSS VSS nfet_03v3 L=0.28U W=0.36U AS=0.1656P AD=0.1944P
+ PS=1.64U PD=1.8U
M$4445 \$3043 RA QAb VSS nfet_03v3 L=0.28U W=0.36U AS=0.1584P AD=0.1152P
+ PS=1.6U PD=1U
M$4446 QBb RB \$3043 VSS nfet_03v3 L=0.28U W=0.36U AS=0.1152P AD=0.1584P PS=1U
+ PD=1.6U
M$4447 \$3440 RA QAb VSS nfet_03v3 L=0.28U W=0.36U AS=0.1584P AD=0.1152P
+ PS=1.6U PD=1U
M$4448 QBb RB \$3440 VSS nfet_03v3 L=0.28U W=0.36U AS=0.1152P AD=0.1584P PS=1U
+ PD=1.6U
M$4449 VSS RB \$3176 VSS nfet_03v3 L=0.28U W=0.36U AS=0.1854P AD=0.1584P
+ PS=1.75U PD=1.6U
M$4450 VSS RB \$3442 VSS nfet_03v3 L=0.28U W=0.36U AS=0.1854P AD=0.1584P
+ PS=1.75U PD=1.6U
M$4451 \$3447 RA VSS VSS nfet_03v3 L=0.28U W=0.36U AS=0.1656P AD=0.1944P
+ PS=1.64U PD=1.8U
M$4452 \$3177 RA VSS VSS nfet_03v3 L=0.28U W=0.36U AS=0.1656P AD=0.1944P
+ PS=1.64U PD=1.8U
M$4453 \$3044 RA QAb VSS nfet_03v3 L=0.28U W=0.36U AS=0.1584P AD=0.1152P
+ PS=1.6U PD=1U
M$4454 QBb RB \$3044 VSS nfet_03v3 L=0.28U W=0.36U AS=0.1152P AD=0.1584P PS=1U
+ PD=1.6U
M$4455 \$3446 RA QAb VSS nfet_03v3 L=0.28U W=0.36U AS=0.1584P AD=0.1152P
+ PS=1.6U PD=1U
M$4456 QBb RB \$3446 VSS nfet_03v3 L=0.28U W=0.36U AS=0.1152P AD=0.1584P PS=1U
+ PD=1.6U
M$4457 VSS RB \$3178 VSS nfet_03v3 L=0.28U W=0.36U AS=0.1854P AD=0.1584P
+ PS=1.75U PD=1.6U
M$4458 VSS RB \$3448 VSS nfet_03v3 L=0.28U W=0.36U AS=0.1854P AD=0.1584P
+ PS=1.75U PD=1.6U
M$4459 \$3453 RA VSS VSS nfet_03v3 L=0.28U W=0.36U AS=0.1656P AD=0.1944P
+ PS=1.64U PD=1.8U
M$4460 \$3179 RA VSS VSS nfet_03v3 L=0.28U W=0.36U AS=0.1656P AD=0.1944P
+ PS=1.64U PD=1.8U
M$4461 \$3452 RA QAb VSS nfet_03v3 L=0.28U W=0.36U AS=0.1584P AD=0.1152P
+ PS=1.6U PD=1U
M$4462 QBb RB \$3452 VSS nfet_03v3 L=0.28U W=0.36U AS=0.1152P AD=0.1584P PS=1U
+ PD=1.6U
M$4463 \$3045 RA QAb VSS nfet_03v3 L=0.28U W=0.36U AS=0.1584P AD=0.1152P
+ PS=1.6U PD=1U
M$4464 QBb RB \$3045 VSS nfet_03v3 L=0.28U W=0.36U AS=0.1152P AD=0.1584P PS=1U
+ PD=1.6U
M$4465 VSS RB \$3454 VSS nfet_03v3 L=0.28U W=0.36U AS=0.1854P AD=0.1584P
+ PS=1.75U PD=1.6U
M$4466 VSS RB \$3180 VSS nfet_03v3 L=0.28U W=0.36U AS=0.1854P AD=0.1584P
+ PS=1.75U PD=1.6U
M$4467 \$3459 RA VSS VSS nfet_03v3 L=0.28U W=0.36U AS=0.1656P AD=0.1944P
+ PS=1.64U PD=1.8U
M$4468 \$3181 RA VSS VSS nfet_03v3 L=0.28U W=0.36U AS=0.1656P AD=0.1944P
+ PS=1.64U PD=1.8U
M$4469 \$3458 RA QAb VSS nfet_03v3 L=0.28U W=0.36U AS=0.1584P AD=0.1152P
+ PS=1.6U PD=1U
M$4470 QBb RB \$3458 VSS nfet_03v3 L=0.28U W=0.36U AS=0.1152P AD=0.1584P PS=1U
+ PD=1.6U
M$4471 \$3046 RA QAb VSS nfet_03v3 L=0.28U W=0.36U AS=0.1584P AD=0.1152P
+ PS=1.6U PD=1U
M$4472 QBb RB \$3046 VSS nfet_03v3 L=0.28U W=0.36U AS=0.1152P AD=0.1584P PS=1U
+ PD=1.6U
M$4473 VSS RB \$3460 VSS nfet_03v3 L=0.28U W=0.36U AS=0.1854P AD=0.1584P
+ PS=1.75U PD=1.6U
M$4474 VSS RB \$3182 VSS nfet_03v3 L=0.28U W=0.36U AS=0.1854P AD=0.1584P
+ PS=1.75U PD=1.6U
M$4475 \$3465 RA VSS VSS nfet_03v3 L=0.28U W=0.36U AS=0.1656P AD=0.1944P
+ PS=1.64U PD=1.8U
M$4476 \$3183 RA VSS VSS nfet_03v3 L=0.28U W=0.36U AS=0.1656P AD=0.1944P
+ PS=1.64U PD=1.8U
M$4477 \$3464 RA QAb VSS nfet_03v3 L=0.28U W=0.36U AS=0.1584P AD=0.1152P
+ PS=1.6U PD=1U
M$4478 QBb RB \$3464 VSS nfet_03v3 L=0.28U W=0.36U AS=0.1152P AD=0.1584P PS=1U
+ PD=1.6U
M$4479 \$3047 RA QAb VSS nfet_03v3 L=0.28U W=0.36U AS=0.1584P AD=0.1152P
+ PS=1.6U PD=1U
M$4480 QBb RB \$3047 VSS nfet_03v3 L=0.28U W=0.36U AS=0.1152P AD=0.1584P PS=1U
+ PD=1.6U
M$4481 VSS RB \$3466 VSS nfet_03v3 L=0.28U W=0.36U AS=0.1854P AD=0.1584P
+ PS=1.75U PD=1.6U
M$4482 VSS RB \$3184 VSS nfet_03v3 L=0.28U W=0.36U AS=0.1854P AD=0.1584P
+ PS=1.75U PD=1.6U
M$4483 \$3185 RA VSS VSS nfet_03v3 L=0.28U W=0.36U AS=0.1656P AD=0.1944P
+ PS=1.64U PD=1.8U
M$4484 \$3471 RA VSS VSS nfet_03v3 L=0.28U W=0.36U AS=0.1656P AD=0.1944P
+ PS=1.64U PD=1.8U
M$4485 \$3048 RA QAb VSS nfet_03v3 L=0.28U W=0.36U AS=0.1584P AD=0.1152P
+ PS=1.6U PD=1U
M$4486 QBb RB \$3048 VSS nfet_03v3 L=0.28U W=0.36U AS=0.1152P AD=0.1584P PS=1U
+ PD=1.6U
M$4487 \$3470 RA QAb VSS nfet_03v3 L=0.28U W=0.36U AS=0.1584P AD=0.1152P
+ PS=1.6U PD=1U
M$4488 QBb RB \$3470 VSS nfet_03v3 L=0.28U W=0.36U AS=0.1152P AD=0.1584P PS=1U
+ PD=1.6U
M$4489 VSS RB \$3186 VSS nfet_03v3 L=0.28U W=0.36U AS=0.1854P AD=0.1584P
+ PS=1.75U PD=1.6U
M$4490 VSS RB \$3472 VSS nfet_03v3 L=0.28U W=0.36U AS=0.1854P AD=0.1584P
+ PS=1.75U PD=1.6U
M$4491 \$3187 RA VSS VSS nfet_03v3 L=0.28U W=0.36U AS=0.1656P AD=0.1944P
+ PS=1.64U PD=1.8U
M$4492 \$3477 RA VSS VSS nfet_03v3 L=0.28U W=0.36U AS=0.1656P AD=0.1944P
+ PS=1.64U PD=1.8U
M$4493 \$3049 RA QAb VSS nfet_03v3 L=0.28U W=0.36U AS=0.1584P AD=0.1152P
+ PS=1.6U PD=1U
M$4494 QBb RB \$3049 VSS nfet_03v3 L=0.28U W=0.36U AS=0.1152P AD=0.1584P PS=1U
+ PD=1.6U
M$4495 \$3476 RA QAb VSS nfet_03v3 L=0.28U W=0.36U AS=0.1584P AD=0.1152P
+ PS=1.6U PD=1U
M$4496 QBb RB \$3476 VSS nfet_03v3 L=0.28U W=0.36U AS=0.1152P AD=0.1584P PS=1U
+ PD=1.6U
M$4497 VSS RB \$3188 VSS nfet_03v3 L=0.28U W=0.36U AS=0.1854P AD=0.1584P
+ PS=1.75U PD=1.6U
M$4498 VSS RB \$3478 VSS nfet_03v3 L=0.28U W=0.36U AS=0.1854P AD=0.1584P
+ PS=1.75U PD=1.6U
M$4499 \$3189 RA VSS VSS nfet_03v3 L=0.28U W=0.36U AS=0.1656P AD=0.1944P
+ PS=1.64U PD=1.8U
M$4500 \$3483 RA VSS VSS nfet_03v3 L=0.28U W=0.36U AS=0.1656P AD=0.1944P
+ PS=1.64U PD=1.8U
M$4501 \$3482 RA QAb VSS nfet_03v3 L=0.28U W=0.36U AS=0.1584P AD=0.1152P
+ PS=1.6U PD=1U
M$4502 QBb RB \$3482 VSS nfet_03v3 L=0.28U W=0.36U AS=0.1152P AD=0.1584P PS=1U
+ PD=1.6U
M$4503 \$3050 RA QAb VSS nfet_03v3 L=0.28U W=0.36U AS=0.1584P AD=0.1152P
+ PS=1.6U PD=1U
M$4504 QBb RB \$3050 VSS nfet_03v3 L=0.28U W=0.36U AS=0.1152P AD=0.1584P PS=1U
+ PD=1.6U
M$4505 VSS RB \$3190 VSS nfet_03v3 L=0.28U W=0.36U AS=0.1854P AD=0.1584P
+ PS=1.75U PD=1.6U
M$4506 VSS RB \$3484 VSS nfet_03v3 L=0.28U W=0.36U AS=0.1854P AD=0.1584P
+ PS=1.75U PD=1.6U
M$4507 \$3620 WE VSS VSS nfet_03v3 L=0.28U W=0.72U AS=0.3168P AD=0.1872P
+ PS=2.32U PD=1.24U
M$4508 \$3383 CLK \$3620 VSS nfet_03v3 L=0.28U W=0.72U AS=0.1872P AD=0.3168P
+ PS=1.24U PD=2.32U
M$4509 WECLK \$3383 VSS VSS nfet_03v3 L=0.28U W=1.27U AS=0.4487P AD=0.3302P
+ PS=3.34U PD=2.31U
M$4513 \$3388 D|Q VSS VSS nfet_03v3 L=0.28U W=0.36U AS=0.1584P AD=0.1188P
+ PS=1.6U PD=1.02U
M$4514 \$3389 WECLK \$3388 VSS nfet_03v3 L=0.28U W=0.36U AS=0.1188P AD=0.1278P
+ PS=1.02U PD=1.07U
M$4515 \$3624 \$3390 \$3389 VSS nfet_03v3 L=0.28U W=0.36U AS=0.1278P AD=0.0567P
+ PS=1.07U PD=0.675U
M$4516 VSS WECLKb \$3624 VSS nfet_03v3 L=0.28U W=0.36U AS=0.0567P AD=0.1584P
+ PS=0.675U PD=1.6U
M$4517 VSS \$3389 \$3390 VSS nfet_03v3 L=0.28U W=0.36U AS=0.1584P AD=0.0972P
+ PS=1.6U PD=0.9U
M$4518 \$3391 \$3389 VSS VSS nfet_03v3 L=0.28U W=0.36U AS=0.0972P AD=0.18P
+ PS=0.9U PD=1.72U
M$4519 \$3395 D|Q VSS VSS nfet_03v3 L=0.28U W=0.36U AS=0.1584P AD=0.1188P
+ PS=1.6U PD=1.02U
M$4520 \$3396 WECLK \$3395 VSS nfet_03v3 L=0.28U W=0.36U AS=0.1188P AD=0.1278P
+ PS=1.02U PD=1.07U
M$4521 \$3631 \$3397 \$3396 VSS nfet_03v3 L=0.28U W=0.36U AS=0.1278P AD=0.0567P
+ PS=1.07U PD=0.675U
M$4522 VSS WECLKb \$3631 VSS nfet_03v3 L=0.28U W=0.36U AS=0.0567P AD=0.1584P
+ PS=0.675U PD=1.6U
M$4523 VSS \$3396 \$3397 VSS nfet_03v3 L=0.28U W=0.36U AS=0.1584P AD=0.0972P
+ PS=1.6U PD=0.9U
M$4524 \$3398 \$3396 VSS VSS nfet_03v3 L=0.28U W=0.36U AS=0.0972P AD=0.18P
+ PS=0.9U PD=1.72U
M$4525 \$3401 D|Q VSS VSS nfet_03v3 L=0.28U W=0.36U AS=0.1584P AD=0.1188P
+ PS=1.6U PD=1.02U
M$4526 \$3402 WECLK \$3401 VSS nfet_03v3 L=0.28U W=0.36U AS=0.1188P AD=0.1278P
+ PS=1.02U PD=1.07U
M$4527 \$3638 \$3403 \$3402 VSS nfet_03v3 L=0.28U W=0.36U AS=0.1278P AD=0.0567P
+ PS=1.07U PD=0.675U
M$4528 VSS WECLKb \$3638 VSS nfet_03v3 L=0.28U W=0.36U AS=0.0567P AD=0.1584P
+ PS=0.675U PD=1.6U
M$4529 VSS \$3402 \$3403 VSS nfet_03v3 L=0.28U W=0.36U AS=0.1584P AD=0.0972P
+ PS=1.6U PD=0.9U
M$4530 \$3404 \$3402 VSS VSS nfet_03v3 L=0.28U W=0.36U AS=0.0972P AD=0.18P
+ PS=0.9U PD=1.72U
M$4531 \$3407 D|Q VSS VSS nfet_03v3 L=0.28U W=0.36U AS=0.1584P AD=0.1188P
+ PS=1.6U PD=1.02U
M$4532 \$3408 WECLK \$3407 VSS nfet_03v3 L=0.28U W=0.36U AS=0.1188P AD=0.1278P
+ PS=1.02U PD=1.07U
M$4533 \$3646 \$3409 \$3408 VSS nfet_03v3 L=0.28U W=0.36U AS=0.1278P AD=0.0567P
+ PS=1.07U PD=0.675U
M$4534 VSS WECLKb \$3646 VSS nfet_03v3 L=0.28U W=0.36U AS=0.0567P AD=0.1584P
+ PS=0.675U PD=1.6U
M$4535 VSS \$3408 \$3409 VSS nfet_03v3 L=0.28U W=0.36U AS=0.1584P AD=0.0972P
+ PS=1.6U PD=0.9U
M$4536 \$3410 \$3408 VSS VSS nfet_03v3 L=0.28U W=0.36U AS=0.0972P AD=0.18P
+ PS=0.9U PD=1.72U
M$4537 \$3413 D|Q VSS VSS nfet_03v3 L=0.28U W=0.36U AS=0.1584P AD=0.1188P
+ PS=1.6U PD=1.02U
M$4538 \$3414 WECLK \$3413 VSS nfet_03v3 L=0.28U W=0.36U AS=0.1188P AD=0.1278P
+ PS=1.02U PD=1.07U
M$4539 \$3652 \$3415 \$3414 VSS nfet_03v3 L=0.28U W=0.36U AS=0.1278P AD=0.0567P
+ PS=1.07U PD=0.675U
M$4540 VSS WECLKb \$3652 VSS nfet_03v3 L=0.28U W=0.36U AS=0.0567P AD=0.1584P
+ PS=0.675U PD=1.6U
M$4541 VSS \$3414 \$3415 VSS nfet_03v3 L=0.28U W=0.36U AS=0.1584P AD=0.0972P
+ PS=1.6U PD=0.9U
M$4542 \$3416 \$3414 VSS VSS nfet_03v3 L=0.28U W=0.36U AS=0.0972P AD=0.18P
+ PS=0.9U PD=1.72U
M$4543 \$3419 D|Q VSS VSS nfet_03v3 L=0.28U W=0.36U AS=0.1584P AD=0.1188P
+ PS=1.6U PD=1.02U
M$4544 \$3420 WECLK \$3419 VSS nfet_03v3 L=0.28U W=0.36U AS=0.1188P AD=0.1278P
+ PS=1.02U PD=1.07U
M$4545 \$3659 \$3421 \$3420 VSS nfet_03v3 L=0.28U W=0.36U AS=0.1278P AD=0.0567P
+ PS=1.07U PD=0.675U
M$4546 VSS WECLKb \$3659 VSS nfet_03v3 L=0.28U W=0.36U AS=0.0567P AD=0.1584P
+ PS=0.675U PD=1.6U
M$4547 VSS \$3420 \$3421 VSS nfet_03v3 L=0.28U W=0.36U AS=0.1584P AD=0.0972P
+ PS=1.6U PD=0.9U
M$4548 \$3422 \$3420 VSS VSS nfet_03v3 L=0.28U W=0.36U AS=0.0972P AD=0.18P
+ PS=0.9U PD=1.72U
M$4549 \$3425 D|Q VSS VSS nfet_03v3 L=0.28U W=0.36U AS=0.1584P AD=0.1188P
+ PS=1.6U PD=1.02U
M$4550 \$3426 WECLK \$3425 VSS nfet_03v3 L=0.28U W=0.36U AS=0.1188P AD=0.1278P
+ PS=1.02U PD=1.07U
M$4551 \$3666 \$3427 \$3426 VSS nfet_03v3 L=0.28U W=0.36U AS=0.1278P AD=0.0567P
+ PS=1.07U PD=0.675U
M$4552 VSS WECLKb \$3666 VSS nfet_03v3 L=0.28U W=0.36U AS=0.0567P AD=0.1584P
+ PS=0.675U PD=1.6U
M$4553 VSS \$3426 \$3427 VSS nfet_03v3 L=0.28U W=0.36U AS=0.1584P AD=0.0972P
+ PS=1.6U PD=0.9U
M$4554 \$3428 \$3426 VSS VSS nfet_03v3 L=0.28U W=0.36U AS=0.0972P AD=0.18P
+ PS=0.9U PD=1.72U
M$4555 \$3431 D|Q VSS VSS nfet_03v3 L=0.28U W=0.36U AS=0.1584P AD=0.1188P
+ PS=1.6U PD=1.02U
M$4556 \$3432 WECLK \$3431 VSS nfet_03v3 L=0.28U W=0.36U AS=0.1188P AD=0.1278P
+ PS=1.02U PD=1.07U
M$4557 \$3674 \$3433 \$3432 VSS nfet_03v3 L=0.28U W=0.36U AS=0.1278P AD=0.0567P
+ PS=1.07U PD=0.675U
M$4558 VSS WECLKb \$3674 VSS nfet_03v3 L=0.28U W=0.36U AS=0.0567P AD=0.1584P
+ PS=0.675U PD=1.6U
M$4559 VSS \$3432 \$3433 VSS nfet_03v3 L=0.28U W=0.36U AS=0.1584P AD=0.0972P
+ PS=1.6U PD=0.9U
M$4560 \$3434 \$3432 VSS VSS nfet_03v3 L=0.28U W=0.36U AS=0.0972P AD=0.18P
+ PS=0.9U PD=1.72U
M$4561 \$3437 D|Q VSS VSS nfet_03v3 L=0.28U W=0.36U AS=0.1584P AD=0.1188P
+ PS=1.6U PD=1.02U
M$4562 \$3438 WECLK \$3437 VSS nfet_03v3 L=0.28U W=0.36U AS=0.1188P AD=0.1278P
+ PS=1.02U PD=1.07U
M$4563 \$3682 \$3439 \$3438 VSS nfet_03v3 L=0.28U W=0.36U AS=0.1278P AD=0.0567P
+ PS=1.07U PD=0.675U
M$4564 VSS WECLKb \$3682 VSS nfet_03v3 L=0.28U W=0.36U AS=0.0567P AD=0.1584P
+ PS=0.675U PD=1.6U
M$4565 VSS \$3438 \$3439 VSS nfet_03v3 L=0.28U W=0.36U AS=0.1584P AD=0.0972P
+ PS=1.6U PD=0.9U
M$4566 \$3440 \$3438 VSS VSS nfet_03v3 L=0.28U W=0.36U AS=0.0972P AD=0.18P
+ PS=0.9U PD=1.72U
M$4567 \$3443 D|Q VSS VSS nfet_03v3 L=0.28U W=0.36U AS=0.1584P AD=0.1188P
+ PS=1.6U PD=1.02U
M$4568 \$3444 WECLK \$3443 VSS nfet_03v3 L=0.28U W=0.36U AS=0.1188P AD=0.1278P
+ PS=1.02U PD=1.07U
M$4569 \$3688 \$3445 \$3444 VSS nfet_03v3 L=0.28U W=0.36U AS=0.1278P AD=0.0567P
+ PS=1.07U PD=0.675U
M$4570 VSS WECLKb \$3688 VSS nfet_03v3 L=0.28U W=0.36U AS=0.0567P AD=0.1584P
+ PS=0.675U PD=1.6U
M$4571 VSS \$3444 \$3445 VSS nfet_03v3 L=0.28U W=0.36U AS=0.1584P AD=0.0972P
+ PS=1.6U PD=0.9U
M$4572 \$3446 \$3444 VSS VSS nfet_03v3 L=0.28U W=0.36U AS=0.0972P AD=0.18P
+ PS=0.9U PD=1.72U
M$4573 \$3449 D|Q VSS VSS nfet_03v3 L=0.28U W=0.36U AS=0.1584P AD=0.1188P
+ PS=1.6U PD=1.02U
M$4574 \$3450 WECLK \$3449 VSS nfet_03v3 L=0.28U W=0.36U AS=0.1188P AD=0.1278P
+ PS=1.02U PD=1.07U
M$4575 \$3695 \$3451 \$3450 VSS nfet_03v3 L=0.28U W=0.36U AS=0.1278P AD=0.0567P
+ PS=1.07U PD=0.675U
M$4576 VSS WECLKb \$3695 VSS nfet_03v3 L=0.28U W=0.36U AS=0.0567P AD=0.1584P
+ PS=0.675U PD=1.6U
M$4577 VSS \$3450 \$3451 VSS nfet_03v3 L=0.28U W=0.36U AS=0.1584P AD=0.0972P
+ PS=1.6U PD=0.9U
M$4578 \$3452 \$3450 VSS VSS nfet_03v3 L=0.28U W=0.36U AS=0.0972P AD=0.18P
+ PS=0.9U PD=1.72U
M$4579 \$3455 D|Q VSS VSS nfet_03v3 L=0.28U W=0.36U AS=0.1584P AD=0.1188P
+ PS=1.6U PD=1.02U
M$4580 \$3456 WECLK \$3455 VSS nfet_03v3 L=0.28U W=0.36U AS=0.1188P AD=0.1278P
+ PS=1.02U PD=1.07U
M$4581 \$3702 \$3457 \$3456 VSS nfet_03v3 L=0.28U W=0.36U AS=0.1278P AD=0.0567P
+ PS=1.07U PD=0.675U
M$4582 VSS WECLKb \$3702 VSS nfet_03v3 L=0.28U W=0.36U AS=0.0567P AD=0.1584P
+ PS=0.675U PD=1.6U
M$4583 VSS \$3456 \$3457 VSS nfet_03v3 L=0.28U W=0.36U AS=0.1584P AD=0.0972P
+ PS=1.6U PD=0.9U
M$4584 \$3458 \$3456 VSS VSS nfet_03v3 L=0.28U W=0.36U AS=0.0972P AD=0.18P
+ PS=0.9U PD=1.72U
M$4585 \$3461 D|Q VSS VSS nfet_03v3 L=0.28U W=0.36U AS=0.1584P AD=0.1188P
+ PS=1.6U PD=1.02U
M$4586 \$3462 WECLK \$3461 VSS nfet_03v3 L=0.28U W=0.36U AS=0.1188P AD=0.1278P
+ PS=1.02U PD=1.07U
M$4587 \$3710 \$3463 \$3462 VSS nfet_03v3 L=0.28U W=0.36U AS=0.1278P AD=0.0567P
+ PS=1.07U PD=0.675U
M$4588 VSS WECLKb \$3710 VSS nfet_03v3 L=0.28U W=0.36U AS=0.0567P AD=0.1584P
+ PS=0.675U PD=1.6U
M$4589 VSS \$3462 \$3463 VSS nfet_03v3 L=0.28U W=0.36U AS=0.1584P AD=0.0972P
+ PS=1.6U PD=0.9U
M$4590 \$3464 \$3462 VSS VSS nfet_03v3 L=0.28U W=0.36U AS=0.0972P AD=0.18P
+ PS=0.9U PD=1.72U
M$4591 \$3467 D|Q VSS VSS nfet_03v3 L=0.28U W=0.36U AS=0.1584P AD=0.1188P
+ PS=1.6U PD=1.02U
M$4592 \$3468 WECLK \$3467 VSS nfet_03v3 L=0.28U W=0.36U AS=0.1188P AD=0.1278P
+ PS=1.02U PD=1.07U
M$4593 \$3717 \$3469 \$3468 VSS nfet_03v3 L=0.28U W=0.36U AS=0.1278P AD=0.0567P
+ PS=1.07U PD=0.675U
M$4594 VSS WECLKb \$3717 VSS nfet_03v3 L=0.28U W=0.36U AS=0.0567P AD=0.1584P
+ PS=0.675U PD=1.6U
M$4595 VSS \$3468 \$3469 VSS nfet_03v3 L=0.28U W=0.36U AS=0.1584P AD=0.0972P
+ PS=1.6U PD=0.9U
M$4596 \$3470 \$3468 VSS VSS nfet_03v3 L=0.28U W=0.36U AS=0.0972P AD=0.18P
+ PS=0.9U PD=1.72U
M$4597 \$3473 D|Q VSS VSS nfet_03v3 L=0.28U W=0.36U AS=0.1584P AD=0.1188P
+ PS=1.6U PD=1.02U
M$4598 \$3474 WECLK \$3473 VSS nfet_03v3 L=0.28U W=0.36U AS=0.1188P AD=0.1278P
+ PS=1.02U PD=1.07U
M$4599 \$3681 \$3475 \$3474 VSS nfet_03v3 L=0.28U W=0.36U AS=0.1278P AD=0.0567P
+ PS=1.07U PD=0.675U
M$4600 VSS WECLKb \$3681 VSS nfet_03v3 L=0.28U W=0.36U AS=0.0567P AD=0.1584P
+ PS=0.675U PD=1.6U
M$4601 VSS \$3474 \$3475 VSS nfet_03v3 L=0.28U W=0.36U AS=0.1584P AD=0.0972P
+ PS=1.6U PD=0.9U
M$4602 \$3476 \$3474 VSS VSS nfet_03v3 L=0.28U W=0.36U AS=0.0972P AD=0.18P
+ PS=0.9U PD=1.72U
M$4603 \$3479 D|Q VSS VSS nfet_03v3 L=0.28U W=0.36U AS=0.1584P AD=0.1188P
+ PS=1.6U PD=1.02U
M$4604 \$3480 WECLK \$3479 VSS nfet_03v3 L=0.28U W=0.36U AS=0.1188P AD=0.1278P
+ PS=1.02U PD=1.07U
M$4605 \$3645 \$3481 \$3480 VSS nfet_03v3 L=0.28U W=0.36U AS=0.1278P AD=0.0567P
+ PS=1.07U PD=0.675U
M$4606 VSS WECLKb \$3645 VSS nfet_03v3 L=0.28U W=0.36U AS=0.0567P AD=0.1584P
+ PS=0.675U PD=1.6U
M$4607 VSS \$3480 \$3481 VSS nfet_03v3 L=0.28U W=0.36U AS=0.1584P AD=0.0972P
+ PS=1.6U PD=0.9U
M$4608 \$3482 \$3480 VSS VSS nfet_03v3 L=0.28U W=0.36U AS=0.0972P AD=0.18P
+ PS=0.9U PD=1.72U
M$4609 \$3868 WE VSS VSS nfet_03v3 L=0.28U W=0.72U AS=0.3168P AD=0.1872P
+ PS=2.32U PD=1.24U
M$4610 \$3734 CLK \$3868 VSS nfet_03v3 L=0.28U W=0.72U AS=0.1872P AD=0.3168P
+ PS=1.24U PD=2.32U
M$4611 WECLK \$3734 VSS VSS nfet_03v3 L=0.28U W=1.27U AS=0.4445P AD=0.3344P
+ PS=3.305U PD=2.345U
M$4615 \$3737 D|Q VSS VSS nfet_03v3 L=0.28U W=0.36U AS=0.1584P AD=0.1188P
+ PS=1.6U PD=1.02U
M$4616 \$3738 WECLK \$3737 VSS nfet_03v3 L=0.28U W=0.36U AS=0.1188P AD=0.1278P
+ PS=1.02U PD=1.07U
M$4617 \$3792 \$3739 \$3738 VSS nfet_03v3 L=0.28U W=0.36U AS=0.1278P AD=0.0567P
+ PS=1.07U PD=0.675U
M$4618 VSS WECLKb \$3792 VSS nfet_03v3 L=0.28U W=0.36U AS=0.0567P AD=0.1584P
+ PS=0.675U PD=1.6U
M$4619 VSS \$3738 \$3739 VSS nfet_03v3 L=0.28U W=0.36U AS=0.1584P AD=0.0972P
+ PS=1.6U PD=0.9U
M$4620 \$3718 \$3738 VSS VSS nfet_03v3 L=0.28U W=0.36U AS=0.0972P AD=0.18P
+ PS=0.9U PD=1.72U
M$4621 \$3740 D|Q VSS VSS nfet_03v3 L=0.28U W=0.36U AS=0.1584P AD=0.1188P
+ PS=1.6U PD=1.02U
M$4622 \$3741 WECLK \$3740 VSS nfet_03v3 L=0.28U W=0.36U AS=0.1188P AD=0.1278P
+ PS=1.02U PD=1.07U
M$4623 \$3801 \$3742 \$3741 VSS nfet_03v3 L=0.28U W=0.36U AS=0.1278P AD=0.0567P
+ PS=1.07U PD=0.675U
M$4624 VSS WECLKb \$3801 VSS nfet_03v3 L=0.28U W=0.36U AS=0.0567P AD=0.1584P
+ PS=0.675U PD=1.6U
M$4625 VSS \$3741 \$3742 VSS nfet_03v3 L=0.28U W=0.36U AS=0.1584P AD=0.0972P
+ PS=1.6U PD=0.9U
M$4626 \$3719 \$3741 VSS VSS nfet_03v3 L=0.28U W=0.36U AS=0.0972P AD=0.18P
+ PS=0.9U PD=1.72U
M$4627 \$3743 D|Q VSS VSS nfet_03v3 L=0.28U W=0.36U AS=0.1584P AD=0.1188P
+ PS=1.6U PD=1.02U
M$4628 \$3744 WECLK \$3743 VSS nfet_03v3 L=0.28U W=0.36U AS=0.1188P AD=0.1278P
+ PS=1.02U PD=1.07U
M$4629 \$3810 \$3745 \$3744 VSS nfet_03v3 L=0.28U W=0.36U AS=0.1278P AD=0.0567P
+ PS=1.07U PD=0.675U
M$4630 VSS WECLKb \$3810 VSS nfet_03v3 L=0.28U W=0.36U AS=0.0567P AD=0.1584P
+ PS=0.675U PD=1.6U
M$4631 VSS \$3744 \$3745 VSS nfet_03v3 L=0.28U W=0.36U AS=0.1584P AD=0.0972P
+ PS=1.6U PD=0.9U
M$4632 \$3720 \$3744 VSS VSS nfet_03v3 L=0.28U W=0.36U AS=0.0972P AD=0.18P
+ PS=0.9U PD=1.72U
M$4633 \$3746 D|Q VSS VSS nfet_03v3 L=0.28U W=0.36U AS=0.1584P AD=0.1188P
+ PS=1.6U PD=1.02U
M$4634 \$3747 WECLK \$3746 VSS nfet_03v3 L=0.28U W=0.36U AS=0.1188P AD=0.1278P
+ PS=1.02U PD=1.07U
M$4635 \$3819 \$3748 \$3747 VSS nfet_03v3 L=0.28U W=0.36U AS=0.1278P AD=0.0567P
+ PS=1.07U PD=0.675U
M$4636 VSS WECLKb \$3819 VSS nfet_03v3 L=0.28U W=0.36U AS=0.0567P AD=0.1584P
+ PS=0.675U PD=1.6U
M$4637 VSS \$3747 \$3748 VSS nfet_03v3 L=0.28U W=0.36U AS=0.1584P AD=0.0972P
+ PS=1.6U PD=0.9U
M$4638 \$3721 \$3747 VSS VSS nfet_03v3 L=0.28U W=0.36U AS=0.0972P AD=0.18P
+ PS=0.9U PD=1.72U
M$4639 \$3749 D|Q VSS VSS nfet_03v3 L=0.28U W=0.36U AS=0.1584P AD=0.1188P
+ PS=1.6U PD=1.02U
M$4640 \$3750 WECLK \$3749 VSS nfet_03v3 L=0.28U W=0.36U AS=0.1188P AD=0.1278P
+ PS=1.02U PD=1.07U
M$4641 \$3828 \$3751 \$3750 VSS nfet_03v3 L=0.28U W=0.36U AS=0.1278P AD=0.0567P
+ PS=1.07U PD=0.675U
M$4642 VSS WECLKb \$3828 VSS nfet_03v3 L=0.28U W=0.36U AS=0.0567P AD=0.1584P
+ PS=0.675U PD=1.6U
M$4643 VSS \$3750 \$3751 VSS nfet_03v3 L=0.28U W=0.36U AS=0.1584P AD=0.0972P
+ PS=1.6U PD=0.9U
M$4644 \$3722 \$3750 VSS VSS nfet_03v3 L=0.28U W=0.36U AS=0.0972P AD=0.18P
+ PS=0.9U PD=1.72U
M$4645 \$3752 D|Q VSS VSS nfet_03v3 L=0.28U W=0.36U AS=0.1584P AD=0.1188P
+ PS=1.6U PD=1.02U
M$4646 \$3753 WECLK \$3752 VSS nfet_03v3 L=0.28U W=0.36U AS=0.1188P AD=0.1278P
+ PS=1.02U PD=1.07U
M$4647 \$3831 \$3754 \$3753 VSS nfet_03v3 L=0.28U W=0.36U AS=0.1278P AD=0.0567P
+ PS=1.07U PD=0.675U
M$4648 VSS WECLKb \$3831 VSS nfet_03v3 L=0.28U W=0.36U AS=0.0567P AD=0.1584P
+ PS=0.675U PD=1.6U
M$4649 VSS \$3753 \$3754 VSS nfet_03v3 L=0.28U W=0.36U AS=0.1584P AD=0.0972P
+ PS=1.6U PD=0.9U
M$4650 \$3723 \$3753 VSS VSS nfet_03v3 L=0.28U W=0.36U AS=0.0972P AD=0.18P
+ PS=0.9U PD=1.72U
M$4651 \$3755 D|Q VSS VSS nfet_03v3 L=0.28U W=0.36U AS=0.1584P AD=0.1188P
+ PS=1.6U PD=1.02U
M$4652 \$3756 WECLK \$3755 VSS nfet_03v3 L=0.28U W=0.36U AS=0.1188P AD=0.1278P
+ PS=1.02U PD=1.07U
M$4653 \$3825 \$3757 \$3756 VSS nfet_03v3 L=0.28U W=0.36U AS=0.1278P AD=0.0567P
+ PS=1.07U PD=0.675U
M$4654 VSS WECLKb \$3825 VSS nfet_03v3 L=0.28U W=0.36U AS=0.0567P AD=0.1584P
+ PS=0.675U PD=1.6U
M$4655 VSS \$3756 \$3757 VSS nfet_03v3 L=0.28U W=0.36U AS=0.1584P AD=0.0972P
+ PS=1.6U PD=0.9U
M$4656 \$3724 \$3756 VSS VSS nfet_03v3 L=0.28U W=0.36U AS=0.0972P AD=0.18P
+ PS=0.9U PD=1.72U
M$4657 \$3758 D|Q VSS VSS nfet_03v3 L=0.28U W=0.36U AS=0.1584P AD=0.1188P
+ PS=1.6U PD=1.02U
M$4658 \$3759 WECLK \$3758 VSS nfet_03v3 L=0.28U W=0.36U AS=0.1188P AD=0.1278P
+ PS=1.02U PD=1.07U
M$4659 \$3823 \$3760 \$3759 VSS nfet_03v3 L=0.28U W=0.36U AS=0.1278P AD=0.0567P
+ PS=1.07U PD=0.675U
M$4660 VSS WECLKb \$3823 VSS nfet_03v3 L=0.28U W=0.36U AS=0.0567P AD=0.1584P
+ PS=0.675U PD=1.6U
M$4661 VSS \$3759 \$3760 VSS nfet_03v3 L=0.28U W=0.36U AS=0.1584P AD=0.0972P
+ PS=1.6U PD=0.9U
M$4662 \$3725 \$3759 VSS VSS nfet_03v3 L=0.28U W=0.36U AS=0.0972P AD=0.18P
+ PS=0.9U PD=1.72U
M$4663 \$3761 D|Q VSS VSS nfet_03v3 L=0.28U W=0.36U AS=0.1584P AD=0.1188P
+ PS=1.6U PD=1.02U
M$4664 \$3762 WECLK \$3761 VSS nfet_03v3 L=0.28U W=0.36U AS=0.1188P AD=0.1278P
+ PS=1.02U PD=1.07U
M$4665 \$3817 \$3763 \$3762 VSS nfet_03v3 L=0.28U W=0.36U AS=0.1278P AD=0.0567P
+ PS=1.07U PD=0.675U
M$4666 VSS WECLKb \$3817 VSS nfet_03v3 L=0.28U W=0.36U AS=0.0567P AD=0.1584P
+ PS=0.675U PD=1.6U
M$4667 VSS \$3762 \$3763 VSS nfet_03v3 L=0.28U W=0.36U AS=0.1584P AD=0.0972P
+ PS=1.6U PD=0.9U
M$4668 \$3726 \$3762 VSS VSS nfet_03v3 L=0.28U W=0.36U AS=0.0972P AD=0.18P
+ PS=0.9U PD=1.72U
M$4669 \$3764 D|Q VSS VSS nfet_03v3 L=0.28U W=0.36U AS=0.1584P AD=0.1188P
+ PS=1.6U PD=1.02U
M$4670 \$3765 WECLK \$3764 VSS nfet_03v3 L=0.28U W=0.36U AS=0.1188P AD=0.1278P
+ PS=1.02U PD=1.07U
M$4671 \$3814 \$3766 \$3765 VSS nfet_03v3 L=0.28U W=0.36U AS=0.1278P AD=0.0567P
+ PS=1.07U PD=0.675U
M$4672 VSS WECLKb \$3814 VSS nfet_03v3 L=0.28U W=0.36U AS=0.0567P AD=0.1584P
+ PS=0.675U PD=1.6U
M$4673 VSS \$3765 \$3766 VSS nfet_03v3 L=0.28U W=0.36U AS=0.1584P AD=0.0972P
+ PS=1.6U PD=0.9U
M$4674 \$3727 \$3765 VSS VSS nfet_03v3 L=0.28U W=0.36U AS=0.0972P AD=0.18P
+ PS=0.9U PD=1.72U
M$4675 \$3767 D|Q VSS VSS nfet_03v3 L=0.28U W=0.36U AS=0.1584P AD=0.1188P
+ PS=1.6U PD=1.02U
M$4676 \$3768 WECLK \$3767 VSS nfet_03v3 L=0.28U W=0.36U AS=0.1188P AD=0.1278P
+ PS=1.02U PD=1.07U
M$4677 \$3808 \$3769 \$3768 VSS nfet_03v3 L=0.28U W=0.36U AS=0.1278P AD=0.0567P
+ PS=1.07U PD=0.675U
M$4678 VSS WECLKb \$3808 VSS nfet_03v3 L=0.28U W=0.36U AS=0.0567P AD=0.1584P
+ PS=0.675U PD=1.6U
M$4679 VSS \$3768 \$3769 VSS nfet_03v3 L=0.28U W=0.36U AS=0.1584P AD=0.0972P
+ PS=1.6U PD=0.9U
M$4680 \$3728 \$3768 VSS VSS nfet_03v3 L=0.28U W=0.36U AS=0.0972P AD=0.18P
+ PS=0.9U PD=1.72U
M$4681 \$3770 D|Q VSS VSS nfet_03v3 L=0.28U W=0.36U AS=0.1584P AD=0.1188P
+ PS=1.6U PD=1.02U
M$4682 \$3771 WECLK \$3770 VSS nfet_03v3 L=0.28U W=0.36U AS=0.1188P AD=0.1278P
+ PS=1.02U PD=1.07U
M$4683 \$3805 \$3772 \$3771 VSS nfet_03v3 L=0.28U W=0.36U AS=0.1278P AD=0.0567P
+ PS=1.07U PD=0.675U
M$4684 VSS WECLKb \$3805 VSS nfet_03v3 L=0.28U W=0.36U AS=0.0567P AD=0.1584P
+ PS=0.675U PD=1.6U
M$4685 VSS \$3771 \$3772 VSS nfet_03v3 L=0.28U W=0.36U AS=0.1584P AD=0.0972P
+ PS=1.6U PD=0.9U
M$4686 \$3729 \$3771 VSS VSS nfet_03v3 L=0.28U W=0.36U AS=0.0972P AD=0.18P
+ PS=0.9U PD=1.72U
M$4687 \$3773 D|Q VSS VSS nfet_03v3 L=0.28U W=0.36U AS=0.1584P AD=0.1188P
+ PS=1.6U PD=1.02U
M$4688 \$3774 WECLK \$3773 VSS nfet_03v3 L=0.28U W=0.36U AS=0.1188P AD=0.1278P
+ PS=1.02U PD=1.07U
M$4689 \$3799 \$3775 \$3774 VSS nfet_03v3 L=0.28U W=0.36U AS=0.1278P AD=0.0567P
+ PS=1.07U PD=0.675U
M$4690 VSS WECLKb \$3799 VSS nfet_03v3 L=0.28U W=0.36U AS=0.0567P AD=0.1584P
+ PS=0.675U PD=1.6U
M$4691 VSS \$3774 \$3775 VSS nfet_03v3 L=0.28U W=0.36U AS=0.1584P AD=0.0972P
+ PS=1.6U PD=0.9U
M$4692 \$3730 \$3774 VSS VSS nfet_03v3 L=0.28U W=0.36U AS=0.0972P AD=0.18P
+ PS=0.9U PD=1.72U
M$4693 \$3776 D|Q VSS VSS nfet_03v3 L=0.28U W=0.36U AS=0.1584P AD=0.1188P
+ PS=1.6U PD=1.02U
M$4694 \$3777 WECLK \$3776 VSS nfet_03v3 L=0.28U W=0.36U AS=0.1188P AD=0.1278P
+ PS=1.02U PD=1.07U
M$4695 \$3796 \$3778 \$3777 VSS nfet_03v3 L=0.28U W=0.36U AS=0.1278P AD=0.0567P
+ PS=1.07U PD=0.675U
M$4696 VSS WECLKb \$3796 VSS nfet_03v3 L=0.28U W=0.36U AS=0.0567P AD=0.1584P
+ PS=0.675U PD=1.6U
M$4697 VSS \$3777 \$3778 VSS nfet_03v3 L=0.28U W=0.36U AS=0.1584P AD=0.0972P
+ PS=1.6U PD=0.9U
M$4698 \$3731 \$3777 VSS VSS nfet_03v3 L=0.28U W=0.36U AS=0.0972P AD=0.18P
+ PS=0.9U PD=1.72U
M$4699 \$3779 D|Q VSS VSS nfet_03v3 L=0.28U W=0.36U AS=0.1584P AD=0.1188P
+ PS=1.6U PD=1.02U
M$4700 \$3780 WECLK \$3779 VSS nfet_03v3 L=0.28U W=0.36U AS=0.1188P AD=0.1278P
+ PS=1.02U PD=1.07U
M$4701 \$3789 \$3781 \$3780 VSS nfet_03v3 L=0.28U W=0.36U AS=0.1278P AD=0.0567P
+ PS=1.07U PD=0.675U
M$4702 VSS WECLKb \$3789 VSS nfet_03v3 L=0.28U W=0.36U AS=0.0567P AD=0.1584P
+ PS=0.675U PD=1.6U
M$4703 VSS \$3780 \$3781 VSS nfet_03v3 L=0.28U W=0.36U AS=0.1584P AD=0.0972P
+ PS=1.6U PD=0.9U
M$4704 \$3732 \$3780 VSS VSS nfet_03v3 L=0.28U W=0.36U AS=0.0972P AD=0.18P
+ PS=0.9U PD=1.72U
M$4705 \$3782 D|Q VSS VSS nfet_03v3 L=0.28U W=0.36U AS=0.1584P AD=0.1188P
+ PS=1.6U PD=1.02U
M$4706 \$3783 WECLK \$3782 VSS nfet_03v3 L=0.28U W=0.36U AS=0.1188P AD=0.1278P
+ PS=1.02U PD=1.07U
M$4707 \$3786 \$3784 \$3783 VSS nfet_03v3 L=0.28U W=0.36U AS=0.1278P AD=0.0567P
+ PS=1.07U PD=0.675U
M$4708 VSS WECLKb \$3786 VSS nfet_03v3 L=0.28U W=0.36U AS=0.0567P AD=0.1584P
+ PS=0.675U PD=1.6U
M$4709 VSS \$3783 \$3784 VSS nfet_03v3 L=0.28U W=0.36U AS=0.1584P AD=0.0972P
+ PS=1.6U PD=0.9U
M$4710 \$3733 \$3783 VSS VSS nfet_03v3 L=0.28U W=0.36U AS=0.0972P AD=0.18P
+ PS=0.9U PD=1.72U
M$4711 \$3836 RA VSS VSS nfet_03v3 L=0.28U W=0.36U AS=0.1656P AD=0.1944P
+ PS=1.64U PD=1.8U
M$4712 \$4069 RA VSS VSS nfet_03v3 L=0.28U W=0.36U AS=0.1656P AD=0.1944P
+ PS=1.64U PD=1.8U
M$4713 \$4068 RA QAb VSS nfet_03v3 L=0.28U W=0.36U AS=0.1584P AD=0.1152P
+ PS=1.6U PD=1U
M$4714 QBb RB \$4068 VSS nfet_03v3 L=0.28U W=0.36U AS=0.1152P AD=0.1584P PS=1U
+ PD=1.6U
M$4715 \$3718 RA QAb VSS nfet_03v3 L=0.28U W=0.36U AS=0.1584P AD=0.1152P
+ PS=1.6U PD=1U
M$4716 QBb RB \$3718 VSS nfet_03v3 L=0.28U W=0.36U AS=0.1152P AD=0.1584P PS=1U
+ PD=1.6U
M$4717 VSS RB \$4070 VSS nfet_03v3 L=0.28U W=0.36U AS=0.1854P AD=0.1584P
+ PS=1.75U PD=1.6U
M$4718 VSS RB \$3837 VSS nfet_03v3 L=0.28U W=0.36U AS=0.1854P AD=0.1584P
+ PS=1.75U PD=1.6U
M$4719 \$4076 RA VSS VSS nfet_03v3 L=0.28U W=0.36U AS=0.1656P AD=0.1944P
+ PS=1.64U PD=1.8U
M$4720 \$3838 RA VSS VSS nfet_03v3 L=0.28U W=0.36U AS=0.1656P AD=0.1944P
+ PS=1.64U PD=1.8U
M$4721 \$3719 RA QAb VSS nfet_03v3 L=0.28U W=0.36U AS=0.1584P AD=0.1152P
+ PS=1.6U PD=1U
M$4722 QBb RB \$3719 VSS nfet_03v3 L=0.28U W=0.36U AS=0.1152P AD=0.1584P PS=1U
+ PD=1.6U
M$4723 \$4075 RA QAb VSS nfet_03v3 L=0.28U W=0.36U AS=0.1584P AD=0.1152P
+ PS=1.6U PD=1U
M$4724 QBb RB \$4075 VSS nfet_03v3 L=0.28U W=0.36U AS=0.1152P AD=0.1584P PS=1U
+ PD=1.6U
M$4725 VSS RB \$3839 VSS nfet_03v3 L=0.28U W=0.36U AS=0.1854P AD=0.1584P
+ PS=1.75U PD=1.6U
M$4726 VSS RB \$4077 VSS nfet_03v3 L=0.28U W=0.36U AS=0.1854P AD=0.1584P
+ PS=1.75U PD=1.6U
M$4727 \$4082 RA VSS VSS nfet_03v3 L=0.28U W=0.36U AS=0.1656P AD=0.1944P
+ PS=1.64U PD=1.8U
M$4728 \$3840 RA VSS VSS nfet_03v3 L=0.28U W=0.36U AS=0.1656P AD=0.1944P
+ PS=1.64U PD=1.8U
M$4729 \$3720 RA QAb VSS nfet_03v3 L=0.28U W=0.36U AS=0.1584P AD=0.1152P
+ PS=1.6U PD=1U
M$4730 QBb RB \$3720 VSS nfet_03v3 L=0.28U W=0.36U AS=0.1152P AD=0.1584P PS=1U
+ PD=1.6U
M$4731 \$4081 RA QAb VSS nfet_03v3 L=0.28U W=0.36U AS=0.1584P AD=0.1152P
+ PS=1.6U PD=1U
M$4732 QBb RB \$4081 VSS nfet_03v3 L=0.28U W=0.36U AS=0.1152P AD=0.1584P PS=1U
+ PD=1.6U
M$4733 VSS RB \$3841 VSS nfet_03v3 L=0.28U W=0.36U AS=0.1854P AD=0.1584P
+ PS=1.75U PD=1.6U
M$4734 VSS RB \$4083 VSS nfet_03v3 L=0.28U W=0.36U AS=0.1854P AD=0.1584P
+ PS=1.75U PD=1.6U
M$4735 \$4088 RA VSS VSS nfet_03v3 L=0.28U W=0.36U AS=0.1656P AD=0.1944P
+ PS=1.64U PD=1.8U
M$4736 \$3842 RA VSS VSS nfet_03v3 L=0.28U W=0.36U AS=0.1656P AD=0.1944P
+ PS=1.64U PD=1.8U
M$4737 \$4087 RA QAb VSS nfet_03v3 L=0.28U W=0.36U AS=0.1584P AD=0.1152P
+ PS=1.6U PD=1U
M$4738 QBb RB \$4087 VSS nfet_03v3 L=0.28U W=0.36U AS=0.1152P AD=0.1584P PS=1U
+ PD=1.6U
M$4739 \$3721 RA QAb VSS nfet_03v3 L=0.28U W=0.36U AS=0.1584P AD=0.1152P
+ PS=1.6U PD=1U
M$4740 QBb RB \$3721 VSS nfet_03v3 L=0.28U W=0.36U AS=0.1152P AD=0.1584P PS=1U
+ PD=1.6U
M$4741 VSS RB \$4089 VSS nfet_03v3 L=0.28U W=0.36U AS=0.1854P AD=0.1584P
+ PS=1.75U PD=1.6U
M$4742 VSS RB \$3843 VSS nfet_03v3 L=0.28U W=0.36U AS=0.1854P AD=0.1584P
+ PS=1.75U PD=1.6U
M$4743 \$4094 RA VSS VSS nfet_03v3 L=0.28U W=0.36U AS=0.1656P AD=0.1944P
+ PS=1.64U PD=1.8U
M$4744 \$3844 RA VSS VSS nfet_03v3 L=0.28U W=0.36U AS=0.1656P AD=0.1944P
+ PS=1.64U PD=1.8U
M$4745 \$4093 RA QAb VSS nfet_03v3 L=0.28U W=0.36U AS=0.1584P AD=0.1152P
+ PS=1.6U PD=1U
M$4746 QBb RB \$4093 VSS nfet_03v3 L=0.28U W=0.36U AS=0.1152P AD=0.1584P PS=1U
+ PD=1.6U
M$4747 \$3722 RA QAb VSS nfet_03v3 L=0.28U W=0.36U AS=0.1584P AD=0.1152P
+ PS=1.6U PD=1U
M$4748 QBb RB \$3722 VSS nfet_03v3 L=0.28U W=0.36U AS=0.1152P AD=0.1584P PS=1U
+ PD=1.6U
M$4749 VSS RB \$3845 VSS nfet_03v3 L=0.28U W=0.36U AS=0.1854P AD=0.1584P
+ PS=1.75U PD=1.6U
M$4750 VSS RB \$4095 VSS nfet_03v3 L=0.28U W=0.36U AS=0.1854P AD=0.1584P
+ PS=1.75U PD=1.6U
M$4751 \$3846 RA VSS VSS nfet_03v3 L=0.28U W=0.36U AS=0.1656P AD=0.1944P
+ PS=1.64U PD=1.8U
M$4752 \$4100 RA VSS VSS nfet_03v3 L=0.28U W=0.36U AS=0.1656P AD=0.1944P
+ PS=1.64U PD=1.8U
M$4753 \$4099 RA QAb VSS nfet_03v3 L=0.28U W=0.36U AS=0.1584P AD=0.1152P
+ PS=1.6U PD=1U
M$4754 QBb RB \$4099 VSS nfet_03v3 L=0.28U W=0.36U AS=0.1152P AD=0.1584P PS=1U
+ PD=1.6U
M$4755 \$3723 RA QAb VSS nfet_03v3 L=0.28U W=0.36U AS=0.1584P AD=0.1152P
+ PS=1.6U PD=1U
M$4756 QBb RB \$3723 VSS nfet_03v3 L=0.28U W=0.36U AS=0.1152P AD=0.1584P PS=1U
+ PD=1.6U
M$4757 VSS RB \$3847 VSS nfet_03v3 L=0.28U W=0.36U AS=0.1854P AD=0.1584P
+ PS=1.75U PD=1.6U
M$4758 VSS RB \$4101 VSS nfet_03v3 L=0.28U W=0.36U AS=0.1854P AD=0.1584P
+ PS=1.75U PD=1.6U
M$4759 \$3848 RA VSS VSS nfet_03v3 L=0.28U W=0.36U AS=0.1656P AD=0.1944P
+ PS=1.64U PD=1.8U
M$4760 \$4106 RA VSS VSS nfet_03v3 L=0.28U W=0.36U AS=0.1656P AD=0.1944P
+ PS=1.64U PD=1.8U
M$4761 \$3724 RA QAb VSS nfet_03v3 L=0.28U W=0.36U AS=0.1584P AD=0.1152P
+ PS=1.6U PD=1U
M$4762 QBb RB \$3724 VSS nfet_03v3 L=0.28U W=0.36U AS=0.1152P AD=0.1584P PS=1U
+ PD=1.6U
M$4763 \$4105 RA QAb VSS nfet_03v3 L=0.28U W=0.36U AS=0.1584P AD=0.1152P
+ PS=1.6U PD=1U
M$4764 QBb RB \$4105 VSS nfet_03v3 L=0.28U W=0.36U AS=0.1152P AD=0.1584P PS=1U
+ PD=1.6U
M$4765 VSS RB \$3849 VSS nfet_03v3 L=0.28U W=0.36U AS=0.1854P AD=0.1584P
+ PS=1.75U PD=1.6U
M$4766 VSS RB \$4107 VSS nfet_03v3 L=0.28U W=0.36U AS=0.1854P AD=0.1584P
+ PS=1.75U PD=1.6U
M$4767 \$3850 RA VSS VSS nfet_03v3 L=0.28U W=0.36U AS=0.1656P AD=0.1944P
+ PS=1.64U PD=1.8U
M$4768 \$4112 RA VSS VSS nfet_03v3 L=0.28U W=0.36U AS=0.1656P AD=0.1944P
+ PS=1.64U PD=1.8U
M$4769 \$4111 RA QAb VSS nfet_03v3 L=0.28U W=0.36U AS=0.1584P AD=0.1152P
+ PS=1.6U PD=1U
M$4770 QBb RB \$4111 VSS nfet_03v3 L=0.28U W=0.36U AS=0.1152P AD=0.1584P PS=1U
+ PD=1.6U
M$4771 \$3725 RA QAb VSS nfet_03v3 L=0.28U W=0.36U AS=0.1584P AD=0.1152P
+ PS=1.6U PD=1U
M$4772 QBb RB \$3725 VSS nfet_03v3 L=0.28U W=0.36U AS=0.1152P AD=0.1584P PS=1U
+ PD=1.6U
M$4773 VSS RB \$3851 VSS nfet_03v3 L=0.28U W=0.36U AS=0.1854P AD=0.1584P
+ PS=1.75U PD=1.6U
M$4774 VSS RB \$4113 VSS nfet_03v3 L=0.28U W=0.36U AS=0.1854P AD=0.1584P
+ PS=1.75U PD=1.6U
M$4775 \$3852 RA VSS VSS nfet_03v3 L=0.28U W=0.36U AS=0.1656P AD=0.1944P
+ PS=1.64U PD=1.8U
M$4776 \$4118 RA VSS VSS nfet_03v3 L=0.28U W=0.36U AS=0.1656P AD=0.1944P
+ PS=1.64U PD=1.8U
M$4777 \$3726 RA QAb VSS nfet_03v3 L=0.28U W=0.36U AS=0.1584P AD=0.1152P
+ PS=1.6U PD=1U
M$4778 QBb RB \$3726 VSS nfet_03v3 L=0.28U W=0.36U AS=0.1152P AD=0.1584P PS=1U
+ PD=1.6U
M$4779 \$4117 RA QAb VSS nfet_03v3 L=0.28U W=0.36U AS=0.1584P AD=0.1152P
+ PS=1.6U PD=1U
M$4780 QBb RB \$4117 VSS nfet_03v3 L=0.28U W=0.36U AS=0.1152P AD=0.1584P PS=1U
+ PD=1.6U
M$4781 VSS RB \$3853 VSS nfet_03v3 L=0.28U W=0.36U AS=0.1854P AD=0.1584P
+ PS=1.75U PD=1.6U
M$4782 VSS RB \$4119 VSS nfet_03v3 L=0.28U W=0.36U AS=0.1854P AD=0.1584P
+ PS=1.75U PD=1.6U
M$4783 \$4124 RA VSS VSS nfet_03v3 L=0.28U W=0.36U AS=0.1656P AD=0.1944P
+ PS=1.64U PD=1.8U
M$4784 \$3854 RA VSS VSS nfet_03v3 L=0.28U W=0.36U AS=0.1656P AD=0.1944P
+ PS=1.64U PD=1.8U
M$4785 \$3727 RA QAb VSS nfet_03v3 L=0.28U W=0.36U AS=0.1584P AD=0.1152P
+ PS=1.6U PD=1U
M$4786 QBb RB \$3727 VSS nfet_03v3 L=0.28U W=0.36U AS=0.1152P AD=0.1584P PS=1U
+ PD=1.6U
M$4787 \$4123 RA QAb VSS nfet_03v3 L=0.28U W=0.36U AS=0.1584P AD=0.1152P
+ PS=1.6U PD=1U
M$4788 QBb RB \$4123 VSS nfet_03v3 L=0.28U W=0.36U AS=0.1152P AD=0.1584P PS=1U
+ PD=1.6U
M$4789 VSS RB \$3855 VSS nfet_03v3 L=0.28U W=0.36U AS=0.1854P AD=0.1584P
+ PS=1.75U PD=1.6U
M$4790 VSS RB \$4125 VSS nfet_03v3 L=0.28U W=0.36U AS=0.1854P AD=0.1584P
+ PS=1.75U PD=1.6U
M$4791 \$4130 RA VSS VSS nfet_03v3 L=0.28U W=0.36U AS=0.1656P AD=0.1944P
+ PS=1.64U PD=1.8U
M$4792 \$3856 RA VSS VSS nfet_03v3 L=0.28U W=0.36U AS=0.1656P AD=0.1944P
+ PS=1.64U PD=1.8U
M$4793 \$3728 RA QAb VSS nfet_03v3 L=0.28U W=0.36U AS=0.1584P AD=0.1152P
+ PS=1.6U PD=1U
M$4794 QBb RB \$3728 VSS nfet_03v3 L=0.28U W=0.36U AS=0.1152P AD=0.1584P PS=1U
+ PD=1.6U
M$4795 \$4129 RA QAb VSS nfet_03v3 L=0.28U W=0.36U AS=0.1584P AD=0.1152P
+ PS=1.6U PD=1U
M$4796 QBb RB \$4129 VSS nfet_03v3 L=0.28U W=0.36U AS=0.1152P AD=0.1584P PS=1U
+ PD=1.6U
M$4797 VSS RB \$3857 VSS nfet_03v3 L=0.28U W=0.36U AS=0.1854P AD=0.1584P
+ PS=1.75U PD=1.6U
M$4798 VSS RB \$4131 VSS nfet_03v3 L=0.28U W=0.36U AS=0.1854P AD=0.1584P
+ PS=1.75U PD=1.6U
M$4799 \$4136 RA VSS VSS nfet_03v3 L=0.28U W=0.36U AS=0.1656P AD=0.1944P
+ PS=1.64U PD=1.8U
M$4800 \$3858 RA VSS VSS nfet_03v3 L=0.28U W=0.36U AS=0.1656P AD=0.1944P
+ PS=1.64U PD=1.8U
M$4801 \$3729 RA QAb VSS nfet_03v3 L=0.28U W=0.36U AS=0.1584P AD=0.1152P
+ PS=1.6U PD=1U
M$4802 QBb RB \$3729 VSS nfet_03v3 L=0.28U W=0.36U AS=0.1152P AD=0.1584P PS=1U
+ PD=1.6U
M$4803 \$4135 RA QAb VSS nfet_03v3 L=0.28U W=0.36U AS=0.1584P AD=0.1152P
+ PS=1.6U PD=1U
M$4804 QBb RB \$4135 VSS nfet_03v3 L=0.28U W=0.36U AS=0.1152P AD=0.1584P PS=1U
+ PD=1.6U
M$4805 VSS RB \$4137 VSS nfet_03v3 L=0.28U W=0.36U AS=0.1854P AD=0.1584P
+ PS=1.75U PD=1.6U
M$4806 VSS RB \$3859 VSS nfet_03v3 L=0.28U W=0.36U AS=0.1854P AD=0.1584P
+ PS=1.75U PD=1.6U
M$4807 \$4142 RA VSS VSS nfet_03v3 L=0.28U W=0.36U AS=0.1656P AD=0.1944P
+ PS=1.64U PD=1.8U
M$4808 \$3860 RA VSS VSS nfet_03v3 L=0.28U W=0.36U AS=0.1656P AD=0.1944P
+ PS=1.64U PD=1.8U
M$4809 \$4141 RA QAb VSS nfet_03v3 L=0.28U W=0.36U AS=0.1584P AD=0.1152P
+ PS=1.6U PD=1U
M$4810 QBb RB \$4141 VSS nfet_03v3 L=0.28U W=0.36U AS=0.1152P AD=0.1584P PS=1U
+ PD=1.6U
M$4811 \$3730 RA QAb VSS nfet_03v3 L=0.28U W=0.36U AS=0.1584P AD=0.1152P
+ PS=1.6U PD=1U
M$4812 QBb RB \$3730 VSS nfet_03v3 L=0.28U W=0.36U AS=0.1152P AD=0.1584P PS=1U
+ PD=1.6U
M$4813 VSS RB \$4143 VSS nfet_03v3 L=0.28U W=0.36U AS=0.1854P AD=0.1584P
+ PS=1.75U PD=1.6U
M$4814 VSS RB \$3861 VSS nfet_03v3 L=0.28U W=0.36U AS=0.1854P AD=0.1584P
+ PS=1.75U PD=1.6U
M$4815 \$3862 RA VSS VSS nfet_03v3 L=0.28U W=0.36U AS=0.1656P AD=0.1944P
+ PS=1.64U PD=1.8U
M$4816 \$4148 RA VSS VSS nfet_03v3 L=0.28U W=0.36U AS=0.1656P AD=0.1944P
+ PS=1.64U PD=1.8U
M$4817 \$4147 RA QAb VSS nfet_03v3 L=0.28U W=0.36U AS=0.1584P AD=0.1152P
+ PS=1.6U PD=1U
M$4818 QBb RB \$4147 VSS nfet_03v3 L=0.28U W=0.36U AS=0.1152P AD=0.1584P PS=1U
+ PD=1.6U
M$4819 \$3731 RA QAb VSS nfet_03v3 L=0.28U W=0.36U AS=0.1584P AD=0.1152P
+ PS=1.6U PD=1U
M$4820 QBb RB \$3731 VSS nfet_03v3 L=0.28U W=0.36U AS=0.1152P AD=0.1584P PS=1U
+ PD=1.6U
M$4821 VSS RB \$4149 VSS nfet_03v3 L=0.28U W=0.36U AS=0.1854P AD=0.1584P
+ PS=1.75U PD=1.6U
M$4822 VSS RB \$3863 VSS nfet_03v3 L=0.28U W=0.36U AS=0.1854P AD=0.1584P
+ PS=1.75U PD=1.6U
M$4823 \$4154 RA VSS VSS nfet_03v3 L=0.28U W=0.36U AS=0.1656P AD=0.1944P
+ PS=1.64U PD=1.8U
M$4824 \$3864 RA VSS VSS nfet_03v3 L=0.28U W=0.36U AS=0.1656P AD=0.1944P
+ PS=1.64U PD=1.8U
M$4825 \$4153 RA QAb VSS nfet_03v3 L=0.28U W=0.36U AS=0.1584P AD=0.1152P
+ PS=1.6U PD=1U
M$4826 QBb RB \$4153 VSS nfet_03v3 L=0.28U W=0.36U AS=0.1152P AD=0.1584P PS=1U
+ PD=1.6U
M$4827 \$3732 RA QAb VSS nfet_03v3 L=0.28U W=0.36U AS=0.1584P AD=0.1152P
+ PS=1.6U PD=1U
M$4828 QBb RB \$3732 VSS nfet_03v3 L=0.28U W=0.36U AS=0.1152P AD=0.1584P PS=1U
+ PD=1.6U
M$4829 VSS RB \$3865 VSS nfet_03v3 L=0.28U W=0.36U AS=0.1854P AD=0.1584P
+ PS=1.75U PD=1.6U
M$4830 VSS RB \$4155 VSS nfet_03v3 L=0.28U W=0.36U AS=0.1854P AD=0.1584P
+ PS=1.75U PD=1.6U
M$4831 \$3866 RA VSS VSS nfet_03v3 L=0.28U W=0.36U AS=0.1656P AD=0.1944P
+ PS=1.64U PD=1.8U
M$4832 \$4160 RA VSS VSS nfet_03v3 L=0.28U W=0.36U AS=0.1656P AD=0.1944P
+ PS=1.64U PD=1.8U
M$4833 \$4159 RA QAb VSS nfet_03v3 L=0.28U W=0.36U AS=0.1584P AD=0.1152P
+ PS=1.6U PD=1U
M$4834 QBb RB \$4159 VSS nfet_03v3 L=0.28U W=0.36U AS=0.1152P AD=0.1584P PS=1U
+ PD=1.6U
M$4835 \$3733 RA QAb VSS nfet_03v3 L=0.28U W=0.36U AS=0.1584P AD=0.1152P
+ PS=1.6U PD=1U
M$4836 QBb RB \$3733 VSS nfet_03v3 L=0.28U W=0.36U AS=0.1152P AD=0.1584P PS=1U
+ PD=1.6U
M$4837 VSS RB \$4161 VSS nfet_03v3 L=0.28U W=0.36U AS=0.1854P AD=0.1584P
+ PS=1.75U PD=1.6U
M$4838 VSS RB \$3867 VSS nfet_03v3 L=0.28U W=0.36U AS=0.1854P AD=0.1584P
+ PS=1.75U PD=1.6U
M$4839 \$4297 WE VSS VSS nfet_03v3 L=0.28U W=0.72U AS=0.3168P AD=0.1872P
+ PS=2.32U PD=1.24U
M$4840 \$4060 CLK \$4297 VSS nfet_03v3 L=0.28U W=0.72U AS=0.1872P AD=0.3168P
+ PS=1.24U PD=2.32U
M$4841 WECLK \$4060 VSS VSS nfet_03v3 L=0.28U W=1.27U AS=0.4487P AD=0.3302P
+ PS=3.34U PD=2.31U
M$4845 \$4065 D|Q VSS VSS nfet_03v3 L=0.28U W=0.36U AS=0.1584P AD=0.1188P
+ PS=1.6U PD=1.02U
M$4846 \$4066 WECLK \$4065 VSS nfet_03v3 L=0.28U W=0.36U AS=0.1188P AD=0.1278P
+ PS=1.02U PD=1.07U
M$4847 \$4301 \$4067 \$4066 VSS nfet_03v3 L=0.28U W=0.36U AS=0.1278P AD=0.0567P
+ PS=1.07U PD=0.675U
M$4848 VSS WECLKb \$4301 VSS nfet_03v3 L=0.28U W=0.36U AS=0.0567P AD=0.1584P
+ PS=0.675U PD=1.6U
M$4849 VSS \$4066 \$4067 VSS nfet_03v3 L=0.28U W=0.36U AS=0.1584P AD=0.0972P
+ PS=1.6U PD=0.9U
M$4850 \$4068 \$4066 VSS VSS nfet_03v3 L=0.28U W=0.36U AS=0.0972P AD=0.18P
+ PS=0.9U PD=1.72U
M$4851 \$4072 D|Q VSS VSS nfet_03v3 L=0.28U W=0.36U AS=0.1584P AD=0.1188P
+ PS=1.6U PD=1.02U
M$4852 \$4073 WECLK \$4072 VSS nfet_03v3 L=0.28U W=0.36U AS=0.1188P AD=0.1278P
+ PS=1.02U PD=1.07U
M$4853 \$4308 \$4074 \$4073 VSS nfet_03v3 L=0.28U W=0.36U AS=0.1278P AD=0.0567P
+ PS=1.07U PD=0.675U
M$4854 VSS WECLKb \$4308 VSS nfet_03v3 L=0.28U W=0.36U AS=0.0567P AD=0.1584P
+ PS=0.675U PD=1.6U
M$4855 VSS \$4073 \$4074 VSS nfet_03v3 L=0.28U W=0.36U AS=0.1584P AD=0.0972P
+ PS=1.6U PD=0.9U
M$4856 \$4075 \$4073 VSS VSS nfet_03v3 L=0.28U W=0.36U AS=0.0972P AD=0.18P
+ PS=0.9U PD=1.72U
M$4857 \$4078 D|Q VSS VSS nfet_03v3 L=0.28U W=0.36U AS=0.1584P AD=0.1188P
+ PS=1.6U PD=1.02U
M$4858 \$4079 WECLK \$4078 VSS nfet_03v3 L=0.28U W=0.36U AS=0.1188P AD=0.1278P
+ PS=1.02U PD=1.07U
M$4859 \$4315 \$4080 \$4079 VSS nfet_03v3 L=0.28U W=0.36U AS=0.1278P AD=0.0567P
+ PS=1.07U PD=0.675U
M$4860 VSS WECLKb \$4315 VSS nfet_03v3 L=0.28U W=0.36U AS=0.0567P AD=0.1584P
+ PS=0.675U PD=1.6U
M$4861 VSS \$4079 \$4080 VSS nfet_03v3 L=0.28U W=0.36U AS=0.1584P AD=0.0972P
+ PS=1.6U PD=0.9U
M$4862 \$4081 \$4079 VSS VSS nfet_03v3 L=0.28U W=0.36U AS=0.0972P AD=0.18P
+ PS=0.9U PD=1.72U
M$4863 \$4084 D|Q VSS VSS nfet_03v3 L=0.28U W=0.36U AS=0.1584P AD=0.1188P
+ PS=1.6U PD=1.02U
M$4864 \$4085 WECLK \$4084 VSS nfet_03v3 L=0.28U W=0.36U AS=0.1188P AD=0.1278P
+ PS=1.02U PD=1.07U
M$4865 \$4323 \$4086 \$4085 VSS nfet_03v3 L=0.28U W=0.36U AS=0.1278P AD=0.0567P
+ PS=1.07U PD=0.675U
M$4866 VSS WECLKb \$4323 VSS nfet_03v3 L=0.28U W=0.36U AS=0.0567P AD=0.1584P
+ PS=0.675U PD=1.6U
M$4867 VSS \$4085 \$4086 VSS nfet_03v3 L=0.28U W=0.36U AS=0.1584P AD=0.0972P
+ PS=1.6U PD=0.9U
M$4868 \$4087 \$4085 VSS VSS nfet_03v3 L=0.28U W=0.36U AS=0.0972P AD=0.18P
+ PS=0.9U PD=1.72U
M$4869 \$4090 D|Q VSS VSS nfet_03v3 L=0.28U W=0.36U AS=0.1584P AD=0.1188P
+ PS=1.6U PD=1.02U
M$4870 \$4091 WECLK \$4090 VSS nfet_03v3 L=0.28U W=0.36U AS=0.1188P AD=0.1278P
+ PS=1.02U PD=1.07U
M$4871 \$4329 \$4092 \$4091 VSS nfet_03v3 L=0.28U W=0.36U AS=0.1278P AD=0.0567P
+ PS=1.07U PD=0.675U
M$4872 VSS WECLKb \$4329 VSS nfet_03v3 L=0.28U W=0.36U AS=0.0567P AD=0.1584P
+ PS=0.675U PD=1.6U
M$4873 VSS \$4091 \$4092 VSS nfet_03v3 L=0.28U W=0.36U AS=0.1584P AD=0.0972P
+ PS=1.6U PD=0.9U
M$4874 \$4093 \$4091 VSS VSS nfet_03v3 L=0.28U W=0.36U AS=0.0972P AD=0.18P
+ PS=0.9U PD=1.72U
M$4875 \$4096 D|Q VSS VSS nfet_03v3 L=0.28U W=0.36U AS=0.1584P AD=0.1188P
+ PS=1.6U PD=1.02U
M$4876 \$4097 WECLK \$4096 VSS nfet_03v3 L=0.28U W=0.36U AS=0.1188P AD=0.1278P
+ PS=1.02U PD=1.07U
M$4877 \$4336 \$4098 \$4097 VSS nfet_03v3 L=0.28U W=0.36U AS=0.1278P AD=0.0567P
+ PS=1.07U PD=0.675U
M$4878 VSS WECLKb \$4336 VSS nfet_03v3 L=0.28U W=0.36U AS=0.0567P AD=0.1584P
+ PS=0.675U PD=1.6U
M$4879 VSS \$4097 \$4098 VSS nfet_03v3 L=0.28U W=0.36U AS=0.1584P AD=0.0972P
+ PS=1.6U PD=0.9U
M$4880 \$4099 \$4097 VSS VSS nfet_03v3 L=0.28U W=0.36U AS=0.0972P AD=0.18P
+ PS=0.9U PD=1.72U
M$4881 \$4102 D|Q VSS VSS nfet_03v3 L=0.28U W=0.36U AS=0.1584P AD=0.1188P
+ PS=1.6U PD=1.02U
M$4882 \$4103 WECLK \$4102 VSS nfet_03v3 L=0.28U W=0.36U AS=0.1188P AD=0.1278P
+ PS=1.02U PD=1.07U
M$4883 \$4343 \$4104 \$4103 VSS nfet_03v3 L=0.28U W=0.36U AS=0.1278P AD=0.0567P
+ PS=1.07U PD=0.675U
M$4884 VSS WECLKb \$4343 VSS nfet_03v3 L=0.28U W=0.36U AS=0.0567P AD=0.1584P
+ PS=0.675U PD=1.6U
M$4885 VSS \$4103 \$4104 VSS nfet_03v3 L=0.28U W=0.36U AS=0.1584P AD=0.0972P
+ PS=1.6U PD=0.9U
M$4886 \$4105 \$4103 VSS VSS nfet_03v3 L=0.28U W=0.36U AS=0.0972P AD=0.18P
+ PS=0.9U PD=1.72U
M$4887 \$4108 D|Q VSS VSS nfet_03v3 L=0.28U W=0.36U AS=0.1584P AD=0.1188P
+ PS=1.6U PD=1.02U
M$4888 \$4109 WECLK \$4108 VSS nfet_03v3 L=0.28U W=0.36U AS=0.1188P AD=0.1278P
+ PS=1.02U PD=1.07U
M$4889 \$4351 \$4110 \$4109 VSS nfet_03v3 L=0.28U W=0.36U AS=0.1278P AD=0.0567P
+ PS=1.07U PD=0.675U
M$4890 VSS WECLKb \$4351 VSS nfet_03v3 L=0.28U W=0.36U AS=0.0567P AD=0.1584P
+ PS=0.675U PD=1.6U
M$4891 VSS \$4109 \$4110 VSS nfet_03v3 L=0.28U W=0.36U AS=0.1584P AD=0.0972P
+ PS=1.6U PD=0.9U
M$4892 \$4111 \$4109 VSS VSS nfet_03v3 L=0.28U W=0.36U AS=0.0972P AD=0.18P
+ PS=0.9U PD=1.72U
M$4893 \$4114 D|Q VSS VSS nfet_03v3 L=0.28U W=0.36U AS=0.1584P AD=0.1188P
+ PS=1.6U PD=1.02U
M$4894 \$4115 WECLK \$4114 VSS nfet_03v3 L=0.28U W=0.36U AS=0.1188P AD=0.1278P
+ PS=1.02U PD=1.07U
M$4895 \$4359 \$4116 \$4115 VSS nfet_03v3 L=0.28U W=0.36U AS=0.1278P AD=0.0567P
+ PS=1.07U PD=0.675U
M$4896 VSS WECLKb \$4359 VSS nfet_03v3 L=0.28U W=0.36U AS=0.0567P AD=0.1584P
+ PS=0.675U PD=1.6U
M$4897 VSS \$4115 \$4116 VSS nfet_03v3 L=0.28U W=0.36U AS=0.1584P AD=0.0972P
+ PS=1.6U PD=0.9U
M$4898 \$4117 \$4115 VSS VSS nfet_03v3 L=0.28U W=0.36U AS=0.0972P AD=0.18P
+ PS=0.9U PD=1.72U
M$4899 \$4120 D|Q VSS VSS nfet_03v3 L=0.28U W=0.36U AS=0.1584P AD=0.1188P
+ PS=1.6U PD=1.02U
M$4900 \$4121 WECLK \$4120 VSS nfet_03v3 L=0.28U W=0.36U AS=0.1188P AD=0.1278P
+ PS=1.02U PD=1.07U
M$4901 \$4365 \$4122 \$4121 VSS nfet_03v3 L=0.28U W=0.36U AS=0.1278P AD=0.0567P
+ PS=1.07U PD=0.675U
M$4902 VSS WECLKb \$4365 VSS nfet_03v3 L=0.28U W=0.36U AS=0.0567P AD=0.1584P
+ PS=0.675U PD=1.6U
M$4903 VSS \$4121 \$4122 VSS nfet_03v3 L=0.28U W=0.36U AS=0.1584P AD=0.0972P
+ PS=1.6U PD=0.9U
M$4904 \$4123 \$4121 VSS VSS nfet_03v3 L=0.28U W=0.36U AS=0.0972P AD=0.18P
+ PS=0.9U PD=1.72U
M$4905 \$4126 D|Q VSS VSS nfet_03v3 L=0.28U W=0.36U AS=0.1584P AD=0.1188P
+ PS=1.6U PD=1.02U
M$4906 \$4127 WECLK \$4126 VSS nfet_03v3 L=0.28U W=0.36U AS=0.1188P AD=0.1278P
+ PS=1.02U PD=1.07U
M$4907 \$4372 \$4128 \$4127 VSS nfet_03v3 L=0.28U W=0.36U AS=0.1278P AD=0.0567P
+ PS=1.07U PD=0.675U
M$4908 VSS WECLKb \$4372 VSS nfet_03v3 L=0.28U W=0.36U AS=0.0567P AD=0.1584P
+ PS=0.675U PD=1.6U
M$4909 VSS \$4127 \$4128 VSS nfet_03v3 L=0.28U W=0.36U AS=0.1584P AD=0.0972P
+ PS=1.6U PD=0.9U
M$4910 \$4129 \$4127 VSS VSS nfet_03v3 L=0.28U W=0.36U AS=0.0972P AD=0.18P
+ PS=0.9U PD=1.72U
M$4911 \$4132 D|Q VSS VSS nfet_03v3 L=0.28U W=0.36U AS=0.1584P AD=0.1188P
+ PS=1.6U PD=1.02U
M$4912 \$4133 WECLK \$4132 VSS nfet_03v3 L=0.28U W=0.36U AS=0.1188P AD=0.1278P
+ PS=1.02U PD=1.07U
M$4913 \$4379 \$4134 \$4133 VSS nfet_03v3 L=0.28U W=0.36U AS=0.1278P AD=0.0567P
+ PS=1.07U PD=0.675U
M$4914 VSS WECLKb \$4379 VSS nfet_03v3 L=0.28U W=0.36U AS=0.0567P AD=0.1584P
+ PS=0.675U PD=1.6U
M$4915 VSS \$4133 \$4134 VSS nfet_03v3 L=0.28U W=0.36U AS=0.1584P AD=0.0972P
+ PS=1.6U PD=0.9U
M$4916 \$4135 \$4133 VSS VSS nfet_03v3 L=0.28U W=0.36U AS=0.0972P AD=0.18P
+ PS=0.9U PD=1.72U
M$4917 \$4138 D|Q VSS VSS nfet_03v3 L=0.28U W=0.36U AS=0.1584P AD=0.1188P
+ PS=1.6U PD=1.02U
M$4918 \$4139 WECLK \$4138 VSS nfet_03v3 L=0.28U W=0.36U AS=0.1188P AD=0.1278P
+ PS=1.02U PD=1.07U
M$4919 \$4387 \$4140 \$4139 VSS nfet_03v3 L=0.28U W=0.36U AS=0.1278P AD=0.0567P
+ PS=1.07U PD=0.675U
M$4920 VSS WECLKb \$4387 VSS nfet_03v3 L=0.28U W=0.36U AS=0.0567P AD=0.1584P
+ PS=0.675U PD=1.6U
M$4921 VSS \$4139 \$4140 VSS nfet_03v3 L=0.28U W=0.36U AS=0.1584P AD=0.0972P
+ PS=1.6U PD=0.9U
M$4922 \$4141 \$4139 VSS VSS nfet_03v3 L=0.28U W=0.36U AS=0.0972P AD=0.18P
+ PS=0.9U PD=1.72U
M$4923 \$4144 D|Q VSS VSS nfet_03v3 L=0.28U W=0.36U AS=0.1584P AD=0.1188P
+ PS=1.6U PD=1.02U
M$4924 \$4145 WECLK \$4144 VSS nfet_03v3 L=0.28U W=0.36U AS=0.1188P AD=0.1278P
+ PS=1.02U PD=1.07U
M$4925 \$4394 \$4146 \$4145 VSS nfet_03v3 L=0.28U W=0.36U AS=0.1278P AD=0.0567P
+ PS=1.07U PD=0.675U
M$4926 VSS WECLKb \$4394 VSS nfet_03v3 L=0.28U W=0.36U AS=0.0567P AD=0.1584P
+ PS=0.675U PD=1.6U
M$4927 VSS \$4145 \$4146 VSS nfet_03v3 L=0.28U W=0.36U AS=0.1584P AD=0.0972P
+ PS=1.6U PD=0.9U
M$4928 \$4147 \$4145 VSS VSS nfet_03v3 L=0.28U W=0.36U AS=0.0972P AD=0.18P
+ PS=0.9U PD=1.72U
M$4929 \$4150 D|Q VSS VSS nfet_03v3 L=0.28U W=0.36U AS=0.1584P AD=0.1188P
+ PS=1.6U PD=1.02U
M$4930 \$4151 WECLK \$4150 VSS nfet_03v3 L=0.28U W=0.36U AS=0.1188P AD=0.1278P
+ PS=1.02U PD=1.07U
M$4931 \$4358 \$4152 \$4151 VSS nfet_03v3 L=0.28U W=0.36U AS=0.1278P AD=0.0567P
+ PS=1.07U PD=0.675U
M$4932 VSS WECLKb \$4358 VSS nfet_03v3 L=0.28U W=0.36U AS=0.0567P AD=0.1584P
+ PS=0.675U PD=1.6U
M$4933 VSS \$4151 \$4152 VSS nfet_03v3 L=0.28U W=0.36U AS=0.1584P AD=0.0972P
+ PS=1.6U PD=0.9U
M$4934 \$4153 \$4151 VSS VSS nfet_03v3 L=0.28U W=0.36U AS=0.0972P AD=0.18P
+ PS=0.9U PD=1.72U
M$4935 \$4156 D|Q VSS VSS nfet_03v3 L=0.28U W=0.36U AS=0.1584P AD=0.1188P
+ PS=1.6U PD=1.02U
M$4936 \$4157 WECLK \$4156 VSS nfet_03v3 L=0.28U W=0.36U AS=0.1188P AD=0.1278P
+ PS=1.02U PD=1.07U
M$4937 \$4322 \$4158 \$4157 VSS nfet_03v3 L=0.28U W=0.36U AS=0.1278P AD=0.0567P
+ PS=1.07U PD=0.675U
M$4938 VSS WECLKb \$4322 VSS nfet_03v3 L=0.28U W=0.36U AS=0.0567P AD=0.1584P
+ PS=0.675U PD=1.6U
M$4939 VSS \$4157 \$4158 VSS nfet_03v3 L=0.28U W=0.36U AS=0.1584P AD=0.0972P
+ PS=1.6U PD=0.9U
M$4940 \$4159 \$4157 VSS VSS nfet_03v3 L=0.28U W=0.36U AS=0.0972P AD=0.18P
+ PS=0.9U PD=1.72U
M$4941 \$4546 WE VSS VSS nfet_03v3 L=0.28U W=0.72U AS=0.3168P AD=0.1872P
+ PS=2.32U PD=1.24U
M$4942 \$4411 CLK \$4546 VSS nfet_03v3 L=0.28U W=0.72U AS=0.1872P AD=0.3168P
+ PS=1.24U PD=2.32U
M$4943 WECLK \$4411 VSS VSS nfet_03v3 L=0.28U W=1.27U AS=0.4445P AD=0.3344P
+ PS=3.305U PD=2.345U
M$4947 \$4414 D|Q VSS VSS nfet_03v3 L=0.28U W=0.36U AS=0.1584P AD=0.1188P
+ PS=1.6U PD=1.02U
M$4948 \$4415 WECLK \$4414 VSS nfet_03v3 L=0.28U W=0.36U AS=0.1188P AD=0.1278P
+ PS=1.02U PD=1.07U
M$4949 \$4469 \$4416 \$4415 VSS nfet_03v3 L=0.28U W=0.36U AS=0.1278P AD=0.0567P
+ PS=1.07U PD=0.675U
M$4950 VSS WECLKb \$4469 VSS nfet_03v3 L=0.28U W=0.36U AS=0.0567P AD=0.1584P
+ PS=0.675U PD=1.6U
M$4951 VSS \$4415 \$4416 VSS nfet_03v3 L=0.28U W=0.36U AS=0.1584P AD=0.0972P
+ PS=1.6U PD=0.9U
M$4952 \$4395 \$4415 VSS VSS nfet_03v3 L=0.28U W=0.36U AS=0.0972P AD=0.18P
+ PS=0.9U PD=1.72U
M$4953 \$4417 D|Q VSS VSS nfet_03v3 L=0.28U W=0.36U AS=0.1584P AD=0.1188P
+ PS=1.6U PD=1.02U
M$4954 \$4418 WECLK \$4417 VSS nfet_03v3 L=0.28U W=0.36U AS=0.1188P AD=0.1278P
+ PS=1.02U PD=1.07U
M$4955 \$4478 \$4419 \$4418 VSS nfet_03v3 L=0.28U W=0.36U AS=0.1278P AD=0.0567P
+ PS=1.07U PD=0.675U
M$4956 VSS WECLKb \$4478 VSS nfet_03v3 L=0.28U W=0.36U AS=0.0567P AD=0.1584P
+ PS=0.675U PD=1.6U
M$4957 VSS \$4418 \$4419 VSS nfet_03v3 L=0.28U W=0.36U AS=0.1584P AD=0.0972P
+ PS=1.6U PD=0.9U
M$4958 \$4396 \$4418 VSS VSS nfet_03v3 L=0.28U W=0.36U AS=0.0972P AD=0.18P
+ PS=0.9U PD=1.72U
M$4959 \$4420 D|Q VSS VSS nfet_03v3 L=0.28U W=0.36U AS=0.1584P AD=0.1188P
+ PS=1.6U PD=1.02U
M$4960 \$4421 WECLK \$4420 VSS nfet_03v3 L=0.28U W=0.36U AS=0.1188P AD=0.1278P
+ PS=1.02U PD=1.07U
M$4961 \$4487 \$4422 \$4421 VSS nfet_03v3 L=0.28U W=0.36U AS=0.1278P AD=0.0567P
+ PS=1.07U PD=0.675U
M$4962 VSS WECLKb \$4487 VSS nfet_03v3 L=0.28U W=0.36U AS=0.0567P AD=0.1584P
+ PS=0.675U PD=1.6U
M$4963 VSS \$4421 \$4422 VSS nfet_03v3 L=0.28U W=0.36U AS=0.1584P AD=0.0972P
+ PS=1.6U PD=0.9U
M$4964 \$4397 \$4421 VSS VSS nfet_03v3 L=0.28U W=0.36U AS=0.0972P AD=0.18P
+ PS=0.9U PD=1.72U
M$4965 \$4423 D|Q VSS VSS nfet_03v3 L=0.28U W=0.36U AS=0.1584P AD=0.1188P
+ PS=1.6U PD=1.02U
M$4966 \$4424 WECLK \$4423 VSS nfet_03v3 L=0.28U W=0.36U AS=0.1188P AD=0.1278P
+ PS=1.02U PD=1.07U
M$4967 \$4496 \$4425 \$4424 VSS nfet_03v3 L=0.28U W=0.36U AS=0.1278P AD=0.0567P
+ PS=1.07U PD=0.675U
M$4968 VSS WECLKb \$4496 VSS nfet_03v3 L=0.28U W=0.36U AS=0.0567P AD=0.1584P
+ PS=0.675U PD=1.6U
M$4969 VSS \$4424 \$4425 VSS nfet_03v3 L=0.28U W=0.36U AS=0.1584P AD=0.0972P
+ PS=1.6U PD=0.9U
M$4970 \$4398 \$4424 VSS VSS nfet_03v3 L=0.28U W=0.36U AS=0.0972P AD=0.18P
+ PS=0.9U PD=1.72U
M$4971 \$4426 D|Q VSS VSS nfet_03v3 L=0.28U W=0.36U AS=0.1584P AD=0.1188P
+ PS=1.6U PD=1.02U
M$4972 \$4427 WECLK \$4426 VSS nfet_03v3 L=0.28U W=0.36U AS=0.1188P AD=0.1278P
+ PS=1.02U PD=1.07U
M$4973 \$4506 \$4428 \$4427 VSS nfet_03v3 L=0.28U W=0.36U AS=0.1278P AD=0.0567P
+ PS=1.07U PD=0.675U
M$4974 VSS WECLKb \$4506 VSS nfet_03v3 L=0.28U W=0.36U AS=0.0567P AD=0.1584P
+ PS=0.675U PD=1.6U
M$4975 VSS \$4427 \$4428 VSS nfet_03v3 L=0.28U W=0.36U AS=0.1584P AD=0.0972P
+ PS=1.6U PD=0.9U
M$4976 \$4399 \$4427 VSS VSS nfet_03v3 L=0.28U W=0.36U AS=0.0972P AD=0.18P
+ PS=0.9U PD=1.72U
M$4977 \$4429 D|Q VSS VSS nfet_03v3 L=0.28U W=0.36U AS=0.1584P AD=0.1188P
+ PS=1.6U PD=1.02U
M$4978 \$4430 WECLK \$4429 VSS nfet_03v3 L=0.28U W=0.36U AS=0.1188P AD=0.1278P
+ PS=1.02U PD=1.07U
M$4979 \$4509 \$4431 \$4430 VSS nfet_03v3 L=0.28U W=0.36U AS=0.1278P AD=0.0567P
+ PS=1.07U PD=0.675U
M$4980 VSS WECLKb \$4509 VSS nfet_03v3 L=0.28U W=0.36U AS=0.0567P AD=0.1584P
+ PS=0.675U PD=1.6U
M$4981 VSS \$4430 \$4431 VSS nfet_03v3 L=0.28U W=0.36U AS=0.1584P AD=0.0972P
+ PS=1.6U PD=0.9U
M$4982 \$4400 \$4430 VSS VSS nfet_03v3 L=0.28U W=0.36U AS=0.0972P AD=0.18P
+ PS=0.9U PD=1.72U
M$4983 \$4432 D|Q VSS VSS nfet_03v3 L=0.28U W=0.36U AS=0.1584P AD=0.1188P
+ PS=1.6U PD=1.02U
M$4984 \$4433 WECLK \$4432 VSS nfet_03v3 L=0.28U W=0.36U AS=0.1188P AD=0.1278P
+ PS=1.02U PD=1.07U
M$4985 \$4503 \$4434 \$4433 VSS nfet_03v3 L=0.28U W=0.36U AS=0.1278P AD=0.0567P
+ PS=1.07U PD=0.675U
M$4986 VSS WECLKb \$4503 VSS nfet_03v3 L=0.28U W=0.36U AS=0.0567P AD=0.1584P
+ PS=0.675U PD=1.6U
M$4987 VSS \$4433 \$4434 VSS nfet_03v3 L=0.28U W=0.36U AS=0.1584P AD=0.0972P
+ PS=1.6U PD=0.9U
M$4988 \$4401 \$4433 VSS VSS nfet_03v3 L=0.28U W=0.36U AS=0.0972P AD=0.18P
+ PS=0.9U PD=1.72U
M$4989 \$4435 D|Q VSS VSS nfet_03v3 L=0.28U W=0.36U AS=0.1584P AD=0.1188P
+ PS=1.6U PD=1.02U
M$4990 \$4436 WECLK \$4435 VSS nfet_03v3 L=0.28U W=0.36U AS=0.1188P AD=0.1278P
+ PS=1.02U PD=1.07U
M$4991 \$4499 \$4437 \$4436 VSS nfet_03v3 L=0.28U W=0.36U AS=0.1278P AD=0.0567P
+ PS=1.07U PD=0.675U
M$4992 VSS WECLKb \$4499 VSS nfet_03v3 L=0.28U W=0.36U AS=0.0567P AD=0.1584P
+ PS=0.675U PD=1.6U
M$4993 VSS \$4436 \$4437 VSS nfet_03v3 L=0.28U W=0.36U AS=0.1584P AD=0.0972P
+ PS=1.6U PD=0.9U
M$4994 \$4402 \$4436 VSS VSS nfet_03v3 L=0.28U W=0.36U AS=0.0972P AD=0.18P
+ PS=0.9U PD=1.72U
M$4995 \$4438 D|Q VSS VSS nfet_03v3 L=0.28U W=0.36U AS=0.1584P AD=0.1188P
+ PS=1.6U PD=1.02U
M$4996 \$4439 WECLK \$4438 VSS nfet_03v3 L=0.28U W=0.36U AS=0.1188P AD=0.1278P
+ PS=1.02U PD=1.07U
M$4997 \$4494 \$4440 \$4439 VSS nfet_03v3 L=0.28U W=0.36U AS=0.1278P AD=0.0567P
+ PS=1.07U PD=0.675U
M$4998 VSS WECLKb \$4494 VSS nfet_03v3 L=0.28U W=0.36U AS=0.0567P AD=0.1584P
+ PS=0.675U PD=1.6U
M$4999 VSS \$4439 \$4440 VSS nfet_03v3 L=0.28U W=0.36U AS=0.1584P AD=0.0972P
+ PS=1.6U PD=0.9U
M$5000 \$4403 \$4439 VSS VSS nfet_03v3 L=0.28U W=0.36U AS=0.0972P AD=0.18P
+ PS=0.9U PD=1.72U
M$5001 \$4441 D|Q VSS VSS nfet_03v3 L=0.28U W=0.36U AS=0.1584P AD=0.1188P
+ PS=1.6U PD=1.02U
M$5002 \$4442 WECLK \$4441 VSS nfet_03v3 L=0.28U W=0.36U AS=0.1188P AD=0.1278P
+ PS=1.02U PD=1.07U
M$5003 \$4491 \$4443 \$4442 VSS nfet_03v3 L=0.28U W=0.36U AS=0.1278P AD=0.0567P
+ PS=1.07U PD=0.675U
M$5004 VSS WECLKb \$4491 VSS nfet_03v3 L=0.28U W=0.36U AS=0.0567P AD=0.1584P
+ PS=0.675U PD=1.6U
M$5005 VSS \$4442 \$4443 VSS nfet_03v3 L=0.28U W=0.36U AS=0.1584P AD=0.0972P
+ PS=1.6U PD=0.9U
M$5006 \$4404 \$4442 VSS VSS nfet_03v3 L=0.28U W=0.36U AS=0.0972P AD=0.18P
+ PS=0.9U PD=1.72U
M$5007 \$4444 D|Q VSS VSS nfet_03v3 L=0.28U W=0.36U AS=0.1584P AD=0.1188P
+ PS=1.6U PD=1.02U
M$5008 \$4445 WECLK \$4444 VSS nfet_03v3 L=0.28U W=0.36U AS=0.1188P AD=0.1278P
+ PS=1.02U PD=1.07U
M$5009 \$4485 \$4446 \$4445 VSS nfet_03v3 L=0.28U W=0.36U AS=0.1278P AD=0.0567P
+ PS=1.07U PD=0.675U
M$5010 VSS WECLKb \$4485 VSS nfet_03v3 L=0.28U W=0.36U AS=0.0567P AD=0.1584P
+ PS=0.675U PD=1.6U
M$5011 VSS \$4445 \$4446 VSS nfet_03v3 L=0.28U W=0.36U AS=0.1584P AD=0.0972P
+ PS=1.6U PD=0.9U
M$5012 \$4405 \$4445 VSS VSS nfet_03v3 L=0.28U W=0.36U AS=0.0972P AD=0.18P
+ PS=0.9U PD=1.72U
M$5013 \$4447 D|Q VSS VSS nfet_03v3 L=0.28U W=0.36U AS=0.1584P AD=0.1188P
+ PS=1.6U PD=1.02U
M$5014 \$4448 WECLK \$4447 VSS nfet_03v3 L=0.28U W=0.36U AS=0.1188P AD=0.1278P
+ PS=1.02U PD=1.07U
M$5015 \$4482 \$4449 \$4448 VSS nfet_03v3 L=0.28U W=0.36U AS=0.1278P AD=0.0567P
+ PS=1.07U PD=0.675U
M$5016 VSS WECLKb \$4482 VSS nfet_03v3 L=0.28U W=0.36U AS=0.0567P AD=0.1584P
+ PS=0.675U PD=1.6U
M$5017 VSS \$4448 \$4449 VSS nfet_03v3 L=0.28U W=0.36U AS=0.1584P AD=0.0972P
+ PS=1.6U PD=0.9U
M$5018 \$4406 \$4448 VSS VSS nfet_03v3 L=0.28U W=0.36U AS=0.0972P AD=0.18P
+ PS=0.9U PD=1.72U
M$5019 \$4450 D|Q VSS VSS nfet_03v3 L=0.28U W=0.36U AS=0.1584P AD=0.1188P
+ PS=1.6U PD=1.02U
M$5020 \$4451 WECLK \$4450 VSS nfet_03v3 L=0.28U W=0.36U AS=0.1188P AD=0.1278P
+ PS=1.02U PD=1.07U
M$5021 \$4476 \$4452 \$4451 VSS nfet_03v3 L=0.28U W=0.36U AS=0.1278P AD=0.0567P
+ PS=1.07U PD=0.675U
M$5022 VSS WECLKb \$4476 VSS nfet_03v3 L=0.28U W=0.36U AS=0.0567P AD=0.1584P
+ PS=0.675U PD=1.6U
M$5023 VSS \$4451 \$4452 VSS nfet_03v3 L=0.28U W=0.36U AS=0.1584P AD=0.0972P
+ PS=1.6U PD=0.9U
M$5024 \$4407 \$4451 VSS VSS nfet_03v3 L=0.28U W=0.36U AS=0.0972P AD=0.18P
+ PS=0.9U PD=1.72U
M$5025 \$4453 D|Q VSS VSS nfet_03v3 L=0.28U W=0.36U AS=0.1584P AD=0.1188P
+ PS=1.6U PD=1.02U
M$5026 \$4454 WECLK \$4453 VSS nfet_03v3 L=0.28U W=0.36U AS=0.1188P AD=0.1278P
+ PS=1.02U PD=1.07U
M$5027 \$4473 \$4455 \$4454 VSS nfet_03v3 L=0.28U W=0.36U AS=0.1278P AD=0.0567P
+ PS=1.07U PD=0.675U
M$5028 VSS WECLKb \$4473 VSS nfet_03v3 L=0.28U W=0.36U AS=0.0567P AD=0.1584P
+ PS=0.675U PD=1.6U
M$5029 VSS \$4454 \$4455 VSS nfet_03v3 L=0.28U W=0.36U AS=0.1584P AD=0.0972P
+ PS=1.6U PD=0.9U
M$5030 \$4408 \$4454 VSS VSS nfet_03v3 L=0.28U W=0.36U AS=0.0972P AD=0.18P
+ PS=0.9U PD=1.72U
M$5031 \$4456 D|Q VSS VSS nfet_03v3 L=0.28U W=0.36U AS=0.1584P AD=0.1188P
+ PS=1.6U PD=1.02U
M$5032 \$4457 WECLK \$4456 VSS nfet_03v3 L=0.28U W=0.36U AS=0.1188P AD=0.1278P
+ PS=1.02U PD=1.07U
M$5033 \$4466 \$4458 \$4457 VSS nfet_03v3 L=0.28U W=0.36U AS=0.1278P AD=0.0567P
+ PS=1.07U PD=0.675U
M$5034 VSS WECLKb \$4466 VSS nfet_03v3 L=0.28U W=0.36U AS=0.0567P AD=0.1584P
+ PS=0.675U PD=1.6U
M$5035 VSS \$4457 \$4458 VSS nfet_03v3 L=0.28U W=0.36U AS=0.1584P AD=0.0972P
+ PS=1.6U PD=0.9U
M$5036 \$4409 \$4457 VSS VSS nfet_03v3 L=0.28U W=0.36U AS=0.0972P AD=0.18P
+ PS=0.9U PD=1.72U
M$5037 \$4459 D|Q VSS VSS nfet_03v3 L=0.28U W=0.36U AS=0.1584P AD=0.1188P
+ PS=1.6U PD=1.02U
M$5038 \$4460 WECLK \$4459 VSS nfet_03v3 L=0.28U W=0.36U AS=0.1188P AD=0.1278P
+ PS=1.02U PD=1.07U
M$5039 \$4463 \$4461 \$4460 VSS nfet_03v3 L=0.28U W=0.36U AS=0.1278P AD=0.0567P
+ PS=1.07U PD=0.675U
M$5040 VSS WECLKb \$4463 VSS nfet_03v3 L=0.28U W=0.36U AS=0.0567P AD=0.1584P
+ PS=0.675U PD=1.6U
M$5041 VSS \$4460 \$4461 VSS nfet_03v3 L=0.28U W=0.36U AS=0.1584P AD=0.0972P
+ PS=1.6U PD=0.9U
M$5042 \$4410 \$4460 VSS VSS nfet_03v3 L=0.28U W=0.36U AS=0.0972P AD=0.18P
+ PS=0.9U PD=1.72U
M$5043 \$4514 RA VSS VSS nfet_03v3 L=0.28U W=0.36U AS=0.1656P AD=0.1944P
+ PS=1.64U PD=1.8U
M$5044 \$4747 RA VSS VSS nfet_03v3 L=0.28U W=0.36U AS=0.1656P AD=0.1944P
+ PS=1.64U PD=1.8U
M$5045 \$4746 RA QAb VSS nfet_03v3 L=0.28U W=0.36U AS=0.1584P AD=0.1152P
+ PS=1.6U PD=1U
M$5046 QBb RB \$4746 VSS nfet_03v3 L=0.28U W=0.36U AS=0.1152P AD=0.1584P PS=1U
+ PD=1.6U
M$5047 \$4395 RA QAb VSS nfet_03v3 L=0.28U W=0.36U AS=0.1584P AD=0.1152P
+ PS=1.6U PD=1U
M$5048 QBb RB \$4395 VSS nfet_03v3 L=0.28U W=0.36U AS=0.1152P AD=0.1584P PS=1U
+ PD=1.6U
M$5049 VSS RB \$4748 VSS nfet_03v3 L=0.28U W=0.36U AS=0.1854P AD=0.1584P
+ PS=1.75U PD=1.6U
M$5050 VSS RB \$4515 VSS nfet_03v3 L=0.28U W=0.36U AS=0.1854P AD=0.1584P
+ PS=1.75U PD=1.6U
M$5051 \$4516 RA VSS VSS nfet_03v3 L=0.28U W=0.36U AS=0.1656P AD=0.1944P
+ PS=1.64U PD=1.8U
M$5052 \$4754 RA VSS VSS nfet_03v3 L=0.28U W=0.36U AS=0.1656P AD=0.1944P
+ PS=1.64U PD=1.8U
M$5053 \$4753 RA QAb VSS nfet_03v3 L=0.28U W=0.36U AS=0.1584P AD=0.1152P
+ PS=1.6U PD=1U
M$5054 QBb RB \$4753 VSS nfet_03v3 L=0.28U W=0.36U AS=0.1152P AD=0.1584P PS=1U
+ PD=1.6U
M$5055 \$4396 RA QAb VSS nfet_03v3 L=0.28U W=0.36U AS=0.1584P AD=0.1152P
+ PS=1.6U PD=1U
M$5056 QBb RB \$4396 VSS nfet_03v3 L=0.28U W=0.36U AS=0.1152P AD=0.1584P PS=1U
+ PD=1.6U
M$5057 VSS RB \$4517 VSS nfet_03v3 L=0.28U W=0.36U AS=0.1854P AD=0.1584P
+ PS=1.75U PD=1.6U
M$5058 VSS RB \$4755 VSS nfet_03v3 L=0.28U W=0.36U AS=0.1854P AD=0.1584P
+ PS=1.75U PD=1.6U
M$5059 \$4518 RA VSS VSS nfet_03v3 L=0.28U W=0.36U AS=0.1656P AD=0.1944P
+ PS=1.64U PD=1.8U
M$5060 \$4760 RA VSS VSS nfet_03v3 L=0.28U W=0.36U AS=0.1656P AD=0.1944P
+ PS=1.64U PD=1.8U
M$5061 \$4397 RA QAb VSS nfet_03v3 L=0.28U W=0.36U AS=0.1584P AD=0.1152P
+ PS=1.6U PD=1U
M$5062 QBb RB \$4397 VSS nfet_03v3 L=0.28U W=0.36U AS=0.1152P AD=0.1584P PS=1U
+ PD=1.6U
M$5063 \$4759 RA QAb VSS nfet_03v3 L=0.28U W=0.36U AS=0.1584P AD=0.1152P
+ PS=1.6U PD=1U
M$5064 QBb RB \$4759 VSS nfet_03v3 L=0.28U W=0.36U AS=0.1152P AD=0.1584P PS=1U
+ PD=1.6U
M$5065 VSS RB \$4761 VSS nfet_03v3 L=0.28U W=0.36U AS=0.1854P AD=0.1584P
+ PS=1.75U PD=1.6U
M$5066 VSS RB \$4519 VSS nfet_03v3 L=0.28U W=0.36U AS=0.1854P AD=0.1584P
+ PS=1.75U PD=1.6U
M$5067 \$4520 RA VSS VSS nfet_03v3 L=0.28U W=0.36U AS=0.1656P AD=0.1944P
+ PS=1.64U PD=1.8U
M$5068 \$4766 RA VSS VSS nfet_03v3 L=0.28U W=0.36U AS=0.1656P AD=0.1944P
+ PS=1.64U PD=1.8U
M$5069 \$4398 RA QAb VSS nfet_03v3 L=0.28U W=0.36U AS=0.1584P AD=0.1152P
+ PS=1.6U PD=1U
M$5070 QBb RB \$4398 VSS nfet_03v3 L=0.28U W=0.36U AS=0.1152P AD=0.1584P PS=1U
+ PD=1.6U
M$5071 \$4765 RA QAb VSS nfet_03v3 L=0.28U W=0.36U AS=0.1584P AD=0.1152P
+ PS=1.6U PD=1U
M$5072 QBb RB \$4765 VSS nfet_03v3 L=0.28U W=0.36U AS=0.1152P AD=0.1584P PS=1U
+ PD=1.6U
M$5073 VSS RB \$4767 VSS nfet_03v3 L=0.28U W=0.36U AS=0.1854P AD=0.1584P
+ PS=1.75U PD=1.6U
M$5074 VSS RB \$4521 VSS nfet_03v3 L=0.28U W=0.36U AS=0.1854P AD=0.1584P
+ PS=1.75U PD=1.6U
M$5075 \$4772 RA VSS VSS nfet_03v3 L=0.28U W=0.36U AS=0.1656P AD=0.1944P
+ PS=1.64U PD=1.8U
M$5076 \$4522 RA VSS VSS nfet_03v3 L=0.28U W=0.36U AS=0.1656P AD=0.1944P
+ PS=1.64U PD=1.8U
M$5077 \$4771 RA QAb VSS nfet_03v3 L=0.28U W=0.36U AS=0.1584P AD=0.1152P
+ PS=1.6U PD=1U
M$5078 QBb RB \$4771 VSS nfet_03v3 L=0.28U W=0.36U AS=0.1152P AD=0.1584P PS=1U
+ PD=1.6U
M$5079 \$4399 RA QAb VSS nfet_03v3 L=0.28U W=0.36U AS=0.1584P AD=0.1152P
+ PS=1.6U PD=1U
M$5080 QBb RB \$4399 VSS nfet_03v3 L=0.28U W=0.36U AS=0.1152P AD=0.1584P PS=1U
+ PD=1.6U
M$5081 VSS RB \$4523 VSS nfet_03v3 L=0.28U W=0.36U AS=0.1854P AD=0.1584P
+ PS=1.75U PD=1.6U
M$5082 VSS RB \$4773 VSS nfet_03v3 L=0.28U W=0.36U AS=0.1854P AD=0.1584P
+ PS=1.75U PD=1.6U
M$5083 \$4524 RA VSS VSS nfet_03v3 L=0.28U W=0.36U AS=0.1656P AD=0.1944P
+ PS=1.64U PD=1.8U
M$5084 \$4778 RA VSS VSS nfet_03v3 L=0.28U W=0.36U AS=0.1656P AD=0.1944P
+ PS=1.64U PD=1.8U
M$5085 \$4777 RA QAb VSS nfet_03v3 L=0.28U W=0.36U AS=0.1584P AD=0.1152P
+ PS=1.6U PD=1U
M$5086 QBb RB \$4777 VSS nfet_03v3 L=0.28U W=0.36U AS=0.1152P AD=0.1584P PS=1U
+ PD=1.6U
M$5087 \$4400 RA QAb VSS nfet_03v3 L=0.28U W=0.36U AS=0.1584P AD=0.1152P
+ PS=1.6U PD=1U
M$5088 QBb RB \$4400 VSS nfet_03v3 L=0.28U W=0.36U AS=0.1152P AD=0.1584P PS=1U
+ PD=1.6U
M$5089 VSS RB \$4525 VSS nfet_03v3 L=0.28U W=0.36U AS=0.1854P AD=0.1584P
+ PS=1.75U PD=1.6U
M$5090 VSS RB \$4779 VSS nfet_03v3 L=0.28U W=0.36U AS=0.1854P AD=0.1584P
+ PS=1.75U PD=1.6U
M$5091 \$4784 RA VSS VSS nfet_03v3 L=0.28U W=0.36U AS=0.1656P AD=0.1944P
+ PS=1.64U PD=1.8U
M$5092 \$4526 RA VSS VSS nfet_03v3 L=0.28U W=0.36U AS=0.1656P AD=0.1944P
+ PS=1.64U PD=1.8U
M$5093 \$4401 RA QAb VSS nfet_03v3 L=0.28U W=0.36U AS=0.1584P AD=0.1152P
+ PS=1.6U PD=1U
M$5094 QBb RB \$4401 VSS nfet_03v3 L=0.28U W=0.36U AS=0.1152P AD=0.1584P PS=1U
+ PD=1.6U
M$5095 \$4783 RA QAb VSS nfet_03v3 L=0.28U W=0.36U AS=0.1584P AD=0.1152P
+ PS=1.6U PD=1U
M$5096 QBb RB \$4783 VSS nfet_03v3 L=0.28U W=0.36U AS=0.1152P AD=0.1584P PS=1U
+ PD=1.6U
M$5097 VSS RB \$4527 VSS nfet_03v3 L=0.28U W=0.36U AS=0.1854P AD=0.1584P
+ PS=1.75U PD=1.6U
M$5098 VSS RB \$4785 VSS nfet_03v3 L=0.28U W=0.36U AS=0.1854P AD=0.1584P
+ PS=1.75U PD=1.6U
M$5099 \$4790 RA VSS VSS nfet_03v3 L=0.28U W=0.36U AS=0.1656P AD=0.1944P
+ PS=1.64U PD=1.8U
M$5100 \$4528 RA VSS VSS nfet_03v3 L=0.28U W=0.36U AS=0.1656P AD=0.1944P
+ PS=1.64U PD=1.8U
M$5101 \$4402 RA QAb VSS nfet_03v3 L=0.28U W=0.36U AS=0.1584P AD=0.1152P
+ PS=1.6U PD=1U
M$5102 QBb RB \$4402 VSS nfet_03v3 L=0.28U W=0.36U AS=0.1152P AD=0.1584P PS=1U
+ PD=1.6U
M$5103 \$4789 RA QAb VSS nfet_03v3 L=0.28U W=0.36U AS=0.1584P AD=0.1152P
+ PS=1.6U PD=1U
M$5104 QBb RB \$4789 VSS nfet_03v3 L=0.28U W=0.36U AS=0.1152P AD=0.1584P PS=1U
+ PD=1.6U
M$5105 VSS RB \$4529 VSS nfet_03v3 L=0.28U W=0.36U AS=0.1854P AD=0.1584P
+ PS=1.75U PD=1.6U
M$5106 VSS RB \$4791 VSS nfet_03v3 L=0.28U W=0.36U AS=0.1854P AD=0.1584P
+ PS=1.75U PD=1.6U
M$5107 \$4530 RA VSS VSS nfet_03v3 L=0.28U W=0.36U AS=0.1656P AD=0.1944P
+ PS=1.64U PD=1.8U
M$5108 \$4796 RA VSS VSS nfet_03v3 L=0.28U W=0.36U AS=0.1656P AD=0.1944P
+ PS=1.64U PD=1.8U
M$5109 \$4795 RA QAb VSS nfet_03v3 L=0.28U W=0.36U AS=0.1584P AD=0.1152P
+ PS=1.6U PD=1U
M$5110 QBb RB \$4795 VSS nfet_03v3 L=0.28U W=0.36U AS=0.1152P AD=0.1584P PS=1U
+ PD=1.6U
M$5111 \$4403 RA QAb VSS nfet_03v3 L=0.28U W=0.36U AS=0.1584P AD=0.1152P
+ PS=1.6U PD=1U
M$5112 QBb RB \$4403 VSS nfet_03v3 L=0.28U W=0.36U AS=0.1152P AD=0.1584P PS=1U
+ PD=1.6U
M$5113 VSS RB \$4797 VSS nfet_03v3 L=0.28U W=0.36U AS=0.1854P AD=0.1584P
+ PS=1.75U PD=1.6U
M$5114 VSS RB \$4531 VSS nfet_03v3 L=0.28U W=0.36U AS=0.1854P AD=0.1584P
+ PS=1.75U PD=1.6U
M$5115 \$4532 RA VSS VSS nfet_03v3 L=0.28U W=0.36U AS=0.1656P AD=0.1944P
+ PS=1.64U PD=1.8U
M$5116 \$4802 RA VSS VSS nfet_03v3 L=0.28U W=0.36U AS=0.1656P AD=0.1944P
+ PS=1.64U PD=1.8U
M$5117 \$4404 RA QAb VSS nfet_03v3 L=0.28U W=0.36U AS=0.1584P AD=0.1152P
+ PS=1.6U PD=1U
M$5118 QBb RB \$4404 VSS nfet_03v3 L=0.28U W=0.36U AS=0.1152P AD=0.1584P PS=1U
+ PD=1.6U
M$5119 \$4801 RA QAb VSS nfet_03v3 L=0.28U W=0.36U AS=0.1584P AD=0.1152P
+ PS=1.6U PD=1U
M$5120 QBb RB \$4801 VSS nfet_03v3 L=0.28U W=0.36U AS=0.1152P AD=0.1584P PS=1U
+ PD=1.6U
M$5121 VSS RB \$4533 VSS nfet_03v3 L=0.28U W=0.36U AS=0.1854P AD=0.1584P
+ PS=1.75U PD=1.6U
M$5122 VSS RB \$4803 VSS nfet_03v3 L=0.28U W=0.36U AS=0.1854P AD=0.1584P
+ PS=1.75U PD=1.6U
M$5123 \$4808 RA VSS VSS nfet_03v3 L=0.28U W=0.36U AS=0.1656P AD=0.1944P
+ PS=1.64U PD=1.8U
M$5124 \$4534 RA VSS VSS nfet_03v3 L=0.28U W=0.36U AS=0.1656P AD=0.1944P
+ PS=1.64U PD=1.8U
M$5125 \$4807 RA QAb VSS nfet_03v3 L=0.28U W=0.36U AS=0.1584P AD=0.1152P
+ PS=1.6U PD=1U
M$5126 QBb RB \$4807 VSS nfet_03v3 L=0.28U W=0.36U AS=0.1152P AD=0.1584P PS=1U
+ PD=1.6U
M$5127 \$4405 RA QAb VSS nfet_03v3 L=0.28U W=0.36U AS=0.1584P AD=0.1152P
+ PS=1.6U PD=1U
M$5128 QBb RB \$4405 VSS nfet_03v3 L=0.28U W=0.36U AS=0.1152P AD=0.1584P PS=1U
+ PD=1.6U
M$5129 VSS RB \$4535 VSS nfet_03v3 L=0.28U W=0.36U AS=0.1854P AD=0.1584P
+ PS=1.75U PD=1.6U
M$5130 VSS RB \$4809 VSS nfet_03v3 L=0.28U W=0.36U AS=0.1854P AD=0.1584P
+ PS=1.75U PD=1.6U
M$5131 \$4814 RA VSS VSS nfet_03v3 L=0.28U W=0.36U AS=0.1656P AD=0.1944P
+ PS=1.64U PD=1.8U
M$5132 \$4536 RA VSS VSS nfet_03v3 L=0.28U W=0.36U AS=0.1656P AD=0.1944P
+ PS=1.64U PD=1.8U
M$5133 \$4406 RA QAb VSS nfet_03v3 L=0.28U W=0.36U AS=0.1584P AD=0.1152P
+ PS=1.6U PD=1U
M$5134 QBb RB \$4406 VSS nfet_03v3 L=0.28U W=0.36U AS=0.1152P AD=0.1584P PS=1U
+ PD=1.6U
M$5135 \$4813 RA QAb VSS nfet_03v3 L=0.28U W=0.36U AS=0.1584P AD=0.1152P
+ PS=1.6U PD=1U
M$5136 QBb RB \$4813 VSS nfet_03v3 L=0.28U W=0.36U AS=0.1152P AD=0.1584P PS=1U
+ PD=1.6U
M$5137 VSS RB \$4537 VSS nfet_03v3 L=0.28U W=0.36U AS=0.1854P AD=0.1584P
+ PS=1.75U PD=1.6U
M$5138 VSS RB \$4815 VSS nfet_03v3 L=0.28U W=0.36U AS=0.1854P AD=0.1584P
+ PS=1.75U PD=1.6U
M$5139 \$4538 RA VSS VSS nfet_03v3 L=0.28U W=0.36U AS=0.1656P AD=0.1944P
+ PS=1.64U PD=1.8U
M$5140 \$4820 RA VSS VSS nfet_03v3 L=0.28U W=0.36U AS=0.1656P AD=0.1944P
+ PS=1.64U PD=1.8U
M$5141 \$4819 RA QAb VSS nfet_03v3 L=0.28U W=0.36U AS=0.1584P AD=0.1152P
+ PS=1.6U PD=1U
M$5142 QBb RB \$4819 VSS nfet_03v3 L=0.28U W=0.36U AS=0.1152P AD=0.1584P PS=1U
+ PD=1.6U
M$5143 \$4407 RA QAb VSS nfet_03v3 L=0.28U W=0.36U AS=0.1584P AD=0.1152P
+ PS=1.6U PD=1U
M$5144 QBb RB \$4407 VSS nfet_03v3 L=0.28U W=0.36U AS=0.1152P AD=0.1584P PS=1U
+ PD=1.6U
M$5145 VSS RB \$4821 VSS nfet_03v3 L=0.28U W=0.36U AS=0.1854P AD=0.1584P
+ PS=1.75U PD=1.6U
M$5146 VSS RB \$4539 VSS nfet_03v3 L=0.28U W=0.36U AS=0.1854P AD=0.1584P
+ PS=1.75U PD=1.6U
M$5147 \$4826 RA VSS VSS nfet_03v3 L=0.28U W=0.36U AS=0.1656P AD=0.1944P
+ PS=1.64U PD=1.8U
M$5148 \$4540 RA VSS VSS nfet_03v3 L=0.28U W=0.36U AS=0.1656P AD=0.1944P
+ PS=1.64U PD=1.8U
M$5149 \$4825 RA QAb VSS nfet_03v3 L=0.28U W=0.36U AS=0.1584P AD=0.1152P
+ PS=1.6U PD=1U
M$5150 QBb RB \$4825 VSS nfet_03v3 L=0.28U W=0.36U AS=0.1152P AD=0.1584P PS=1U
+ PD=1.6U
M$5151 \$4408 RA QAb VSS nfet_03v3 L=0.28U W=0.36U AS=0.1584P AD=0.1152P
+ PS=1.6U PD=1U
M$5152 QBb RB \$4408 VSS nfet_03v3 L=0.28U W=0.36U AS=0.1152P AD=0.1584P PS=1U
+ PD=1.6U
M$5153 VSS RB \$4541 VSS nfet_03v3 L=0.28U W=0.36U AS=0.1854P AD=0.1584P
+ PS=1.75U PD=1.6U
M$5154 VSS RB \$4827 VSS nfet_03v3 L=0.28U W=0.36U AS=0.1854P AD=0.1584P
+ PS=1.75U PD=1.6U
M$5155 \$4832 RA VSS VSS nfet_03v3 L=0.28U W=0.36U AS=0.1656P AD=0.1944P
+ PS=1.64U PD=1.8U
M$5156 \$4542 RA VSS VSS nfet_03v3 L=0.28U W=0.36U AS=0.1656P AD=0.1944P
+ PS=1.64U PD=1.8U
M$5157 \$4409 RA QAb VSS nfet_03v3 L=0.28U W=0.36U AS=0.1584P AD=0.1152P
+ PS=1.6U PD=1U
M$5158 QBb RB \$4409 VSS nfet_03v3 L=0.28U W=0.36U AS=0.1152P AD=0.1584P PS=1U
+ PD=1.6U
M$5159 \$4831 RA QAb VSS nfet_03v3 L=0.28U W=0.36U AS=0.1584P AD=0.1152P
+ PS=1.6U PD=1U
M$5160 QBb RB \$4831 VSS nfet_03v3 L=0.28U W=0.36U AS=0.1152P AD=0.1584P PS=1U
+ PD=1.6U
M$5161 VSS RB \$4833 VSS nfet_03v3 L=0.28U W=0.36U AS=0.1854P AD=0.1584P
+ PS=1.75U PD=1.6U
M$5162 VSS RB \$4543 VSS nfet_03v3 L=0.28U W=0.36U AS=0.1854P AD=0.1584P
+ PS=1.75U PD=1.6U
M$5163 \$4544 RA VSS VSS nfet_03v3 L=0.28U W=0.36U AS=0.1656P AD=0.1944P
+ PS=1.64U PD=1.8U
M$5164 \$4838 RA VSS VSS nfet_03v3 L=0.28U W=0.36U AS=0.1656P AD=0.1944P
+ PS=1.64U PD=1.8U
M$5165 \$4410 RA QAb VSS nfet_03v3 L=0.28U W=0.36U AS=0.1584P AD=0.1152P
+ PS=1.6U PD=1U
M$5166 QBb RB \$4410 VSS nfet_03v3 L=0.28U W=0.36U AS=0.1152P AD=0.1584P PS=1U
+ PD=1.6U
M$5167 \$4837 RA QAb VSS nfet_03v3 L=0.28U W=0.36U AS=0.1584P AD=0.1152P
+ PS=1.6U PD=1U
M$5168 QBb RB \$4837 VSS nfet_03v3 L=0.28U W=0.36U AS=0.1152P AD=0.1584P PS=1U
+ PD=1.6U
M$5169 VSS RB \$4545 VSS nfet_03v3 L=0.28U W=0.36U AS=0.1854P AD=0.1584P
+ PS=1.75U PD=1.6U
M$5170 VSS RB \$4839 VSS nfet_03v3 L=0.28U W=0.36U AS=0.1854P AD=0.1584P
+ PS=1.75U PD=1.6U
M$5171 \$4975 WE VSS VSS nfet_03v3 L=0.28U W=0.72U AS=0.3168P AD=0.1872P
+ PS=2.32U PD=1.24U
M$5172 \$4738 CLK \$4975 VSS nfet_03v3 L=0.28U W=0.72U AS=0.1872P AD=0.3168P
+ PS=1.24U PD=2.32U
M$5173 WECLK \$4738 VSS VSS nfet_03v3 L=0.28U W=1.27U AS=0.4487P AD=0.3302P
+ PS=3.34U PD=2.31U
M$5177 \$4743 D|Q VSS VSS nfet_03v3 L=0.28U W=0.36U AS=0.1584P AD=0.1188P
+ PS=1.6U PD=1.02U
M$5178 \$4744 WECLK \$4743 VSS nfet_03v3 L=0.28U W=0.36U AS=0.1188P AD=0.1278P
+ PS=1.02U PD=1.07U
M$5179 \$4979 \$4745 \$4744 VSS nfet_03v3 L=0.28U W=0.36U AS=0.1278P AD=0.0567P
+ PS=1.07U PD=0.675U
M$5180 VSS WECLKb \$4979 VSS nfet_03v3 L=0.28U W=0.36U AS=0.0567P AD=0.1584P
+ PS=0.675U PD=1.6U
M$5181 VSS \$4744 \$4745 VSS nfet_03v3 L=0.28U W=0.36U AS=0.1584P AD=0.0972P
+ PS=1.6U PD=0.9U
M$5182 \$4746 \$4744 VSS VSS nfet_03v3 L=0.28U W=0.36U AS=0.0972P AD=0.18P
+ PS=0.9U PD=1.72U
M$5183 \$4750 D|Q VSS VSS nfet_03v3 L=0.28U W=0.36U AS=0.1584P AD=0.1188P
+ PS=1.6U PD=1.02U
M$5184 \$4751 WECLK \$4750 VSS nfet_03v3 L=0.28U W=0.36U AS=0.1188P AD=0.1278P
+ PS=1.02U PD=1.07U
M$5185 \$4986 \$4752 \$4751 VSS nfet_03v3 L=0.28U W=0.36U AS=0.1278P AD=0.0567P
+ PS=1.07U PD=0.675U
M$5186 VSS WECLKb \$4986 VSS nfet_03v3 L=0.28U W=0.36U AS=0.0567P AD=0.1584P
+ PS=0.675U PD=1.6U
M$5187 VSS \$4751 \$4752 VSS nfet_03v3 L=0.28U W=0.36U AS=0.1584P AD=0.0972P
+ PS=1.6U PD=0.9U
M$5188 \$4753 \$4751 VSS VSS nfet_03v3 L=0.28U W=0.36U AS=0.0972P AD=0.18P
+ PS=0.9U PD=1.72U
M$5189 \$4756 D|Q VSS VSS nfet_03v3 L=0.28U W=0.36U AS=0.1584P AD=0.1188P
+ PS=1.6U PD=1.02U
M$5190 \$4757 WECLK \$4756 VSS nfet_03v3 L=0.28U W=0.36U AS=0.1188P AD=0.1278P
+ PS=1.02U PD=1.07U
M$5191 \$4993 \$4758 \$4757 VSS nfet_03v3 L=0.28U W=0.36U AS=0.1278P AD=0.0567P
+ PS=1.07U PD=0.675U
M$5192 VSS WECLKb \$4993 VSS nfet_03v3 L=0.28U W=0.36U AS=0.0567P AD=0.1584P
+ PS=0.675U PD=1.6U
M$5193 VSS \$4757 \$4758 VSS nfet_03v3 L=0.28U W=0.36U AS=0.1584P AD=0.0972P
+ PS=1.6U PD=0.9U
M$5194 \$4759 \$4757 VSS VSS nfet_03v3 L=0.28U W=0.36U AS=0.0972P AD=0.18P
+ PS=0.9U PD=1.72U
M$5195 \$4762 D|Q VSS VSS nfet_03v3 L=0.28U W=0.36U AS=0.1584P AD=0.1188P
+ PS=1.6U PD=1.02U
M$5196 \$4763 WECLK \$4762 VSS nfet_03v3 L=0.28U W=0.36U AS=0.1188P AD=0.1278P
+ PS=1.02U PD=1.07U
M$5197 \$5001 \$4764 \$4763 VSS nfet_03v3 L=0.28U W=0.36U AS=0.1278P AD=0.0567P
+ PS=1.07U PD=0.675U
M$5198 VSS WECLKb \$5001 VSS nfet_03v3 L=0.28U W=0.36U AS=0.0567P AD=0.1584P
+ PS=0.675U PD=1.6U
M$5199 VSS \$4763 \$4764 VSS nfet_03v3 L=0.28U W=0.36U AS=0.1584P AD=0.0972P
+ PS=1.6U PD=0.9U
M$5200 \$4765 \$4763 VSS VSS nfet_03v3 L=0.28U W=0.36U AS=0.0972P AD=0.18P
+ PS=0.9U PD=1.72U
M$5201 \$4768 D|Q VSS VSS nfet_03v3 L=0.28U W=0.36U AS=0.1584P AD=0.1188P
+ PS=1.6U PD=1.02U
M$5202 \$4769 WECLK \$4768 VSS nfet_03v3 L=0.28U W=0.36U AS=0.1188P AD=0.1278P
+ PS=1.02U PD=1.07U
M$5203 \$5007 \$4770 \$4769 VSS nfet_03v3 L=0.28U W=0.36U AS=0.1278P AD=0.0567P
+ PS=1.07U PD=0.675U
M$5204 VSS WECLKb \$5007 VSS nfet_03v3 L=0.28U W=0.36U AS=0.0567P AD=0.1584P
+ PS=0.675U PD=1.6U
M$5205 VSS \$4769 \$4770 VSS nfet_03v3 L=0.28U W=0.36U AS=0.1584P AD=0.0972P
+ PS=1.6U PD=0.9U
M$5206 \$4771 \$4769 VSS VSS nfet_03v3 L=0.28U W=0.36U AS=0.0972P AD=0.18P
+ PS=0.9U PD=1.72U
M$5207 \$4774 D|Q VSS VSS nfet_03v3 L=0.28U W=0.36U AS=0.1584P AD=0.1188P
+ PS=1.6U PD=1.02U
M$5208 \$4775 WECLK \$4774 VSS nfet_03v3 L=0.28U W=0.36U AS=0.1188P AD=0.1278P
+ PS=1.02U PD=1.07U
M$5209 \$5014 \$4776 \$4775 VSS nfet_03v3 L=0.28U W=0.36U AS=0.1278P AD=0.0567P
+ PS=1.07U PD=0.675U
M$5210 VSS WECLKb \$5014 VSS nfet_03v3 L=0.28U W=0.36U AS=0.0567P AD=0.1584P
+ PS=0.675U PD=1.6U
M$5211 VSS \$4775 \$4776 VSS nfet_03v3 L=0.28U W=0.36U AS=0.1584P AD=0.0972P
+ PS=1.6U PD=0.9U
M$5212 \$4777 \$4775 VSS VSS nfet_03v3 L=0.28U W=0.36U AS=0.0972P AD=0.18P
+ PS=0.9U PD=1.72U
M$5213 \$4780 D|Q VSS VSS nfet_03v3 L=0.28U W=0.36U AS=0.1584P AD=0.1188P
+ PS=1.6U PD=1.02U
M$5214 \$4781 WECLK \$4780 VSS nfet_03v3 L=0.28U W=0.36U AS=0.1188P AD=0.1278P
+ PS=1.02U PD=1.07U
M$5215 \$5021 \$4782 \$4781 VSS nfet_03v3 L=0.28U W=0.36U AS=0.1278P AD=0.0567P
+ PS=1.07U PD=0.675U
M$5216 VSS WECLKb \$5021 VSS nfet_03v3 L=0.28U W=0.36U AS=0.0567P AD=0.1584P
+ PS=0.675U PD=1.6U
M$5217 VSS \$4781 \$4782 VSS nfet_03v3 L=0.28U W=0.36U AS=0.1584P AD=0.0972P
+ PS=1.6U PD=0.9U
M$5218 \$4783 \$4781 VSS VSS nfet_03v3 L=0.28U W=0.36U AS=0.0972P AD=0.18P
+ PS=0.9U PD=1.72U
M$5219 \$4786 D|Q VSS VSS nfet_03v3 L=0.28U W=0.36U AS=0.1584P AD=0.1188P
+ PS=1.6U PD=1.02U
M$5220 \$4787 WECLK \$4786 VSS nfet_03v3 L=0.28U W=0.36U AS=0.1188P AD=0.1278P
+ PS=1.02U PD=1.07U
M$5221 \$5029 \$4788 \$4787 VSS nfet_03v3 L=0.28U W=0.36U AS=0.1278P AD=0.0567P
+ PS=1.07U PD=0.675U
M$5222 VSS WECLKb \$5029 VSS nfet_03v3 L=0.28U W=0.36U AS=0.0567P AD=0.1584P
+ PS=0.675U PD=1.6U
M$5223 VSS \$4787 \$4788 VSS nfet_03v3 L=0.28U W=0.36U AS=0.1584P AD=0.0972P
+ PS=1.6U PD=0.9U
M$5224 \$4789 \$4787 VSS VSS nfet_03v3 L=0.28U W=0.36U AS=0.0972P AD=0.18P
+ PS=0.9U PD=1.72U
M$5225 \$4792 D|Q VSS VSS nfet_03v3 L=0.28U W=0.36U AS=0.1584P AD=0.1188P
+ PS=1.6U PD=1.02U
M$5226 \$4793 WECLK \$4792 VSS nfet_03v3 L=0.28U W=0.36U AS=0.1188P AD=0.1278P
+ PS=1.02U PD=1.07U
M$5227 \$5037 \$4794 \$4793 VSS nfet_03v3 L=0.28U W=0.36U AS=0.1278P AD=0.0567P
+ PS=1.07U PD=0.675U
M$5228 VSS WECLKb \$5037 VSS nfet_03v3 L=0.28U W=0.36U AS=0.0567P AD=0.1584P
+ PS=0.675U PD=1.6U
M$5229 VSS \$4793 \$4794 VSS nfet_03v3 L=0.28U W=0.36U AS=0.1584P AD=0.0972P
+ PS=1.6U PD=0.9U
M$5230 \$4795 \$4793 VSS VSS nfet_03v3 L=0.28U W=0.36U AS=0.0972P AD=0.18P
+ PS=0.9U PD=1.72U
M$5231 \$4798 D|Q VSS VSS nfet_03v3 L=0.28U W=0.36U AS=0.1584P AD=0.1188P
+ PS=1.6U PD=1.02U
M$5232 \$4799 WECLK \$4798 VSS nfet_03v3 L=0.28U W=0.36U AS=0.1188P AD=0.1278P
+ PS=1.02U PD=1.07U
M$5233 \$5043 \$4800 \$4799 VSS nfet_03v3 L=0.28U W=0.36U AS=0.1278P AD=0.0567P
+ PS=1.07U PD=0.675U
M$5234 VSS WECLKb \$5043 VSS nfet_03v3 L=0.28U W=0.36U AS=0.0567P AD=0.1584P
+ PS=0.675U PD=1.6U
M$5235 VSS \$4799 \$4800 VSS nfet_03v3 L=0.28U W=0.36U AS=0.1584P AD=0.0972P
+ PS=1.6U PD=0.9U
M$5236 \$4801 \$4799 VSS VSS nfet_03v3 L=0.28U W=0.36U AS=0.0972P AD=0.18P
+ PS=0.9U PD=1.72U
M$5237 \$4804 D|Q VSS VSS nfet_03v3 L=0.28U W=0.36U AS=0.1584P AD=0.1188P
+ PS=1.6U PD=1.02U
M$5238 \$4805 WECLK \$4804 VSS nfet_03v3 L=0.28U W=0.36U AS=0.1188P AD=0.1278P
+ PS=1.02U PD=1.07U
M$5239 \$5050 \$4806 \$4805 VSS nfet_03v3 L=0.28U W=0.36U AS=0.1278P AD=0.0567P
+ PS=1.07U PD=0.675U
M$5240 VSS WECLKb \$5050 VSS nfet_03v3 L=0.28U W=0.36U AS=0.0567P AD=0.1584P
+ PS=0.675U PD=1.6U
M$5241 VSS \$4805 \$4806 VSS nfet_03v3 L=0.28U W=0.36U AS=0.1584P AD=0.0972P
+ PS=1.6U PD=0.9U
M$5242 \$4807 \$4805 VSS VSS nfet_03v3 L=0.28U W=0.36U AS=0.0972P AD=0.18P
+ PS=0.9U PD=1.72U
M$5243 \$4810 D|Q VSS VSS nfet_03v3 L=0.28U W=0.36U AS=0.1584P AD=0.1188P
+ PS=1.6U PD=1.02U
M$5244 \$4811 WECLK \$4810 VSS nfet_03v3 L=0.28U W=0.36U AS=0.1188P AD=0.1278P
+ PS=1.02U PD=1.07U
M$5245 \$5057 \$4812 \$4811 VSS nfet_03v3 L=0.28U W=0.36U AS=0.1278P AD=0.0567P
+ PS=1.07U PD=0.675U
M$5246 VSS WECLKb \$5057 VSS nfet_03v3 L=0.28U W=0.36U AS=0.0567P AD=0.1584P
+ PS=0.675U PD=1.6U
M$5247 VSS \$4811 \$4812 VSS nfet_03v3 L=0.28U W=0.36U AS=0.1584P AD=0.0972P
+ PS=1.6U PD=0.9U
M$5248 \$4813 \$4811 VSS VSS nfet_03v3 L=0.28U W=0.36U AS=0.0972P AD=0.18P
+ PS=0.9U PD=1.72U
M$5249 \$4816 D|Q VSS VSS nfet_03v3 L=0.28U W=0.36U AS=0.1584P AD=0.1188P
+ PS=1.6U PD=1.02U
M$5250 \$4817 WECLK \$4816 VSS nfet_03v3 L=0.28U W=0.36U AS=0.1188P AD=0.1278P
+ PS=1.02U PD=1.07U
M$5251 \$5065 \$4818 \$4817 VSS nfet_03v3 L=0.28U W=0.36U AS=0.1278P AD=0.0567P
+ PS=1.07U PD=0.675U
M$5252 VSS WECLKb \$5065 VSS nfet_03v3 L=0.28U W=0.36U AS=0.0567P AD=0.1584P
+ PS=0.675U PD=1.6U
M$5253 VSS \$4817 \$4818 VSS nfet_03v3 L=0.28U W=0.36U AS=0.1584P AD=0.0972P
+ PS=1.6U PD=0.9U
M$5254 \$4819 \$4817 VSS VSS nfet_03v3 L=0.28U W=0.36U AS=0.0972P AD=0.18P
+ PS=0.9U PD=1.72U
M$5255 \$4822 D|Q VSS VSS nfet_03v3 L=0.28U W=0.36U AS=0.1584P AD=0.1188P
+ PS=1.6U PD=1.02U
M$5256 \$4823 WECLK \$4822 VSS nfet_03v3 L=0.28U W=0.36U AS=0.1188P AD=0.1278P
+ PS=1.02U PD=1.07U
M$5257 \$5072 \$4824 \$4823 VSS nfet_03v3 L=0.28U W=0.36U AS=0.1278P AD=0.0567P
+ PS=1.07U PD=0.675U
M$5258 VSS WECLKb \$5072 VSS nfet_03v3 L=0.28U W=0.36U AS=0.0567P AD=0.1584P
+ PS=0.675U PD=1.6U
M$5259 VSS \$4823 \$4824 VSS nfet_03v3 L=0.28U W=0.36U AS=0.1584P AD=0.0972P
+ PS=1.6U PD=0.9U
M$5260 \$4825 \$4823 VSS VSS nfet_03v3 L=0.28U W=0.36U AS=0.0972P AD=0.18P
+ PS=0.9U PD=1.72U
M$5261 \$4828 D|Q VSS VSS nfet_03v3 L=0.28U W=0.36U AS=0.1584P AD=0.1188P
+ PS=1.6U PD=1.02U
M$5262 \$4829 WECLK \$4828 VSS nfet_03v3 L=0.28U W=0.36U AS=0.1188P AD=0.1278P
+ PS=1.02U PD=1.07U
M$5263 \$5036 \$4830 \$4829 VSS nfet_03v3 L=0.28U W=0.36U AS=0.1278P AD=0.0567P
+ PS=1.07U PD=0.675U
M$5264 VSS WECLKb \$5036 VSS nfet_03v3 L=0.28U W=0.36U AS=0.0567P AD=0.1584P
+ PS=0.675U PD=1.6U
M$5265 VSS \$4829 \$4830 VSS nfet_03v3 L=0.28U W=0.36U AS=0.1584P AD=0.0972P
+ PS=1.6U PD=0.9U
M$5266 \$4831 \$4829 VSS VSS nfet_03v3 L=0.28U W=0.36U AS=0.0972P AD=0.18P
+ PS=0.9U PD=1.72U
M$5267 \$4834 D|Q VSS VSS nfet_03v3 L=0.28U W=0.36U AS=0.1584P AD=0.1188P
+ PS=1.6U PD=1.02U
M$5268 \$4835 WECLK \$4834 VSS nfet_03v3 L=0.28U W=0.36U AS=0.1188P AD=0.1278P
+ PS=1.02U PD=1.07U
M$5269 \$5000 \$4836 \$4835 VSS nfet_03v3 L=0.28U W=0.36U AS=0.1278P AD=0.0567P
+ PS=1.07U PD=0.675U
M$5270 VSS WECLKb \$5000 VSS nfet_03v3 L=0.28U W=0.36U AS=0.0567P AD=0.1584P
+ PS=0.675U PD=1.6U
M$5271 VSS \$4835 \$4836 VSS nfet_03v3 L=0.28U W=0.36U AS=0.1584P AD=0.0972P
+ PS=1.6U PD=0.9U
M$5272 \$4837 \$4835 VSS VSS nfet_03v3 L=0.28U W=0.36U AS=0.0972P AD=0.18P
+ PS=0.9U PD=1.72U
M$5273 \$5228 WE VSS VSS nfet_03v3 L=0.28U W=0.72U AS=0.3168P AD=0.1872P
+ PS=2.32U PD=1.24U
M$5274 \$5089 CLK \$5228 VSS nfet_03v3 L=0.28U W=0.72U AS=0.1872P AD=0.3168P
+ PS=1.24U PD=2.32U
M$5275 WECLK \$5089 VSS VSS nfet_03v3 L=0.28U W=1.27U AS=0.4445P AD=0.3344P
+ PS=3.305U PD=2.345U
M$5279 \$5092 D|Q VSS VSS nfet_03v3 L=0.28U W=0.36U AS=0.1584P AD=0.1188P
+ PS=1.6U PD=1.02U
M$5280 \$5093 WECLK \$5092 VSS nfet_03v3 L=0.28U W=0.36U AS=0.1188P AD=0.1278P
+ PS=1.02U PD=1.07U
M$5281 \$5146 \$5094 \$5093 VSS nfet_03v3 L=0.28U W=0.36U AS=0.1278P AD=0.0567P
+ PS=1.07U PD=0.675U
M$5282 VSS WECLKb \$5146 VSS nfet_03v3 L=0.28U W=0.36U AS=0.0567P AD=0.1584P
+ PS=0.675U PD=1.6U
M$5283 VSS \$5093 \$5094 VSS nfet_03v3 L=0.28U W=0.36U AS=0.1584P AD=0.0972P
+ PS=1.6U PD=0.9U
M$5284 \$5073 \$5093 VSS VSS nfet_03v3 L=0.28U W=0.36U AS=0.0972P AD=0.18P
+ PS=0.9U PD=1.72U
M$5285 \$5095 D|Q VSS VSS nfet_03v3 L=0.28U W=0.36U AS=0.1584P AD=0.1188P
+ PS=1.6U PD=1.02U
M$5286 \$5096 WECLK \$5095 VSS nfet_03v3 L=0.28U W=0.36U AS=0.1188P AD=0.1278P
+ PS=1.02U PD=1.07U
M$5287 \$5157 \$5097 \$5096 VSS nfet_03v3 L=0.28U W=0.36U AS=0.1278P AD=0.0567P
+ PS=1.07U PD=0.675U
M$5288 VSS WECLKb \$5157 VSS nfet_03v3 L=0.28U W=0.36U AS=0.0567P AD=0.1584P
+ PS=0.675U PD=1.6U
M$5289 VSS \$5096 \$5097 VSS nfet_03v3 L=0.28U W=0.36U AS=0.1584P AD=0.0972P
+ PS=1.6U PD=0.9U
M$5290 \$5074 \$5096 VSS VSS nfet_03v3 L=0.28U W=0.36U AS=0.0972P AD=0.18P
+ PS=0.9U PD=1.72U
M$5291 \$5098 D|Q VSS VSS nfet_03v3 L=0.28U W=0.36U AS=0.1584P AD=0.1188P
+ PS=1.6U PD=1.02U
M$5292 \$5099 WECLK \$5098 VSS nfet_03v3 L=0.28U W=0.36U AS=0.1188P AD=0.1278P
+ PS=1.02U PD=1.07U
M$5293 \$5166 \$5100 \$5099 VSS nfet_03v3 L=0.28U W=0.36U AS=0.1278P AD=0.0567P
+ PS=1.07U PD=0.675U
M$5294 VSS WECLKb \$5166 VSS nfet_03v3 L=0.28U W=0.36U AS=0.0567P AD=0.1584P
+ PS=0.675U PD=1.6U
M$5295 VSS \$5099 \$5100 VSS nfet_03v3 L=0.28U W=0.36U AS=0.1584P AD=0.0972P
+ PS=1.6U PD=0.9U
M$5296 \$5075 \$5099 VSS VSS nfet_03v3 L=0.28U W=0.36U AS=0.0972P AD=0.18P
+ PS=0.9U PD=1.72U
M$5297 \$5101 D|Q VSS VSS nfet_03v3 L=0.28U W=0.36U AS=0.1584P AD=0.1188P
+ PS=1.6U PD=1.02U
M$5298 \$5102 WECLK \$5101 VSS nfet_03v3 L=0.28U W=0.36U AS=0.1188P AD=0.1278P
+ PS=1.02U PD=1.07U
M$5299 \$5176 \$5103 \$5102 VSS nfet_03v3 L=0.28U W=0.36U AS=0.1278P AD=0.0567P
+ PS=1.07U PD=0.675U
M$5300 VSS WECLKb \$5176 VSS nfet_03v3 L=0.28U W=0.36U AS=0.0567P AD=0.1584P
+ PS=0.675U PD=1.6U
M$5301 VSS \$5102 \$5103 VSS nfet_03v3 L=0.28U W=0.36U AS=0.1584P AD=0.0972P
+ PS=1.6U PD=0.9U
M$5302 \$5076 \$5102 VSS VSS nfet_03v3 L=0.28U W=0.36U AS=0.0972P AD=0.18P
+ PS=0.9U PD=1.72U
M$5303 \$5104 D|Q VSS VSS nfet_03v3 L=0.28U W=0.36U AS=0.1584P AD=0.1188P
+ PS=1.6U PD=1.02U
M$5304 \$5105 WECLK \$5104 VSS nfet_03v3 L=0.28U W=0.36U AS=0.1188P AD=0.1278P
+ PS=1.02U PD=1.07U
M$5305 \$5187 \$5106 \$5105 VSS nfet_03v3 L=0.28U W=0.36U AS=0.1278P AD=0.0567P
+ PS=1.07U PD=0.675U
M$5306 VSS WECLKb \$5187 VSS nfet_03v3 L=0.28U W=0.36U AS=0.0567P AD=0.1584P
+ PS=0.675U PD=1.6U
M$5307 VSS \$5105 \$5106 VSS nfet_03v3 L=0.28U W=0.36U AS=0.1584P AD=0.0972P
+ PS=1.6U PD=0.9U
M$5308 \$5077 \$5105 VSS VSS nfet_03v3 L=0.28U W=0.36U AS=0.0972P AD=0.18P
+ PS=0.9U PD=1.72U
M$5309 \$5107 D|Q VSS VSS nfet_03v3 L=0.28U W=0.36U AS=0.1584P AD=0.1188P
+ PS=1.6U PD=1.02U
M$5310 \$5108 WECLK \$5107 VSS nfet_03v3 L=0.28U W=0.36U AS=0.1188P AD=0.1278P
+ PS=1.02U PD=1.07U
M$5311 \$5191 \$5109 \$5108 VSS nfet_03v3 L=0.28U W=0.36U AS=0.1278P AD=0.0567P
+ PS=1.07U PD=0.675U
M$5312 VSS WECLKb \$5191 VSS nfet_03v3 L=0.28U W=0.36U AS=0.0567P AD=0.1584P
+ PS=0.675U PD=1.6U
M$5313 VSS \$5108 \$5109 VSS nfet_03v3 L=0.28U W=0.36U AS=0.1584P AD=0.0972P
+ PS=1.6U PD=0.9U
M$5314 \$5078 \$5108 VSS VSS nfet_03v3 L=0.28U W=0.36U AS=0.0972P AD=0.18P
+ PS=0.9U PD=1.72U
M$5315 \$5110 D|Q VSS VSS nfet_03v3 L=0.28U W=0.36U AS=0.1584P AD=0.1188P
+ PS=1.6U PD=1.02U
M$5316 \$5111 WECLK \$5110 VSS nfet_03v3 L=0.28U W=0.36U AS=0.1188P AD=0.1278P
+ PS=1.02U PD=1.07U
M$5317 \$5185 \$5112 \$5111 VSS nfet_03v3 L=0.28U W=0.36U AS=0.1278P AD=0.0567P
+ PS=1.07U PD=0.675U
M$5318 VSS WECLKb \$5185 VSS nfet_03v3 L=0.28U W=0.36U AS=0.0567P AD=0.1584P
+ PS=0.675U PD=1.6U
M$5319 VSS \$5111 \$5112 VSS nfet_03v3 L=0.28U W=0.36U AS=0.1584P AD=0.0972P
+ PS=1.6U PD=0.9U
M$5320 \$5079 \$5111 VSS VSS nfet_03v3 L=0.28U W=0.36U AS=0.0972P AD=0.18P
+ PS=0.9U PD=1.72U
M$5321 \$5113 D|Q VSS VSS nfet_03v3 L=0.28U W=0.36U AS=0.1584P AD=0.1188P
+ PS=1.6U PD=1.02U
M$5322 \$5114 WECLK \$5113 VSS nfet_03v3 L=0.28U W=0.36U AS=0.1188P AD=0.1278P
+ PS=1.02U PD=1.07U
M$5323 \$5182 \$5115 \$5114 VSS nfet_03v3 L=0.28U W=0.36U AS=0.1278P AD=0.0567P
+ PS=1.07U PD=0.675U
M$5324 VSS WECLKb \$5182 VSS nfet_03v3 L=0.28U W=0.36U AS=0.0567P AD=0.1584P
+ PS=0.675U PD=1.6U
M$5325 VSS \$5114 \$5115 VSS nfet_03v3 L=0.28U W=0.36U AS=0.1584P AD=0.0972P
+ PS=1.6U PD=0.9U
M$5326 \$5080 \$5114 VSS VSS nfet_03v3 L=0.28U W=0.36U AS=0.0972P AD=0.18P
+ PS=0.9U PD=1.72U
M$5327 \$5116 D|Q VSS VSS nfet_03v3 L=0.28U W=0.36U AS=0.1584P AD=0.1188P
+ PS=1.6U PD=1.02U
M$5328 \$5117 WECLK \$5116 VSS nfet_03v3 L=0.28U W=0.36U AS=0.1188P AD=0.1278P
+ PS=1.02U PD=1.07U
M$5329 \$5178 \$5118 \$5117 VSS nfet_03v3 L=0.28U W=0.36U AS=0.1278P AD=0.0567P
+ PS=1.07U PD=0.675U
M$5330 VSS WECLKb \$5178 VSS nfet_03v3 L=0.28U W=0.36U AS=0.0567P AD=0.1584P
+ PS=0.675U PD=1.6U
M$5331 VSS \$5117 \$5118 VSS nfet_03v3 L=0.28U W=0.36U AS=0.1584P AD=0.0972P
+ PS=1.6U PD=0.9U
M$5332 \$5081 \$5117 VSS VSS nfet_03v3 L=0.28U W=0.36U AS=0.0972P AD=0.18P
+ PS=0.9U PD=1.72U
M$5333 \$5119 D|Q VSS VSS nfet_03v3 L=0.28U W=0.36U AS=0.1584P AD=0.1188P
+ PS=1.6U PD=1.02U
M$5334 \$5120 WECLK \$5119 VSS nfet_03v3 L=0.28U W=0.36U AS=0.1188P AD=0.1278P
+ PS=1.02U PD=1.07U
M$5335 \$5173 \$5121 \$5120 VSS nfet_03v3 L=0.28U W=0.36U AS=0.1278P AD=0.0567P
+ PS=1.07U PD=0.675U
M$5336 VSS WECLKb \$5173 VSS nfet_03v3 L=0.28U W=0.36U AS=0.0567P AD=0.1584P
+ PS=0.675U PD=1.6U
M$5337 VSS \$5120 \$5121 VSS nfet_03v3 L=0.28U W=0.36U AS=0.1584P AD=0.0972P
+ PS=1.6U PD=0.9U
M$5338 \$5082 \$5120 VSS VSS nfet_03v3 L=0.28U W=0.36U AS=0.0972P AD=0.18P
+ PS=0.9U PD=1.72U
M$5339 \$5122 D|Q VSS VSS nfet_03v3 L=0.28U W=0.36U AS=0.1584P AD=0.1188P
+ PS=1.6U PD=1.02U
M$5340 \$5123 WECLK \$5122 VSS nfet_03v3 L=0.28U W=0.36U AS=0.1188P AD=0.1278P
+ PS=1.02U PD=1.07U
M$5341 \$5167 \$5124 \$5123 VSS nfet_03v3 L=0.28U W=0.36U AS=0.1278P AD=0.0567P
+ PS=1.07U PD=0.675U
M$5342 VSS WECLKb \$5167 VSS nfet_03v3 L=0.28U W=0.36U AS=0.0567P AD=0.1584P
+ PS=0.675U PD=1.6U
M$5343 VSS \$5123 \$5124 VSS nfet_03v3 L=0.28U W=0.36U AS=0.1584P AD=0.0972P
+ PS=1.6U PD=0.9U
M$5344 \$5083 \$5123 VSS VSS nfet_03v3 L=0.28U W=0.36U AS=0.0972P AD=0.18P
+ PS=0.9U PD=1.72U
M$5345 \$5125 D|Q VSS VSS nfet_03v3 L=0.28U W=0.36U AS=0.1584P AD=0.1188P
+ PS=1.6U PD=1.02U
M$5346 \$5126 WECLK \$5125 VSS nfet_03v3 L=0.28U W=0.36U AS=0.1188P AD=0.1278P
+ PS=1.02U PD=1.07U
M$5347 \$5163 \$5127 \$5126 VSS nfet_03v3 L=0.28U W=0.36U AS=0.1278P AD=0.0567P
+ PS=1.07U PD=0.675U
M$5348 VSS WECLKb \$5163 VSS nfet_03v3 L=0.28U W=0.36U AS=0.0567P AD=0.1584P
+ PS=0.675U PD=1.6U
M$5349 VSS \$5126 \$5127 VSS nfet_03v3 L=0.28U W=0.36U AS=0.1584P AD=0.0972P
+ PS=1.6U PD=0.9U
M$5350 \$5084 \$5126 VSS VSS nfet_03v3 L=0.28U W=0.36U AS=0.0972P AD=0.18P
+ PS=0.9U PD=1.72U
M$5351 \$5128 D|Q VSS VSS nfet_03v3 L=0.28U W=0.36U AS=0.1584P AD=0.1188P
+ PS=1.6U PD=1.02U
M$5352 \$5129 WECLK \$5128 VSS nfet_03v3 L=0.28U W=0.36U AS=0.1188P AD=0.1278P
+ PS=1.02U PD=1.07U
M$5353 \$5159 \$5130 \$5129 VSS nfet_03v3 L=0.28U W=0.36U AS=0.1278P AD=0.0567P
+ PS=1.07U PD=0.675U
M$5354 VSS WECLKb \$5159 VSS nfet_03v3 L=0.28U W=0.36U AS=0.0567P AD=0.1584P
+ PS=0.675U PD=1.6U
M$5355 VSS \$5129 \$5130 VSS nfet_03v3 L=0.28U W=0.36U AS=0.1584P AD=0.0972P
+ PS=1.6U PD=0.9U
M$5356 \$5085 \$5129 VSS VSS nfet_03v3 L=0.28U W=0.36U AS=0.0972P AD=0.18P
+ PS=0.9U PD=1.72U
M$5357 \$5131 D|Q VSS VSS nfet_03v3 L=0.28U W=0.36U AS=0.1584P AD=0.1188P
+ PS=1.6U PD=1.02U
M$5358 \$5132 WECLK \$5131 VSS nfet_03v3 L=0.28U W=0.36U AS=0.1188P AD=0.1278P
+ PS=1.02U PD=1.07U
M$5359 \$5152 \$5133 \$5132 VSS nfet_03v3 L=0.28U W=0.36U AS=0.1278P AD=0.0567P
+ PS=1.07U PD=0.675U
M$5360 VSS WECLKb \$5152 VSS nfet_03v3 L=0.28U W=0.36U AS=0.0567P AD=0.1584P
+ PS=0.675U PD=1.6U
M$5361 VSS \$5132 \$5133 VSS nfet_03v3 L=0.28U W=0.36U AS=0.1584P AD=0.0972P
+ PS=1.6U PD=0.9U
M$5362 \$5086 \$5132 VSS VSS nfet_03v3 L=0.28U W=0.36U AS=0.0972P AD=0.18P
+ PS=0.9U PD=1.72U
M$5363 \$5134 D|Q VSS VSS nfet_03v3 L=0.28U W=0.36U AS=0.1584P AD=0.1188P
+ PS=1.6U PD=1.02U
M$5364 \$5135 WECLK \$5134 VSS nfet_03v3 L=0.28U W=0.36U AS=0.1188P AD=0.1278P
+ PS=1.02U PD=1.07U
M$5365 \$5147 \$5136 \$5135 VSS nfet_03v3 L=0.28U W=0.36U AS=0.1278P AD=0.0567P
+ PS=1.07U PD=0.675U
M$5366 VSS WECLKb \$5147 VSS nfet_03v3 L=0.28U W=0.36U AS=0.0567P AD=0.1584P
+ PS=0.675U PD=1.6U
M$5367 VSS \$5135 \$5136 VSS nfet_03v3 L=0.28U W=0.36U AS=0.1584P AD=0.0972P
+ PS=1.6U PD=0.9U
M$5368 \$5087 \$5135 VSS VSS nfet_03v3 L=0.28U W=0.36U AS=0.0972P AD=0.18P
+ PS=0.9U PD=1.72U
M$5369 \$5137 D|Q VSS VSS nfet_03v3 L=0.28U W=0.36U AS=0.1584P AD=0.1188P
+ PS=1.6U PD=1.02U
M$5370 \$5138 WECLK \$5137 VSS nfet_03v3 L=0.28U W=0.36U AS=0.1188P AD=0.1278P
+ PS=1.02U PD=1.07U
M$5371 \$5142 \$5139 \$5138 VSS nfet_03v3 L=0.28U W=0.36U AS=0.1278P AD=0.0567P
+ PS=1.07U PD=0.675U
M$5372 VSS WECLKb \$5142 VSS nfet_03v3 L=0.28U W=0.36U AS=0.0567P AD=0.1584P
+ PS=0.675U PD=1.6U
M$5373 VSS \$5138 \$5139 VSS nfet_03v3 L=0.28U W=0.36U AS=0.1584P AD=0.0972P
+ PS=1.6U PD=0.9U
M$5374 \$5088 \$5138 VSS VSS nfet_03v3 L=0.28U W=0.36U AS=0.0972P AD=0.18P
+ PS=0.9U PD=1.72U
M$5375 \$5429 RA VSS VSS nfet_03v3 L=0.28U W=0.36U AS=0.1656P AD=0.1944P
+ PS=1.64U PD=1.8U
M$5376 \$5196 RA VSS VSS nfet_03v3 L=0.28U W=0.36U AS=0.1656P AD=0.1944P
+ PS=1.64U PD=1.8U
M$5377 \$5428 RA QAb VSS nfet_03v3 L=0.28U W=0.36U AS=0.1584P AD=0.1152P
+ PS=1.6U PD=1U
M$5378 QBb RB \$5428 VSS nfet_03v3 L=0.28U W=0.36U AS=0.1152P AD=0.1584P PS=1U
+ PD=1.6U
M$5379 \$5073 RA QAb VSS nfet_03v3 L=0.28U W=0.36U AS=0.1584P AD=0.1152P
+ PS=1.6U PD=1U
M$5380 QBb RB \$5073 VSS nfet_03v3 L=0.28U W=0.36U AS=0.1152P AD=0.1584P PS=1U
+ PD=1.6U
M$5381 VSS RB \$5430 VSS nfet_03v3 L=0.28U W=0.36U AS=0.1854P AD=0.1584P
+ PS=1.75U PD=1.6U
M$5382 VSS RB \$5197 VSS nfet_03v3 L=0.28U W=0.36U AS=0.1854P AD=0.1584P
+ PS=1.75U PD=1.6U
M$5383 \$5436 RA VSS VSS nfet_03v3 L=0.28U W=0.36U AS=0.1656P AD=0.1944P
+ PS=1.64U PD=1.8U
M$5384 \$5198 RA VSS VSS nfet_03v3 L=0.28U W=0.36U AS=0.1656P AD=0.1944P
+ PS=1.64U PD=1.8U
M$5385 \$5074 RA QAb VSS nfet_03v3 L=0.28U W=0.36U AS=0.1584P AD=0.1152P
+ PS=1.6U PD=1U
M$5386 QBb RB \$5074 VSS nfet_03v3 L=0.28U W=0.36U AS=0.1152P AD=0.1584P PS=1U
+ PD=1.6U
M$5387 \$5435 RA QAb VSS nfet_03v3 L=0.28U W=0.36U AS=0.1584P AD=0.1152P
+ PS=1.6U PD=1U
M$5388 QBb RB \$5435 VSS nfet_03v3 L=0.28U W=0.36U AS=0.1152P AD=0.1584P PS=1U
+ PD=1.6U
M$5389 VSS RB \$5199 VSS nfet_03v3 L=0.28U W=0.36U AS=0.1854P AD=0.1584P
+ PS=1.75U PD=1.6U
M$5390 VSS RB \$5437 VSS nfet_03v3 L=0.28U W=0.36U AS=0.1854P AD=0.1584P
+ PS=1.75U PD=1.6U
M$5391 \$5442 RA VSS VSS nfet_03v3 L=0.28U W=0.36U AS=0.1656P AD=0.1944P
+ PS=1.64U PD=1.8U
M$5392 \$5200 RA VSS VSS nfet_03v3 L=0.28U W=0.36U AS=0.1656P AD=0.1944P
+ PS=1.64U PD=1.8U
M$5393 \$5075 RA QAb VSS nfet_03v3 L=0.28U W=0.36U AS=0.1584P AD=0.1152P
+ PS=1.6U PD=1U
M$5394 QBb RB \$5075 VSS nfet_03v3 L=0.28U W=0.36U AS=0.1152P AD=0.1584P PS=1U
+ PD=1.6U
M$5395 \$5441 RA QAb VSS nfet_03v3 L=0.28U W=0.36U AS=0.1584P AD=0.1152P
+ PS=1.6U PD=1U
M$5396 QBb RB \$5441 VSS nfet_03v3 L=0.28U W=0.36U AS=0.1152P AD=0.1584P PS=1U
+ PD=1.6U
M$5397 VSS RB \$5201 VSS nfet_03v3 L=0.28U W=0.36U AS=0.1854P AD=0.1584P
+ PS=1.75U PD=1.6U
M$5398 VSS RB \$5443 VSS nfet_03v3 L=0.28U W=0.36U AS=0.1854P AD=0.1584P
+ PS=1.75U PD=1.6U
M$5399 \$5448 RA VSS VSS nfet_03v3 L=0.28U W=0.36U AS=0.1656P AD=0.1944P
+ PS=1.64U PD=1.8U
M$5400 \$5202 RA VSS VSS nfet_03v3 L=0.28U W=0.36U AS=0.1656P AD=0.1944P
+ PS=1.64U PD=1.8U
M$5401 \$5447 RA QAb VSS nfet_03v3 L=0.28U W=0.36U AS=0.1584P AD=0.1152P
+ PS=1.6U PD=1U
M$5402 QBb RB \$5447 VSS nfet_03v3 L=0.28U W=0.36U AS=0.1152P AD=0.1584P PS=1U
+ PD=1.6U
M$5403 \$5076 RA QAb VSS nfet_03v3 L=0.28U W=0.36U AS=0.1584P AD=0.1152P
+ PS=1.6U PD=1U
M$5404 QBb RB \$5076 VSS nfet_03v3 L=0.28U W=0.36U AS=0.1152P AD=0.1584P PS=1U
+ PD=1.6U
M$5405 VSS RB \$5203 VSS nfet_03v3 L=0.28U W=0.36U AS=0.1854P AD=0.1584P
+ PS=1.75U PD=1.6U
M$5406 VSS RB \$5449 VSS nfet_03v3 L=0.28U W=0.36U AS=0.1854P AD=0.1584P
+ PS=1.75U PD=1.6U
M$5407 \$5204 RA VSS VSS nfet_03v3 L=0.28U W=0.36U AS=0.1656P AD=0.1944P
+ PS=1.64U PD=1.8U
M$5408 \$5454 RA VSS VSS nfet_03v3 L=0.28U W=0.36U AS=0.1656P AD=0.1944P
+ PS=1.64U PD=1.8U
M$5409 \$5453 RA QAb VSS nfet_03v3 L=0.28U W=0.36U AS=0.1584P AD=0.1152P
+ PS=1.6U PD=1U
M$5410 QBb RB \$5453 VSS nfet_03v3 L=0.28U W=0.36U AS=0.1152P AD=0.1584P PS=1U
+ PD=1.6U
M$5411 \$5077 RA QAb VSS nfet_03v3 L=0.28U W=0.36U AS=0.1584P AD=0.1152P
+ PS=1.6U PD=1U
M$5412 QBb RB \$5077 VSS nfet_03v3 L=0.28U W=0.36U AS=0.1152P AD=0.1584P PS=1U
+ PD=1.6U
M$5413 VSS RB \$5205 VSS nfet_03v3 L=0.28U W=0.36U AS=0.1854P AD=0.1584P
+ PS=1.75U PD=1.6U
M$5414 VSS RB \$5455 VSS nfet_03v3 L=0.28U W=0.36U AS=0.1854P AD=0.1584P
+ PS=1.75U PD=1.6U
M$5415 \$5460 RA VSS VSS nfet_03v3 L=0.28U W=0.36U AS=0.1656P AD=0.1944P
+ PS=1.64U PD=1.8U
M$5416 \$5206 RA VSS VSS nfet_03v3 L=0.28U W=0.36U AS=0.1656P AD=0.1944P
+ PS=1.64U PD=1.8U
M$5417 \$5459 RA QAb VSS nfet_03v3 L=0.28U W=0.36U AS=0.1584P AD=0.1152P
+ PS=1.6U PD=1U
M$5418 QBb RB \$5459 VSS nfet_03v3 L=0.28U W=0.36U AS=0.1152P AD=0.1584P PS=1U
+ PD=1.6U
M$5419 \$5078 RA QAb VSS nfet_03v3 L=0.28U W=0.36U AS=0.1584P AD=0.1152P
+ PS=1.6U PD=1U
M$5420 QBb RB \$5078 VSS nfet_03v3 L=0.28U W=0.36U AS=0.1152P AD=0.1584P PS=1U
+ PD=1.6U
M$5421 VSS RB \$5207 VSS nfet_03v3 L=0.28U W=0.36U AS=0.1854P AD=0.1584P
+ PS=1.75U PD=1.6U
M$5422 VSS RB \$5461 VSS nfet_03v3 L=0.28U W=0.36U AS=0.1854P AD=0.1584P
+ PS=1.75U PD=1.6U
M$5423 \$5208 RA VSS VSS nfet_03v3 L=0.28U W=0.36U AS=0.1656P AD=0.1944P
+ PS=1.64U PD=1.8U
M$5424 \$5466 RA VSS VSS nfet_03v3 L=0.28U W=0.36U AS=0.1656P AD=0.1944P
+ PS=1.64U PD=1.8U
M$5425 \$5465 RA QAb VSS nfet_03v3 L=0.28U W=0.36U AS=0.1584P AD=0.1152P
+ PS=1.6U PD=1U
M$5426 QBb RB \$5465 VSS nfet_03v3 L=0.28U W=0.36U AS=0.1152P AD=0.1584P PS=1U
+ PD=1.6U
M$5427 \$5079 RA QAb VSS nfet_03v3 L=0.28U W=0.36U AS=0.1584P AD=0.1152P
+ PS=1.6U PD=1U
M$5428 QBb RB \$5079 VSS nfet_03v3 L=0.28U W=0.36U AS=0.1152P AD=0.1584P PS=1U
+ PD=1.6U
M$5429 VSS RB \$5467 VSS nfet_03v3 L=0.28U W=0.36U AS=0.1854P AD=0.1584P
+ PS=1.75U PD=1.6U
M$5430 VSS RB \$5209 VSS nfet_03v3 L=0.28U W=0.36U AS=0.1854P AD=0.1584P
+ PS=1.75U PD=1.6U
M$5431 \$5210 RA VSS VSS nfet_03v3 L=0.28U W=0.36U AS=0.1656P AD=0.1944P
+ PS=1.64U PD=1.8U
M$5432 \$5472 RA VSS VSS nfet_03v3 L=0.28U W=0.36U AS=0.1656P AD=0.1944P
+ PS=1.64U PD=1.8U
M$5433 \$5471 RA QAb VSS nfet_03v3 L=0.28U W=0.36U AS=0.1584P AD=0.1152P
+ PS=1.6U PD=1U
M$5434 QBb RB \$5471 VSS nfet_03v3 L=0.28U W=0.36U AS=0.1152P AD=0.1584P PS=1U
+ PD=1.6U
M$5435 \$5080 RA QAb VSS nfet_03v3 L=0.28U W=0.36U AS=0.1584P AD=0.1152P
+ PS=1.6U PD=1U
M$5436 QBb RB \$5080 VSS nfet_03v3 L=0.28U W=0.36U AS=0.1152P AD=0.1584P PS=1U
+ PD=1.6U
M$5437 VSS RB \$5211 VSS nfet_03v3 L=0.28U W=0.36U AS=0.1854P AD=0.1584P
+ PS=1.75U PD=1.6U
M$5438 VSS RB \$5473 VSS nfet_03v3 L=0.28U W=0.36U AS=0.1854P AD=0.1584P
+ PS=1.75U PD=1.6U
M$5439 \$5478 RA VSS VSS nfet_03v3 L=0.28U W=0.36U AS=0.1656P AD=0.1944P
+ PS=1.64U PD=1.8U
M$5440 \$5212 RA VSS VSS nfet_03v3 L=0.28U W=0.36U AS=0.1656P AD=0.1944P
+ PS=1.64U PD=1.8U
M$5441 \$5477 RA QAb VSS nfet_03v3 L=0.28U W=0.36U AS=0.1584P AD=0.1152P
+ PS=1.6U PD=1U
M$5442 QBb RB \$5477 VSS nfet_03v3 L=0.28U W=0.36U AS=0.1152P AD=0.1584P PS=1U
+ PD=1.6U
M$5443 \$5081 RA QAb VSS nfet_03v3 L=0.28U W=0.36U AS=0.1584P AD=0.1152P
+ PS=1.6U PD=1U
M$5444 QBb RB \$5081 VSS nfet_03v3 L=0.28U W=0.36U AS=0.1152P AD=0.1584P PS=1U
+ PD=1.6U
M$5445 VSS RB \$5213 VSS nfet_03v3 L=0.28U W=0.36U AS=0.1854P AD=0.1584P
+ PS=1.75U PD=1.6U
M$5446 VSS RB \$5479 VSS nfet_03v3 L=0.28U W=0.36U AS=0.1854P AD=0.1584P
+ PS=1.75U PD=1.6U
M$5447 \$5484 RA VSS VSS nfet_03v3 L=0.28U W=0.36U AS=0.1656P AD=0.1944P
+ PS=1.64U PD=1.8U
M$5448 \$5214 RA VSS VSS nfet_03v3 L=0.28U W=0.36U AS=0.1656P AD=0.1944P
+ PS=1.64U PD=1.8U
M$5449 \$5483 RA QAb VSS nfet_03v3 L=0.28U W=0.36U AS=0.1584P AD=0.1152P
+ PS=1.6U PD=1U
M$5450 QBb RB \$5483 VSS nfet_03v3 L=0.28U W=0.36U AS=0.1152P AD=0.1584P PS=1U
+ PD=1.6U
M$5451 \$5082 RA QAb VSS nfet_03v3 L=0.28U W=0.36U AS=0.1584P AD=0.1152P
+ PS=1.6U PD=1U
M$5452 QBb RB \$5082 VSS nfet_03v3 L=0.28U W=0.36U AS=0.1152P AD=0.1584P PS=1U
+ PD=1.6U
M$5453 VSS RB \$5485 VSS nfet_03v3 L=0.28U W=0.36U AS=0.1854P AD=0.1584P
+ PS=1.75U PD=1.6U
M$5454 VSS RB \$5215 VSS nfet_03v3 L=0.28U W=0.36U AS=0.1854P AD=0.1584P
+ PS=1.75U PD=1.6U
M$5455 \$5490 RA VSS VSS nfet_03v3 L=0.28U W=0.36U AS=0.1656P AD=0.1944P
+ PS=1.64U PD=1.8U
M$5456 \$5216 RA VSS VSS nfet_03v3 L=0.28U W=0.36U AS=0.1656P AD=0.1944P
+ PS=1.64U PD=1.8U
M$5457 \$5083 RA QAb VSS nfet_03v3 L=0.28U W=0.36U AS=0.1584P AD=0.1152P
+ PS=1.6U PD=1U
M$5458 QBb RB \$5083 VSS nfet_03v3 L=0.28U W=0.36U AS=0.1152P AD=0.1584P PS=1U
+ PD=1.6U
M$5459 \$5489 RA QAb VSS nfet_03v3 L=0.28U W=0.36U AS=0.1584P AD=0.1152P
+ PS=1.6U PD=1U
M$5460 QBb RB \$5489 VSS nfet_03v3 L=0.28U W=0.36U AS=0.1152P AD=0.1584P PS=1U
+ PD=1.6U
M$5461 VSS RB \$5217 VSS nfet_03v3 L=0.28U W=0.36U AS=0.1854P AD=0.1584P
+ PS=1.75U PD=1.6U
M$5462 VSS RB \$5491 VSS nfet_03v3 L=0.28U W=0.36U AS=0.1854P AD=0.1584P
+ PS=1.75U PD=1.6U
M$5463 \$5218 RA VSS VSS nfet_03v3 L=0.28U W=0.36U AS=0.1656P AD=0.1944P
+ PS=1.64U PD=1.8U
M$5464 \$5496 RA VSS VSS nfet_03v3 L=0.28U W=0.36U AS=0.1656P AD=0.1944P
+ PS=1.64U PD=1.8U
M$5465 \$5084 RA QAb VSS nfet_03v3 L=0.28U W=0.36U AS=0.1584P AD=0.1152P
+ PS=1.6U PD=1U
M$5466 QBb RB \$5084 VSS nfet_03v3 L=0.28U W=0.36U AS=0.1152P AD=0.1584P PS=1U
+ PD=1.6U
M$5467 \$5495 RA QAb VSS nfet_03v3 L=0.28U W=0.36U AS=0.1584P AD=0.1152P
+ PS=1.6U PD=1U
M$5468 QBb RB \$5495 VSS nfet_03v3 L=0.28U W=0.36U AS=0.1152P AD=0.1584P PS=1U
+ PD=1.6U
M$5469 VSS RB \$5219 VSS nfet_03v3 L=0.28U W=0.36U AS=0.1854P AD=0.1584P
+ PS=1.75U PD=1.6U
M$5470 VSS RB \$5497 VSS nfet_03v3 L=0.28U W=0.36U AS=0.1854P AD=0.1584P
+ PS=1.75U PD=1.6U
M$5471 \$5502 RA VSS VSS nfet_03v3 L=0.28U W=0.36U AS=0.1656P AD=0.1944P
+ PS=1.64U PD=1.8U
M$5472 \$5220 RA VSS VSS nfet_03v3 L=0.28U W=0.36U AS=0.1656P AD=0.1944P
+ PS=1.64U PD=1.8U
M$5473 \$5085 RA QAb VSS nfet_03v3 L=0.28U W=0.36U AS=0.1584P AD=0.1152P
+ PS=1.6U PD=1U
M$5474 QBb RB \$5085 VSS nfet_03v3 L=0.28U W=0.36U AS=0.1152P AD=0.1584P PS=1U
+ PD=1.6U
M$5475 \$5501 RA QAb VSS nfet_03v3 L=0.28U W=0.36U AS=0.1584P AD=0.1152P
+ PS=1.6U PD=1U
M$5476 QBb RB \$5501 VSS nfet_03v3 L=0.28U W=0.36U AS=0.1152P AD=0.1584P PS=1U
+ PD=1.6U
M$5477 VSS RB \$5221 VSS nfet_03v3 L=0.28U W=0.36U AS=0.1854P AD=0.1584P
+ PS=1.75U PD=1.6U
M$5478 VSS RB \$5503 VSS nfet_03v3 L=0.28U W=0.36U AS=0.1854P AD=0.1584P
+ PS=1.75U PD=1.6U
M$5479 \$5508 RA VSS VSS nfet_03v3 L=0.28U W=0.36U AS=0.1656P AD=0.1944P
+ PS=1.64U PD=1.8U
M$5480 \$5222 RA VSS VSS nfet_03v3 L=0.28U W=0.36U AS=0.1656P AD=0.1944P
+ PS=1.64U PD=1.8U
M$5481 \$5507 RA QAb VSS nfet_03v3 L=0.28U W=0.36U AS=0.1584P AD=0.1152P
+ PS=1.6U PD=1U
M$5482 QBb RB \$5507 VSS nfet_03v3 L=0.28U W=0.36U AS=0.1152P AD=0.1584P PS=1U
+ PD=1.6U
M$5483 \$5086 RA QAb VSS nfet_03v3 L=0.28U W=0.36U AS=0.1584P AD=0.1152P
+ PS=1.6U PD=1U
M$5484 QBb RB \$5086 VSS nfet_03v3 L=0.28U W=0.36U AS=0.1152P AD=0.1584P PS=1U
+ PD=1.6U
M$5485 VSS RB \$5509 VSS nfet_03v3 L=0.28U W=0.36U AS=0.1854P AD=0.1584P
+ PS=1.75U PD=1.6U
M$5486 VSS RB \$5223 VSS nfet_03v3 L=0.28U W=0.36U AS=0.1854P AD=0.1584P
+ PS=1.75U PD=1.6U
M$5487 \$5514 RA VSS VSS nfet_03v3 L=0.28U W=0.36U AS=0.1656P AD=0.1944P
+ PS=1.64U PD=1.8U
M$5488 \$5224 RA VSS VSS nfet_03v3 L=0.28U W=0.36U AS=0.1656P AD=0.1944P
+ PS=1.64U PD=1.8U
M$5489 \$5513 RA QAb VSS nfet_03v3 L=0.28U W=0.36U AS=0.1584P AD=0.1152P
+ PS=1.6U PD=1U
M$5490 QBb RB \$5513 VSS nfet_03v3 L=0.28U W=0.36U AS=0.1152P AD=0.1584P PS=1U
+ PD=1.6U
M$5491 \$5087 RA QAb VSS nfet_03v3 L=0.28U W=0.36U AS=0.1584P AD=0.1152P
+ PS=1.6U PD=1U
M$5492 QBb RB \$5087 VSS nfet_03v3 L=0.28U W=0.36U AS=0.1152P AD=0.1584P PS=1U
+ PD=1.6U
M$5493 VSS RB \$5515 VSS nfet_03v3 L=0.28U W=0.36U AS=0.1854P AD=0.1584P
+ PS=1.75U PD=1.6U
M$5494 VSS RB \$5225 VSS nfet_03v3 L=0.28U W=0.36U AS=0.1854P AD=0.1584P
+ PS=1.75U PD=1.6U
M$5495 \$5226 RA VSS VSS nfet_03v3 L=0.28U W=0.36U AS=0.1656P AD=0.1944P
+ PS=1.64U PD=1.8U
M$5496 \$5520 RA VSS VSS nfet_03v3 L=0.28U W=0.36U AS=0.1656P AD=0.1944P
+ PS=1.64U PD=1.8U
M$5497 \$5519 RA QAb VSS nfet_03v3 L=0.28U W=0.36U AS=0.1584P AD=0.1152P
+ PS=1.6U PD=1U
M$5498 QBb RB \$5519 VSS nfet_03v3 L=0.28U W=0.36U AS=0.1152P AD=0.1584P PS=1U
+ PD=1.6U
M$5499 \$5088 RA QAb VSS nfet_03v3 L=0.28U W=0.36U AS=0.1584P AD=0.1152P
+ PS=1.6U PD=1U
M$5500 QBb RB \$5088 VSS nfet_03v3 L=0.28U W=0.36U AS=0.1152P AD=0.1584P PS=1U
+ PD=1.6U
M$5501 VSS RB \$5227 VSS nfet_03v3 L=0.28U W=0.36U AS=0.1854P AD=0.1584P
+ PS=1.75U PD=1.6U
M$5502 VSS RB \$5521 VSS nfet_03v3 L=0.28U W=0.36U AS=0.1854P AD=0.1584P
+ PS=1.75U PD=1.6U
M$5503 \$5656 WE VSS VSS nfet_03v3 L=0.28U W=0.72U AS=0.3168P AD=0.1872P
+ PS=2.32U PD=1.24U
M$5504 \$5420 CLK \$5656 VSS nfet_03v3 L=0.28U W=0.72U AS=0.1872P AD=0.3168P
+ PS=1.24U PD=2.32U
M$5505 WECLK \$5420 VSS VSS nfet_03v3 L=0.28U W=1.27U AS=0.4487P AD=0.3302P
+ PS=3.34U PD=2.31U
M$5509 \$5425 D|Q VSS VSS nfet_03v3 L=0.28U W=0.36U AS=0.1584P AD=0.1188P
+ PS=1.6U PD=1.02U
M$5510 \$5426 WECLK \$5425 VSS nfet_03v3 L=0.28U W=0.36U AS=0.1188P AD=0.1278P
+ PS=1.02U PD=1.07U
M$5511 \$5659 \$5427 \$5426 VSS nfet_03v3 L=0.28U W=0.36U AS=0.1278P AD=0.0567P
+ PS=1.07U PD=0.675U
M$5512 VSS WECLKb \$5659 VSS nfet_03v3 L=0.28U W=0.36U AS=0.0567P AD=0.1584P
+ PS=0.675U PD=1.6U
M$5513 VSS \$5426 \$5427 VSS nfet_03v3 L=0.28U W=0.36U AS=0.1584P AD=0.0972P
+ PS=1.6U PD=0.9U
M$5514 \$5428 \$5426 VSS VSS nfet_03v3 L=0.28U W=0.36U AS=0.0972P AD=0.18P
+ PS=0.9U PD=1.72U
M$5515 \$5432 D|Q VSS VSS nfet_03v3 L=0.28U W=0.36U AS=0.1584P AD=0.1188P
+ PS=1.6U PD=1.02U
M$5516 \$5433 WECLK \$5432 VSS nfet_03v3 L=0.28U W=0.36U AS=0.1188P AD=0.1278P
+ PS=1.02U PD=1.07U
M$5517 \$5665 \$5434 \$5433 VSS nfet_03v3 L=0.28U W=0.36U AS=0.1278P AD=0.0567P
+ PS=1.07U PD=0.675U
M$5518 VSS WECLKb \$5665 VSS nfet_03v3 L=0.28U W=0.36U AS=0.0567P AD=0.1584P
+ PS=0.675U PD=1.6U
M$5519 VSS \$5433 \$5434 VSS nfet_03v3 L=0.28U W=0.36U AS=0.1584P AD=0.0972P
+ PS=1.6U PD=0.9U
M$5520 \$5435 \$5433 VSS VSS nfet_03v3 L=0.28U W=0.36U AS=0.0972P AD=0.18P
+ PS=0.9U PD=1.72U
M$5521 \$5438 D|Q VSS VSS nfet_03v3 L=0.28U W=0.36U AS=0.1584P AD=0.1188P
+ PS=1.6U PD=1.02U
M$5522 \$5439 WECLK \$5438 VSS nfet_03v3 L=0.28U W=0.36U AS=0.1188P AD=0.1278P
+ PS=1.02U PD=1.07U
M$5523 \$5671 \$5440 \$5439 VSS nfet_03v3 L=0.28U W=0.36U AS=0.1278P AD=0.0567P
+ PS=1.07U PD=0.675U
M$5524 VSS WECLKb \$5671 VSS nfet_03v3 L=0.28U W=0.36U AS=0.0567P AD=0.1584P
+ PS=0.675U PD=1.6U
M$5525 VSS \$5439 \$5440 VSS nfet_03v3 L=0.28U W=0.36U AS=0.1584P AD=0.0972P
+ PS=1.6U PD=0.9U
M$5526 \$5441 \$5439 VSS VSS nfet_03v3 L=0.28U W=0.36U AS=0.0972P AD=0.18P
+ PS=0.9U PD=1.72U
M$5527 \$5444 D|Q VSS VSS nfet_03v3 L=0.28U W=0.36U AS=0.1584P AD=0.1188P
+ PS=1.6U PD=1.02U
M$5528 \$5445 WECLK \$5444 VSS nfet_03v3 L=0.28U W=0.36U AS=0.1188P AD=0.1278P
+ PS=1.02U PD=1.07U
M$5529 \$5677 \$5446 \$5445 VSS nfet_03v3 L=0.28U W=0.36U AS=0.1278P AD=0.0567P
+ PS=1.07U PD=0.675U
M$5530 VSS WECLKb \$5677 VSS nfet_03v3 L=0.28U W=0.36U AS=0.0567P AD=0.1584P
+ PS=0.675U PD=1.6U
M$5531 VSS \$5445 \$5446 VSS nfet_03v3 L=0.28U W=0.36U AS=0.1584P AD=0.0972P
+ PS=1.6U PD=0.9U
M$5532 \$5447 \$5445 VSS VSS nfet_03v3 L=0.28U W=0.36U AS=0.0972P AD=0.18P
+ PS=0.9U PD=1.72U
M$5533 \$5450 D|Q VSS VSS nfet_03v3 L=0.28U W=0.36U AS=0.1584P AD=0.1188P
+ PS=1.6U PD=1.02U
M$5534 \$5451 WECLK \$5450 VSS nfet_03v3 L=0.28U W=0.36U AS=0.1188P AD=0.1278P
+ PS=1.02U PD=1.07U
M$5535 \$5683 \$5452 \$5451 VSS nfet_03v3 L=0.28U W=0.36U AS=0.1278P AD=0.0567P
+ PS=1.07U PD=0.675U
M$5536 VSS WECLKb \$5683 VSS nfet_03v3 L=0.28U W=0.36U AS=0.0567P AD=0.1584P
+ PS=0.675U PD=1.6U
M$5537 VSS \$5451 \$5452 VSS nfet_03v3 L=0.28U W=0.36U AS=0.1584P AD=0.0972P
+ PS=1.6U PD=0.9U
M$5538 \$5453 \$5451 VSS VSS nfet_03v3 L=0.28U W=0.36U AS=0.0972P AD=0.18P
+ PS=0.9U PD=1.72U
M$5539 \$5456 D|Q VSS VSS nfet_03v3 L=0.28U W=0.36U AS=0.1584P AD=0.1188P
+ PS=1.6U PD=1.02U
M$5540 \$5457 WECLK \$5456 VSS nfet_03v3 L=0.28U W=0.36U AS=0.1188P AD=0.1278P
+ PS=1.02U PD=1.07U
M$5541 \$5689 \$5458 \$5457 VSS nfet_03v3 L=0.28U W=0.36U AS=0.1278P AD=0.0567P
+ PS=1.07U PD=0.675U
M$5542 VSS WECLKb \$5689 VSS nfet_03v3 L=0.28U W=0.36U AS=0.0567P AD=0.1584P
+ PS=0.675U PD=1.6U
M$5543 VSS \$5457 \$5458 VSS nfet_03v3 L=0.28U W=0.36U AS=0.1584P AD=0.0972P
+ PS=1.6U PD=0.9U
M$5544 \$5459 \$5457 VSS VSS nfet_03v3 L=0.28U W=0.36U AS=0.0972P AD=0.18P
+ PS=0.9U PD=1.72U
M$5545 \$5462 D|Q VSS VSS nfet_03v3 L=0.28U W=0.36U AS=0.1584P AD=0.1188P
+ PS=1.6U PD=1.02U
M$5546 \$5463 WECLK \$5462 VSS nfet_03v3 L=0.28U W=0.36U AS=0.1188P AD=0.1278P
+ PS=1.02U PD=1.07U
M$5547 \$5695 \$5464 \$5463 VSS nfet_03v3 L=0.28U W=0.36U AS=0.1278P AD=0.0567P
+ PS=1.07U PD=0.675U
M$5548 VSS WECLKb \$5695 VSS nfet_03v3 L=0.28U W=0.36U AS=0.0567P AD=0.1584P
+ PS=0.675U PD=1.6U
M$5549 VSS \$5463 \$5464 VSS nfet_03v3 L=0.28U W=0.36U AS=0.1584P AD=0.0972P
+ PS=1.6U PD=0.9U
M$5550 \$5465 \$5463 VSS VSS nfet_03v3 L=0.28U W=0.36U AS=0.0972P AD=0.18P
+ PS=0.9U PD=1.72U
M$5551 \$5468 D|Q VSS VSS nfet_03v3 L=0.28U W=0.36U AS=0.1584P AD=0.1188P
+ PS=1.6U PD=1.02U
M$5552 \$5469 WECLK \$5468 VSS nfet_03v3 L=0.28U W=0.36U AS=0.1188P AD=0.1278P
+ PS=1.02U PD=1.07U
M$5553 \$5701 \$5470 \$5469 VSS nfet_03v3 L=0.28U W=0.36U AS=0.1278P AD=0.0567P
+ PS=1.07U PD=0.675U
M$5554 VSS WECLKb \$5701 VSS nfet_03v3 L=0.28U W=0.36U AS=0.0567P AD=0.1584P
+ PS=0.675U PD=1.6U
M$5555 VSS \$5469 \$5470 VSS nfet_03v3 L=0.28U W=0.36U AS=0.1584P AD=0.0972P
+ PS=1.6U PD=0.9U
M$5556 \$5471 \$5469 VSS VSS nfet_03v3 L=0.28U W=0.36U AS=0.0972P AD=0.18P
+ PS=0.9U PD=1.72U
M$5557 \$5474 D|Q VSS VSS nfet_03v3 L=0.28U W=0.36U AS=0.1584P AD=0.1188P
+ PS=1.6U PD=1.02U
M$5558 \$5475 WECLK \$5474 VSS nfet_03v3 L=0.28U W=0.36U AS=0.1188P AD=0.1278P
+ PS=1.02U PD=1.07U
M$5559 \$5707 \$5476 \$5475 VSS nfet_03v3 L=0.28U W=0.36U AS=0.1278P AD=0.0567P
+ PS=1.07U PD=0.675U
M$5560 VSS WECLKb \$5707 VSS nfet_03v3 L=0.28U W=0.36U AS=0.0567P AD=0.1584P
+ PS=0.675U PD=1.6U
M$5561 VSS \$5475 \$5476 VSS nfet_03v3 L=0.28U W=0.36U AS=0.1584P AD=0.0972P
+ PS=1.6U PD=0.9U
M$5562 \$5477 \$5475 VSS VSS nfet_03v3 L=0.28U W=0.36U AS=0.0972P AD=0.18P
+ PS=0.9U PD=1.72U
M$5563 \$5480 D|Q VSS VSS nfet_03v3 L=0.28U W=0.36U AS=0.1584P AD=0.1188P
+ PS=1.6U PD=1.02U
M$5564 \$5481 WECLK \$5480 VSS nfet_03v3 L=0.28U W=0.36U AS=0.1188P AD=0.1278P
+ PS=1.02U PD=1.07U
M$5565 \$5713 \$5482 \$5481 VSS nfet_03v3 L=0.28U W=0.36U AS=0.1278P AD=0.0567P
+ PS=1.07U PD=0.675U
M$5566 VSS WECLKb \$5713 VSS nfet_03v3 L=0.28U W=0.36U AS=0.0567P AD=0.1584P
+ PS=0.675U PD=1.6U
M$5567 VSS \$5481 \$5482 VSS nfet_03v3 L=0.28U W=0.36U AS=0.1584P AD=0.0972P
+ PS=1.6U PD=0.9U
M$5568 \$5483 \$5481 VSS VSS nfet_03v3 L=0.28U W=0.36U AS=0.0972P AD=0.18P
+ PS=0.9U PD=1.72U
M$5569 \$5486 D|Q VSS VSS nfet_03v3 L=0.28U W=0.36U AS=0.1584P AD=0.1188P
+ PS=1.6U PD=1.02U
M$5570 \$5487 WECLK \$5486 VSS nfet_03v3 L=0.28U W=0.36U AS=0.1188P AD=0.1278P
+ PS=1.02U PD=1.07U
M$5571 \$5719 \$5488 \$5487 VSS nfet_03v3 L=0.28U W=0.36U AS=0.1278P AD=0.0567P
+ PS=1.07U PD=0.675U
M$5572 VSS WECLKb \$5719 VSS nfet_03v3 L=0.28U W=0.36U AS=0.0567P AD=0.1584P
+ PS=0.675U PD=1.6U
M$5573 VSS \$5487 \$5488 VSS nfet_03v3 L=0.28U W=0.36U AS=0.1584P AD=0.0972P
+ PS=1.6U PD=0.9U
M$5574 \$5489 \$5487 VSS VSS nfet_03v3 L=0.28U W=0.36U AS=0.0972P AD=0.18P
+ PS=0.9U PD=1.72U
M$5575 \$5492 D|Q VSS VSS nfet_03v3 L=0.28U W=0.36U AS=0.1584P AD=0.1188P
+ PS=1.6U PD=1.02U
M$5576 \$5493 WECLK \$5492 VSS nfet_03v3 L=0.28U W=0.36U AS=0.1188P AD=0.1278P
+ PS=1.02U PD=1.07U
M$5577 \$5725 \$5494 \$5493 VSS nfet_03v3 L=0.28U W=0.36U AS=0.1278P AD=0.0567P
+ PS=1.07U PD=0.675U
M$5578 VSS WECLKb \$5725 VSS nfet_03v3 L=0.28U W=0.36U AS=0.0567P AD=0.1584P
+ PS=0.675U PD=1.6U
M$5579 VSS \$5493 \$5494 VSS nfet_03v3 L=0.28U W=0.36U AS=0.1584P AD=0.0972P
+ PS=1.6U PD=0.9U
M$5580 \$5495 \$5493 VSS VSS nfet_03v3 L=0.28U W=0.36U AS=0.0972P AD=0.18P
+ PS=0.9U PD=1.72U
M$5581 \$5498 D|Q VSS VSS nfet_03v3 L=0.28U W=0.36U AS=0.1584P AD=0.1188P
+ PS=1.6U PD=1.02U
M$5582 \$5499 WECLK \$5498 VSS nfet_03v3 L=0.28U W=0.36U AS=0.1188P AD=0.1278P
+ PS=1.02U PD=1.07U
M$5583 \$5732 \$5500 \$5499 VSS nfet_03v3 L=0.28U W=0.36U AS=0.1278P AD=0.0567P
+ PS=1.07U PD=0.675U
M$5584 VSS WECLKb \$5732 VSS nfet_03v3 L=0.28U W=0.36U AS=0.0567P AD=0.1584P
+ PS=0.675U PD=1.6U
M$5585 VSS \$5499 \$5500 VSS nfet_03v3 L=0.28U W=0.36U AS=0.1584P AD=0.0972P
+ PS=1.6U PD=0.9U
M$5586 \$5501 \$5499 VSS VSS nfet_03v3 L=0.28U W=0.36U AS=0.0972P AD=0.18P
+ PS=0.9U PD=1.72U
M$5587 \$5504 D|Q VSS VSS nfet_03v3 L=0.28U W=0.36U AS=0.1584P AD=0.1188P
+ PS=1.6U PD=1.02U
M$5588 \$5505 WECLK \$5504 VSS nfet_03v3 L=0.28U W=0.36U AS=0.1188P AD=0.1278P
+ PS=1.02U PD=1.07U
M$5589 \$5738 \$5506 \$5505 VSS nfet_03v3 L=0.28U W=0.36U AS=0.1278P AD=0.0567P
+ PS=1.07U PD=0.675U
M$5590 VSS WECLKb \$5738 VSS nfet_03v3 L=0.28U W=0.36U AS=0.0567P AD=0.1584P
+ PS=0.675U PD=1.6U
M$5591 VSS \$5505 \$5506 VSS nfet_03v3 L=0.28U W=0.36U AS=0.1584P AD=0.0972P
+ PS=1.6U PD=0.9U
M$5592 \$5507 \$5505 VSS VSS nfet_03v3 L=0.28U W=0.36U AS=0.0972P AD=0.18P
+ PS=0.9U PD=1.72U
M$5593 \$5510 D|Q VSS VSS nfet_03v3 L=0.28U W=0.36U AS=0.1584P AD=0.1188P
+ PS=1.6U PD=1.02U
M$5594 \$5511 WECLK \$5510 VSS nfet_03v3 L=0.28U W=0.36U AS=0.1188P AD=0.1278P
+ PS=1.02U PD=1.07U
M$5595 \$5744 \$5512 \$5511 VSS nfet_03v3 L=0.28U W=0.36U AS=0.1278P AD=0.0567P
+ PS=1.07U PD=0.675U
M$5596 VSS WECLKb \$5744 VSS nfet_03v3 L=0.28U W=0.36U AS=0.0567P AD=0.1584P
+ PS=0.675U PD=1.6U
M$5597 VSS \$5511 \$5512 VSS nfet_03v3 L=0.28U W=0.36U AS=0.1584P AD=0.0972P
+ PS=1.6U PD=0.9U
M$5598 \$5513 \$5511 VSS VSS nfet_03v3 L=0.28U W=0.36U AS=0.0972P AD=0.18P
+ PS=0.9U PD=1.72U
M$5599 \$5516 D|Q VSS VSS nfet_03v3 L=0.28U W=0.36U AS=0.1584P AD=0.1188P
+ PS=1.6U PD=1.02U
M$5600 \$5517 WECLK \$5516 VSS nfet_03v3 L=0.28U W=0.36U AS=0.1188P AD=0.1278P
+ PS=1.02U PD=1.07U
M$5601 \$5750 \$5518 \$5517 VSS nfet_03v3 L=0.28U W=0.36U AS=0.1278P AD=0.0567P
+ PS=1.07U PD=0.675U
M$5602 VSS WECLKb \$5750 VSS nfet_03v3 L=0.28U W=0.36U AS=0.0567P AD=0.1584P
+ PS=0.675U PD=1.6U
M$5603 VSS \$5517 \$5518 VSS nfet_03v3 L=0.28U W=0.36U AS=0.1584P AD=0.0972P
+ PS=1.6U PD=0.9U
M$5604 \$5519 \$5517 VSS VSS nfet_03v3 L=0.28U W=0.36U AS=0.0972P AD=0.18P
+ PS=0.9U PD=1.72U
.ENDS rf
