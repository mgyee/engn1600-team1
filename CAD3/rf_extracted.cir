* Extracted by KLayout with GF180MCU LVS runset on : 26/02/2026 19:43

.SUBCKT rf VDD WEMb WEM D0 D1 D2 D3 D4 D5 D6 D7 D8 D9 D10 D11 D12 D13 D14 D15
+ VSS WE15 CLK RB15 RA15 WE14 RA14 RB14 RB13 WE13 RA13 WE12 RA12 RB12 RB11 WE11
+ RA11 WE10 RA10 RB10 RB9 WE9 RA9 WE8 RB8 RA8 RB7 WE7 RA7 WE6 RA6 RB6 RB5 WE5
+ RA5 WE4 RB4 RA4 RB3 WE3 RA3 WE2 RA2 RB2 RB1 WE1 RA1 WE0 RA0 RB0
M$1 WEMb WEM VDD VDD pfet_03v3 L=0.28U W=2.52U AS=0.9198P AD=0.9198P PS=5.24U
+ PD=5.24U
M$3 \$44 \$141 VDD VDD pfet_03v3 L=0.28U W=2.48U AS=0.868P AD=0.868P PS=5.12U
+ PD=5.12U
M$5 \$45 \$141 VDD VDD pfet_03v3 L=0.28U W=0.36U AS=0.1584P AD=0.1584P PS=1.6U
+ PD=1.6U
M$6 \$95 WEM VDD VDD pfet_03v3 L=0.28U W=0.36U AS=0.1584P AD=0.0567P PS=1.6U
+ PD=0.675U
M$7 \$141 \$45 \$95 VDD pfet_03v3 L=0.28U W=0.36U AS=0.0567P AD=0.1278P
+ PS=0.675U PD=1.07U
M$8 \$46 WEMb \$141 VDD pfet_03v3 L=0.28U W=0.36U AS=0.1278P AD=0.2097P
+ PS=1.07U PD=1.38U
M$9 VDD D0 \$46 VDD pfet_03v3 L=0.28U W=0.72U AS=0.2097P AD=0.3168P PS=1.38U
+ PD=2.32U
M$10 \$47 \$143 VDD VDD pfet_03v3 L=0.28U W=2.48U AS=0.868P AD=0.868P PS=5.12U
+ PD=5.12U
M$12 \$48 \$143 VDD VDD pfet_03v3 L=0.28U W=0.36U AS=0.1584P AD=0.1584P PS=1.6U
+ PD=1.6U
M$13 \$100 WEM VDD VDD pfet_03v3 L=0.28U W=0.36U AS=0.1584P AD=0.0567P PS=1.6U
+ PD=0.675U
M$14 \$143 \$48 \$100 VDD pfet_03v3 L=0.28U W=0.36U AS=0.0567P AD=0.1278P
+ PS=0.675U PD=1.07U
M$15 \$49 WEMb \$143 VDD pfet_03v3 L=0.28U W=0.36U AS=0.1278P AD=0.2097P
+ PS=1.07U PD=1.38U
M$16 VDD D1 \$49 VDD pfet_03v3 L=0.28U W=0.72U AS=0.2097P AD=0.3168P PS=1.38U
+ PD=2.32U
M$17 \$50 \$145 VDD VDD pfet_03v3 L=0.28U W=2.48U AS=0.868P AD=0.868P PS=5.12U
+ PD=5.12U
M$19 \$51 \$145 VDD VDD pfet_03v3 L=0.28U W=0.36U AS=0.1584P AD=0.1584P PS=1.6U
+ PD=1.6U
M$20 \$105 WEM VDD VDD pfet_03v3 L=0.28U W=0.36U AS=0.1584P AD=0.0567P PS=1.6U
+ PD=0.675U
M$21 \$145 \$51 \$105 VDD pfet_03v3 L=0.28U W=0.36U AS=0.0567P AD=0.1278P
+ PS=0.675U PD=1.07U
M$22 \$52 WEMb \$145 VDD pfet_03v3 L=0.28U W=0.36U AS=0.1278P AD=0.2097P
+ PS=1.07U PD=1.38U
M$23 VDD D2 \$52 VDD pfet_03v3 L=0.28U W=0.72U AS=0.2097P AD=0.3168P PS=1.38U
+ PD=2.32U
M$24 \$53 \$147 VDD VDD pfet_03v3 L=0.28U W=2.48U AS=0.868P AD=0.868P PS=5.12U
+ PD=5.12U
M$26 \$54 \$147 VDD VDD pfet_03v3 L=0.28U W=0.36U AS=0.1584P AD=0.1584P PS=1.6U
+ PD=1.6U
M$27 \$110 WEM VDD VDD pfet_03v3 L=0.28U W=0.36U AS=0.1584P AD=0.0567P PS=1.6U
+ PD=0.675U
M$28 \$147 \$54 \$110 VDD pfet_03v3 L=0.28U W=0.36U AS=0.0567P AD=0.1278P
+ PS=0.675U PD=1.07U
M$29 \$55 WEMb \$147 VDD pfet_03v3 L=0.28U W=0.36U AS=0.1278P AD=0.2097P
+ PS=1.07U PD=1.38U
M$30 VDD D3 \$55 VDD pfet_03v3 L=0.28U W=0.72U AS=0.2097P AD=0.3168P PS=1.38U
+ PD=2.32U
M$31 \$56 \$149 VDD VDD pfet_03v3 L=0.28U W=2.48U AS=0.868P AD=0.868P PS=5.12U
+ PD=5.12U
M$33 \$57 \$149 VDD VDD pfet_03v3 L=0.28U W=0.36U AS=0.1584P AD=0.1584P PS=1.6U
+ PD=1.6U
M$34 \$115 WEM VDD VDD pfet_03v3 L=0.28U W=0.36U AS=0.1584P AD=0.0567P PS=1.6U
+ PD=0.675U
M$35 \$149 \$57 \$115 VDD pfet_03v3 L=0.28U W=0.36U AS=0.0567P AD=0.1278P
+ PS=0.675U PD=1.07U
M$36 \$58 WEMb \$149 VDD pfet_03v3 L=0.28U W=0.36U AS=0.1278P AD=0.2097P
+ PS=1.07U PD=1.38U
M$37 VDD D4 \$58 VDD pfet_03v3 L=0.28U W=0.72U AS=0.2097P AD=0.3168P PS=1.38U
+ PD=2.32U
M$38 \$59 \$151 VDD VDD pfet_03v3 L=0.28U W=2.48U AS=0.868P AD=0.868P PS=5.12U
+ PD=5.12U
M$40 \$60 \$151 VDD VDD pfet_03v3 L=0.28U W=0.36U AS=0.1584P AD=0.1584P PS=1.6U
+ PD=1.6U
M$41 \$120 WEM VDD VDD pfet_03v3 L=0.28U W=0.36U AS=0.1584P AD=0.0567P PS=1.6U
+ PD=0.675U
M$42 \$151 \$60 \$120 VDD pfet_03v3 L=0.28U W=0.36U AS=0.0567P AD=0.1278P
+ PS=0.675U PD=1.07U
M$43 \$61 WEMb \$151 VDD pfet_03v3 L=0.28U W=0.36U AS=0.1278P AD=0.2097P
+ PS=1.07U PD=1.38U
M$44 VDD D5 \$61 VDD pfet_03v3 L=0.28U W=0.72U AS=0.2097P AD=0.3168P PS=1.38U
+ PD=2.32U
M$45 \$62 \$153 VDD VDD pfet_03v3 L=0.28U W=2.48U AS=0.868P AD=0.868P PS=5.12U
+ PD=5.12U
M$47 \$63 \$153 VDD VDD pfet_03v3 L=0.28U W=0.36U AS=0.1584P AD=0.1584P PS=1.6U
+ PD=1.6U
M$48 \$125 WEM VDD VDD pfet_03v3 L=0.28U W=0.36U AS=0.1584P AD=0.0567P PS=1.6U
+ PD=0.675U
M$49 \$153 \$63 \$125 VDD pfet_03v3 L=0.28U W=0.36U AS=0.0567P AD=0.1278P
+ PS=0.675U PD=1.07U
M$50 \$64 WEMb \$153 VDD pfet_03v3 L=0.28U W=0.36U AS=0.1278P AD=0.2097P
+ PS=1.07U PD=1.38U
M$51 VDD D6 \$64 VDD pfet_03v3 L=0.28U W=0.72U AS=0.2097P AD=0.3168P PS=1.38U
+ PD=2.32U
M$52 \$65 \$155 VDD VDD pfet_03v3 L=0.28U W=2.48U AS=0.868P AD=0.868P PS=5.12U
+ PD=5.12U
M$54 \$66 \$155 VDD VDD pfet_03v3 L=0.28U W=0.36U AS=0.1584P AD=0.1584P PS=1.6U
+ PD=1.6U
M$55 \$130 WEM VDD VDD pfet_03v3 L=0.28U W=0.36U AS=0.1584P AD=0.0567P PS=1.6U
+ PD=0.675U
M$56 \$155 \$66 \$130 VDD pfet_03v3 L=0.28U W=0.36U AS=0.0567P AD=0.1278P
+ PS=0.675U PD=1.07U
M$57 \$67 WEMb \$155 VDD pfet_03v3 L=0.28U W=0.36U AS=0.1278P AD=0.2097P
+ PS=1.07U PD=1.38U
M$58 VDD D7 \$67 VDD pfet_03v3 L=0.28U W=0.72U AS=0.2097P AD=0.3168P PS=1.38U
+ PD=2.32U
M$59 \$68 \$157 VDD VDD pfet_03v3 L=0.28U W=2.48U AS=0.868P AD=0.868P PS=5.12U
+ PD=5.12U
M$61 \$69 \$157 VDD VDD pfet_03v3 L=0.28U W=0.36U AS=0.1584P AD=0.1584P PS=1.6U
+ PD=1.6U
M$62 \$135 WEM VDD VDD pfet_03v3 L=0.28U W=0.36U AS=0.1584P AD=0.0567P PS=1.6U
+ PD=0.675U
M$63 \$157 \$69 \$135 VDD pfet_03v3 L=0.28U W=0.36U AS=0.0567P AD=0.1278P
+ PS=0.675U PD=1.07U
M$64 \$70 WEMb \$157 VDD pfet_03v3 L=0.28U W=0.36U AS=0.1278P AD=0.2097P
+ PS=1.07U PD=1.38U
M$65 VDD D8 \$70 VDD pfet_03v3 L=0.28U W=0.72U AS=0.2097P AD=0.3168P PS=1.38U
+ PD=2.32U
M$66 \$71 \$159 VDD VDD pfet_03v3 L=0.28U W=2.48U AS=0.868P AD=0.868P PS=5.12U
+ PD=5.12U
M$68 \$72 \$159 VDD VDD pfet_03v3 L=0.28U W=0.36U AS=0.1584P AD=0.1584P PS=1.6U
+ PD=1.6U
M$69 \$139 WEM VDD VDD pfet_03v3 L=0.28U W=0.36U AS=0.1584P AD=0.0567P PS=1.6U
+ PD=0.675U
M$70 \$159 \$72 \$139 VDD pfet_03v3 L=0.28U W=0.36U AS=0.0567P AD=0.1278P
+ PS=0.675U PD=1.07U
M$71 \$73 WEMb \$159 VDD pfet_03v3 L=0.28U W=0.36U AS=0.1278P AD=0.2097P
+ PS=1.07U PD=1.38U
M$72 VDD D9 \$73 VDD pfet_03v3 L=0.28U W=0.72U AS=0.2097P AD=0.3168P PS=1.38U
+ PD=2.32U
M$73 \$74 \$161 VDD VDD pfet_03v3 L=0.28U W=2.48U AS=0.868P AD=0.868P PS=5.12U
+ PD=5.12U
M$75 \$75 \$161 VDD VDD pfet_03v3 L=0.28U W=0.36U AS=0.1584P AD=0.1584P PS=1.6U
+ PD=1.6U
M$76 \$132 WEM VDD VDD pfet_03v3 L=0.28U W=0.36U AS=0.1584P AD=0.0567P PS=1.6U
+ PD=0.675U
M$77 \$161 \$75 \$132 VDD pfet_03v3 L=0.28U W=0.36U AS=0.0567P AD=0.1278P
+ PS=0.675U PD=1.07U
M$78 \$76 WEMb \$161 VDD pfet_03v3 L=0.28U W=0.36U AS=0.1278P AD=0.2097P
+ PS=1.07U PD=1.38U
M$79 VDD D10 \$76 VDD pfet_03v3 L=0.28U W=0.72U AS=0.2097P AD=0.3168P PS=1.38U
+ PD=2.32U
M$80 \$77 \$163 VDD VDD pfet_03v3 L=0.28U W=2.48U AS=0.868P AD=0.868P PS=5.12U
+ PD=5.12U
M$82 \$78 \$163 VDD VDD pfet_03v3 L=0.28U W=0.36U AS=0.1584P AD=0.1584P PS=1.6U
+ PD=1.6U
M$83 \$123 WEM VDD VDD pfet_03v3 L=0.28U W=0.36U AS=0.1584P AD=0.0567P PS=1.6U
+ PD=0.675U
M$84 \$163 \$78 \$123 VDD pfet_03v3 L=0.28U W=0.36U AS=0.0567P AD=0.1278P
+ PS=0.675U PD=1.07U
M$85 \$79 WEMb \$163 VDD pfet_03v3 L=0.28U W=0.36U AS=0.1278P AD=0.2097P
+ PS=1.07U PD=1.38U
M$86 VDD D11 \$79 VDD pfet_03v3 L=0.28U W=0.72U AS=0.2097P AD=0.3168P PS=1.38U
+ PD=2.32U
M$87 \$80 \$165 VDD VDD pfet_03v3 L=0.28U W=2.48U AS=0.868P AD=0.868P PS=5.12U
+ PD=5.12U
M$89 \$81 \$165 VDD VDD pfet_03v3 L=0.28U W=0.36U AS=0.1584P AD=0.1584P PS=1.6U
+ PD=1.6U
M$90 \$117 WEM VDD VDD pfet_03v3 L=0.28U W=0.36U AS=0.1584P AD=0.0567P PS=1.6U
+ PD=0.675U
M$91 \$165 \$81 \$117 VDD pfet_03v3 L=0.28U W=0.36U AS=0.0567P AD=0.1278P
+ PS=0.675U PD=1.07U
M$92 \$82 WEMb \$165 VDD pfet_03v3 L=0.28U W=0.36U AS=0.1278P AD=0.2097P
+ PS=1.07U PD=1.38U
M$93 VDD D12 \$82 VDD pfet_03v3 L=0.28U W=0.72U AS=0.2097P AD=0.3168P PS=1.38U
+ PD=2.32U
M$94 \$83 \$167 VDD VDD pfet_03v3 L=0.28U W=2.48U AS=0.868P AD=0.868P PS=5.12U
+ PD=5.12U
M$96 \$84 \$167 VDD VDD pfet_03v3 L=0.28U W=0.36U AS=0.1584P AD=0.1584P PS=1.6U
+ PD=1.6U
M$97 \$108 WEM VDD VDD pfet_03v3 L=0.28U W=0.36U AS=0.1584P AD=0.0567P PS=1.6U
+ PD=0.675U
M$98 \$167 \$84 \$108 VDD pfet_03v3 L=0.28U W=0.36U AS=0.0567P AD=0.1278P
+ PS=0.675U PD=1.07U
M$99 \$85 WEMb \$167 VDD pfet_03v3 L=0.28U W=0.36U AS=0.1278P AD=0.2097P
+ PS=1.07U PD=1.38U
M$100 VDD D13 \$85 VDD pfet_03v3 L=0.28U W=0.72U AS=0.2097P AD=0.3168P PS=1.38U
+ PD=2.32U
M$101 \$86 \$169 VDD VDD pfet_03v3 L=0.28U W=2.48U AS=0.868P AD=0.868P PS=5.12U
+ PD=5.12U
M$103 \$87 \$169 VDD VDD pfet_03v3 L=0.28U W=0.36U AS=0.1584P AD=0.1584P
+ PS=1.6U PD=1.6U
M$104 \$101 WEM VDD VDD pfet_03v3 L=0.28U W=0.36U AS=0.1584P AD=0.0567P PS=1.6U
+ PD=0.675U
M$105 \$169 \$87 \$101 VDD pfet_03v3 L=0.28U W=0.36U AS=0.0567P AD=0.1278P
+ PS=0.675U PD=1.07U
M$106 \$88 WEMb \$169 VDD pfet_03v3 L=0.28U W=0.36U AS=0.1278P AD=0.2097P
+ PS=1.07U PD=1.38U
M$107 VDD D14 \$88 VDD pfet_03v3 L=0.28U W=0.72U AS=0.2097P AD=0.3168P PS=1.38U
+ PD=2.32U
M$108 \$89 \$171 VDD VDD pfet_03v3 L=0.28U W=2.48U AS=0.868P AD=0.868P PS=5.12U
+ PD=5.12U
M$110 \$90 \$171 VDD VDD pfet_03v3 L=0.28U W=0.36U AS=0.1584P AD=0.1584P
+ PS=1.6U PD=1.6U
M$111 \$93 WEM VDD VDD pfet_03v3 L=0.28U W=0.36U AS=0.1584P AD=0.0567P PS=1.6U
+ PD=0.675U
M$112 \$171 \$90 \$93 VDD pfet_03v3 L=0.28U W=0.36U AS=0.0567P AD=0.1278P
+ PS=0.675U PD=1.07U
M$113 \$91 WEMb \$171 VDD pfet_03v3 L=0.28U W=0.36U AS=0.1278P AD=0.2097P
+ PS=1.07U PD=1.38U
M$114 VDD D15 \$91 VDD pfet_03v3 L=0.28U W=0.72U AS=0.2097P AD=0.3168P PS=1.38U
+ PD=2.32U
M$115 \$272 WE15 VDD VDD pfet_03v3 L=0.28U W=0.72U AS=0.3168P AD=0.1872P
+ PS=2.32U PD=1.24U
M$116 VDD CLK \$272 VDD pfet_03v3 L=0.28U W=0.72U AS=0.1872P AD=0.3168P
+ PS=1.24U PD=2.32U
M$117 \$273 \$272 VDD VDD pfet_03v3 L=0.28U W=2.54U AS=0.8974P AD=0.6604P
+ PS=5.28U PD=3.58U
M$119 \$492 \$273 VDD VDD pfet_03v3 L=0.28U W=2.68U AS=0.7272P AD=0.9782P
+ PS=3.78U PD=5.48U
M$121 \$274 \$44 VDD VDD pfet_03v3 L=0.28U W=0.72U AS=0.3168P AD=0.2097P
+ PS=2.32U PD=1.38U
M$122 \$275 \$492 \$274 VDD pfet_03v3 L=0.28U W=0.36U AS=0.2097P AD=0.1278P
+ PS=1.38U PD=1.07U
M$123 \$498 \$357 \$275 VDD pfet_03v3 L=0.28U W=0.36U AS=0.1278P AD=0.0567P
+ PS=1.07U PD=0.675U
M$124 VDD \$273 \$498 VDD pfet_03v3 L=0.28U W=0.36U AS=0.0567P AD=0.1584P
+ PS=0.675U PD=1.6U
M$125 \$357 \$275 VDD VDD pfet_03v3 L=0.28U W=0.36U AS=0.1764P AD=0.1584P
+ PS=1.26U PD=1.6U
M$126 \$256 \$275 VDD VDD pfet_03v3 L=0.28U W=0.72U AS=0.1764P AD=0.36P
+ PS=1.26U PD=2.44U
M$127 \$359 RA15 VDD VDD pfet_03v3 L=0.28U W=0.72U AS=0.3312P AD=0.3888P
+ PS=2.36U PD=2.52U
M$128 \$256 \$359 \$360 VDD pfet_03v3 L=0.28U W=0.36U AS=0.1584P AD=0.1152P
+ PS=1.6U PD=1U
M$129 \$361 \$362 \$256 VDD pfet_03v3 L=0.28U W=0.36U AS=0.1152P AD=0.1584P
+ PS=1U PD=1.6U
M$130 VDD RB15 \$362 VDD pfet_03v3 L=0.28U W=0.72U AS=0.3708P AD=0.3168P
+ PS=2.47U PD=2.32U
M$131 \$276 \$47 VDD VDD pfet_03v3 L=0.28U W=0.72U AS=0.3168P AD=0.2097P
+ PS=2.32U PD=1.38U
M$132 \$277 \$492 \$276 VDD pfet_03v3 L=0.28U W=0.36U AS=0.2097P AD=0.1278P
+ PS=1.38U PD=1.07U
M$133 \$508 \$363 \$277 VDD pfet_03v3 L=0.28U W=0.36U AS=0.1278P AD=0.0567P
+ PS=1.07U PD=0.675U
M$134 VDD \$273 \$508 VDD pfet_03v3 L=0.28U W=0.36U AS=0.0567P AD=0.1584P
+ PS=0.675U PD=1.6U
M$135 \$363 \$277 VDD VDD pfet_03v3 L=0.28U W=0.36U AS=0.1764P AD=0.1584P
+ PS=1.26U PD=1.6U
M$136 \$257 \$277 VDD VDD pfet_03v3 L=0.28U W=0.72U AS=0.1764P AD=0.36P
+ PS=1.26U PD=2.44U
M$137 \$364 RA15 VDD VDD pfet_03v3 L=0.28U W=0.72U AS=0.3312P AD=0.3888P
+ PS=2.36U PD=2.52U
M$138 \$257 \$364 \$365 VDD pfet_03v3 L=0.28U W=0.36U AS=0.1584P AD=0.1152P
+ PS=1.6U PD=1U
M$139 \$366 \$367 \$257 VDD pfet_03v3 L=0.28U W=0.36U AS=0.1152P AD=0.1584P
+ PS=1U PD=1.6U
M$140 VDD RB15 \$367 VDD pfet_03v3 L=0.28U W=0.72U AS=0.3708P AD=0.3168P
+ PS=2.47U PD=2.32U
M$141 \$278 \$50 VDD VDD pfet_03v3 L=0.28U W=0.72U AS=0.3168P AD=0.2097P
+ PS=2.32U PD=1.38U
M$142 \$279 \$492 \$278 VDD pfet_03v3 L=0.28U W=0.36U AS=0.2097P AD=0.1278P
+ PS=1.38U PD=1.07U
M$143 \$514 \$368 \$279 VDD pfet_03v3 L=0.28U W=0.36U AS=0.1278P AD=0.0567P
+ PS=1.07U PD=0.675U
M$144 VDD \$273 \$514 VDD pfet_03v3 L=0.28U W=0.36U AS=0.0567P AD=0.1584P
+ PS=0.675U PD=1.6U
M$145 \$368 \$279 VDD VDD pfet_03v3 L=0.28U W=0.36U AS=0.1764P AD=0.1584P
+ PS=1.26U PD=1.6U
M$146 \$258 \$279 VDD VDD pfet_03v3 L=0.28U W=0.72U AS=0.1764P AD=0.36P
+ PS=1.26U PD=2.44U
M$147 \$369 RA15 VDD VDD pfet_03v3 L=0.28U W=0.72U AS=0.3312P AD=0.3888P
+ PS=2.36U PD=2.52U
M$148 \$258 \$369 \$370 VDD pfet_03v3 L=0.28U W=0.36U AS=0.1584P AD=0.1152P
+ PS=1.6U PD=1U
M$149 \$371 \$372 \$258 VDD pfet_03v3 L=0.28U W=0.36U AS=0.1152P AD=0.1584P
+ PS=1U PD=1.6U
M$150 VDD RB15 \$372 VDD pfet_03v3 L=0.28U W=0.72U AS=0.3708P AD=0.3168P
+ PS=2.47U PD=2.32U
M$151 \$280 \$53 VDD VDD pfet_03v3 L=0.28U W=0.72U AS=0.3168P AD=0.2097P
+ PS=2.32U PD=1.38U
M$152 \$281 \$492 \$280 VDD pfet_03v3 L=0.28U W=0.36U AS=0.2097P AD=0.1278P
+ PS=1.38U PD=1.07U
M$153 \$523 \$373 \$281 VDD pfet_03v3 L=0.28U W=0.36U AS=0.1278P AD=0.0567P
+ PS=1.07U PD=0.675U
M$154 VDD \$273 \$523 VDD pfet_03v3 L=0.28U W=0.36U AS=0.0567P AD=0.1584P
+ PS=0.675U PD=1.6U
M$155 \$373 \$281 VDD VDD pfet_03v3 L=0.28U W=0.36U AS=0.1764P AD=0.1584P
+ PS=1.26U PD=1.6U
M$156 \$259 \$281 VDD VDD pfet_03v3 L=0.28U W=0.72U AS=0.1764P AD=0.36P
+ PS=1.26U PD=2.44U
M$157 \$374 RA15 VDD VDD pfet_03v3 L=0.28U W=0.72U AS=0.3312P AD=0.3888P
+ PS=2.36U PD=2.52U
M$158 \$259 \$374 \$375 VDD pfet_03v3 L=0.28U W=0.36U AS=0.1584P AD=0.1152P
+ PS=1.6U PD=1U
M$159 \$376 \$377 \$259 VDD pfet_03v3 L=0.28U W=0.36U AS=0.1152P AD=0.1584P
+ PS=1U PD=1.6U
M$160 VDD RB15 \$377 VDD pfet_03v3 L=0.28U W=0.72U AS=0.3708P AD=0.3168P
+ PS=2.47U PD=2.32U
M$161 \$282 \$56 VDD VDD pfet_03v3 L=0.28U W=0.72U AS=0.3168P AD=0.2097P
+ PS=2.32U PD=1.38U
M$162 \$283 \$492 \$282 VDD pfet_03v3 L=0.28U W=0.36U AS=0.2097P AD=0.1278P
+ PS=1.38U PD=1.07U
M$163 \$533 \$378 \$283 VDD pfet_03v3 L=0.28U W=0.36U AS=0.1278P AD=0.0567P
+ PS=1.07U PD=0.675U
M$164 VDD \$273 \$533 VDD pfet_03v3 L=0.28U W=0.36U AS=0.0567P AD=0.1584P
+ PS=0.675U PD=1.6U
M$165 \$378 \$283 VDD VDD pfet_03v3 L=0.28U W=0.36U AS=0.1764P AD=0.1584P
+ PS=1.26U PD=1.6U
M$166 \$260 \$283 VDD VDD pfet_03v3 L=0.28U W=0.72U AS=0.1764P AD=0.36P
+ PS=1.26U PD=2.44U
M$167 \$379 RA15 VDD VDD pfet_03v3 L=0.28U W=0.72U AS=0.3312P AD=0.3888P
+ PS=2.36U PD=2.52U
M$168 \$260 \$379 \$380 VDD pfet_03v3 L=0.28U W=0.36U AS=0.1584P AD=0.1152P
+ PS=1.6U PD=1U
M$169 \$381 \$382 \$260 VDD pfet_03v3 L=0.28U W=0.36U AS=0.1152P AD=0.1584P
+ PS=1U PD=1.6U
M$170 VDD RB15 \$382 VDD pfet_03v3 L=0.28U W=0.72U AS=0.3708P AD=0.3168P
+ PS=2.47U PD=2.32U
M$171 \$284 \$59 VDD VDD pfet_03v3 L=0.28U W=0.72U AS=0.3168P AD=0.2097P
+ PS=2.32U PD=1.38U
M$172 \$285 \$492 \$284 VDD pfet_03v3 L=0.28U W=0.36U AS=0.2097P AD=0.1278P
+ PS=1.38U PD=1.07U
M$173 \$542 \$383 \$285 VDD pfet_03v3 L=0.28U W=0.36U AS=0.1278P AD=0.0567P
+ PS=1.07U PD=0.675U
M$174 VDD \$273 \$542 VDD pfet_03v3 L=0.28U W=0.36U AS=0.0567P AD=0.1584P
+ PS=0.675U PD=1.6U
M$175 \$383 \$285 VDD VDD pfet_03v3 L=0.28U W=0.36U AS=0.1764P AD=0.1584P
+ PS=1.26U PD=1.6U
M$176 \$261 \$285 VDD VDD pfet_03v3 L=0.28U W=0.72U AS=0.1764P AD=0.36P
+ PS=1.26U PD=2.44U
M$177 \$384 RA15 VDD VDD pfet_03v3 L=0.28U W=0.72U AS=0.3312P AD=0.3888P
+ PS=2.36U PD=2.52U
M$178 \$261 \$384 \$385 VDD pfet_03v3 L=0.28U W=0.36U AS=0.1584P AD=0.1152P
+ PS=1.6U PD=1U
M$179 \$386 \$387 \$261 VDD pfet_03v3 L=0.28U W=0.36U AS=0.1152P AD=0.1584P
+ PS=1U PD=1.6U
M$180 VDD RB15 \$387 VDD pfet_03v3 L=0.28U W=0.72U AS=0.3708P AD=0.3168P
+ PS=2.47U PD=2.32U
M$181 \$286 \$62 VDD VDD pfet_03v3 L=0.28U W=0.72U AS=0.3168P AD=0.2097P
+ PS=2.32U PD=1.38U
M$182 \$287 \$492 \$286 VDD pfet_03v3 L=0.28U W=0.36U AS=0.2097P AD=0.1278P
+ PS=1.38U PD=1.07U
M$183 \$550 \$388 \$287 VDD pfet_03v3 L=0.28U W=0.36U AS=0.1278P AD=0.0567P
+ PS=1.07U PD=0.675U
M$184 VDD \$273 \$550 VDD pfet_03v3 L=0.28U W=0.36U AS=0.0567P AD=0.1584P
+ PS=0.675U PD=1.6U
M$185 \$388 \$287 VDD VDD pfet_03v3 L=0.28U W=0.36U AS=0.1764P AD=0.1584P
+ PS=1.26U PD=1.6U
M$186 \$262 \$287 VDD VDD pfet_03v3 L=0.28U W=0.72U AS=0.1764P AD=0.36P
+ PS=1.26U PD=2.44U
M$187 \$389 RA15 VDD VDD pfet_03v3 L=0.28U W=0.72U AS=0.3312P AD=0.3888P
+ PS=2.36U PD=2.52U
M$188 \$262 \$389 \$390 VDD pfet_03v3 L=0.28U W=0.36U AS=0.1584P AD=0.1152P
+ PS=1.6U PD=1U
M$189 \$391 \$392 \$262 VDD pfet_03v3 L=0.28U W=0.36U AS=0.1152P AD=0.1584P
+ PS=1U PD=1.6U
M$190 VDD RB15 \$392 VDD pfet_03v3 L=0.28U W=0.72U AS=0.3708P AD=0.3168P
+ PS=2.47U PD=2.32U
M$191 \$288 \$65 VDD VDD pfet_03v3 L=0.28U W=0.72U AS=0.3168P AD=0.2097P
+ PS=2.32U PD=1.38U
M$192 \$289 \$492 \$288 VDD pfet_03v3 L=0.28U W=0.36U AS=0.2097P AD=0.1278P
+ PS=1.38U PD=1.07U
M$193 \$559 \$393 \$289 VDD pfet_03v3 L=0.28U W=0.36U AS=0.1278P AD=0.0567P
+ PS=1.07U PD=0.675U
M$194 VDD \$273 \$559 VDD pfet_03v3 L=0.28U W=0.36U AS=0.0567P AD=0.1584P
+ PS=0.675U PD=1.6U
M$195 \$393 \$289 VDD VDD pfet_03v3 L=0.28U W=0.36U AS=0.1764P AD=0.1584P
+ PS=1.26U PD=1.6U
M$196 \$263 \$289 VDD VDD pfet_03v3 L=0.28U W=0.72U AS=0.1764P AD=0.36P
+ PS=1.26U PD=2.44U
M$197 \$394 RA15 VDD VDD pfet_03v3 L=0.28U W=0.72U AS=0.3312P AD=0.3888P
+ PS=2.36U PD=2.52U
M$198 \$263 \$394 \$395 VDD pfet_03v3 L=0.28U W=0.36U AS=0.1584P AD=0.1152P
+ PS=1.6U PD=1U
M$199 \$396 \$397 \$263 VDD pfet_03v3 L=0.28U W=0.36U AS=0.1152P AD=0.1584P
+ PS=1U PD=1.6U
M$200 VDD RB15 \$397 VDD pfet_03v3 L=0.28U W=0.72U AS=0.3708P AD=0.3168P
+ PS=2.47U PD=2.32U
M$201 \$290 \$68 VDD VDD pfet_03v3 L=0.28U W=0.72U AS=0.3168P AD=0.2097P
+ PS=2.32U PD=1.38U
M$202 \$291 \$492 \$290 VDD pfet_03v3 L=0.28U W=0.36U AS=0.2097P AD=0.1278P
+ PS=1.38U PD=1.07U
M$203 \$568 \$398 \$291 VDD pfet_03v3 L=0.28U W=0.36U AS=0.1278P AD=0.0567P
+ PS=1.07U PD=0.675U
M$204 VDD \$273 \$568 VDD pfet_03v3 L=0.28U W=0.36U AS=0.0567P AD=0.1584P
+ PS=0.675U PD=1.6U
M$205 \$398 \$291 VDD VDD pfet_03v3 L=0.28U W=0.36U AS=0.1764P AD=0.1584P
+ PS=1.26U PD=1.6U
M$206 \$264 \$291 VDD VDD pfet_03v3 L=0.28U W=0.72U AS=0.1764P AD=0.36P
+ PS=1.26U PD=2.44U
M$207 \$399 RA15 VDD VDD pfet_03v3 L=0.28U W=0.72U AS=0.3312P AD=0.3888P
+ PS=2.36U PD=2.52U
M$208 \$264 \$399 \$400 VDD pfet_03v3 L=0.28U W=0.36U AS=0.1584P AD=0.1152P
+ PS=1.6U PD=1U
M$209 \$401 \$402 \$264 VDD pfet_03v3 L=0.28U W=0.36U AS=0.1152P AD=0.1584P
+ PS=1U PD=1.6U
M$210 VDD RB15 \$402 VDD pfet_03v3 L=0.28U W=0.72U AS=0.3708P AD=0.3168P
+ PS=2.47U PD=2.32U
M$211 \$292 \$71 VDD VDD pfet_03v3 L=0.28U W=0.72U AS=0.3168P AD=0.2097P
+ PS=2.32U PD=1.38U
M$212 \$293 \$492 \$292 VDD pfet_03v3 L=0.28U W=0.36U AS=0.2097P AD=0.1278P
+ PS=1.38U PD=1.07U
M$213 \$577 \$403 \$293 VDD pfet_03v3 L=0.28U W=0.36U AS=0.1278P AD=0.0567P
+ PS=1.07U PD=0.675U
M$214 VDD \$273 \$577 VDD pfet_03v3 L=0.28U W=0.36U AS=0.0567P AD=0.1584P
+ PS=0.675U PD=1.6U
M$215 \$403 \$293 VDD VDD pfet_03v3 L=0.28U W=0.36U AS=0.1764P AD=0.1584P
+ PS=1.26U PD=1.6U
M$216 \$265 \$293 VDD VDD pfet_03v3 L=0.28U W=0.72U AS=0.1764P AD=0.36P
+ PS=1.26U PD=2.44U
M$217 \$404 RA15 VDD VDD pfet_03v3 L=0.28U W=0.72U AS=0.3312P AD=0.3888P
+ PS=2.36U PD=2.52U
M$218 \$265 \$404 \$405 VDD pfet_03v3 L=0.28U W=0.36U AS=0.1584P AD=0.1152P
+ PS=1.6U PD=1U
M$219 \$406 \$407 \$265 VDD pfet_03v3 L=0.28U W=0.36U AS=0.1152P AD=0.1584P
+ PS=1U PD=1.6U
M$220 VDD RB15 \$407 VDD pfet_03v3 L=0.28U W=0.72U AS=0.3708P AD=0.3168P
+ PS=2.47U PD=2.32U
M$221 \$294 \$74 VDD VDD pfet_03v3 L=0.28U W=0.72U AS=0.3168P AD=0.2097P
+ PS=2.32U PD=1.38U
M$222 \$295 \$492 \$294 VDD pfet_03v3 L=0.28U W=0.36U AS=0.2097P AD=0.1278P
+ PS=1.38U PD=1.07U
M$223 \$586 \$408 \$295 VDD pfet_03v3 L=0.28U W=0.36U AS=0.1278P AD=0.0567P
+ PS=1.07U PD=0.675U
M$224 VDD \$273 \$586 VDD pfet_03v3 L=0.28U W=0.36U AS=0.0567P AD=0.1584P
+ PS=0.675U PD=1.6U
M$225 \$408 \$295 VDD VDD pfet_03v3 L=0.28U W=0.36U AS=0.1764P AD=0.1584P
+ PS=1.26U PD=1.6U
M$226 \$266 \$295 VDD VDD pfet_03v3 L=0.28U W=0.72U AS=0.1764P AD=0.36P
+ PS=1.26U PD=2.44U
M$227 \$409 RA15 VDD VDD pfet_03v3 L=0.28U W=0.72U AS=0.3312P AD=0.3888P
+ PS=2.36U PD=2.52U
M$228 \$266 \$409 \$410 VDD pfet_03v3 L=0.28U W=0.36U AS=0.1584P AD=0.1152P
+ PS=1.6U PD=1U
M$229 \$411 \$412 \$266 VDD pfet_03v3 L=0.28U W=0.36U AS=0.1152P AD=0.1584P
+ PS=1U PD=1.6U
M$230 VDD RB15 \$412 VDD pfet_03v3 L=0.28U W=0.72U AS=0.3708P AD=0.3168P
+ PS=2.47U PD=2.32U
M$231 \$296 \$77 VDD VDD pfet_03v3 L=0.28U W=0.72U AS=0.3168P AD=0.2097P
+ PS=2.32U PD=1.38U
M$232 \$297 \$492 \$296 VDD pfet_03v3 L=0.28U W=0.36U AS=0.2097P AD=0.1278P
+ PS=1.38U PD=1.07U
M$233 \$594 \$413 \$297 VDD pfet_03v3 L=0.28U W=0.36U AS=0.1278P AD=0.0567P
+ PS=1.07U PD=0.675U
M$234 VDD \$273 \$594 VDD pfet_03v3 L=0.28U W=0.36U AS=0.0567P AD=0.1584P
+ PS=0.675U PD=1.6U
M$235 \$413 \$297 VDD VDD pfet_03v3 L=0.28U W=0.36U AS=0.1764P AD=0.1584P
+ PS=1.26U PD=1.6U
M$236 \$267 \$297 VDD VDD pfet_03v3 L=0.28U W=0.72U AS=0.1764P AD=0.36P
+ PS=1.26U PD=2.44U
M$237 \$414 RA15 VDD VDD pfet_03v3 L=0.28U W=0.72U AS=0.3312P AD=0.3888P
+ PS=2.36U PD=2.52U
M$238 \$267 \$414 \$415 VDD pfet_03v3 L=0.28U W=0.36U AS=0.1584P AD=0.1152P
+ PS=1.6U PD=1U
M$239 \$416 \$417 \$267 VDD pfet_03v3 L=0.28U W=0.36U AS=0.1152P AD=0.1584P
+ PS=1U PD=1.6U
M$240 VDD RB15 \$417 VDD pfet_03v3 L=0.28U W=0.72U AS=0.3708P AD=0.3168P
+ PS=2.47U PD=2.32U
M$241 \$298 \$80 VDD VDD pfet_03v3 L=0.28U W=0.72U AS=0.3168P AD=0.2097P
+ PS=2.32U PD=1.38U
M$242 \$299 \$492 \$298 VDD pfet_03v3 L=0.28U W=0.36U AS=0.2097P AD=0.1278P
+ PS=1.38U PD=1.07U
M$243 \$580 \$418 \$299 VDD pfet_03v3 L=0.28U W=0.36U AS=0.1278P AD=0.0567P
+ PS=1.07U PD=0.675U
M$244 VDD \$273 \$580 VDD pfet_03v3 L=0.28U W=0.36U AS=0.0567P AD=0.1584P
+ PS=0.675U PD=1.6U
M$245 \$418 \$299 VDD VDD pfet_03v3 L=0.28U W=0.36U AS=0.1764P AD=0.1584P
+ PS=1.26U PD=1.6U
M$246 \$268 \$299 VDD VDD pfet_03v3 L=0.28U W=0.72U AS=0.1764P AD=0.36P
+ PS=1.26U PD=2.44U
M$247 \$419 RA15 VDD VDD pfet_03v3 L=0.28U W=0.72U AS=0.3312P AD=0.3888P
+ PS=2.36U PD=2.52U
M$248 \$268 \$419 \$420 VDD pfet_03v3 L=0.28U W=0.36U AS=0.1584P AD=0.1152P
+ PS=1.6U PD=1U
M$249 \$421 \$422 \$268 VDD pfet_03v3 L=0.28U W=0.36U AS=0.1152P AD=0.1584P
+ PS=1U PD=1.6U
M$250 VDD RB15 \$422 VDD pfet_03v3 L=0.28U W=0.72U AS=0.3708P AD=0.3168P
+ PS=2.47U PD=2.32U
M$251 \$300 \$83 VDD VDD pfet_03v3 L=0.28U W=0.72U AS=0.3168P AD=0.2097P
+ PS=2.32U PD=1.38U
M$252 \$301 \$492 \$300 VDD pfet_03v3 L=0.28U W=0.36U AS=0.2097P AD=0.1278P
+ PS=1.38U PD=1.07U
M$253 \$552 \$423 \$301 VDD pfet_03v3 L=0.28U W=0.36U AS=0.1278P AD=0.0567P
+ PS=1.07U PD=0.675U
M$254 VDD \$273 \$552 VDD pfet_03v3 L=0.28U W=0.36U AS=0.0567P AD=0.1584P
+ PS=0.675U PD=1.6U
M$255 \$423 \$301 VDD VDD pfet_03v3 L=0.28U W=0.36U AS=0.1764P AD=0.1584P
+ PS=1.26U PD=1.6U
M$256 \$269 \$301 VDD VDD pfet_03v3 L=0.28U W=0.72U AS=0.1764P AD=0.36P
+ PS=1.26U PD=2.44U
M$257 \$424 RA15 VDD VDD pfet_03v3 L=0.28U W=0.72U AS=0.3312P AD=0.3888P
+ PS=2.36U PD=2.52U
M$258 \$269 \$424 \$425 VDD pfet_03v3 L=0.28U W=0.36U AS=0.1584P AD=0.1152P
+ PS=1.6U PD=1U
M$259 \$426 \$427 \$269 VDD pfet_03v3 L=0.28U W=0.36U AS=0.1152P AD=0.1584P
+ PS=1U PD=1.6U
M$260 VDD RB15 \$427 VDD pfet_03v3 L=0.28U W=0.72U AS=0.3708P AD=0.3168P
+ PS=2.47U PD=2.32U
M$261 \$302 \$86 VDD VDD pfet_03v3 L=0.28U W=0.72U AS=0.3168P AD=0.2097P
+ PS=2.32U PD=1.38U
M$262 \$303 \$492 \$302 VDD pfet_03v3 L=0.28U W=0.36U AS=0.2097P AD=0.1278P
+ PS=1.38U PD=1.07U
M$263 \$534 \$428 \$303 VDD pfet_03v3 L=0.28U W=0.36U AS=0.1278P AD=0.0567P
+ PS=1.07U PD=0.675U
M$264 VDD \$273 \$534 VDD pfet_03v3 L=0.28U W=0.36U AS=0.0567P AD=0.1584P
+ PS=0.675U PD=1.6U
M$265 \$428 \$303 VDD VDD pfet_03v3 L=0.28U W=0.36U AS=0.1764P AD=0.1584P
+ PS=1.26U PD=1.6U
M$266 \$270 \$303 VDD VDD pfet_03v3 L=0.28U W=0.72U AS=0.1764P AD=0.36P
+ PS=1.26U PD=2.44U
M$267 \$429 RA15 VDD VDD pfet_03v3 L=0.28U W=0.72U AS=0.3312P AD=0.3888P
+ PS=2.36U PD=2.52U
M$268 \$270 \$429 \$430 VDD pfet_03v3 L=0.28U W=0.36U AS=0.1584P AD=0.1152P
+ PS=1.6U PD=1U
M$269 \$431 \$432 \$270 VDD pfet_03v3 L=0.28U W=0.36U AS=0.1152P AD=0.1584P
+ PS=1U PD=1.6U
M$270 VDD RB15 \$432 VDD pfet_03v3 L=0.28U W=0.72U AS=0.3708P AD=0.3168P
+ PS=2.47U PD=2.32U
M$271 \$304 \$89 VDD VDD pfet_03v3 L=0.28U W=0.72U AS=0.3168P AD=0.2097P
+ PS=2.32U PD=1.38U
M$272 \$305 \$492 \$304 VDD pfet_03v3 L=0.28U W=0.36U AS=0.2097P AD=0.1278P
+ PS=1.38U PD=1.07U
M$273 \$506 \$433 \$305 VDD pfet_03v3 L=0.28U W=0.36U AS=0.1278P AD=0.0567P
+ PS=1.07U PD=0.675U
M$274 VDD \$273 \$506 VDD pfet_03v3 L=0.28U W=0.36U AS=0.0567P AD=0.1584P
+ PS=0.675U PD=1.6U
M$275 \$433 \$305 VDD VDD pfet_03v3 L=0.28U W=0.36U AS=0.1764P AD=0.1584P
+ PS=1.26U PD=1.6U
M$276 \$271 \$305 VDD VDD pfet_03v3 L=0.28U W=0.72U AS=0.1764P AD=0.36P
+ PS=1.26U PD=2.44U
M$277 \$434 RA15 VDD VDD pfet_03v3 L=0.28U W=0.72U AS=0.3312P AD=0.3888P
+ PS=2.36U PD=2.52U
M$278 \$271 \$434 \$435 VDD pfet_03v3 L=0.28U W=0.36U AS=0.1584P AD=0.1152P
+ PS=1.6U PD=1U
M$279 \$436 \$437 \$271 VDD pfet_03v3 L=0.28U W=0.36U AS=0.1152P AD=0.1584P
+ PS=1U PD=1.6U
M$280 VDD RB15 \$437 VDD pfet_03v3 L=0.28U W=0.72U AS=0.3708P AD=0.3168P
+ PS=2.47U PD=2.32U
M$281 \$598 WE14 VDD VDD pfet_03v3 L=0.28U W=0.72U AS=0.3168P AD=0.1872P
+ PS=2.32U PD=1.24U
M$282 VDD CLK \$598 VDD pfet_03v3 L=0.28U W=0.72U AS=0.1872P AD=0.3168P
+ PS=1.24U PD=2.32U
M$283 \$600 \$598 VDD VDD pfet_03v3 L=0.28U W=2.54U AS=0.889P AD=0.6688P
+ PS=5.21U PD=3.65U
M$285 \$601 \$600 VDD VDD pfet_03v3 L=0.28U W=2.68U AS=0.7272P AD=0.9782P
+ PS=3.78U PD=5.48U
M$287 \$605 \$601 \$604 VDD pfet_03v3 L=0.28U W=0.36U AS=0.2097P AD=0.1278P
+ PS=1.38U PD=1.07U
M$288 \$705 \$606 \$605 VDD pfet_03v3 L=0.28U W=0.36U AS=0.1278P AD=0.0567P
+ PS=1.07U PD=0.675U
M$289 VDD \$600 \$705 VDD pfet_03v3 L=0.28U W=0.36U AS=0.0567P AD=0.1584P
+ PS=0.675U PD=1.6U
M$290 \$604 \$44 VDD VDD pfet_03v3 L=0.28U W=0.72U AS=0.3168P AD=0.2097P
+ PS=2.32U PD=1.38U
M$291 VDD \$605 \$606 VDD pfet_03v3 L=0.28U W=0.36U AS=0.1584P AD=0.1764P
+ PS=1.6U PD=1.26U
M$292 \$607 \$605 VDD VDD pfet_03v3 L=0.28U W=0.72U AS=0.1764P AD=0.36P
+ PS=1.26U PD=2.44U
M$293 \$608 RB14 VDD VDD pfet_03v3 L=0.28U W=0.72U AS=0.3312P AD=0.3888P
+ PS=2.36U PD=2.52U
M$294 \$607 \$608 \$360 VDD pfet_03v3 L=0.28U W=0.36U AS=0.1584P AD=0.1152P
+ PS=1.6U PD=1U
M$295 \$361 \$609 \$607 VDD pfet_03v3 L=0.28U W=0.36U AS=0.1152P AD=0.1584P
+ PS=1U PD=1.6U
M$296 VDD RA14 \$609 VDD pfet_03v3 L=0.28U W=0.72U AS=0.3708P AD=0.3168P
+ PS=2.47U PD=2.32U
M$297 \$611 \$601 \$610 VDD pfet_03v3 L=0.28U W=0.36U AS=0.2097P AD=0.1278P
+ PS=1.38U PD=1.07U
M$298 \$713 \$612 \$611 VDD pfet_03v3 L=0.28U W=0.36U AS=0.1278P AD=0.0567P
+ PS=1.07U PD=0.675U
M$299 VDD \$600 \$713 VDD pfet_03v3 L=0.28U W=0.36U AS=0.0567P AD=0.1584P
+ PS=0.675U PD=1.6U
M$300 \$610 \$47 VDD VDD pfet_03v3 L=0.28U W=0.72U AS=0.3168P AD=0.2097P
+ PS=2.32U PD=1.38U
M$301 VDD \$611 \$612 VDD pfet_03v3 L=0.28U W=0.36U AS=0.1584P AD=0.1764P
+ PS=1.6U PD=1.26U
M$302 \$613 \$611 VDD VDD pfet_03v3 L=0.28U W=0.72U AS=0.1764P AD=0.36P
+ PS=1.26U PD=2.44U
M$303 \$614 RB14 VDD VDD pfet_03v3 L=0.28U W=0.72U AS=0.3312P AD=0.3888P
+ PS=2.36U PD=2.52U
M$304 \$613 \$614 \$365 VDD pfet_03v3 L=0.28U W=0.36U AS=0.1584P AD=0.1152P
+ PS=1.6U PD=1U
M$305 \$366 \$615 \$613 VDD pfet_03v3 L=0.28U W=0.36U AS=0.1152P AD=0.1584P
+ PS=1U PD=1.6U
M$306 VDD RA14 \$615 VDD pfet_03v3 L=0.28U W=0.72U AS=0.3708P AD=0.3168P
+ PS=2.47U PD=2.32U
M$307 \$617 \$601 \$616 VDD pfet_03v3 L=0.28U W=0.36U AS=0.2097P AD=0.1278P
+ PS=1.38U PD=1.07U
M$308 \$720 \$618 \$617 VDD pfet_03v3 L=0.28U W=0.36U AS=0.1278P AD=0.0567P
+ PS=1.07U PD=0.675U
M$309 VDD \$600 \$720 VDD pfet_03v3 L=0.28U W=0.36U AS=0.0567P AD=0.1584P
+ PS=0.675U PD=1.6U
M$310 \$616 \$50 VDD VDD pfet_03v3 L=0.28U W=0.72U AS=0.3168P AD=0.2097P
+ PS=2.32U PD=1.38U
M$311 VDD \$617 \$618 VDD pfet_03v3 L=0.28U W=0.36U AS=0.1584P AD=0.1764P
+ PS=1.6U PD=1.26U
M$312 \$619 \$617 VDD VDD pfet_03v3 L=0.28U W=0.72U AS=0.1764P AD=0.36P
+ PS=1.26U PD=2.44U
M$313 \$620 RB14 VDD VDD pfet_03v3 L=0.28U W=0.72U AS=0.3312P AD=0.3888P
+ PS=2.36U PD=2.52U
M$314 \$619 \$620 \$370 VDD pfet_03v3 L=0.28U W=0.36U AS=0.1584P AD=0.1152P
+ PS=1.6U PD=1U
M$315 \$371 \$621 \$619 VDD pfet_03v3 L=0.28U W=0.36U AS=0.1152P AD=0.1584P
+ PS=1U PD=1.6U
M$316 VDD RA14 \$621 VDD pfet_03v3 L=0.28U W=0.72U AS=0.3708P AD=0.3168P
+ PS=2.47U PD=2.32U
M$317 \$623 \$601 \$622 VDD pfet_03v3 L=0.28U W=0.36U AS=0.2097P AD=0.1278P
+ PS=1.38U PD=1.07U
M$318 \$728 \$624 \$623 VDD pfet_03v3 L=0.28U W=0.36U AS=0.1278P AD=0.0567P
+ PS=1.07U PD=0.675U
M$319 VDD \$600 \$728 VDD pfet_03v3 L=0.28U W=0.36U AS=0.0567P AD=0.1584P
+ PS=0.675U PD=1.6U
M$320 \$622 \$53 VDD VDD pfet_03v3 L=0.28U W=0.72U AS=0.3168P AD=0.2097P
+ PS=2.32U PD=1.38U
M$321 VDD \$623 \$624 VDD pfet_03v3 L=0.28U W=0.36U AS=0.1584P AD=0.1764P
+ PS=1.6U PD=1.26U
M$322 \$625 \$623 VDD VDD pfet_03v3 L=0.28U W=0.72U AS=0.1764P AD=0.36P
+ PS=1.26U PD=2.44U
M$323 \$626 RB14 VDD VDD pfet_03v3 L=0.28U W=0.72U AS=0.3312P AD=0.3888P
+ PS=2.36U PD=2.52U
M$324 \$625 \$626 \$375 VDD pfet_03v3 L=0.28U W=0.36U AS=0.1584P AD=0.1152P
+ PS=1.6U PD=1U
M$325 \$376 \$627 \$625 VDD pfet_03v3 L=0.28U W=0.36U AS=0.1152P AD=0.1584P
+ PS=1U PD=1.6U
M$326 VDD RA14 \$627 VDD pfet_03v3 L=0.28U W=0.72U AS=0.3708P AD=0.3168P
+ PS=2.47U PD=2.32U
M$327 \$629 \$601 \$628 VDD pfet_03v3 L=0.28U W=0.36U AS=0.2097P AD=0.1278P
+ PS=1.38U PD=1.07U
M$328 \$737 \$630 \$629 VDD pfet_03v3 L=0.28U W=0.36U AS=0.1278P AD=0.0567P
+ PS=1.07U PD=0.675U
M$329 VDD \$600 \$737 VDD pfet_03v3 L=0.28U W=0.36U AS=0.0567P AD=0.1584P
+ PS=0.675U PD=1.6U
M$330 \$628 \$56 VDD VDD pfet_03v3 L=0.28U W=0.72U AS=0.3168P AD=0.2097P
+ PS=2.32U PD=1.38U
M$331 VDD \$629 \$630 VDD pfet_03v3 L=0.28U W=0.36U AS=0.1584P AD=0.1764P
+ PS=1.6U PD=1.26U
M$332 \$631 \$629 VDD VDD pfet_03v3 L=0.28U W=0.72U AS=0.1764P AD=0.36P
+ PS=1.26U PD=2.44U
M$333 \$632 RB14 VDD VDD pfet_03v3 L=0.28U W=0.72U AS=0.3312P AD=0.3888P
+ PS=2.36U PD=2.52U
M$334 \$631 \$632 \$380 VDD pfet_03v3 L=0.28U W=0.36U AS=0.1584P AD=0.1152P
+ PS=1.6U PD=1U
M$335 \$381 \$633 \$631 VDD pfet_03v3 L=0.28U W=0.36U AS=0.1152P AD=0.1584P
+ PS=1U PD=1.6U
M$336 VDD RA14 \$633 VDD pfet_03v3 L=0.28U W=0.72U AS=0.3708P AD=0.3168P
+ PS=2.47U PD=2.32U
M$337 \$635 \$601 \$634 VDD pfet_03v3 L=0.28U W=0.36U AS=0.2097P AD=0.1278P
+ PS=1.38U PD=1.07U
M$338 \$743 \$636 \$635 VDD pfet_03v3 L=0.28U W=0.36U AS=0.1278P AD=0.0567P
+ PS=1.07U PD=0.675U
M$339 VDD \$600 \$743 VDD pfet_03v3 L=0.28U W=0.36U AS=0.0567P AD=0.1584P
+ PS=0.675U PD=1.6U
M$340 \$634 \$59 VDD VDD pfet_03v3 L=0.28U W=0.72U AS=0.3168P AD=0.2097P
+ PS=2.32U PD=1.38U
M$341 VDD \$635 \$636 VDD pfet_03v3 L=0.28U W=0.36U AS=0.1584P AD=0.1764P
+ PS=1.6U PD=1.26U
M$342 \$637 \$635 VDD VDD pfet_03v3 L=0.28U W=0.72U AS=0.1764P AD=0.36P
+ PS=1.26U PD=2.44U
M$343 \$638 RB14 VDD VDD pfet_03v3 L=0.28U W=0.72U AS=0.3312P AD=0.3888P
+ PS=2.36U PD=2.52U
M$344 \$637 \$638 \$385 VDD pfet_03v3 L=0.28U W=0.36U AS=0.1584P AD=0.1152P
+ PS=1.6U PD=1U
M$345 \$386 \$639 \$637 VDD pfet_03v3 L=0.28U W=0.36U AS=0.1152P AD=0.1584P
+ PS=1U PD=1.6U
M$346 VDD RA14 \$639 VDD pfet_03v3 L=0.28U W=0.72U AS=0.3708P AD=0.3168P
+ PS=2.47U PD=2.32U
M$347 \$641 \$601 \$640 VDD pfet_03v3 L=0.28U W=0.36U AS=0.2097P AD=0.1278P
+ PS=1.38U PD=1.07U
M$348 \$750 \$642 \$641 VDD pfet_03v3 L=0.28U W=0.36U AS=0.1278P AD=0.0567P
+ PS=1.07U PD=0.675U
M$349 VDD \$600 \$750 VDD pfet_03v3 L=0.28U W=0.36U AS=0.0567P AD=0.1584P
+ PS=0.675U PD=1.6U
M$350 \$640 \$62 VDD VDD pfet_03v3 L=0.28U W=0.72U AS=0.3168P AD=0.2097P
+ PS=2.32U PD=1.38U
M$351 VDD \$641 \$642 VDD pfet_03v3 L=0.28U W=0.36U AS=0.1584P AD=0.1764P
+ PS=1.6U PD=1.26U
M$352 \$643 \$641 VDD VDD pfet_03v3 L=0.28U W=0.72U AS=0.1764P AD=0.36P
+ PS=1.26U PD=2.44U
M$353 \$644 RB14 VDD VDD pfet_03v3 L=0.28U W=0.72U AS=0.3312P AD=0.3888P
+ PS=2.36U PD=2.52U
M$354 \$643 \$644 \$390 VDD pfet_03v3 L=0.28U W=0.36U AS=0.1584P AD=0.1152P
+ PS=1.6U PD=1U
M$355 \$391 \$645 \$643 VDD pfet_03v3 L=0.28U W=0.36U AS=0.1152P AD=0.1584P
+ PS=1U PD=1.6U
M$356 VDD RA14 \$645 VDD pfet_03v3 L=0.28U W=0.72U AS=0.3708P AD=0.3168P
+ PS=2.47U PD=2.32U
M$357 \$647 \$601 \$646 VDD pfet_03v3 L=0.28U W=0.36U AS=0.2097P AD=0.1278P
+ PS=1.38U PD=1.07U
M$358 \$759 \$648 \$647 VDD pfet_03v3 L=0.28U W=0.36U AS=0.1278P AD=0.0567P
+ PS=1.07U PD=0.675U
M$359 VDD \$600 \$759 VDD pfet_03v3 L=0.28U W=0.36U AS=0.0567P AD=0.1584P
+ PS=0.675U PD=1.6U
M$360 \$646 \$65 VDD VDD pfet_03v3 L=0.28U W=0.72U AS=0.3168P AD=0.2097P
+ PS=2.32U PD=1.38U
M$361 VDD \$647 \$648 VDD pfet_03v3 L=0.28U W=0.36U AS=0.1584P AD=0.1764P
+ PS=1.6U PD=1.26U
M$362 \$649 \$647 VDD VDD pfet_03v3 L=0.28U W=0.72U AS=0.1764P AD=0.36P
+ PS=1.26U PD=2.44U
M$363 \$650 RB14 VDD VDD pfet_03v3 L=0.28U W=0.72U AS=0.3312P AD=0.3888P
+ PS=2.36U PD=2.52U
M$364 \$649 \$650 \$395 VDD pfet_03v3 L=0.28U W=0.36U AS=0.1584P AD=0.1152P
+ PS=1.6U PD=1U
M$365 \$396 \$651 \$649 VDD pfet_03v3 L=0.28U W=0.36U AS=0.1152P AD=0.1584P
+ PS=1U PD=1.6U
M$366 VDD RA14 \$651 VDD pfet_03v3 L=0.28U W=0.72U AS=0.3708P AD=0.3168P
+ PS=2.47U PD=2.32U
M$367 \$653 \$601 \$652 VDD pfet_03v3 L=0.28U W=0.36U AS=0.2097P AD=0.1278P
+ PS=1.38U PD=1.07U
M$368 \$765 \$654 \$653 VDD pfet_03v3 L=0.28U W=0.36U AS=0.1278P AD=0.0567P
+ PS=1.07U PD=0.675U
M$369 VDD \$600 \$765 VDD pfet_03v3 L=0.28U W=0.36U AS=0.0567P AD=0.1584P
+ PS=0.675U PD=1.6U
M$370 \$652 \$68 VDD VDD pfet_03v3 L=0.28U W=0.72U AS=0.3168P AD=0.2097P
+ PS=2.32U PD=1.38U
M$371 VDD \$653 \$654 VDD pfet_03v3 L=0.28U W=0.36U AS=0.1584P AD=0.1764P
+ PS=1.6U PD=1.26U
M$372 \$655 \$653 VDD VDD pfet_03v3 L=0.28U W=0.72U AS=0.1764P AD=0.36P
+ PS=1.26U PD=2.44U
M$373 \$656 RB14 VDD VDD pfet_03v3 L=0.28U W=0.72U AS=0.3312P AD=0.3888P
+ PS=2.36U PD=2.52U
M$374 \$655 \$656 \$400 VDD pfet_03v3 L=0.28U W=0.36U AS=0.1584P AD=0.1152P
+ PS=1.6U PD=1U
M$375 \$401 \$657 \$655 VDD pfet_03v3 L=0.28U W=0.36U AS=0.1152P AD=0.1584P
+ PS=1U PD=1.6U
M$376 VDD RA14 \$657 VDD pfet_03v3 L=0.28U W=0.72U AS=0.3708P AD=0.3168P
+ PS=2.47U PD=2.32U
M$377 \$659 \$601 \$658 VDD pfet_03v3 L=0.28U W=0.36U AS=0.2097P AD=0.1278P
+ PS=1.38U PD=1.07U
M$378 \$772 \$660 \$659 VDD pfet_03v3 L=0.28U W=0.36U AS=0.1278P AD=0.0567P
+ PS=1.07U PD=0.675U
M$379 VDD \$600 \$772 VDD pfet_03v3 L=0.28U W=0.36U AS=0.0567P AD=0.1584P
+ PS=0.675U PD=1.6U
M$380 \$658 \$71 VDD VDD pfet_03v3 L=0.28U W=0.72U AS=0.3168P AD=0.2097P
+ PS=2.32U PD=1.38U
M$381 VDD \$659 \$660 VDD pfet_03v3 L=0.28U W=0.36U AS=0.1584P AD=0.1764P
+ PS=1.6U PD=1.26U
M$382 \$661 \$659 VDD VDD pfet_03v3 L=0.28U W=0.72U AS=0.1764P AD=0.36P
+ PS=1.26U PD=2.44U
M$383 \$662 RB14 VDD VDD pfet_03v3 L=0.28U W=0.72U AS=0.3312P AD=0.3888P
+ PS=2.36U PD=2.52U
M$384 \$661 \$662 \$405 VDD pfet_03v3 L=0.28U W=0.36U AS=0.1584P AD=0.1152P
+ PS=1.6U PD=1U
M$385 \$406 \$663 \$661 VDD pfet_03v3 L=0.28U W=0.36U AS=0.1152P AD=0.1584P
+ PS=1U PD=1.6U
M$386 VDD RA14 \$663 VDD pfet_03v3 L=0.28U W=0.72U AS=0.3708P AD=0.3168P
+ PS=2.47U PD=2.32U
M$387 \$665 \$601 \$664 VDD pfet_03v3 L=0.28U W=0.36U AS=0.2097P AD=0.1278P
+ PS=1.38U PD=1.07U
M$388 \$780 \$666 \$665 VDD pfet_03v3 L=0.28U W=0.36U AS=0.1278P AD=0.0567P
+ PS=1.07U PD=0.675U
M$389 VDD \$600 \$780 VDD pfet_03v3 L=0.28U W=0.36U AS=0.0567P AD=0.1584P
+ PS=0.675U PD=1.6U
M$390 \$664 \$74 VDD VDD pfet_03v3 L=0.28U W=0.72U AS=0.3168P AD=0.2097P
+ PS=2.32U PD=1.38U
M$391 VDD \$665 \$666 VDD pfet_03v3 L=0.28U W=0.36U AS=0.1584P AD=0.1764P
+ PS=1.6U PD=1.26U
M$392 \$667 \$665 VDD VDD pfet_03v3 L=0.28U W=0.72U AS=0.1764P AD=0.36P
+ PS=1.26U PD=2.44U
M$393 \$668 RB14 VDD VDD pfet_03v3 L=0.28U W=0.72U AS=0.3312P AD=0.3888P
+ PS=2.36U PD=2.52U
M$394 \$667 \$668 \$410 VDD pfet_03v3 L=0.28U W=0.36U AS=0.1584P AD=0.1152P
+ PS=1.6U PD=1U
M$395 \$411 \$669 \$667 VDD pfet_03v3 L=0.28U W=0.36U AS=0.1152P AD=0.1584P
+ PS=1U PD=1.6U
M$396 VDD RA14 \$669 VDD pfet_03v3 L=0.28U W=0.72U AS=0.3708P AD=0.3168P
+ PS=2.47U PD=2.32U
M$397 \$671 \$601 \$670 VDD pfet_03v3 L=0.28U W=0.36U AS=0.2097P AD=0.1278P
+ PS=1.38U PD=1.07U
M$398 \$788 \$672 \$671 VDD pfet_03v3 L=0.28U W=0.36U AS=0.1278P AD=0.0567P
+ PS=1.07U PD=0.675U
M$399 VDD \$600 \$788 VDD pfet_03v3 L=0.28U W=0.36U AS=0.0567P AD=0.1584P
+ PS=0.675U PD=1.6U
M$400 \$670 \$77 VDD VDD pfet_03v3 L=0.28U W=0.72U AS=0.3168P AD=0.2097P
+ PS=2.32U PD=1.38U
M$401 VDD \$671 \$672 VDD pfet_03v3 L=0.28U W=0.36U AS=0.1584P AD=0.1764P
+ PS=1.6U PD=1.26U
M$402 \$673 \$671 VDD VDD pfet_03v3 L=0.28U W=0.72U AS=0.1764P AD=0.36P
+ PS=1.26U PD=2.44U
M$403 \$674 RB14 VDD VDD pfet_03v3 L=0.28U W=0.72U AS=0.3312P AD=0.3888P
+ PS=2.36U PD=2.52U
M$404 \$673 \$674 \$415 VDD pfet_03v3 L=0.28U W=0.36U AS=0.1584P AD=0.1152P
+ PS=1.6U PD=1U
M$405 \$416 \$675 \$673 VDD pfet_03v3 L=0.28U W=0.36U AS=0.1152P AD=0.1584P
+ PS=1U PD=1.6U
M$406 VDD RA14 \$675 VDD pfet_03v3 L=0.28U W=0.72U AS=0.3708P AD=0.3168P
+ PS=2.47U PD=2.32U
M$407 \$677 \$601 \$676 VDD pfet_03v3 L=0.28U W=0.36U AS=0.2097P AD=0.1278P
+ PS=1.38U PD=1.07U
M$408 \$795 \$678 \$677 VDD pfet_03v3 L=0.28U W=0.36U AS=0.1278P AD=0.0567P
+ PS=1.07U PD=0.675U
M$409 VDD \$600 \$795 VDD pfet_03v3 L=0.28U W=0.36U AS=0.0567P AD=0.1584P
+ PS=0.675U PD=1.6U
M$410 \$676 \$80 VDD VDD pfet_03v3 L=0.28U W=0.72U AS=0.3168P AD=0.2097P
+ PS=2.32U PD=1.38U
M$411 VDD \$677 \$678 VDD pfet_03v3 L=0.28U W=0.36U AS=0.1584P AD=0.1764P
+ PS=1.6U PD=1.26U
M$412 \$679 \$677 VDD VDD pfet_03v3 L=0.28U W=0.72U AS=0.1764P AD=0.36P
+ PS=1.26U PD=2.44U
M$413 \$680 RB14 VDD VDD pfet_03v3 L=0.28U W=0.72U AS=0.3312P AD=0.3888P
+ PS=2.36U PD=2.52U
M$414 \$679 \$680 \$420 VDD pfet_03v3 L=0.28U W=0.36U AS=0.1584P AD=0.1152P
+ PS=1.6U PD=1U
M$415 \$421 \$681 \$679 VDD pfet_03v3 L=0.28U W=0.36U AS=0.1152P AD=0.1584P
+ PS=1U PD=1.6U
M$416 VDD RA14 \$681 VDD pfet_03v3 L=0.28U W=0.72U AS=0.3708P AD=0.3168P
+ PS=2.47U PD=2.32U
M$417 \$683 \$601 \$682 VDD pfet_03v3 L=0.28U W=0.36U AS=0.2097P AD=0.1278P
+ PS=1.38U PD=1.07U
M$418 \$794 \$684 \$683 VDD pfet_03v3 L=0.28U W=0.36U AS=0.1278P AD=0.0567P
+ PS=1.07U PD=0.675U
M$419 VDD \$600 \$794 VDD pfet_03v3 L=0.28U W=0.36U AS=0.0567P AD=0.1584P
+ PS=0.675U PD=1.6U
M$420 \$682 \$83 VDD VDD pfet_03v3 L=0.28U W=0.72U AS=0.3168P AD=0.2097P
+ PS=2.32U PD=1.38U
M$421 VDD \$683 \$684 VDD pfet_03v3 L=0.28U W=0.36U AS=0.1584P AD=0.1764P
+ PS=1.6U PD=1.26U
M$422 \$685 \$683 VDD VDD pfet_03v3 L=0.28U W=0.72U AS=0.1764P AD=0.36P
+ PS=1.26U PD=2.44U
M$423 \$686 RB14 VDD VDD pfet_03v3 L=0.28U W=0.72U AS=0.3312P AD=0.3888P
+ PS=2.36U PD=2.52U
M$424 \$685 \$686 \$425 VDD pfet_03v3 L=0.28U W=0.36U AS=0.1584P AD=0.1152P
+ PS=1.6U PD=1U
M$425 \$426 \$687 \$685 VDD pfet_03v3 L=0.28U W=0.36U AS=0.1152P AD=0.1584P
+ PS=1U PD=1.6U
M$426 VDD RA14 \$687 VDD pfet_03v3 L=0.28U W=0.72U AS=0.3708P AD=0.3168P
+ PS=2.47U PD=2.32U
M$427 \$689 \$601 \$688 VDD pfet_03v3 L=0.28U W=0.36U AS=0.2097P AD=0.1278P
+ PS=1.38U PD=1.07U
M$428 \$761 \$690 \$689 VDD pfet_03v3 L=0.28U W=0.36U AS=0.1278P AD=0.0567P
+ PS=1.07U PD=0.675U
M$429 VDD \$600 \$761 VDD pfet_03v3 L=0.28U W=0.36U AS=0.0567P AD=0.1584P
+ PS=0.675U PD=1.6U
M$430 \$688 \$86 VDD VDD pfet_03v3 L=0.28U W=0.72U AS=0.3168P AD=0.2097P
+ PS=2.32U PD=1.38U
M$431 VDD \$689 \$690 VDD pfet_03v3 L=0.28U W=0.36U AS=0.1584P AD=0.1764P
+ PS=1.6U PD=1.26U
M$432 \$691 \$689 VDD VDD pfet_03v3 L=0.28U W=0.72U AS=0.1764P AD=0.36P
+ PS=1.26U PD=2.44U
M$433 \$692 RB14 VDD VDD pfet_03v3 L=0.28U W=0.72U AS=0.3312P AD=0.3888P
+ PS=2.36U PD=2.52U
M$434 \$691 \$692 \$430 VDD pfet_03v3 L=0.28U W=0.36U AS=0.1584P AD=0.1152P
+ PS=1.6U PD=1U
M$435 \$431 \$693 \$691 VDD pfet_03v3 L=0.28U W=0.36U AS=0.1152P AD=0.1584P
+ PS=1U PD=1.6U
M$436 VDD RA14 \$693 VDD pfet_03v3 L=0.28U W=0.72U AS=0.3708P AD=0.3168P
+ PS=2.47U PD=2.32U
M$437 \$695 \$601 \$694 VDD pfet_03v3 L=0.28U W=0.36U AS=0.2097P AD=0.1278P
+ PS=1.38U PD=1.07U
M$438 \$729 \$696 \$695 VDD pfet_03v3 L=0.28U W=0.36U AS=0.1278P AD=0.0567P
+ PS=1.07U PD=0.675U
M$439 VDD \$600 \$729 VDD pfet_03v3 L=0.28U W=0.36U AS=0.0567P AD=0.1584P
+ PS=0.675U PD=1.6U
M$440 \$694 \$89 VDD VDD pfet_03v3 L=0.28U W=0.72U AS=0.3168P AD=0.2097P
+ PS=2.32U PD=1.38U
M$441 VDD \$695 \$696 VDD pfet_03v3 L=0.28U W=0.36U AS=0.1584P AD=0.1764P
+ PS=1.6U PD=1.26U
M$442 \$697 \$695 VDD VDD pfet_03v3 L=0.28U W=0.72U AS=0.1764P AD=0.36P
+ PS=1.26U PD=2.44U
M$443 \$698 RB14 VDD VDD pfet_03v3 L=0.28U W=0.72U AS=0.3312P AD=0.3888P
+ PS=2.36U PD=2.52U
M$444 \$697 \$698 \$435 VDD pfet_03v3 L=0.28U W=0.36U AS=0.1584P AD=0.1152P
+ PS=1.6U PD=1U
M$445 \$436 \$699 \$697 VDD pfet_03v3 L=0.28U W=0.36U AS=0.1152P AD=0.1584P
+ PS=1U PD=1.6U
M$446 VDD RA14 \$699 VDD pfet_03v3 L=0.28U W=0.72U AS=0.3708P AD=0.3168P
+ PS=2.47U PD=2.32U
M$447 \$901 WE13 VDD VDD pfet_03v3 L=0.28U W=0.72U AS=0.3168P AD=0.1872P
+ PS=2.32U PD=1.24U
M$448 VDD CLK \$901 VDD pfet_03v3 L=0.28U W=0.72U AS=0.1872P AD=0.3168P
+ PS=1.24U PD=2.32U
M$449 \$902 \$901 VDD VDD pfet_03v3 L=0.28U W=2.54U AS=0.8974P AD=0.6604P
+ PS=5.28U PD=3.58U
M$451 \$903 \$902 VDD VDD pfet_03v3 L=0.28U W=2.68U AS=0.7272P AD=0.9782P
+ PS=3.78U PD=5.48U
M$453 \$904 \$44 VDD VDD pfet_03v3 L=0.28U W=0.72U AS=0.3168P AD=0.2097P
+ PS=2.32U PD=1.38U
M$454 \$905 \$903 \$904 VDD pfet_03v3 L=0.28U W=0.36U AS=0.2097P AD=0.1278P
+ PS=1.38U PD=1.07U
M$455 \$1117 \$906 \$905 VDD pfet_03v3 L=0.28U W=0.36U AS=0.1278P AD=0.0567P
+ PS=1.07U PD=0.675U
M$456 VDD \$902 \$1117 VDD pfet_03v3 L=0.28U W=0.36U AS=0.0567P AD=0.1584P
+ PS=0.675U PD=1.6U
M$457 \$906 \$905 VDD VDD pfet_03v3 L=0.28U W=0.36U AS=0.1764P AD=0.1584P
+ PS=1.26U PD=1.6U
M$458 \$907 \$905 VDD VDD pfet_03v3 L=0.28U W=0.72U AS=0.1764P AD=0.36P
+ PS=1.26U PD=2.44U
M$459 \$1024 RA13 VDD VDD pfet_03v3 L=0.28U W=0.72U AS=0.3312P AD=0.3888P
+ PS=2.36U PD=2.52U
M$460 \$907 \$1024 \$360 VDD pfet_03v3 L=0.28U W=0.36U AS=0.1584P AD=0.1152P
+ PS=1.6U PD=1U
M$461 \$361 \$1025 \$907 VDD pfet_03v3 L=0.28U W=0.36U AS=0.1152P AD=0.1584P
+ PS=1U PD=1.6U
M$462 VDD RB13 \$1025 VDD pfet_03v3 L=0.28U W=0.72U AS=0.3708P AD=0.3168P
+ PS=2.47U PD=2.32U
M$463 \$908 \$47 VDD VDD pfet_03v3 L=0.28U W=0.72U AS=0.3168P AD=0.2097P
+ PS=2.32U PD=1.38U
M$464 \$909 \$903 \$908 VDD pfet_03v3 L=0.28U W=0.36U AS=0.2097P AD=0.1278P
+ PS=1.38U PD=1.07U
M$465 \$1127 \$910 \$909 VDD pfet_03v3 L=0.28U W=0.36U AS=0.1278P AD=0.0567P
+ PS=1.07U PD=0.675U
M$466 VDD \$902 \$1127 VDD pfet_03v3 L=0.28U W=0.36U AS=0.0567P AD=0.1584P
+ PS=0.675U PD=1.6U
M$467 \$910 \$909 VDD VDD pfet_03v3 L=0.28U W=0.36U AS=0.1764P AD=0.1584P
+ PS=1.26U PD=1.6U
M$468 \$911 \$909 VDD VDD pfet_03v3 L=0.28U W=0.72U AS=0.1764P AD=0.36P
+ PS=1.26U PD=2.44U
M$469 \$1026 RA13 VDD VDD pfet_03v3 L=0.28U W=0.72U AS=0.3312P AD=0.3888P
+ PS=2.36U PD=2.52U
M$470 \$911 \$1026 \$365 VDD pfet_03v3 L=0.28U W=0.36U AS=0.1584P AD=0.1152P
+ PS=1.6U PD=1U
M$471 \$366 \$1027 \$911 VDD pfet_03v3 L=0.28U W=0.36U AS=0.1152P AD=0.1584P
+ PS=1U PD=1.6U
M$472 VDD RB13 \$1027 VDD pfet_03v3 L=0.28U W=0.72U AS=0.3708P AD=0.3168P
+ PS=2.47U PD=2.32U
M$473 \$912 \$50 VDD VDD pfet_03v3 L=0.28U W=0.72U AS=0.3168P AD=0.2097P
+ PS=2.32U PD=1.38U
M$474 \$913 \$903 \$912 VDD pfet_03v3 L=0.28U W=0.36U AS=0.2097P AD=0.1278P
+ PS=1.38U PD=1.07U
M$475 \$1133 \$914 \$913 VDD pfet_03v3 L=0.28U W=0.36U AS=0.1278P AD=0.0567P
+ PS=1.07U PD=0.675U
M$476 VDD \$902 \$1133 VDD pfet_03v3 L=0.28U W=0.36U AS=0.0567P AD=0.1584P
+ PS=0.675U PD=1.6U
M$477 \$914 \$913 VDD VDD pfet_03v3 L=0.28U W=0.36U AS=0.1764P AD=0.1584P
+ PS=1.26U PD=1.6U
M$478 \$915 \$913 VDD VDD pfet_03v3 L=0.28U W=0.72U AS=0.1764P AD=0.36P
+ PS=1.26U PD=2.44U
M$479 \$1028 RA13 VDD VDD pfet_03v3 L=0.28U W=0.72U AS=0.3312P AD=0.3888P
+ PS=2.36U PD=2.52U
M$480 \$915 \$1028 \$370 VDD pfet_03v3 L=0.28U W=0.36U AS=0.1584P AD=0.1152P
+ PS=1.6U PD=1U
M$481 \$371 \$1029 \$915 VDD pfet_03v3 L=0.28U W=0.36U AS=0.1152P AD=0.1584P
+ PS=1U PD=1.6U
M$482 VDD RB13 \$1029 VDD pfet_03v3 L=0.28U W=0.72U AS=0.3708P AD=0.3168P
+ PS=2.47U PD=2.32U
M$483 \$916 \$53 VDD VDD pfet_03v3 L=0.28U W=0.72U AS=0.3168P AD=0.2097P
+ PS=2.32U PD=1.38U
M$484 \$917 \$903 \$916 VDD pfet_03v3 L=0.28U W=0.36U AS=0.2097P AD=0.1278P
+ PS=1.38U PD=1.07U
M$485 \$1143 \$918 \$917 VDD pfet_03v3 L=0.28U W=0.36U AS=0.1278P AD=0.0567P
+ PS=1.07U PD=0.675U
M$486 VDD \$902 \$1143 VDD pfet_03v3 L=0.28U W=0.36U AS=0.0567P AD=0.1584P
+ PS=0.675U PD=1.6U
M$487 \$918 \$917 VDD VDD pfet_03v3 L=0.28U W=0.36U AS=0.1764P AD=0.1584P
+ PS=1.26U PD=1.6U
M$488 \$919 \$917 VDD VDD pfet_03v3 L=0.28U W=0.72U AS=0.1764P AD=0.36P
+ PS=1.26U PD=2.44U
M$489 \$1030 RA13 VDD VDD pfet_03v3 L=0.28U W=0.72U AS=0.3312P AD=0.3888P
+ PS=2.36U PD=2.52U
M$490 \$919 \$1030 \$375 VDD pfet_03v3 L=0.28U W=0.36U AS=0.1584P AD=0.1152P
+ PS=1.6U PD=1U
M$491 \$376 \$1031 \$919 VDD pfet_03v3 L=0.28U W=0.36U AS=0.1152P AD=0.1584P
+ PS=1U PD=1.6U
M$492 VDD RB13 \$1031 VDD pfet_03v3 L=0.28U W=0.72U AS=0.3708P AD=0.3168P
+ PS=2.47U PD=2.32U
M$493 \$920 \$56 VDD VDD pfet_03v3 L=0.28U W=0.72U AS=0.3168P AD=0.2097P
+ PS=2.32U PD=1.38U
M$494 \$921 \$903 \$920 VDD pfet_03v3 L=0.28U W=0.36U AS=0.2097P AD=0.1278P
+ PS=1.38U PD=1.07U
M$495 \$1152 \$922 \$921 VDD pfet_03v3 L=0.28U W=0.36U AS=0.1278P AD=0.0567P
+ PS=1.07U PD=0.675U
M$496 VDD \$902 \$1152 VDD pfet_03v3 L=0.28U W=0.36U AS=0.0567P AD=0.1584P
+ PS=0.675U PD=1.6U
M$497 \$922 \$921 VDD VDD pfet_03v3 L=0.28U W=0.36U AS=0.1764P AD=0.1584P
+ PS=1.26U PD=1.6U
M$498 \$923 \$921 VDD VDD pfet_03v3 L=0.28U W=0.72U AS=0.1764P AD=0.36P
+ PS=1.26U PD=2.44U
M$499 \$1032 RA13 VDD VDD pfet_03v3 L=0.28U W=0.72U AS=0.3312P AD=0.3888P
+ PS=2.36U PD=2.52U
M$500 \$923 \$1032 \$380 VDD pfet_03v3 L=0.28U W=0.36U AS=0.1584P AD=0.1152P
+ PS=1.6U PD=1U
M$501 \$381 \$1033 \$923 VDD pfet_03v3 L=0.28U W=0.36U AS=0.1152P AD=0.1584P
+ PS=1U PD=1.6U
M$502 VDD RB13 \$1033 VDD pfet_03v3 L=0.28U W=0.72U AS=0.3708P AD=0.3168P
+ PS=2.47U PD=2.32U
M$503 \$924 \$59 VDD VDD pfet_03v3 L=0.28U W=0.72U AS=0.3168P AD=0.2097P
+ PS=2.32U PD=1.38U
M$504 \$925 \$903 \$924 VDD pfet_03v3 L=0.28U W=0.36U AS=0.2097P AD=0.1278P
+ PS=1.38U PD=1.07U
M$505 \$1161 \$926 \$925 VDD pfet_03v3 L=0.28U W=0.36U AS=0.1278P AD=0.0567P
+ PS=1.07U PD=0.675U
M$506 VDD \$902 \$1161 VDD pfet_03v3 L=0.28U W=0.36U AS=0.0567P AD=0.1584P
+ PS=0.675U PD=1.6U
M$507 \$926 \$925 VDD VDD pfet_03v3 L=0.28U W=0.36U AS=0.1764P AD=0.1584P
+ PS=1.26U PD=1.6U
M$508 \$927 \$925 VDD VDD pfet_03v3 L=0.28U W=0.72U AS=0.1764P AD=0.36P
+ PS=1.26U PD=2.44U
M$509 \$1034 RA13 VDD VDD pfet_03v3 L=0.28U W=0.72U AS=0.3312P AD=0.3888P
+ PS=2.36U PD=2.52U
M$510 \$927 \$1034 \$385 VDD pfet_03v3 L=0.28U W=0.36U AS=0.1584P AD=0.1152P
+ PS=1.6U PD=1U
M$511 \$386 \$1035 \$927 VDD pfet_03v3 L=0.28U W=0.36U AS=0.1152P AD=0.1584P
+ PS=1U PD=1.6U
M$512 VDD RB13 \$1035 VDD pfet_03v3 L=0.28U W=0.72U AS=0.3708P AD=0.3168P
+ PS=2.47U PD=2.32U
M$513 \$928 \$62 VDD VDD pfet_03v3 L=0.28U W=0.72U AS=0.3168P AD=0.2097P
+ PS=2.32U PD=1.38U
M$514 \$929 \$903 \$928 VDD pfet_03v3 L=0.28U W=0.36U AS=0.2097P AD=0.1278P
+ PS=1.38U PD=1.07U
M$515 \$1169 \$930 \$929 VDD pfet_03v3 L=0.28U W=0.36U AS=0.1278P AD=0.0567P
+ PS=1.07U PD=0.675U
M$516 VDD \$902 \$1169 VDD pfet_03v3 L=0.28U W=0.36U AS=0.0567P AD=0.1584P
+ PS=0.675U PD=1.6U
M$517 \$930 \$929 VDD VDD pfet_03v3 L=0.28U W=0.36U AS=0.1764P AD=0.1584P
+ PS=1.26U PD=1.6U
M$518 \$931 \$929 VDD VDD pfet_03v3 L=0.28U W=0.72U AS=0.1764P AD=0.36P
+ PS=1.26U PD=2.44U
M$519 \$1036 RA13 VDD VDD pfet_03v3 L=0.28U W=0.72U AS=0.3312P AD=0.3888P
+ PS=2.36U PD=2.52U
M$520 \$931 \$1036 \$390 VDD pfet_03v3 L=0.28U W=0.36U AS=0.1584P AD=0.1152P
+ PS=1.6U PD=1U
M$521 \$391 \$1037 \$931 VDD pfet_03v3 L=0.28U W=0.36U AS=0.1152P AD=0.1584P
+ PS=1U PD=1.6U
M$522 VDD RB13 \$1037 VDD pfet_03v3 L=0.28U W=0.72U AS=0.3708P AD=0.3168P
+ PS=2.47U PD=2.32U
M$523 \$932 \$65 VDD VDD pfet_03v3 L=0.28U W=0.72U AS=0.3168P AD=0.2097P
+ PS=2.32U PD=1.38U
M$524 \$933 \$903 \$932 VDD pfet_03v3 L=0.28U W=0.36U AS=0.2097P AD=0.1278P
+ PS=1.38U PD=1.07U
M$525 \$1178 \$934 \$933 VDD pfet_03v3 L=0.28U W=0.36U AS=0.1278P AD=0.0567P
+ PS=1.07U PD=0.675U
M$526 VDD \$902 \$1178 VDD pfet_03v3 L=0.28U W=0.36U AS=0.0567P AD=0.1584P
+ PS=0.675U PD=1.6U
M$527 \$934 \$933 VDD VDD pfet_03v3 L=0.28U W=0.36U AS=0.1764P AD=0.1584P
+ PS=1.26U PD=1.6U
M$528 \$935 \$933 VDD VDD pfet_03v3 L=0.28U W=0.72U AS=0.1764P AD=0.36P
+ PS=1.26U PD=2.44U
M$529 \$1038 RA13 VDD VDD pfet_03v3 L=0.28U W=0.72U AS=0.3312P AD=0.3888P
+ PS=2.36U PD=2.52U
M$530 \$935 \$1038 \$395 VDD pfet_03v3 L=0.28U W=0.36U AS=0.1584P AD=0.1152P
+ PS=1.6U PD=1U
M$531 \$396 \$1039 \$935 VDD pfet_03v3 L=0.28U W=0.36U AS=0.1152P AD=0.1584P
+ PS=1U PD=1.6U
M$532 VDD RB13 \$1039 VDD pfet_03v3 L=0.28U W=0.72U AS=0.3708P AD=0.3168P
+ PS=2.47U PD=2.32U
M$533 \$936 \$68 VDD VDD pfet_03v3 L=0.28U W=0.72U AS=0.3168P AD=0.2097P
+ PS=2.32U PD=1.38U
M$534 \$937 \$903 \$936 VDD pfet_03v3 L=0.28U W=0.36U AS=0.2097P AD=0.1278P
+ PS=1.38U PD=1.07U
M$535 \$1187 \$938 \$937 VDD pfet_03v3 L=0.28U W=0.36U AS=0.1278P AD=0.0567P
+ PS=1.07U PD=0.675U
M$536 VDD \$902 \$1187 VDD pfet_03v3 L=0.28U W=0.36U AS=0.0567P AD=0.1584P
+ PS=0.675U PD=1.6U
M$537 \$938 \$937 VDD VDD pfet_03v3 L=0.28U W=0.36U AS=0.1764P AD=0.1584P
+ PS=1.26U PD=1.6U
M$538 \$939 \$937 VDD VDD pfet_03v3 L=0.28U W=0.72U AS=0.1764P AD=0.36P
+ PS=1.26U PD=2.44U
M$539 \$1040 RA13 VDD VDD pfet_03v3 L=0.28U W=0.72U AS=0.3312P AD=0.3888P
+ PS=2.36U PD=2.52U
M$540 \$939 \$1040 \$400 VDD pfet_03v3 L=0.28U W=0.36U AS=0.1584P AD=0.1152P
+ PS=1.6U PD=1U
M$541 \$401 \$1041 \$939 VDD pfet_03v3 L=0.28U W=0.36U AS=0.1152P AD=0.1584P
+ PS=1U PD=1.6U
M$542 VDD RB13 \$1041 VDD pfet_03v3 L=0.28U W=0.72U AS=0.3708P AD=0.3168P
+ PS=2.47U PD=2.32U
M$543 \$940 \$71 VDD VDD pfet_03v3 L=0.28U W=0.72U AS=0.3168P AD=0.2097P
+ PS=2.32U PD=1.38U
M$544 \$941 \$903 \$940 VDD pfet_03v3 L=0.28U W=0.36U AS=0.2097P AD=0.1278P
+ PS=1.38U PD=1.07U
M$545 \$1196 \$942 \$941 VDD pfet_03v3 L=0.28U W=0.36U AS=0.1278P AD=0.0567P
+ PS=1.07U PD=0.675U
M$546 VDD \$902 \$1196 VDD pfet_03v3 L=0.28U W=0.36U AS=0.0567P AD=0.1584P
+ PS=0.675U PD=1.6U
M$547 \$942 \$941 VDD VDD pfet_03v3 L=0.28U W=0.36U AS=0.1764P AD=0.1584P
+ PS=1.26U PD=1.6U
M$548 \$943 \$941 VDD VDD pfet_03v3 L=0.28U W=0.72U AS=0.1764P AD=0.36P
+ PS=1.26U PD=2.44U
M$549 \$1042 RA13 VDD VDD pfet_03v3 L=0.28U W=0.72U AS=0.3312P AD=0.3888P
+ PS=2.36U PD=2.52U
M$550 \$943 \$1042 \$405 VDD pfet_03v3 L=0.28U W=0.36U AS=0.1584P AD=0.1152P
+ PS=1.6U PD=1U
M$551 \$406 \$1043 \$943 VDD pfet_03v3 L=0.28U W=0.36U AS=0.1152P AD=0.1584P
+ PS=1U PD=1.6U
M$552 VDD RB13 \$1043 VDD pfet_03v3 L=0.28U W=0.72U AS=0.3708P AD=0.3168P
+ PS=2.47U PD=2.32U
M$553 \$944 \$74 VDD VDD pfet_03v3 L=0.28U W=0.72U AS=0.3168P AD=0.2097P
+ PS=2.32U PD=1.38U
M$554 \$945 \$903 \$944 VDD pfet_03v3 L=0.28U W=0.36U AS=0.2097P AD=0.1278P
+ PS=1.38U PD=1.07U
M$555 \$1205 \$946 \$945 VDD pfet_03v3 L=0.28U W=0.36U AS=0.1278P AD=0.0567P
+ PS=1.07U PD=0.675U
M$556 VDD \$902 \$1205 VDD pfet_03v3 L=0.28U W=0.36U AS=0.0567P AD=0.1584P
+ PS=0.675U PD=1.6U
M$557 \$946 \$945 VDD VDD pfet_03v3 L=0.28U W=0.36U AS=0.1764P AD=0.1584P
+ PS=1.26U PD=1.6U
M$558 \$947 \$945 VDD VDD pfet_03v3 L=0.28U W=0.72U AS=0.1764P AD=0.36P
+ PS=1.26U PD=2.44U
M$559 \$1044 RA13 VDD VDD pfet_03v3 L=0.28U W=0.72U AS=0.3312P AD=0.3888P
+ PS=2.36U PD=2.52U
M$560 \$947 \$1044 \$410 VDD pfet_03v3 L=0.28U W=0.36U AS=0.1584P AD=0.1152P
+ PS=1.6U PD=1U
M$561 \$411 \$1045 \$947 VDD pfet_03v3 L=0.28U W=0.36U AS=0.1152P AD=0.1584P
+ PS=1U PD=1.6U
M$562 VDD RB13 \$1045 VDD pfet_03v3 L=0.28U W=0.72U AS=0.3708P AD=0.3168P
+ PS=2.47U PD=2.32U
M$563 \$948 \$77 VDD VDD pfet_03v3 L=0.28U W=0.72U AS=0.3168P AD=0.2097P
+ PS=2.32U PD=1.38U
M$564 \$949 \$903 \$948 VDD pfet_03v3 L=0.28U W=0.36U AS=0.2097P AD=0.1278P
+ PS=1.38U PD=1.07U
M$565 \$1213 \$950 \$949 VDD pfet_03v3 L=0.28U W=0.36U AS=0.1278P AD=0.0567P
+ PS=1.07U PD=0.675U
M$566 VDD \$902 \$1213 VDD pfet_03v3 L=0.28U W=0.36U AS=0.0567P AD=0.1584P
+ PS=0.675U PD=1.6U
M$567 \$950 \$949 VDD VDD pfet_03v3 L=0.28U W=0.36U AS=0.1764P AD=0.1584P
+ PS=1.26U PD=1.6U
M$568 \$951 \$949 VDD VDD pfet_03v3 L=0.28U W=0.72U AS=0.1764P AD=0.36P
+ PS=1.26U PD=2.44U
M$569 \$1046 RA13 VDD VDD pfet_03v3 L=0.28U W=0.72U AS=0.3312P AD=0.3888P
+ PS=2.36U PD=2.52U
M$570 \$951 \$1046 \$415 VDD pfet_03v3 L=0.28U W=0.36U AS=0.1584P AD=0.1152P
+ PS=1.6U PD=1U
M$571 \$416 \$1047 \$951 VDD pfet_03v3 L=0.28U W=0.36U AS=0.1152P AD=0.1584P
+ PS=1U PD=1.6U
M$572 VDD RB13 \$1047 VDD pfet_03v3 L=0.28U W=0.72U AS=0.3708P AD=0.3168P
+ PS=2.47U PD=2.32U
M$573 \$952 \$80 VDD VDD pfet_03v3 L=0.28U W=0.72U AS=0.3168P AD=0.2097P
+ PS=2.32U PD=1.38U
M$574 \$953 \$903 \$952 VDD pfet_03v3 L=0.28U W=0.36U AS=0.2097P AD=0.1278P
+ PS=1.38U PD=1.07U
M$575 \$1199 \$954 \$953 VDD pfet_03v3 L=0.28U W=0.36U AS=0.1278P AD=0.0567P
+ PS=1.07U PD=0.675U
M$576 VDD \$902 \$1199 VDD pfet_03v3 L=0.28U W=0.36U AS=0.0567P AD=0.1584P
+ PS=0.675U PD=1.6U
M$577 \$954 \$953 VDD VDD pfet_03v3 L=0.28U W=0.36U AS=0.1764P AD=0.1584P
+ PS=1.26U PD=1.6U
M$578 \$955 \$953 VDD VDD pfet_03v3 L=0.28U W=0.72U AS=0.1764P AD=0.36P
+ PS=1.26U PD=2.44U
M$579 \$1048 RA13 VDD VDD pfet_03v3 L=0.28U W=0.72U AS=0.3312P AD=0.3888P
+ PS=2.36U PD=2.52U
M$580 \$955 \$1048 \$420 VDD pfet_03v3 L=0.28U W=0.36U AS=0.1584P AD=0.1152P
+ PS=1.6U PD=1U
M$581 \$421 \$1049 \$955 VDD pfet_03v3 L=0.28U W=0.36U AS=0.1152P AD=0.1584P
+ PS=1U PD=1.6U
M$582 VDD RB13 \$1049 VDD pfet_03v3 L=0.28U W=0.72U AS=0.3708P AD=0.3168P
+ PS=2.47U PD=2.32U
M$583 \$956 \$83 VDD VDD pfet_03v3 L=0.28U W=0.72U AS=0.3168P AD=0.2097P
+ PS=2.32U PD=1.38U
M$584 \$957 \$903 \$956 VDD pfet_03v3 L=0.28U W=0.36U AS=0.2097P AD=0.1278P
+ PS=1.38U PD=1.07U
M$585 \$1171 \$958 \$957 VDD pfet_03v3 L=0.28U W=0.36U AS=0.1278P AD=0.0567P
+ PS=1.07U PD=0.675U
M$586 VDD \$902 \$1171 VDD pfet_03v3 L=0.28U W=0.36U AS=0.0567P AD=0.1584P
+ PS=0.675U PD=1.6U
M$587 \$958 \$957 VDD VDD pfet_03v3 L=0.28U W=0.36U AS=0.1764P AD=0.1584P
+ PS=1.26U PD=1.6U
M$588 \$959 \$957 VDD VDD pfet_03v3 L=0.28U W=0.72U AS=0.1764P AD=0.36P
+ PS=1.26U PD=2.44U
M$589 \$1050 RA13 VDD VDD pfet_03v3 L=0.28U W=0.72U AS=0.3312P AD=0.3888P
+ PS=2.36U PD=2.52U
M$590 \$959 \$1050 \$425 VDD pfet_03v3 L=0.28U W=0.36U AS=0.1584P AD=0.1152P
+ PS=1.6U PD=1U
M$591 \$426 \$1051 \$959 VDD pfet_03v3 L=0.28U W=0.36U AS=0.1152P AD=0.1584P
+ PS=1U PD=1.6U
M$592 VDD RB13 \$1051 VDD pfet_03v3 L=0.28U W=0.72U AS=0.3708P AD=0.3168P
+ PS=2.47U PD=2.32U
M$593 \$960 \$86 VDD VDD pfet_03v3 L=0.28U W=0.72U AS=0.3168P AD=0.2097P
+ PS=2.32U PD=1.38U
M$594 \$961 \$903 \$960 VDD pfet_03v3 L=0.28U W=0.36U AS=0.2097P AD=0.1278P
+ PS=1.38U PD=1.07U
M$595 \$1153 \$962 \$961 VDD pfet_03v3 L=0.28U W=0.36U AS=0.1278P AD=0.0567P
+ PS=1.07U PD=0.675U
M$596 VDD \$902 \$1153 VDD pfet_03v3 L=0.28U W=0.36U AS=0.0567P AD=0.1584P
+ PS=0.675U PD=1.6U
M$597 \$962 \$961 VDD VDD pfet_03v3 L=0.28U W=0.36U AS=0.1764P AD=0.1584P
+ PS=1.26U PD=1.6U
M$598 \$963 \$961 VDD VDD pfet_03v3 L=0.28U W=0.72U AS=0.1764P AD=0.36P
+ PS=1.26U PD=2.44U
M$599 \$1052 RA13 VDD VDD pfet_03v3 L=0.28U W=0.72U AS=0.3312P AD=0.3888P
+ PS=2.36U PD=2.52U
M$600 \$963 \$1052 \$430 VDD pfet_03v3 L=0.28U W=0.36U AS=0.1584P AD=0.1152P
+ PS=1.6U PD=1U
M$601 \$431 \$1053 \$963 VDD pfet_03v3 L=0.28U W=0.36U AS=0.1152P AD=0.1584P
+ PS=1U PD=1.6U
M$602 VDD RB13 \$1053 VDD pfet_03v3 L=0.28U W=0.72U AS=0.3708P AD=0.3168P
+ PS=2.47U PD=2.32U
M$603 \$964 \$89 VDD VDD pfet_03v3 L=0.28U W=0.72U AS=0.3168P AD=0.2097P
+ PS=2.32U PD=1.38U
M$604 \$965 \$903 \$964 VDD pfet_03v3 L=0.28U W=0.36U AS=0.2097P AD=0.1278P
+ PS=1.38U PD=1.07U
M$605 \$1125 \$966 \$965 VDD pfet_03v3 L=0.28U W=0.36U AS=0.1278P AD=0.0567P
+ PS=1.07U PD=0.675U
M$606 VDD \$902 \$1125 VDD pfet_03v3 L=0.28U W=0.36U AS=0.0567P AD=0.1584P
+ PS=0.675U PD=1.6U
M$607 \$966 \$965 VDD VDD pfet_03v3 L=0.28U W=0.36U AS=0.1764P AD=0.1584P
+ PS=1.26U PD=1.6U
M$608 \$967 \$965 VDD VDD pfet_03v3 L=0.28U W=0.72U AS=0.1764P AD=0.36P
+ PS=1.26U PD=2.44U
M$609 \$1054 RA13 VDD VDD pfet_03v3 L=0.28U W=0.72U AS=0.3312P AD=0.3888P
+ PS=2.36U PD=2.52U
M$610 \$967 \$1054 \$435 VDD pfet_03v3 L=0.28U W=0.36U AS=0.1584P AD=0.1152P
+ PS=1.6U PD=1U
M$611 \$436 \$1055 \$967 VDD pfet_03v3 L=0.28U W=0.36U AS=0.1152P AD=0.1584P
+ PS=1U PD=1.6U
M$612 VDD RB13 \$1055 VDD pfet_03v3 L=0.28U W=0.72U AS=0.3708P AD=0.3168P
+ PS=2.47U PD=2.32U
M$613 \$1217 WE12 VDD VDD pfet_03v3 L=0.28U W=0.72U AS=0.3168P AD=0.1872P
+ PS=2.32U PD=1.24U
M$614 VDD CLK \$1217 VDD pfet_03v3 L=0.28U W=0.72U AS=0.1872P AD=0.3168P
+ PS=1.24U PD=2.32U
M$615 \$1219 \$1217 VDD VDD pfet_03v3 L=0.28U W=2.54U AS=0.889P AD=0.6688P
+ PS=5.21U PD=3.65U
M$617 \$1220 \$1219 VDD VDD pfet_03v3 L=0.28U W=2.68U AS=0.7272P AD=0.9782P
+ PS=3.78U PD=5.48U
M$619 \$1224 \$1220 \$1223 VDD pfet_03v3 L=0.28U W=0.36U AS=0.2097P AD=0.1278P
+ PS=1.38U PD=1.07U
M$620 \$1324 \$1225 \$1224 VDD pfet_03v3 L=0.28U W=0.36U AS=0.1278P AD=0.0567P
+ PS=1.07U PD=0.675U
M$621 VDD \$1219 \$1324 VDD pfet_03v3 L=0.28U W=0.36U AS=0.0567P AD=0.1584P
+ PS=0.675U PD=1.6U
M$622 \$1223 \$44 VDD VDD pfet_03v3 L=0.28U W=0.72U AS=0.3168P AD=0.2097P
+ PS=2.32U PD=1.38U
M$623 VDD \$1224 \$1225 VDD pfet_03v3 L=0.28U W=0.36U AS=0.1584P AD=0.1764P
+ PS=1.6U PD=1.26U
M$624 \$1226 \$1224 VDD VDD pfet_03v3 L=0.28U W=0.72U AS=0.1764P AD=0.36P
+ PS=1.26U PD=2.44U
M$625 \$1227 RB12 VDD VDD pfet_03v3 L=0.28U W=0.72U AS=0.3312P AD=0.3888P
+ PS=2.36U PD=2.52U
M$626 \$1226 \$1227 \$360 VDD pfet_03v3 L=0.28U W=0.36U AS=0.1584P AD=0.1152P
+ PS=1.6U PD=1U
M$627 \$361 \$1228 \$1226 VDD pfet_03v3 L=0.28U W=0.36U AS=0.1152P AD=0.1584P
+ PS=1U PD=1.6U
M$628 VDD RA12 \$1228 VDD pfet_03v3 L=0.28U W=0.72U AS=0.3708P AD=0.3168P
+ PS=2.47U PD=2.32U
M$629 \$1230 \$1220 \$1229 VDD pfet_03v3 L=0.28U W=0.36U AS=0.2097P AD=0.1278P
+ PS=1.38U PD=1.07U
M$630 \$1332 \$1231 \$1230 VDD pfet_03v3 L=0.28U W=0.36U AS=0.1278P AD=0.0567P
+ PS=1.07U PD=0.675U
M$631 VDD \$1219 \$1332 VDD pfet_03v3 L=0.28U W=0.36U AS=0.0567P AD=0.1584P
+ PS=0.675U PD=1.6U
M$632 \$1229 \$47 VDD VDD pfet_03v3 L=0.28U W=0.72U AS=0.3168P AD=0.2097P
+ PS=2.32U PD=1.38U
M$633 VDD \$1230 \$1231 VDD pfet_03v3 L=0.28U W=0.36U AS=0.1584P AD=0.1764P
+ PS=1.6U PD=1.26U
M$634 \$1232 \$1230 VDD VDD pfet_03v3 L=0.28U W=0.72U AS=0.1764P AD=0.36P
+ PS=1.26U PD=2.44U
M$635 \$1233 RB12 VDD VDD pfet_03v3 L=0.28U W=0.72U AS=0.3312P AD=0.3888P
+ PS=2.36U PD=2.52U
M$636 \$1232 \$1233 \$365 VDD pfet_03v3 L=0.28U W=0.36U AS=0.1584P AD=0.1152P
+ PS=1.6U PD=1U
M$637 \$366 \$1234 \$1232 VDD pfet_03v3 L=0.28U W=0.36U AS=0.1152P AD=0.1584P
+ PS=1U PD=1.6U
M$638 VDD RA12 \$1234 VDD pfet_03v3 L=0.28U W=0.72U AS=0.3708P AD=0.3168P
+ PS=2.47U PD=2.32U
M$639 \$1236 \$1220 \$1235 VDD pfet_03v3 L=0.28U W=0.36U AS=0.2097P AD=0.1278P
+ PS=1.38U PD=1.07U
M$640 \$1339 \$1237 \$1236 VDD pfet_03v3 L=0.28U W=0.36U AS=0.1278P AD=0.0567P
+ PS=1.07U PD=0.675U
M$641 VDD \$1219 \$1339 VDD pfet_03v3 L=0.28U W=0.36U AS=0.0567P AD=0.1584P
+ PS=0.675U PD=1.6U
M$642 \$1235 \$50 VDD VDD pfet_03v3 L=0.28U W=0.72U AS=0.3168P AD=0.2097P
+ PS=2.32U PD=1.38U
M$643 VDD \$1236 \$1237 VDD pfet_03v3 L=0.28U W=0.36U AS=0.1584P AD=0.1764P
+ PS=1.6U PD=1.26U
M$644 \$1238 \$1236 VDD VDD pfet_03v3 L=0.28U W=0.72U AS=0.1764P AD=0.36P
+ PS=1.26U PD=2.44U
M$645 \$1239 RB12 VDD VDD pfet_03v3 L=0.28U W=0.72U AS=0.3312P AD=0.3888P
+ PS=2.36U PD=2.52U
M$646 \$1238 \$1239 \$370 VDD pfet_03v3 L=0.28U W=0.36U AS=0.1584P AD=0.1152P
+ PS=1.6U PD=1U
M$647 \$371 \$1240 \$1238 VDD pfet_03v3 L=0.28U W=0.36U AS=0.1152P AD=0.1584P
+ PS=1U PD=1.6U
M$648 VDD RA12 \$1240 VDD pfet_03v3 L=0.28U W=0.72U AS=0.3708P AD=0.3168P
+ PS=2.47U PD=2.32U
M$649 \$1242 \$1220 \$1241 VDD pfet_03v3 L=0.28U W=0.36U AS=0.2097P AD=0.1278P
+ PS=1.38U PD=1.07U
M$650 \$1347 \$1243 \$1242 VDD pfet_03v3 L=0.28U W=0.36U AS=0.1278P AD=0.0567P
+ PS=1.07U PD=0.675U
M$651 VDD \$1219 \$1347 VDD pfet_03v3 L=0.28U W=0.36U AS=0.0567P AD=0.1584P
+ PS=0.675U PD=1.6U
M$652 \$1241 \$53 VDD VDD pfet_03v3 L=0.28U W=0.72U AS=0.3168P AD=0.2097P
+ PS=2.32U PD=1.38U
M$653 VDD \$1242 \$1243 VDD pfet_03v3 L=0.28U W=0.36U AS=0.1584P AD=0.1764P
+ PS=1.6U PD=1.26U
M$654 \$1244 \$1242 VDD VDD pfet_03v3 L=0.28U W=0.72U AS=0.1764P AD=0.36P
+ PS=1.26U PD=2.44U
M$655 \$1245 RB12 VDD VDD pfet_03v3 L=0.28U W=0.72U AS=0.3312P AD=0.3888P
+ PS=2.36U PD=2.52U
M$656 \$1244 \$1245 \$375 VDD pfet_03v3 L=0.28U W=0.36U AS=0.1584P AD=0.1152P
+ PS=1.6U PD=1U
M$657 \$376 \$1246 \$1244 VDD pfet_03v3 L=0.28U W=0.36U AS=0.1152P AD=0.1584P
+ PS=1U PD=1.6U
M$658 VDD RA12 \$1246 VDD pfet_03v3 L=0.28U W=0.72U AS=0.3708P AD=0.3168P
+ PS=2.47U PD=2.32U
M$659 \$1248 \$1220 \$1247 VDD pfet_03v3 L=0.28U W=0.36U AS=0.2097P AD=0.1278P
+ PS=1.38U PD=1.07U
M$660 \$1356 \$1249 \$1248 VDD pfet_03v3 L=0.28U W=0.36U AS=0.1278P AD=0.0567P
+ PS=1.07U PD=0.675U
M$661 VDD \$1219 \$1356 VDD pfet_03v3 L=0.28U W=0.36U AS=0.0567P AD=0.1584P
+ PS=0.675U PD=1.6U
M$662 \$1247 \$56 VDD VDD pfet_03v3 L=0.28U W=0.72U AS=0.3168P AD=0.2097P
+ PS=2.32U PD=1.38U
M$663 VDD \$1248 \$1249 VDD pfet_03v3 L=0.28U W=0.36U AS=0.1584P AD=0.1764P
+ PS=1.6U PD=1.26U
M$664 \$1250 \$1248 VDD VDD pfet_03v3 L=0.28U W=0.72U AS=0.1764P AD=0.36P
+ PS=1.26U PD=2.44U
M$665 \$1251 RB12 VDD VDD pfet_03v3 L=0.28U W=0.72U AS=0.3312P AD=0.3888P
+ PS=2.36U PD=2.52U
M$666 \$1250 \$1251 \$380 VDD pfet_03v3 L=0.28U W=0.36U AS=0.1584P AD=0.1152P
+ PS=1.6U PD=1U
M$667 \$381 \$1252 \$1250 VDD pfet_03v3 L=0.28U W=0.36U AS=0.1152P AD=0.1584P
+ PS=1U PD=1.6U
M$668 VDD RA12 \$1252 VDD pfet_03v3 L=0.28U W=0.72U AS=0.3708P AD=0.3168P
+ PS=2.47U PD=2.32U
M$669 \$1254 \$1220 \$1253 VDD pfet_03v3 L=0.28U W=0.36U AS=0.2097P AD=0.1278P
+ PS=1.38U PD=1.07U
M$670 \$1362 \$1255 \$1254 VDD pfet_03v3 L=0.28U W=0.36U AS=0.1278P AD=0.0567P
+ PS=1.07U PD=0.675U
M$671 VDD \$1219 \$1362 VDD pfet_03v3 L=0.28U W=0.36U AS=0.0567P AD=0.1584P
+ PS=0.675U PD=1.6U
M$672 \$1253 \$59 VDD VDD pfet_03v3 L=0.28U W=0.72U AS=0.3168P AD=0.2097P
+ PS=2.32U PD=1.38U
M$673 VDD \$1254 \$1255 VDD pfet_03v3 L=0.28U W=0.36U AS=0.1584P AD=0.1764P
+ PS=1.6U PD=1.26U
M$674 \$1256 \$1254 VDD VDD pfet_03v3 L=0.28U W=0.72U AS=0.1764P AD=0.36P
+ PS=1.26U PD=2.44U
M$675 \$1257 RB12 VDD VDD pfet_03v3 L=0.28U W=0.72U AS=0.3312P AD=0.3888P
+ PS=2.36U PD=2.52U
M$676 \$1256 \$1257 \$385 VDD pfet_03v3 L=0.28U W=0.36U AS=0.1584P AD=0.1152P
+ PS=1.6U PD=1U
M$677 \$386 \$1258 \$1256 VDD pfet_03v3 L=0.28U W=0.36U AS=0.1152P AD=0.1584P
+ PS=1U PD=1.6U
M$678 VDD RA12 \$1258 VDD pfet_03v3 L=0.28U W=0.72U AS=0.3708P AD=0.3168P
+ PS=2.47U PD=2.32U
M$679 \$1260 \$1220 \$1259 VDD pfet_03v3 L=0.28U W=0.36U AS=0.2097P AD=0.1278P
+ PS=1.38U PD=1.07U
M$680 \$1369 \$1261 \$1260 VDD pfet_03v3 L=0.28U W=0.36U AS=0.1278P AD=0.0567P
+ PS=1.07U PD=0.675U
M$681 VDD \$1219 \$1369 VDD pfet_03v3 L=0.28U W=0.36U AS=0.0567P AD=0.1584P
+ PS=0.675U PD=1.6U
M$682 \$1259 \$62 VDD VDD pfet_03v3 L=0.28U W=0.72U AS=0.3168P AD=0.2097P
+ PS=2.32U PD=1.38U
M$683 VDD \$1260 \$1261 VDD pfet_03v3 L=0.28U W=0.36U AS=0.1584P AD=0.1764P
+ PS=1.6U PD=1.26U
M$684 \$1262 \$1260 VDD VDD pfet_03v3 L=0.28U W=0.72U AS=0.1764P AD=0.36P
+ PS=1.26U PD=2.44U
M$685 \$1263 RB12 VDD VDD pfet_03v3 L=0.28U W=0.72U AS=0.3312P AD=0.3888P
+ PS=2.36U PD=2.52U
M$686 \$1262 \$1263 \$390 VDD pfet_03v3 L=0.28U W=0.36U AS=0.1584P AD=0.1152P
+ PS=1.6U PD=1U
M$687 \$391 \$1264 \$1262 VDD pfet_03v3 L=0.28U W=0.36U AS=0.1152P AD=0.1584P
+ PS=1U PD=1.6U
M$688 VDD RA12 \$1264 VDD pfet_03v3 L=0.28U W=0.72U AS=0.3708P AD=0.3168P
+ PS=2.47U PD=2.32U
M$689 \$1266 \$1220 \$1265 VDD pfet_03v3 L=0.28U W=0.36U AS=0.2097P AD=0.1278P
+ PS=1.38U PD=1.07U
M$690 \$1378 \$1267 \$1266 VDD pfet_03v3 L=0.28U W=0.36U AS=0.1278P AD=0.0567P
+ PS=1.07U PD=0.675U
M$691 VDD \$1219 \$1378 VDD pfet_03v3 L=0.28U W=0.36U AS=0.0567P AD=0.1584P
+ PS=0.675U PD=1.6U
M$692 \$1265 \$65 VDD VDD pfet_03v3 L=0.28U W=0.72U AS=0.3168P AD=0.2097P
+ PS=2.32U PD=1.38U
M$693 VDD \$1266 \$1267 VDD pfet_03v3 L=0.28U W=0.36U AS=0.1584P AD=0.1764P
+ PS=1.6U PD=1.26U
M$694 \$1268 \$1266 VDD VDD pfet_03v3 L=0.28U W=0.72U AS=0.1764P AD=0.36P
+ PS=1.26U PD=2.44U
M$695 \$1269 RB12 VDD VDD pfet_03v3 L=0.28U W=0.72U AS=0.3312P AD=0.3888P
+ PS=2.36U PD=2.52U
M$696 \$1268 \$1269 \$395 VDD pfet_03v3 L=0.28U W=0.36U AS=0.1584P AD=0.1152P
+ PS=1.6U PD=1U
M$697 \$396 \$1270 \$1268 VDD pfet_03v3 L=0.28U W=0.36U AS=0.1152P AD=0.1584P
+ PS=1U PD=1.6U
M$698 VDD RA12 \$1270 VDD pfet_03v3 L=0.28U W=0.72U AS=0.3708P AD=0.3168P
+ PS=2.47U PD=2.32U
M$699 \$1272 \$1220 \$1271 VDD pfet_03v3 L=0.28U W=0.36U AS=0.2097P AD=0.1278P
+ PS=1.38U PD=1.07U
M$700 \$1384 \$1273 \$1272 VDD pfet_03v3 L=0.28U W=0.36U AS=0.1278P AD=0.0567P
+ PS=1.07U PD=0.675U
M$701 VDD \$1219 \$1384 VDD pfet_03v3 L=0.28U W=0.36U AS=0.0567P AD=0.1584P
+ PS=0.675U PD=1.6U
M$702 \$1271 \$68 VDD VDD pfet_03v3 L=0.28U W=0.72U AS=0.3168P AD=0.2097P
+ PS=2.32U PD=1.38U
M$703 VDD \$1272 \$1273 VDD pfet_03v3 L=0.28U W=0.36U AS=0.1584P AD=0.1764P
+ PS=1.6U PD=1.26U
M$704 \$1274 \$1272 VDD VDD pfet_03v3 L=0.28U W=0.72U AS=0.1764P AD=0.36P
+ PS=1.26U PD=2.44U
M$705 \$1275 RB12 VDD VDD pfet_03v3 L=0.28U W=0.72U AS=0.3312P AD=0.3888P
+ PS=2.36U PD=2.52U
M$706 \$1274 \$1275 \$400 VDD pfet_03v3 L=0.28U W=0.36U AS=0.1584P AD=0.1152P
+ PS=1.6U PD=1U
M$707 \$401 \$1276 \$1274 VDD pfet_03v3 L=0.28U W=0.36U AS=0.1152P AD=0.1584P
+ PS=1U PD=1.6U
M$708 VDD RA12 \$1276 VDD pfet_03v3 L=0.28U W=0.72U AS=0.3708P AD=0.3168P
+ PS=2.47U PD=2.32U
M$709 \$1278 \$1220 \$1277 VDD pfet_03v3 L=0.28U W=0.36U AS=0.2097P AD=0.1278P
+ PS=1.38U PD=1.07U
M$710 \$1391 \$1279 \$1278 VDD pfet_03v3 L=0.28U W=0.36U AS=0.1278P AD=0.0567P
+ PS=1.07U PD=0.675U
M$711 VDD \$1219 \$1391 VDD pfet_03v3 L=0.28U W=0.36U AS=0.0567P AD=0.1584P
+ PS=0.675U PD=1.6U
M$712 \$1277 \$71 VDD VDD pfet_03v3 L=0.28U W=0.72U AS=0.3168P AD=0.2097P
+ PS=2.32U PD=1.38U
M$713 VDD \$1278 \$1279 VDD pfet_03v3 L=0.28U W=0.36U AS=0.1584P AD=0.1764P
+ PS=1.6U PD=1.26U
M$714 \$1280 \$1278 VDD VDD pfet_03v3 L=0.28U W=0.72U AS=0.1764P AD=0.36P
+ PS=1.26U PD=2.44U
M$715 \$1281 RB12 VDD VDD pfet_03v3 L=0.28U W=0.72U AS=0.3312P AD=0.3888P
+ PS=2.36U PD=2.52U
M$716 \$1280 \$1281 \$405 VDD pfet_03v3 L=0.28U W=0.36U AS=0.1584P AD=0.1152P
+ PS=1.6U PD=1U
M$717 \$406 \$1282 \$1280 VDD pfet_03v3 L=0.28U W=0.36U AS=0.1152P AD=0.1584P
+ PS=1U PD=1.6U
M$718 VDD RA12 \$1282 VDD pfet_03v3 L=0.28U W=0.72U AS=0.3708P AD=0.3168P
+ PS=2.47U PD=2.32U
M$719 \$1284 \$1220 \$1283 VDD pfet_03v3 L=0.28U W=0.36U AS=0.2097P AD=0.1278P
+ PS=1.38U PD=1.07U
M$720 \$1399 \$1285 \$1284 VDD pfet_03v3 L=0.28U W=0.36U AS=0.1278P AD=0.0567P
+ PS=1.07U PD=0.675U
M$721 VDD \$1219 \$1399 VDD pfet_03v3 L=0.28U W=0.36U AS=0.0567P AD=0.1584P
+ PS=0.675U PD=1.6U
M$722 \$1283 \$74 VDD VDD pfet_03v3 L=0.28U W=0.72U AS=0.3168P AD=0.2097P
+ PS=2.32U PD=1.38U
M$723 VDD \$1284 \$1285 VDD pfet_03v3 L=0.28U W=0.36U AS=0.1584P AD=0.1764P
+ PS=1.6U PD=1.26U
M$724 \$1286 \$1284 VDD VDD pfet_03v3 L=0.28U W=0.72U AS=0.1764P AD=0.36P
+ PS=1.26U PD=2.44U
M$725 \$1287 RB12 VDD VDD pfet_03v3 L=0.28U W=0.72U AS=0.3312P AD=0.3888P
+ PS=2.36U PD=2.52U
M$726 \$1286 \$1287 \$410 VDD pfet_03v3 L=0.28U W=0.36U AS=0.1584P AD=0.1152P
+ PS=1.6U PD=1U
M$727 \$411 \$1288 \$1286 VDD pfet_03v3 L=0.28U W=0.36U AS=0.1152P AD=0.1584P
+ PS=1U PD=1.6U
M$728 VDD RA12 \$1288 VDD pfet_03v3 L=0.28U W=0.72U AS=0.3708P AD=0.3168P
+ PS=2.47U PD=2.32U
M$729 \$1290 \$1220 \$1289 VDD pfet_03v3 L=0.28U W=0.36U AS=0.2097P AD=0.1278P
+ PS=1.38U PD=1.07U
M$730 \$1407 \$1291 \$1290 VDD pfet_03v3 L=0.28U W=0.36U AS=0.1278P AD=0.0567P
+ PS=1.07U PD=0.675U
M$731 VDD \$1219 \$1407 VDD pfet_03v3 L=0.28U W=0.36U AS=0.0567P AD=0.1584P
+ PS=0.675U PD=1.6U
M$732 \$1289 \$77 VDD VDD pfet_03v3 L=0.28U W=0.72U AS=0.3168P AD=0.2097P
+ PS=2.32U PD=1.38U
M$733 VDD \$1290 \$1291 VDD pfet_03v3 L=0.28U W=0.36U AS=0.1584P AD=0.1764P
+ PS=1.6U PD=1.26U
M$734 \$1292 \$1290 VDD VDD pfet_03v3 L=0.28U W=0.72U AS=0.1764P AD=0.36P
+ PS=1.26U PD=2.44U
M$735 \$1293 RB12 VDD VDD pfet_03v3 L=0.28U W=0.72U AS=0.3312P AD=0.3888P
+ PS=2.36U PD=2.52U
M$736 \$1292 \$1293 \$415 VDD pfet_03v3 L=0.28U W=0.36U AS=0.1584P AD=0.1152P
+ PS=1.6U PD=1U
M$737 \$416 \$1294 \$1292 VDD pfet_03v3 L=0.28U W=0.36U AS=0.1152P AD=0.1584P
+ PS=1U PD=1.6U
M$738 VDD RA12 \$1294 VDD pfet_03v3 L=0.28U W=0.72U AS=0.3708P AD=0.3168P
+ PS=2.47U PD=2.32U
M$739 \$1296 \$1220 \$1295 VDD pfet_03v3 L=0.28U W=0.36U AS=0.2097P AD=0.1278P
+ PS=1.38U PD=1.07U
M$740 \$1414 \$1297 \$1296 VDD pfet_03v3 L=0.28U W=0.36U AS=0.1278P AD=0.0567P
+ PS=1.07U PD=0.675U
M$741 VDD \$1219 \$1414 VDD pfet_03v3 L=0.28U W=0.36U AS=0.0567P AD=0.1584P
+ PS=0.675U PD=1.6U
M$742 \$1295 \$80 VDD VDD pfet_03v3 L=0.28U W=0.72U AS=0.3168P AD=0.2097P
+ PS=2.32U PD=1.38U
M$743 VDD \$1296 \$1297 VDD pfet_03v3 L=0.28U W=0.36U AS=0.1584P AD=0.1764P
+ PS=1.6U PD=1.26U
M$744 \$1298 \$1296 VDD VDD pfet_03v3 L=0.28U W=0.72U AS=0.1764P AD=0.36P
+ PS=1.26U PD=2.44U
M$745 \$1299 RB12 VDD VDD pfet_03v3 L=0.28U W=0.72U AS=0.3312P AD=0.3888P
+ PS=2.36U PD=2.52U
M$746 \$1298 \$1299 \$420 VDD pfet_03v3 L=0.28U W=0.36U AS=0.1584P AD=0.1152P
+ PS=1.6U PD=1U
M$747 \$421 \$1300 \$1298 VDD pfet_03v3 L=0.28U W=0.36U AS=0.1152P AD=0.1584P
+ PS=1U PD=1.6U
M$748 VDD RA12 \$1300 VDD pfet_03v3 L=0.28U W=0.72U AS=0.3708P AD=0.3168P
+ PS=2.47U PD=2.32U
M$749 \$1302 \$1220 \$1301 VDD pfet_03v3 L=0.28U W=0.36U AS=0.2097P AD=0.1278P
+ PS=1.38U PD=1.07U
M$750 \$1413 \$1303 \$1302 VDD pfet_03v3 L=0.28U W=0.36U AS=0.1278P AD=0.0567P
+ PS=1.07U PD=0.675U
M$751 VDD \$1219 \$1413 VDD pfet_03v3 L=0.28U W=0.36U AS=0.0567P AD=0.1584P
+ PS=0.675U PD=1.6U
M$752 \$1301 \$83 VDD VDD pfet_03v3 L=0.28U W=0.72U AS=0.3168P AD=0.2097P
+ PS=2.32U PD=1.38U
M$753 VDD \$1302 \$1303 VDD pfet_03v3 L=0.28U W=0.36U AS=0.1584P AD=0.1764P
+ PS=1.6U PD=1.26U
M$754 \$1304 \$1302 VDD VDD pfet_03v3 L=0.28U W=0.72U AS=0.1764P AD=0.36P
+ PS=1.26U PD=2.44U
M$755 \$1305 RB12 VDD VDD pfet_03v3 L=0.28U W=0.72U AS=0.3312P AD=0.3888P
+ PS=2.36U PD=2.52U
M$756 \$1304 \$1305 \$425 VDD pfet_03v3 L=0.28U W=0.36U AS=0.1584P AD=0.1152P
+ PS=1.6U PD=1U
M$757 \$426 \$1306 \$1304 VDD pfet_03v3 L=0.28U W=0.36U AS=0.1152P AD=0.1584P
+ PS=1U PD=1.6U
M$758 VDD RA12 \$1306 VDD pfet_03v3 L=0.28U W=0.72U AS=0.3708P AD=0.3168P
+ PS=2.47U PD=2.32U
M$759 \$1308 \$1220 \$1307 VDD pfet_03v3 L=0.28U W=0.36U AS=0.2097P AD=0.1278P
+ PS=1.38U PD=1.07U
M$760 \$1381 \$1309 \$1308 VDD pfet_03v3 L=0.28U W=0.36U AS=0.1278P AD=0.0567P
+ PS=1.07U PD=0.675U
M$761 VDD \$1219 \$1381 VDD pfet_03v3 L=0.28U W=0.36U AS=0.0567P AD=0.1584P
+ PS=0.675U PD=1.6U
M$762 \$1307 \$86 VDD VDD pfet_03v3 L=0.28U W=0.72U AS=0.3168P AD=0.2097P
+ PS=2.32U PD=1.38U
M$763 VDD \$1308 \$1309 VDD pfet_03v3 L=0.28U W=0.36U AS=0.1584P AD=0.1764P
+ PS=1.6U PD=1.26U
M$764 \$1310 \$1308 VDD VDD pfet_03v3 L=0.28U W=0.72U AS=0.1764P AD=0.36P
+ PS=1.26U PD=2.44U
M$765 \$1311 RB12 VDD VDD pfet_03v3 L=0.28U W=0.72U AS=0.3312P AD=0.3888P
+ PS=2.36U PD=2.52U
M$766 \$1310 \$1311 \$430 VDD pfet_03v3 L=0.28U W=0.36U AS=0.1584P AD=0.1152P
+ PS=1.6U PD=1U
M$767 \$431 \$1312 \$1310 VDD pfet_03v3 L=0.28U W=0.36U AS=0.1152P AD=0.1584P
+ PS=1U PD=1.6U
M$768 VDD RA12 \$1312 VDD pfet_03v3 L=0.28U W=0.72U AS=0.3708P AD=0.3168P
+ PS=2.47U PD=2.32U
M$769 \$1314 \$1220 \$1313 VDD pfet_03v3 L=0.28U W=0.36U AS=0.2097P AD=0.1278P
+ PS=1.38U PD=1.07U
M$770 \$1348 \$1315 \$1314 VDD pfet_03v3 L=0.28U W=0.36U AS=0.1278P AD=0.0567P
+ PS=1.07U PD=0.675U
M$771 VDD \$1219 \$1348 VDD pfet_03v3 L=0.28U W=0.36U AS=0.0567P AD=0.1584P
+ PS=0.675U PD=1.6U
M$772 \$1313 \$89 VDD VDD pfet_03v3 L=0.28U W=0.72U AS=0.3168P AD=0.2097P
+ PS=2.32U PD=1.38U
M$773 VDD \$1314 \$1315 VDD pfet_03v3 L=0.28U W=0.36U AS=0.1584P AD=0.1764P
+ PS=1.6U PD=1.26U
M$774 \$1316 \$1314 VDD VDD pfet_03v3 L=0.28U W=0.72U AS=0.1764P AD=0.36P
+ PS=1.26U PD=2.44U
M$775 \$1317 RB12 VDD VDD pfet_03v3 L=0.28U W=0.72U AS=0.3312P AD=0.3888P
+ PS=2.36U PD=2.52U
M$776 \$1316 \$1317 \$435 VDD pfet_03v3 L=0.28U W=0.36U AS=0.1584P AD=0.1152P
+ PS=1.6U PD=1U
M$777 \$436 \$1318 \$1316 VDD pfet_03v3 L=0.28U W=0.36U AS=0.1152P AD=0.1584P
+ PS=1U PD=1.6U
M$778 VDD RA12 \$1318 VDD pfet_03v3 L=0.28U W=0.72U AS=0.3708P AD=0.3168P
+ PS=2.47U PD=2.32U
M$779 \$1520 WE11 VDD VDD pfet_03v3 L=0.28U W=0.72U AS=0.3168P AD=0.1872P
+ PS=2.32U PD=1.24U
M$780 VDD CLK \$1520 VDD pfet_03v3 L=0.28U W=0.72U AS=0.1872P AD=0.3168P
+ PS=1.24U PD=2.32U
M$781 \$1521 \$1520 VDD VDD pfet_03v3 L=0.28U W=2.54U AS=0.8974P AD=0.6604P
+ PS=5.28U PD=3.58U
M$783 \$1522 \$1521 VDD VDD pfet_03v3 L=0.28U W=2.68U AS=0.7272P AD=0.9782P
+ PS=3.78U PD=5.48U
M$785 \$1523 \$44 VDD VDD pfet_03v3 L=0.28U W=0.72U AS=0.3168P AD=0.2097P
+ PS=2.32U PD=1.38U
M$786 \$1524 \$1522 \$1523 VDD pfet_03v3 L=0.28U W=0.36U AS=0.2097P AD=0.1278P
+ PS=1.38U PD=1.07U
M$787 \$1730 \$1525 \$1524 VDD pfet_03v3 L=0.28U W=0.36U AS=0.1278P AD=0.0567P
+ PS=1.07U PD=0.675U
M$788 VDD \$1521 \$1730 VDD pfet_03v3 L=0.28U W=0.36U AS=0.0567P AD=0.1584P
+ PS=0.675U PD=1.6U
M$789 \$1525 \$1524 VDD VDD pfet_03v3 L=0.28U W=0.36U AS=0.1764P AD=0.1584P
+ PS=1.26U PD=1.6U
M$790 \$1526 \$1524 VDD VDD pfet_03v3 L=0.28U W=0.72U AS=0.1764P AD=0.36P
+ PS=1.26U PD=2.44U
M$791 \$1637 RA11 VDD VDD pfet_03v3 L=0.28U W=0.72U AS=0.3312P AD=0.3888P
+ PS=2.36U PD=2.52U
M$792 \$1526 \$1637 \$360 VDD pfet_03v3 L=0.28U W=0.36U AS=0.1584P AD=0.1152P
+ PS=1.6U PD=1U
M$793 \$361 \$1638 \$1526 VDD pfet_03v3 L=0.28U W=0.36U AS=0.1152P AD=0.1584P
+ PS=1U PD=1.6U
M$794 VDD RB11 \$1638 VDD pfet_03v3 L=0.28U W=0.72U AS=0.3708P AD=0.3168P
+ PS=2.47U PD=2.32U
M$795 \$1527 \$47 VDD VDD pfet_03v3 L=0.28U W=0.72U AS=0.3168P AD=0.2097P
+ PS=2.32U PD=1.38U
M$796 \$1528 \$1522 \$1527 VDD pfet_03v3 L=0.28U W=0.36U AS=0.2097P AD=0.1278P
+ PS=1.38U PD=1.07U
M$797 \$1740 \$1529 \$1528 VDD pfet_03v3 L=0.28U W=0.36U AS=0.1278P AD=0.0567P
+ PS=1.07U PD=0.675U
M$798 VDD \$1521 \$1740 VDD pfet_03v3 L=0.28U W=0.36U AS=0.0567P AD=0.1584P
+ PS=0.675U PD=1.6U
M$799 \$1529 \$1528 VDD VDD pfet_03v3 L=0.28U W=0.36U AS=0.1764P AD=0.1584P
+ PS=1.26U PD=1.6U
M$800 \$1530 \$1528 VDD VDD pfet_03v3 L=0.28U W=0.72U AS=0.1764P AD=0.36P
+ PS=1.26U PD=2.44U
M$801 \$1639 RA11 VDD VDD pfet_03v3 L=0.28U W=0.72U AS=0.3312P AD=0.3888P
+ PS=2.36U PD=2.52U
M$802 \$1530 \$1639 \$365 VDD pfet_03v3 L=0.28U W=0.36U AS=0.1584P AD=0.1152P
+ PS=1.6U PD=1U
M$803 \$366 \$1640 \$1530 VDD pfet_03v3 L=0.28U W=0.36U AS=0.1152P AD=0.1584P
+ PS=1U PD=1.6U
M$804 VDD RB11 \$1640 VDD pfet_03v3 L=0.28U W=0.72U AS=0.3708P AD=0.3168P
+ PS=2.47U PD=2.32U
M$805 \$1531 \$50 VDD VDD pfet_03v3 L=0.28U W=0.72U AS=0.3168P AD=0.2097P
+ PS=2.32U PD=1.38U
M$806 \$1532 \$1522 \$1531 VDD pfet_03v3 L=0.28U W=0.36U AS=0.2097P AD=0.1278P
+ PS=1.38U PD=1.07U
M$807 \$1746 \$1533 \$1532 VDD pfet_03v3 L=0.28U W=0.36U AS=0.1278P AD=0.0567P
+ PS=1.07U PD=0.675U
M$808 VDD \$1521 \$1746 VDD pfet_03v3 L=0.28U W=0.36U AS=0.0567P AD=0.1584P
+ PS=0.675U PD=1.6U
M$809 \$1533 \$1532 VDD VDD pfet_03v3 L=0.28U W=0.36U AS=0.1764P AD=0.1584P
+ PS=1.26U PD=1.6U
M$810 \$1534 \$1532 VDD VDD pfet_03v3 L=0.28U W=0.72U AS=0.1764P AD=0.36P
+ PS=1.26U PD=2.44U
M$811 \$1641 RA11 VDD VDD pfet_03v3 L=0.28U W=0.72U AS=0.3312P AD=0.3888P
+ PS=2.36U PD=2.52U
M$812 \$1534 \$1641 \$370 VDD pfet_03v3 L=0.28U W=0.36U AS=0.1584P AD=0.1152P
+ PS=1.6U PD=1U
M$813 \$371 \$1642 \$1534 VDD pfet_03v3 L=0.28U W=0.36U AS=0.1152P AD=0.1584P
+ PS=1U PD=1.6U
M$814 VDD RB11 \$1642 VDD pfet_03v3 L=0.28U W=0.72U AS=0.3708P AD=0.3168P
+ PS=2.47U PD=2.32U
M$815 \$1535 \$53 VDD VDD pfet_03v3 L=0.28U W=0.72U AS=0.3168P AD=0.2097P
+ PS=2.32U PD=1.38U
M$816 \$1536 \$1522 \$1535 VDD pfet_03v3 L=0.28U W=0.36U AS=0.2097P AD=0.1278P
+ PS=1.38U PD=1.07U
M$817 \$1756 \$1537 \$1536 VDD pfet_03v3 L=0.28U W=0.36U AS=0.1278P AD=0.0567P
+ PS=1.07U PD=0.675U
M$818 VDD \$1521 \$1756 VDD pfet_03v3 L=0.28U W=0.36U AS=0.0567P AD=0.1584P
+ PS=0.675U PD=1.6U
M$819 \$1537 \$1536 VDD VDD pfet_03v3 L=0.28U W=0.36U AS=0.1764P AD=0.1584P
+ PS=1.26U PD=1.6U
M$820 \$1538 \$1536 VDD VDD pfet_03v3 L=0.28U W=0.72U AS=0.1764P AD=0.36P
+ PS=1.26U PD=2.44U
M$821 \$1643 RA11 VDD VDD pfet_03v3 L=0.28U W=0.72U AS=0.3312P AD=0.3888P
+ PS=2.36U PD=2.52U
M$822 \$1538 \$1643 \$375 VDD pfet_03v3 L=0.28U W=0.36U AS=0.1584P AD=0.1152P
+ PS=1.6U PD=1U
M$823 \$376 \$1644 \$1538 VDD pfet_03v3 L=0.28U W=0.36U AS=0.1152P AD=0.1584P
+ PS=1U PD=1.6U
M$824 VDD RB11 \$1644 VDD pfet_03v3 L=0.28U W=0.72U AS=0.3708P AD=0.3168P
+ PS=2.47U PD=2.32U
M$825 \$1539 \$56 VDD VDD pfet_03v3 L=0.28U W=0.72U AS=0.3168P AD=0.2097P
+ PS=2.32U PD=1.38U
M$826 \$1540 \$1522 \$1539 VDD pfet_03v3 L=0.28U W=0.36U AS=0.2097P AD=0.1278P
+ PS=1.38U PD=1.07U
M$827 \$1765 \$1541 \$1540 VDD pfet_03v3 L=0.28U W=0.36U AS=0.1278P AD=0.0567P
+ PS=1.07U PD=0.675U
M$828 VDD \$1521 \$1765 VDD pfet_03v3 L=0.28U W=0.36U AS=0.0567P AD=0.1584P
+ PS=0.675U PD=1.6U
M$829 \$1541 \$1540 VDD VDD pfet_03v3 L=0.28U W=0.36U AS=0.1764P AD=0.1584P
+ PS=1.26U PD=1.6U
M$830 \$1542 \$1540 VDD VDD pfet_03v3 L=0.28U W=0.72U AS=0.1764P AD=0.36P
+ PS=1.26U PD=2.44U
M$831 \$1645 RA11 VDD VDD pfet_03v3 L=0.28U W=0.72U AS=0.3312P AD=0.3888P
+ PS=2.36U PD=2.52U
M$832 \$1542 \$1645 \$380 VDD pfet_03v3 L=0.28U W=0.36U AS=0.1584P AD=0.1152P
+ PS=1.6U PD=1U
M$833 \$381 \$1646 \$1542 VDD pfet_03v3 L=0.28U W=0.36U AS=0.1152P AD=0.1584P
+ PS=1U PD=1.6U
M$834 VDD RB11 \$1646 VDD pfet_03v3 L=0.28U W=0.72U AS=0.3708P AD=0.3168P
+ PS=2.47U PD=2.32U
M$835 \$1543 \$59 VDD VDD pfet_03v3 L=0.28U W=0.72U AS=0.3168P AD=0.2097P
+ PS=2.32U PD=1.38U
M$836 \$1544 \$1522 \$1543 VDD pfet_03v3 L=0.28U W=0.36U AS=0.2097P AD=0.1278P
+ PS=1.38U PD=1.07U
M$837 \$1774 \$1545 \$1544 VDD pfet_03v3 L=0.28U W=0.36U AS=0.1278P AD=0.0567P
+ PS=1.07U PD=0.675U
M$838 VDD \$1521 \$1774 VDD pfet_03v3 L=0.28U W=0.36U AS=0.0567P AD=0.1584P
+ PS=0.675U PD=1.6U
M$839 \$1545 \$1544 VDD VDD pfet_03v3 L=0.28U W=0.36U AS=0.1764P AD=0.1584P
+ PS=1.26U PD=1.6U
M$840 \$1546 \$1544 VDD VDD pfet_03v3 L=0.28U W=0.72U AS=0.1764P AD=0.36P
+ PS=1.26U PD=2.44U
M$841 \$1647 RA11 VDD VDD pfet_03v3 L=0.28U W=0.72U AS=0.3312P AD=0.3888P
+ PS=2.36U PD=2.52U
M$842 \$1546 \$1647 \$385 VDD pfet_03v3 L=0.28U W=0.36U AS=0.1584P AD=0.1152P
+ PS=1.6U PD=1U
M$843 \$386 \$1648 \$1546 VDD pfet_03v3 L=0.28U W=0.36U AS=0.1152P AD=0.1584P
+ PS=1U PD=1.6U
M$844 VDD RB11 \$1648 VDD pfet_03v3 L=0.28U W=0.72U AS=0.3708P AD=0.3168P
+ PS=2.47U PD=2.32U
M$845 \$1547 \$62 VDD VDD pfet_03v3 L=0.28U W=0.72U AS=0.3168P AD=0.2097P
+ PS=2.32U PD=1.38U
M$846 \$1548 \$1522 \$1547 VDD pfet_03v3 L=0.28U W=0.36U AS=0.2097P AD=0.1278P
+ PS=1.38U PD=1.07U
M$847 \$1782 \$1549 \$1548 VDD pfet_03v3 L=0.28U W=0.36U AS=0.1278P AD=0.0567P
+ PS=1.07U PD=0.675U
M$848 VDD \$1521 \$1782 VDD pfet_03v3 L=0.28U W=0.36U AS=0.0567P AD=0.1584P
+ PS=0.675U PD=1.6U
M$849 \$1549 \$1548 VDD VDD pfet_03v3 L=0.28U W=0.36U AS=0.1764P AD=0.1584P
+ PS=1.26U PD=1.6U
M$850 \$1550 \$1548 VDD VDD pfet_03v3 L=0.28U W=0.72U AS=0.1764P AD=0.36P
+ PS=1.26U PD=2.44U
M$851 \$1649 RA11 VDD VDD pfet_03v3 L=0.28U W=0.72U AS=0.3312P AD=0.3888P
+ PS=2.36U PD=2.52U
M$852 \$1550 \$1649 \$390 VDD pfet_03v3 L=0.28U W=0.36U AS=0.1584P AD=0.1152P
+ PS=1.6U PD=1U
M$853 \$391 \$1650 \$1550 VDD pfet_03v3 L=0.28U W=0.36U AS=0.1152P AD=0.1584P
+ PS=1U PD=1.6U
M$854 VDD RB11 \$1650 VDD pfet_03v3 L=0.28U W=0.72U AS=0.3708P AD=0.3168P
+ PS=2.47U PD=2.32U
M$855 \$1551 \$65 VDD VDD pfet_03v3 L=0.28U W=0.72U AS=0.3168P AD=0.2097P
+ PS=2.32U PD=1.38U
M$856 \$1552 \$1522 \$1551 VDD pfet_03v3 L=0.28U W=0.36U AS=0.2097P AD=0.1278P
+ PS=1.38U PD=1.07U
M$857 \$1791 \$1553 \$1552 VDD pfet_03v3 L=0.28U W=0.36U AS=0.1278P AD=0.0567P
+ PS=1.07U PD=0.675U
M$858 VDD \$1521 \$1791 VDD pfet_03v3 L=0.28U W=0.36U AS=0.0567P AD=0.1584P
+ PS=0.675U PD=1.6U
M$859 \$1553 \$1552 VDD VDD pfet_03v3 L=0.28U W=0.36U AS=0.1764P AD=0.1584P
+ PS=1.26U PD=1.6U
M$860 \$1554 \$1552 VDD VDD pfet_03v3 L=0.28U W=0.72U AS=0.1764P AD=0.36P
+ PS=1.26U PD=2.44U
M$861 \$1651 RA11 VDD VDD pfet_03v3 L=0.28U W=0.72U AS=0.3312P AD=0.3888P
+ PS=2.36U PD=2.52U
M$862 \$1554 \$1651 \$395 VDD pfet_03v3 L=0.28U W=0.36U AS=0.1584P AD=0.1152P
+ PS=1.6U PD=1U
M$863 \$396 \$1652 \$1554 VDD pfet_03v3 L=0.28U W=0.36U AS=0.1152P AD=0.1584P
+ PS=1U PD=1.6U
M$864 VDD RB11 \$1652 VDD pfet_03v3 L=0.28U W=0.72U AS=0.3708P AD=0.3168P
+ PS=2.47U PD=2.32U
M$865 \$1555 \$68 VDD VDD pfet_03v3 L=0.28U W=0.72U AS=0.3168P AD=0.2097P
+ PS=2.32U PD=1.38U
M$866 \$1556 \$1522 \$1555 VDD pfet_03v3 L=0.28U W=0.36U AS=0.2097P AD=0.1278P
+ PS=1.38U PD=1.07U
M$867 \$1800 \$1557 \$1556 VDD pfet_03v3 L=0.28U W=0.36U AS=0.1278P AD=0.0567P
+ PS=1.07U PD=0.675U
M$868 VDD \$1521 \$1800 VDD pfet_03v3 L=0.28U W=0.36U AS=0.0567P AD=0.1584P
+ PS=0.675U PD=1.6U
M$869 \$1557 \$1556 VDD VDD pfet_03v3 L=0.28U W=0.36U AS=0.1764P AD=0.1584P
+ PS=1.26U PD=1.6U
M$870 \$1558 \$1556 VDD VDD pfet_03v3 L=0.28U W=0.72U AS=0.1764P AD=0.36P
+ PS=1.26U PD=2.44U
M$871 \$1653 RA11 VDD VDD pfet_03v3 L=0.28U W=0.72U AS=0.3312P AD=0.3888P
+ PS=2.36U PD=2.52U
M$872 \$1558 \$1653 \$400 VDD pfet_03v3 L=0.28U W=0.36U AS=0.1584P AD=0.1152P
+ PS=1.6U PD=1U
M$873 \$401 \$1654 \$1558 VDD pfet_03v3 L=0.28U W=0.36U AS=0.1152P AD=0.1584P
+ PS=1U PD=1.6U
M$874 VDD RB11 \$1654 VDD pfet_03v3 L=0.28U W=0.72U AS=0.3708P AD=0.3168P
+ PS=2.47U PD=2.32U
M$875 \$1559 \$71 VDD VDD pfet_03v3 L=0.28U W=0.72U AS=0.3168P AD=0.2097P
+ PS=2.32U PD=1.38U
M$876 \$1560 \$1522 \$1559 VDD pfet_03v3 L=0.28U W=0.36U AS=0.2097P AD=0.1278P
+ PS=1.38U PD=1.07U
M$877 \$1809 \$1561 \$1560 VDD pfet_03v3 L=0.28U W=0.36U AS=0.1278P AD=0.0567P
+ PS=1.07U PD=0.675U
M$878 VDD \$1521 \$1809 VDD pfet_03v3 L=0.28U W=0.36U AS=0.0567P AD=0.1584P
+ PS=0.675U PD=1.6U
M$879 \$1561 \$1560 VDD VDD pfet_03v3 L=0.28U W=0.36U AS=0.1764P AD=0.1584P
+ PS=1.26U PD=1.6U
M$880 \$1562 \$1560 VDD VDD pfet_03v3 L=0.28U W=0.72U AS=0.1764P AD=0.36P
+ PS=1.26U PD=2.44U
M$881 \$1655 RA11 VDD VDD pfet_03v3 L=0.28U W=0.72U AS=0.3312P AD=0.3888P
+ PS=2.36U PD=2.52U
M$882 \$1562 \$1655 \$405 VDD pfet_03v3 L=0.28U W=0.36U AS=0.1584P AD=0.1152P
+ PS=1.6U PD=1U
M$883 \$406 \$1656 \$1562 VDD pfet_03v3 L=0.28U W=0.36U AS=0.1152P AD=0.1584P
+ PS=1U PD=1.6U
M$884 VDD RB11 \$1656 VDD pfet_03v3 L=0.28U W=0.72U AS=0.3708P AD=0.3168P
+ PS=2.47U PD=2.32U
M$885 \$1563 \$74 VDD VDD pfet_03v3 L=0.28U W=0.72U AS=0.3168P AD=0.2097P
+ PS=2.32U PD=1.38U
M$886 \$1564 \$1522 \$1563 VDD pfet_03v3 L=0.28U W=0.36U AS=0.2097P AD=0.1278P
+ PS=1.38U PD=1.07U
M$887 \$1818 \$1565 \$1564 VDD pfet_03v3 L=0.28U W=0.36U AS=0.1278P AD=0.0567P
+ PS=1.07U PD=0.675U
M$888 VDD \$1521 \$1818 VDD pfet_03v3 L=0.28U W=0.36U AS=0.0567P AD=0.1584P
+ PS=0.675U PD=1.6U
M$889 \$1565 \$1564 VDD VDD pfet_03v3 L=0.28U W=0.36U AS=0.1764P AD=0.1584P
+ PS=1.26U PD=1.6U
M$890 \$1566 \$1564 VDD VDD pfet_03v3 L=0.28U W=0.72U AS=0.1764P AD=0.36P
+ PS=1.26U PD=2.44U
M$891 \$1657 RA11 VDD VDD pfet_03v3 L=0.28U W=0.72U AS=0.3312P AD=0.3888P
+ PS=2.36U PD=2.52U
M$892 \$1566 \$1657 \$410 VDD pfet_03v3 L=0.28U W=0.36U AS=0.1584P AD=0.1152P
+ PS=1.6U PD=1U
M$893 \$411 \$1658 \$1566 VDD pfet_03v3 L=0.28U W=0.36U AS=0.1152P AD=0.1584P
+ PS=1U PD=1.6U
M$894 VDD RB11 \$1658 VDD pfet_03v3 L=0.28U W=0.72U AS=0.3708P AD=0.3168P
+ PS=2.47U PD=2.32U
M$895 \$1567 \$77 VDD VDD pfet_03v3 L=0.28U W=0.72U AS=0.3168P AD=0.2097P
+ PS=2.32U PD=1.38U
M$896 \$1568 \$1522 \$1567 VDD pfet_03v3 L=0.28U W=0.36U AS=0.2097P AD=0.1278P
+ PS=1.38U PD=1.07U
M$897 \$1826 \$1569 \$1568 VDD pfet_03v3 L=0.28U W=0.36U AS=0.1278P AD=0.0567P
+ PS=1.07U PD=0.675U
M$898 VDD \$1521 \$1826 VDD pfet_03v3 L=0.28U W=0.36U AS=0.0567P AD=0.1584P
+ PS=0.675U PD=1.6U
M$899 \$1569 \$1568 VDD VDD pfet_03v3 L=0.28U W=0.36U AS=0.1764P AD=0.1584P
+ PS=1.26U PD=1.6U
M$900 \$1570 \$1568 VDD VDD pfet_03v3 L=0.28U W=0.72U AS=0.1764P AD=0.36P
+ PS=1.26U PD=2.44U
M$901 \$1659 RA11 VDD VDD pfet_03v3 L=0.28U W=0.72U AS=0.3312P AD=0.3888P
+ PS=2.36U PD=2.52U
M$902 \$1570 \$1659 \$415 VDD pfet_03v3 L=0.28U W=0.36U AS=0.1584P AD=0.1152P
+ PS=1.6U PD=1U
M$903 \$416 \$1660 \$1570 VDD pfet_03v3 L=0.28U W=0.36U AS=0.1152P AD=0.1584P
+ PS=1U PD=1.6U
M$904 VDD RB11 \$1660 VDD pfet_03v3 L=0.28U W=0.72U AS=0.3708P AD=0.3168P
+ PS=2.47U PD=2.32U
M$905 \$1571 \$80 VDD VDD pfet_03v3 L=0.28U W=0.72U AS=0.3168P AD=0.2097P
+ PS=2.32U PD=1.38U
M$906 \$1572 \$1522 \$1571 VDD pfet_03v3 L=0.28U W=0.36U AS=0.2097P AD=0.1278P
+ PS=1.38U PD=1.07U
M$907 \$1812 \$1573 \$1572 VDD pfet_03v3 L=0.28U W=0.36U AS=0.1278P AD=0.0567P
+ PS=1.07U PD=0.675U
M$908 VDD \$1521 \$1812 VDD pfet_03v3 L=0.28U W=0.36U AS=0.0567P AD=0.1584P
+ PS=0.675U PD=1.6U
M$909 \$1573 \$1572 VDD VDD pfet_03v3 L=0.28U W=0.36U AS=0.1764P AD=0.1584P
+ PS=1.26U PD=1.6U
M$910 \$1574 \$1572 VDD VDD pfet_03v3 L=0.28U W=0.72U AS=0.1764P AD=0.36P
+ PS=1.26U PD=2.44U
M$911 \$1661 RA11 VDD VDD pfet_03v3 L=0.28U W=0.72U AS=0.3312P AD=0.3888P
+ PS=2.36U PD=2.52U
M$912 \$1574 \$1661 \$420 VDD pfet_03v3 L=0.28U W=0.36U AS=0.1584P AD=0.1152P
+ PS=1.6U PD=1U
M$913 \$421 \$1662 \$1574 VDD pfet_03v3 L=0.28U W=0.36U AS=0.1152P AD=0.1584P
+ PS=1U PD=1.6U
M$914 VDD RB11 \$1662 VDD pfet_03v3 L=0.28U W=0.72U AS=0.3708P AD=0.3168P
+ PS=2.47U PD=2.32U
M$915 \$1575 \$83 VDD VDD pfet_03v3 L=0.28U W=0.72U AS=0.3168P AD=0.2097P
+ PS=2.32U PD=1.38U
M$916 \$1576 \$1522 \$1575 VDD pfet_03v3 L=0.28U W=0.36U AS=0.2097P AD=0.1278P
+ PS=1.38U PD=1.07U
M$917 \$1784 \$1577 \$1576 VDD pfet_03v3 L=0.28U W=0.36U AS=0.1278P AD=0.0567P
+ PS=1.07U PD=0.675U
M$918 VDD \$1521 \$1784 VDD pfet_03v3 L=0.28U W=0.36U AS=0.0567P AD=0.1584P
+ PS=0.675U PD=1.6U
M$919 \$1577 \$1576 VDD VDD pfet_03v3 L=0.28U W=0.36U AS=0.1764P AD=0.1584P
+ PS=1.26U PD=1.6U
M$920 \$1578 \$1576 VDD VDD pfet_03v3 L=0.28U W=0.72U AS=0.1764P AD=0.36P
+ PS=1.26U PD=2.44U
M$921 \$1663 RA11 VDD VDD pfet_03v3 L=0.28U W=0.72U AS=0.3312P AD=0.3888P
+ PS=2.36U PD=2.52U
M$922 \$1578 \$1663 \$425 VDD pfet_03v3 L=0.28U W=0.36U AS=0.1584P AD=0.1152P
+ PS=1.6U PD=1U
M$923 \$426 \$1664 \$1578 VDD pfet_03v3 L=0.28U W=0.36U AS=0.1152P AD=0.1584P
+ PS=1U PD=1.6U
M$924 VDD RB11 \$1664 VDD pfet_03v3 L=0.28U W=0.72U AS=0.3708P AD=0.3168P
+ PS=2.47U PD=2.32U
M$925 \$1579 \$86 VDD VDD pfet_03v3 L=0.28U W=0.72U AS=0.3168P AD=0.2097P
+ PS=2.32U PD=1.38U
M$926 \$1580 \$1522 \$1579 VDD pfet_03v3 L=0.28U W=0.36U AS=0.2097P AD=0.1278P
+ PS=1.38U PD=1.07U
M$927 \$1766 \$1581 \$1580 VDD pfet_03v3 L=0.28U W=0.36U AS=0.1278P AD=0.0567P
+ PS=1.07U PD=0.675U
M$928 VDD \$1521 \$1766 VDD pfet_03v3 L=0.28U W=0.36U AS=0.0567P AD=0.1584P
+ PS=0.675U PD=1.6U
M$929 \$1581 \$1580 VDD VDD pfet_03v3 L=0.28U W=0.36U AS=0.1764P AD=0.1584P
+ PS=1.26U PD=1.6U
M$930 \$1582 \$1580 VDD VDD pfet_03v3 L=0.28U W=0.72U AS=0.1764P AD=0.36P
+ PS=1.26U PD=2.44U
M$931 \$1665 RA11 VDD VDD pfet_03v3 L=0.28U W=0.72U AS=0.3312P AD=0.3888P
+ PS=2.36U PD=2.52U
M$932 \$1582 \$1665 \$430 VDD pfet_03v3 L=0.28U W=0.36U AS=0.1584P AD=0.1152P
+ PS=1.6U PD=1U
M$933 \$431 \$1666 \$1582 VDD pfet_03v3 L=0.28U W=0.36U AS=0.1152P AD=0.1584P
+ PS=1U PD=1.6U
M$934 VDD RB11 \$1666 VDD pfet_03v3 L=0.28U W=0.72U AS=0.3708P AD=0.3168P
+ PS=2.47U PD=2.32U
M$935 \$1583 \$89 VDD VDD pfet_03v3 L=0.28U W=0.72U AS=0.3168P AD=0.2097P
+ PS=2.32U PD=1.38U
M$936 \$1584 \$1522 \$1583 VDD pfet_03v3 L=0.28U W=0.36U AS=0.2097P AD=0.1278P
+ PS=1.38U PD=1.07U
M$937 \$1738 \$1585 \$1584 VDD pfet_03v3 L=0.28U W=0.36U AS=0.1278P AD=0.0567P
+ PS=1.07U PD=0.675U
M$938 VDD \$1521 \$1738 VDD pfet_03v3 L=0.28U W=0.36U AS=0.0567P AD=0.1584P
+ PS=0.675U PD=1.6U
M$939 \$1585 \$1584 VDD VDD pfet_03v3 L=0.28U W=0.36U AS=0.1764P AD=0.1584P
+ PS=1.26U PD=1.6U
M$940 \$1586 \$1584 VDD VDD pfet_03v3 L=0.28U W=0.72U AS=0.1764P AD=0.36P
+ PS=1.26U PD=2.44U
M$941 \$1667 RA11 VDD VDD pfet_03v3 L=0.28U W=0.72U AS=0.3312P AD=0.3888P
+ PS=2.36U PD=2.52U
M$942 \$1586 \$1667 \$435 VDD pfet_03v3 L=0.28U W=0.36U AS=0.1584P AD=0.1152P
+ PS=1.6U PD=1U
M$943 \$436 \$1668 \$1586 VDD pfet_03v3 L=0.28U W=0.36U AS=0.1152P AD=0.1584P
+ PS=1U PD=1.6U
M$944 VDD RB11 \$1668 VDD pfet_03v3 L=0.28U W=0.72U AS=0.3708P AD=0.3168P
+ PS=2.47U PD=2.32U
M$945 \$1830 WE10 VDD VDD pfet_03v3 L=0.28U W=0.72U AS=0.3168P AD=0.1872P
+ PS=2.32U PD=1.24U
M$946 VDD CLK \$1830 VDD pfet_03v3 L=0.28U W=0.72U AS=0.1872P AD=0.3168P
+ PS=1.24U PD=2.32U
M$947 \$1832 \$1830 VDD VDD pfet_03v3 L=0.28U W=2.54U AS=0.889P AD=0.6688P
+ PS=5.21U PD=3.65U
M$949 \$1833 \$1832 VDD VDD pfet_03v3 L=0.28U W=2.68U AS=0.7272P AD=0.9782P
+ PS=3.78U PD=5.48U
M$951 \$1837 \$1833 \$1836 VDD pfet_03v3 L=0.28U W=0.36U AS=0.2097P AD=0.1278P
+ PS=1.38U PD=1.07U
M$952 \$1937 \$1838 \$1837 VDD pfet_03v3 L=0.28U W=0.36U AS=0.1278P AD=0.0567P
+ PS=1.07U PD=0.675U
M$953 VDD \$1832 \$1937 VDD pfet_03v3 L=0.28U W=0.36U AS=0.0567P AD=0.1584P
+ PS=0.675U PD=1.6U
M$954 \$1836 \$44 VDD VDD pfet_03v3 L=0.28U W=0.72U AS=0.3168P AD=0.2097P
+ PS=2.32U PD=1.38U
M$955 VDD \$1837 \$1838 VDD pfet_03v3 L=0.28U W=0.36U AS=0.1584P AD=0.1764P
+ PS=1.6U PD=1.26U
M$956 \$1839 \$1837 VDD VDD pfet_03v3 L=0.28U W=0.72U AS=0.1764P AD=0.36P
+ PS=1.26U PD=2.44U
M$957 \$1840 RB10 VDD VDD pfet_03v3 L=0.28U W=0.72U AS=0.3312P AD=0.3888P
+ PS=2.36U PD=2.52U
M$958 \$1839 \$1840 \$360 VDD pfet_03v3 L=0.28U W=0.36U AS=0.1584P AD=0.1152P
+ PS=1.6U PD=1U
M$959 \$361 \$1841 \$1839 VDD pfet_03v3 L=0.28U W=0.36U AS=0.1152P AD=0.1584P
+ PS=1U PD=1.6U
M$960 VDD RA10 \$1841 VDD pfet_03v3 L=0.28U W=0.72U AS=0.3708P AD=0.3168P
+ PS=2.47U PD=2.32U
M$961 \$1843 \$1833 \$1842 VDD pfet_03v3 L=0.28U W=0.36U AS=0.2097P AD=0.1278P
+ PS=1.38U PD=1.07U
M$962 \$1945 \$1844 \$1843 VDD pfet_03v3 L=0.28U W=0.36U AS=0.1278P AD=0.0567P
+ PS=1.07U PD=0.675U
M$963 VDD \$1832 \$1945 VDD pfet_03v3 L=0.28U W=0.36U AS=0.0567P AD=0.1584P
+ PS=0.675U PD=1.6U
M$964 \$1842 \$47 VDD VDD pfet_03v3 L=0.28U W=0.72U AS=0.3168P AD=0.2097P
+ PS=2.32U PD=1.38U
M$965 VDD \$1843 \$1844 VDD pfet_03v3 L=0.28U W=0.36U AS=0.1584P AD=0.1764P
+ PS=1.6U PD=1.26U
M$966 \$1845 \$1843 VDD VDD pfet_03v3 L=0.28U W=0.72U AS=0.1764P AD=0.36P
+ PS=1.26U PD=2.44U
M$967 \$1846 RB10 VDD VDD pfet_03v3 L=0.28U W=0.72U AS=0.3312P AD=0.3888P
+ PS=2.36U PD=2.52U
M$968 \$1845 \$1846 \$365 VDD pfet_03v3 L=0.28U W=0.36U AS=0.1584P AD=0.1152P
+ PS=1.6U PD=1U
M$969 \$366 \$1847 \$1845 VDD pfet_03v3 L=0.28U W=0.36U AS=0.1152P AD=0.1584P
+ PS=1U PD=1.6U
M$970 VDD RA10 \$1847 VDD pfet_03v3 L=0.28U W=0.72U AS=0.3708P AD=0.3168P
+ PS=2.47U PD=2.32U
M$971 \$1849 \$1833 \$1848 VDD pfet_03v3 L=0.28U W=0.36U AS=0.2097P AD=0.1278P
+ PS=1.38U PD=1.07U
M$972 \$1952 \$1850 \$1849 VDD pfet_03v3 L=0.28U W=0.36U AS=0.1278P AD=0.0567P
+ PS=1.07U PD=0.675U
M$973 VDD \$1832 \$1952 VDD pfet_03v3 L=0.28U W=0.36U AS=0.0567P AD=0.1584P
+ PS=0.675U PD=1.6U
M$974 \$1848 \$50 VDD VDD pfet_03v3 L=0.28U W=0.72U AS=0.3168P AD=0.2097P
+ PS=2.32U PD=1.38U
M$975 VDD \$1849 \$1850 VDD pfet_03v3 L=0.28U W=0.36U AS=0.1584P AD=0.1764P
+ PS=1.6U PD=1.26U
M$976 \$1851 \$1849 VDD VDD pfet_03v3 L=0.28U W=0.72U AS=0.1764P AD=0.36P
+ PS=1.26U PD=2.44U
M$977 \$1852 RB10 VDD VDD pfet_03v3 L=0.28U W=0.72U AS=0.3312P AD=0.3888P
+ PS=2.36U PD=2.52U
M$978 \$1851 \$1852 \$370 VDD pfet_03v3 L=0.28U W=0.36U AS=0.1584P AD=0.1152P
+ PS=1.6U PD=1U
M$979 \$371 \$1853 \$1851 VDD pfet_03v3 L=0.28U W=0.36U AS=0.1152P AD=0.1584P
+ PS=1U PD=1.6U
M$980 VDD RA10 \$1853 VDD pfet_03v3 L=0.28U W=0.72U AS=0.3708P AD=0.3168P
+ PS=2.47U PD=2.32U
M$981 \$1855 \$1833 \$1854 VDD pfet_03v3 L=0.28U W=0.36U AS=0.2097P AD=0.1278P
+ PS=1.38U PD=1.07U
M$982 \$1960 \$1856 \$1855 VDD pfet_03v3 L=0.28U W=0.36U AS=0.1278P AD=0.0567P
+ PS=1.07U PD=0.675U
M$983 VDD \$1832 \$1960 VDD pfet_03v3 L=0.28U W=0.36U AS=0.0567P AD=0.1584P
+ PS=0.675U PD=1.6U
M$984 \$1854 \$53 VDD VDD pfet_03v3 L=0.28U W=0.72U AS=0.3168P AD=0.2097P
+ PS=2.32U PD=1.38U
M$985 VDD \$1855 \$1856 VDD pfet_03v3 L=0.28U W=0.36U AS=0.1584P AD=0.1764P
+ PS=1.6U PD=1.26U
M$986 \$1857 \$1855 VDD VDD pfet_03v3 L=0.28U W=0.72U AS=0.1764P AD=0.36P
+ PS=1.26U PD=2.44U
M$987 \$1858 RB10 VDD VDD pfet_03v3 L=0.28U W=0.72U AS=0.3312P AD=0.3888P
+ PS=2.36U PD=2.52U
M$988 \$1857 \$1858 \$375 VDD pfet_03v3 L=0.28U W=0.36U AS=0.1584P AD=0.1152P
+ PS=1.6U PD=1U
M$989 \$376 \$1859 \$1857 VDD pfet_03v3 L=0.28U W=0.36U AS=0.1152P AD=0.1584P
+ PS=1U PD=1.6U
M$990 VDD RA10 \$1859 VDD pfet_03v3 L=0.28U W=0.72U AS=0.3708P AD=0.3168P
+ PS=2.47U PD=2.32U
M$991 \$1861 \$1833 \$1860 VDD pfet_03v3 L=0.28U W=0.36U AS=0.2097P AD=0.1278P
+ PS=1.38U PD=1.07U
M$992 \$1969 \$1862 \$1861 VDD pfet_03v3 L=0.28U W=0.36U AS=0.1278P AD=0.0567P
+ PS=1.07U PD=0.675U
M$993 VDD \$1832 \$1969 VDD pfet_03v3 L=0.28U W=0.36U AS=0.0567P AD=0.1584P
+ PS=0.675U PD=1.6U
M$994 \$1860 \$56 VDD VDD pfet_03v3 L=0.28U W=0.72U AS=0.3168P AD=0.2097P
+ PS=2.32U PD=1.38U
M$995 VDD \$1861 \$1862 VDD pfet_03v3 L=0.28U W=0.36U AS=0.1584P AD=0.1764P
+ PS=1.6U PD=1.26U
M$996 \$1863 \$1861 VDD VDD pfet_03v3 L=0.28U W=0.72U AS=0.1764P AD=0.36P
+ PS=1.26U PD=2.44U
M$997 \$1864 RB10 VDD VDD pfet_03v3 L=0.28U W=0.72U AS=0.3312P AD=0.3888P
+ PS=2.36U PD=2.52U
M$998 \$1863 \$1864 \$380 VDD pfet_03v3 L=0.28U W=0.36U AS=0.1584P AD=0.1152P
+ PS=1.6U PD=1U
M$999 \$381 \$1865 \$1863 VDD pfet_03v3 L=0.28U W=0.36U AS=0.1152P AD=0.1584P
+ PS=1U PD=1.6U
M$1000 VDD RA10 \$1865 VDD pfet_03v3 L=0.28U W=0.72U AS=0.3708P AD=0.3168P
+ PS=2.47U PD=2.32U
M$1001 \$1867 \$1833 \$1866 VDD pfet_03v3 L=0.28U W=0.36U AS=0.2097P AD=0.1278P
+ PS=1.38U PD=1.07U
M$1002 \$1975 \$1868 \$1867 VDD pfet_03v3 L=0.28U W=0.36U AS=0.1278P AD=0.0567P
+ PS=1.07U PD=0.675U
M$1003 VDD \$1832 \$1975 VDD pfet_03v3 L=0.28U W=0.36U AS=0.0567P AD=0.1584P
+ PS=0.675U PD=1.6U
M$1004 \$1866 \$59 VDD VDD pfet_03v3 L=0.28U W=0.72U AS=0.3168P AD=0.2097P
+ PS=2.32U PD=1.38U
M$1005 VDD \$1867 \$1868 VDD pfet_03v3 L=0.28U W=0.36U AS=0.1584P AD=0.1764P
+ PS=1.6U PD=1.26U
M$1006 \$1869 \$1867 VDD VDD pfet_03v3 L=0.28U W=0.72U AS=0.1764P AD=0.36P
+ PS=1.26U PD=2.44U
M$1007 \$1870 RB10 VDD VDD pfet_03v3 L=0.28U W=0.72U AS=0.3312P AD=0.3888P
+ PS=2.36U PD=2.52U
M$1008 \$1869 \$1870 \$385 VDD pfet_03v3 L=0.28U W=0.36U AS=0.1584P AD=0.1152P
+ PS=1.6U PD=1U
M$1009 \$386 \$1871 \$1869 VDD pfet_03v3 L=0.28U W=0.36U AS=0.1152P AD=0.1584P
+ PS=1U PD=1.6U
M$1010 VDD RA10 \$1871 VDD pfet_03v3 L=0.28U W=0.72U AS=0.3708P AD=0.3168P
+ PS=2.47U PD=2.32U
M$1011 \$1873 \$1833 \$1872 VDD pfet_03v3 L=0.28U W=0.36U AS=0.2097P AD=0.1278P
+ PS=1.38U PD=1.07U
M$1012 \$1982 \$1874 \$1873 VDD pfet_03v3 L=0.28U W=0.36U AS=0.1278P AD=0.0567P
+ PS=1.07U PD=0.675U
M$1013 VDD \$1832 \$1982 VDD pfet_03v3 L=0.28U W=0.36U AS=0.0567P AD=0.1584P
+ PS=0.675U PD=1.6U
M$1014 \$1872 \$62 VDD VDD pfet_03v3 L=0.28U W=0.72U AS=0.3168P AD=0.2097P
+ PS=2.32U PD=1.38U
M$1015 VDD \$1873 \$1874 VDD pfet_03v3 L=0.28U W=0.36U AS=0.1584P AD=0.1764P
+ PS=1.6U PD=1.26U
M$1016 \$1875 \$1873 VDD VDD pfet_03v3 L=0.28U W=0.72U AS=0.1764P AD=0.36P
+ PS=1.26U PD=2.44U
M$1017 \$1876 RB10 VDD VDD pfet_03v3 L=0.28U W=0.72U AS=0.3312P AD=0.3888P
+ PS=2.36U PD=2.52U
M$1018 \$1875 \$1876 \$390 VDD pfet_03v3 L=0.28U W=0.36U AS=0.1584P AD=0.1152P
+ PS=1.6U PD=1U
M$1019 \$391 \$1877 \$1875 VDD pfet_03v3 L=0.28U W=0.36U AS=0.1152P AD=0.1584P
+ PS=1U PD=1.6U
M$1020 VDD RA10 \$1877 VDD pfet_03v3 L=0.28U W=0.72U AS=0.3708P AD=0.3168P
+ PS=2.47U PD=2.32U
M$1021 \$1879 \$1833 \$1878 VDD pfet_03v3 L=0.28U W=0.36U AS=0.2097P AD=0.1278P
+ PS=1.38U PD=1.07U
M$1022 \$1991 \$1880 \$1879 VDD pfet_03v3 L=0.28U W=0.36U AS=0.1278P AD=0.0567P
+ PS=1.07U PD=0.675U
M$1023 VDD \$1832 \$1991 VDD pfet_03v3 L=0.28U W=0.36U AS=0.0567P AD=0.1584P
+ PS=0.675U PD=1.6U
M$1024 \$1878 \$65 VDD VDD pfet_03v3 L=0.28U W=0.72U AS=0.3168P AD=0.2097P
+ PS=2.32U PD=1.38U
M$1025 VDD \$1879 \$1880 VDD pfet_03v3 L=0.28U W=0.36U AS=0.1584P AD=0.1764P
+ PS=1.6U PD=1.26U
M$1026 \$1881 \$1879 VDD VDD pfet_03v3 L=0.28U W=0.72U AS=0.1764P AD=0.36P
+ PS=1.26U PD=2.44U
M$1027 \$1882 RB10 VDD VDD pfet_03v3 L=0.28U W=0.72U AS=0.3312P AD=0.3888P
+ PS=2.36U PD=2.52U
M$1028 \$1881 \$1882 \$395 VDD pfet_03v3 L=0.28U W=0.36U AS=0.1584P AD=0.1152P
+ PS=1.6U PD=1U
M$1029 \$396 \$1883 \$1881 VDD pfet_03v3 L=0.28U W=0.36U AS=0.1152P AD=0.1584P
+ PS=1U PD=1.6U
M$1030 VDD RA10 \$1883 VDD pfet_03v3 L=0.28U W=0.72U AS=0.3708P AD=0.3168P
+ PS=2.47U PD=2.32U
M$1031 \$1885 \$1833 \$1884 VDD pfet_03v3 L=0.28U W=0.36U AS=0.2097P AD=0.1278P
+ PS=1.38U PD=1.07U
M$1032 \$1997 \$1886 \$1885 VDD pfet_03v3 L=0.28U W=0.36U AS=0.1278P AD=0.0567P
+ PS=1.07U PD=0.675U
M$1033 VDD \$1832 \$1997 VDD pfet_03v3 L=0.28U W=0.36U AS=0.0567P AD=0.1584P
+ PS=0.675U PD=1.6U
M$1034 \$1884 \$68 VDD VDD pfet_03v3 L=0.28U W=0.72U AS=0.3168P AD=0.2097P
+ PS=2.32U PD=1.38U
M$1035 VDD \$1885 \$1886 VDD pfet_03v3 L=0.28U W=0.36U AS=0.1584P AD=0.1764P
+ PS=1.6U PD=1.26U
M$1036 \$1887 \$1885 VDD VDD pfet_03v3 L=0.28U W=0.72U AS=0.1764P AD=0.36P
+ PS=1.26U PD=2.44U
M$1037 \$1888 RB10 VDD VDD pfet_03v3 L=0.28U W=0.72U AS=0.3312P AD=0.3888P
+ PS=2.36U PD=2.52U
M$1038 \$1887 \$1888 \$400 VDD pfet_03v3 L=0.28U W=0.36U AS=0.1584P AD=0.1152P
+ PS=1.6U PD=1U
M$1039 \$401 \$1889 \$1887 VDD pfet_03v3 L=0.28U W=0.36U AS=0.1152P AD=0.1584P
+ PS=1U PD=1.6U
M$1040 VDD RA10 \$1889 VDD pfet_03v3 L=0.28U W=0.72U AS=0.3708P AD=0.3168P
+ PS=2.47U PD=2.32U
M$1041 \$1891 \$1833 \$1890 VDD pfet_03v3 L=0.28U W=0.36U AS=0.2097P AD=0.1278P
+ PS=1.38U PD=1.07U
M$1042 \$2004 \$1892 \$1891 VDD pfet_03v3 L=0.28U W=0.36U AS=0.1278P AD=0.0567P
+ PS=1.07U PD=0.675U
M$1043 VDD \$1832 \$2004 VDD pfet_03v3 L=0.28U W=0.36U AS=0.0567P AD=0.1584P
+ PS=0.675U PD=1.6U
M$1044 \$1890 \$71 VDD VDD pfet_03v3 L=0.28U W=0.72U AS=0.3168P AD=0.2097P
+ PS=2.32U PD=1.38U
M$1045 VDD \$1891 \$1892 VDD pfet_03v3 L=0.28U W=0.36U AS=0.1584P AD=0.1764P
+ PS=1.6U PD=1.26U
M$1046 \$1893 \$1891 VDD VDD pfet_03v3 L=0.28U W=0.72U AS=0.1764P AD=0.36P
+ PS=1.26U PD=2.44U
M$1047 \$1894 RB10 VDD VDD pfet_03v3 L=0.28U W=0.72U AS=0.3312P AD=0.3888P
+ PS=2.36U PD=2.52U
M$1048 \$1893 \$1894 \$405 VDD pfet_03v3 L=0.28U W=0.36U AS=0.1584P AD=0.1152P
+ PS=1.6U PD=1U
M$1049 \$406 \$1895 \$1893 VDD pfet_03v3 L=0.28U W=0.36U AS=0.1152P AD=0.1584P
+ PS=1U PD=1.6U
M$1050 VDD RA10 \$1895 VDD pfet_03v3 L=0.28U W=0.72U AS=0.3708P AD=0.3168P
+ PS=2.47U PD=2.32U
M$1051 \$1897 \$1833 \$1896 VDD pfet_03v3 L=0.28U W=0.36U AS=0.2097P AD=0.1278P
+ PS=1.38U PD=1.07U
M$1052 \$2012 \$1898 \$1897 VDD pfet_03v3 L=0.28U W=0.36U AS=0.1278P AD=0.0567P
+ PS=1.07U PD=0.675U
M$1053 VDD \$1832 \$2012 VDD pfet_03v3 L=0.28U W=0.36U AS=0.0567P AD=0.1584P
+ PS=0.675U PD=1.6U
M$1054 \$1896 \$74 VDD VDD pfet_03v3 L=0.28U W=0.72U AS=0.3168P AD=0.2097P
+ PS=2.32U PD=1.38U
M$1055 VDD \$1897 \$1898 VDD pfet_03v3 L=0.28U W=0.36U AS=0.1584P AD=0.1764P
+ PS=1.6U PD=1.26U
M$1056 \$1899 \$1897 VDD VDD pfet_03v3 L=0.28U W=0.72U AS=0.1764P AD=0.36P
+ PS=1.26U PD=2.44U
M$1057 \$1900 RB10 VDD VDD pfet_03v3 L=0.28U W=0.72U AS=0.3312P AD=0.3888P
+ PS=2.36U PD=2.52U
M$1058 \$1899 \$1900 \$410 VDD pfet_03v3 L=0.28U W=0.36U AS=0.1584P AD=0.1152P
+ PS=1.6U PD=1U
M$1059 \$411 \$1901 \$1899 VDD pfet_03v3 L=0.28U W=0.36U AS=0.1152P AD=0.1584P
+ PS=1U PD=1.6U
M$1060 VDD RA10 \$1901 VDD pfet_03v3 L=0.28U W=0.72U AS=0.3708P AD=0.3168P
+ PS=2.47U PD=2.32U
M$1061 \$1903 \$1833 \$1902 VDD pfet_03v3 L=0.28U W=0.36U AS=0.2097P AD=0.1278P
+ PS=1.38U PD=1.07U
M$1062 \$2020 \$1904 \$1903 VDD pfet_03v3 L=0.28U W=0.36U AS=0.1278P AD=0.0567P
+ PS=1.07U PD=0.675U
M$1063 VDD \$1832 \$2020 VDD pfet_03v3 L=0.28U W=0.36U AS=0.0567P AD=0.1584P
+ PS=0.675U PD=1.6U
M$1064 \$1902 \$77 VDD VDD pfet_03v3 L=0.28U W=0.72U AS=0.3168P AD=0.2097P
+ PS=2.32U PD=1.38U
M$1065 VDD \$1903 \$1904 VDD pfet_03v3 L=0.28U W=0.36U AS=0.1584P AD=0.1764P
+ PS=1.6U PD=1.26U
M$1066 \$1905 \$1903 VDD VDD pfet_03v3 L=0.28U W=0.72U AS=0.1764P AD=0.36P
+ PS=1.26U PD=2.44U
M$1067 \$1906 RB10 VDD VDD pfet_03v3 L=0.28U W=0.72U AS=0.3312P AD=0.3888P
+ PS=2.36U PD=2.52U
M$1068 \$1905 \$1906 \$415 VDD pfet_03v3 L=0.28U W=0.36U AS=0.1584P AD=0.1152P
+ PS=1.6U PD=1U
M$1069 \$416 \$1907 \$1905 VDD pfet_03v3 L=0.28U W=0.36U AS=0.1152P AD=0.1584P
+ PS=1U PD=1.6U
M$1070 VDD RA10 \$1907 VDD pfet_03v3 L=0.28U W=0.72U AS=0.3708P AD=0.3168P
+ PS=2.47U PD=2.32U
M$1071 \$1909 \$1833 \$1908 VDD pfet_03v3 L=0.28U W=0.36U AS=0.2097P AD=0.1278P
+ PS=1.38U PD=1.07U
M$1072 \$2027 \$1910 \$1909 VDD pfet_03v3 L=0.28U W=0.36U AS=0.1278P AD=0.0567P
+ PS=1.07U PD=0.675U
M$1073 VDD \$1832 \$2027 VDD pfet_03v3 L=0.28U W=0.36U AS=0.0567P AD=0.1584P
+ PS=0.675U PD=1.6U
M$1074 \$1908 \$80 VDD VDD pfet_03v3 L=0.28U W=0.72U AS=0.3168P AD=0.2097P
+ PS=2.32U PD=1.38U
M$1075 VDD \$1909 \$1910 VDD pfet_03v3 L=0.28U W=0.36U AS=0.1584P AD=0.1764P
+ PS=1.6U PD=1.26U
M$1076 \$1911 \$1909 VDD VDD pfet_03v3 L=0.28U W=0.72U AS=0.1764P AD=0.36P
+ PS=1.26U PD=2.44U
M$1077 \$1912 RB10 VDD VDD pfet_03v3 L=0.28U W=0.72U AS=0.3312P AD=0.3888P
+ PS=2.36U PD=2.52U
M$1078 \$1911 \$1912 \$420 VDD pfet_03v3 L=0.28U W=0.36U AS=0.1584P AD=0.1152P
+ PS=1.6U PD=1U
M$1079 \$421 \$1913 \$1911 VDD pfet_03v3 L=0.28U W=0.36U AS=0.1152P AD=0.1584P
+ PS=1U PD=1.6U
M$1080 VDD RA10 \$1913 VDD pfet_03v3 L=0.28U W=0.72U AS=0.3708P AD=0.3168P
+ PS=2.47U PD=2.32U
M$1081 \$1915 \$1833 \$1914 VDD pfet_03v3 L=0.28U W=0.36U AS=0.2097P AD=0.1278P
+ PS=1.38U PD=1.07U
M$1082 \$2026 \$1916 \$1915 VDD pfet_03v3 L=0.28U W=0.36U AS=0.1278P AD=0.0567P
+ PS=1.07U PD=0.675U
M$1083 VDD \$1832 \$2026 VDD pfet_03v3 L=0.28U W=0.36U AS=0.0567P AD=0.1584P
+ PS=0.675U PD=1.6U
M$1084 \$1914 \$83 VDD VDD pfet_03v3 L=0.28U W=0.72U AS=0.3168P AD=0.2097P
+ PS=2.32U PD=1.38U
M$1085 VDD \$1915 \$1916 VDD pfet_03v3 L=0.28U W=0.36U AS=0.1584P AD=0.1764P
+ PS=1.6U PD=1.26U
M$1086 \$1917 \$1915 VDD VDD pfet_03v3 L=0.28U W=0.72U AS=0.1764P AD=0.36P
+ PS=1.26U PD=2.44U
M$1087 \$1918 RB10 VDD VDD pfet_03v3 L=0.28U W=0.72U AS=0.3312P AD=0.3888P
+ PS=2.36U PD=2.52U
M$1088 \$1917 \$1918 \$425 VDD pfet_03v3 L=0.28U W=0.36U AS=0.1584P AD=0.1152P
+ PS=1.6U PD=1U
M$1089 \$426 \$1919 \$1917 VDD pfet_03v3 L=0.28U W=0.36U AS=0.1152P AD=0.1584P
+ PS=1U PD=1.6U
M$1090 VDD RA10 \$1919 VDD pfet_03v3 L=0.28U W=0.72U AS=0.3708P AD=0.3168P
+ PS=2.47U PD=2.32U
M$1091 \$1921 \$1833 \$1920 VDD pfet_03v3 L=0.28U W=0.36U AS=0.2097P AD=0.1278P
+ PS=1.38U PD=1.07U
M$1092 \$1994 \$1922 \$1921 VDD pfet_03v3 L=0.28U W=0.36U AS=0.1278P AD=0.0567P
+ PS=1.07U PD=0.675U
M$1093 VDD \$1832 \$1994 VDD pfet_03v3 L=0.28U W=0.36U AS=0.0567P AD=0.1584P
+ PS=0.675U PD=1.6U
M$1094 \$1920 \$86 VDD VDD pfet_03v3 L=0.28U W=0.72U AS=0.3168P AD=0.2097P
+ PS=2.32U PD=1.38U
M$1095 VDD \$1921 \$1922 VDD pfet_03v3 L=0.28U W=0.36U AS=0.1584P AD=0.1764P
+ PS=1.6U PD=1.26U
M$1096 \$1923 \$1921 VDD VDD pfet_03v3 L=0.28U W=0.72U AS=0.1764P AD=0.36P
+ PS=1.26U PD=2.44U
M$1097 \$1924 RB10 VDD VDD pfet_03v3 L=0.28U W=0.72U AS=0.3312P AD=0.3888P
+ PS=2.36U PD=2.52U
M$1098 \$1923 \$1924 \$430 VDD pfet_03v3 L=0.28U W=0.36U AS=0.1584P AD=0.1152P
+ PS=1.6U PD=1U
M$1099 \$431 \$1925 \$1923 VDD pfet_03v3 L=0.28U W=0.36U AS=0.1152P AD=0.1584P
+ PS=1U PD=1.6U
M$1100 VDD RA10 \$1925 VDD pfet_03v3 L=0.28U W=0.72U AS=0.3708P AD=0.3168P
+ PS=2.47U PD=2.32U
M$1101 \$1927 \$1833 \$1926 VDD pfet_03v3 L=0.28U W=0.36U AS=0.2097P AD=0.1278P
+ PS=1.38U PD=1.07U
M$1102 \$1961 \$1928 \$1927 VDD pfet_03v3 L=0.28U W=0.36U AS=0.1278P AD=0.0567P
+ PS=1.07U PD=0.675U
M$1103 VDD \$1832 \$1961 VDD pfet_03v3 L=0.28U W=0.36U AS=0.0567P AD=0.1584P
+ PS=0.675U PD=1.6U
M$1104 \$1926 \$89 VDD VDD pfet_03v3 L=0.28U W=0.72U AS=0.3168P AD=0.2097P
+ PS=2.32U PD=1.38U
M$1105 VDD \$1927 \$1928 VDD pfet_03v3 L=0.28U W=0.36U AS=0.1584P AD=0.1764P
+ PS=1.6U PD=1.26U
M$1106 \$1929 \$1927 VDD VDD pfet_03v3 L=0.28U W=0.72U AS=0.1764P AD=0.36P
+ PS=1.26U PD=2.44U
M$1107 \$1930 RB10 VDD VDD pfet_03v3 L=0.28U W=0.72U AS=0.3312P AD=0.3888P
+ PS=2.36U PD=2.52U
M$1108 \$1929 \$1930 \$435 VDD pfet_03v3 L=0.28U W=0.36U AS=0.1584P AD=0.1152P
+ PS=1.6U PD=1U
M$1109 \$436 \$1931 \$1929 VDD pfet_03v3 L=0.28U W=0.36U AS=0.1152P AD=0.1584P
+ PS=1U PD=1.6U
M$1110 VDD RA10 \$1931 VDD pfet_03v3 L=0.28U W=0.72U AS=0.3708P AD=0.3168P
+ PS=2.47U PD=2.32U
M$1111 \$2133 WE9 VDD VDD pfet_03v3 L=0.28U W=0.72U AS=0.3168P AD=0.1872P
+ PS=2.32U PD=1.24U
M$1112 VDD CLK \$2133 VDD pfet_03v3 L=0.28U W=0.72U AS=0.1872P AD=0.3168P
+ PS=1.24U PD=2.32U
M$1113 \$2134 \$2133 VDD VDD pfet_03v3 L=0.28U W=2.54U AS=0.8974P AD=0.6604P
+ PS=5.28U PD=3.58U
M$1115 \$2135 \$2134 VDD VDD pfet_03v3 L=0.28U W=2.68U AS=0.7272P AD=0.9782P
+ PS=3.78U PD=5.48U
M$1117 \$2136 \$44 VDD VDD pfet_03v3 L=0.28U W=0.72U AS=0.3168P AD=0.2097P
+ PS=2.32U PD=1.38U
M$1118 \$2137 \$2135 \$2136 VDD pfet_03v3 L=0.28U W=0.36U AS=0.2097P AD=0.1278P
+ PS=1.38U PD=1.07U
M$1119 \$2343 \$2138 \$2137 VDD pfet_03v3 L=0.28U W=0.36U AS=0.1278P AD=0.0567P
+ PS=1.07U PD=0.675U
M$1120 VDD \$2134 \$2343 VDD pfet_03v3 L=0.28U W=0.36U AS=0.0567P AD=0.1584P
+ PS=0.675U PD=1.6U
M$1121 \$2138 \$2137 VDD VDD pfet_03v3 L=0.28U W=0.36U AS=0.1764P AD=0.1584P
+ PS=1.26U PD=1.6U
M$1122 \$2139 \$2137 VDD VDD pfet_03v3 L=0.28U W=0.72U AS=0.1764P AD=0.36P
+ PS=1.26U PD=2.44U
M$1123 \$2250 RA9 VDD VDD pfet_03v3 L=0.28U W=0.72U AS=0.3312P AD=0.3888P
+ PS=2.36U PD=2.52U
M$1124 \$2139 \$2250 \$360 VDD pfet_03v3 L=0.28U W=0.36U AS=0.1584P AD=0.1152P
+ PS=1.6U PD=1U
M$1125 \$361 \$2251 \$2139 VDD pfet_03v3 L=0.28U W=0.36U AS=0.1152P AD=0.1584P
+ PS=1U PD=1.6U
M$1126 VDD RB9 \$2251 VDD pfet_03v3 L=0.28U W=0.72U AS=0.3708P AD=0.3168P
+ PS=2.47U PD=2.32U
M$1127 \$2140 \$47 VDD VDD pfet_03v3 L=0.28U W=0.72U AS=0.3168P AD=0.2097P
+ PS=2.32U PD=1.38U
M$1128 \$2141 \$2135 \$2140 VDD pfet_03v3 L=0.28U W=0.36U AS=0.2097P AD=0.1278P
+ PS=1.38U PD=1.07U
M$1129 \$2353 \$2142 \$2141 VDD pfet_03v3 L=0.28U W=0.36U AS=0.1278P AD=0.0567P
+ PS=1.07U PD=0.675U
M$1130 VDD \$2134 \$2353 VDD pfet_03v3 L=0.28U W=0.36U AS=0.0567P AD=0.1584P
+ PS=0.675U PD=1.6U
M$1131 \$2142 \$2141 VDD VDD pfet_03v3 L=0.28U W=0.36U AS=0.1764P AD=0.1584P
+ PS=1.26U PD=1.6U
M$1132 \$2143 \$2141 VDD VDD pfet_03v3 L=0.28U W=0.72U AS=0.1764P AD=0.36P
+ PS=1.26U PD=2.44U
M$1133 \$2252 RA9 VDD VDD pfet_03v3 L=0.28U W=0.72U AS=0.3312P AD=0.3888P
+ PS=2.36U PD=2.52U
M$1134 \$2143 \$2252 \$365 VDD pfet_03v3 L=0.28U W=0.36U AS=0.1584P AD=0.1152P
+ PS=1.6U PD=1U
M$1135 \$366 \$2253 \$2143 VDD pfet_03v3 L=0.28U W=0.36U AS=0.1152P AD=0.1584P
+ PS=1U PD=1.6U
M$1136 VDD RB9 \$2253 VDD pfet_03v3 L=0.28U W=0.72U AS=0.3708P AD=0.3168P
+ PS=2.47U PD=2.32U
M$1137 \$2144 \$50 VDD VDD pfet_03v3 L=0.28U W=0.72U AS=0.3168P AD=0.2097P
+ PS=2.32U PD=1.38U
M$1138 \$2145 \$2135 \$2144 VDD pfet_03v3 L=0.28U W=0.36U AS=0.2097P AD=0.1278P
+ PS=1.38U PD=1.07U
M$1139 \$2359 \$2146 \$2145 VDD pfet_03v3 L=0.28U W=0.36U AS=0.1278P AD=0.0567P
+ PS=1.07U PD=0.675U
M$1140 VDD \$2134 \$2359 VDD pfet_03v3 L=0.28U W=0.36U AS=0.0567P AD=0.1584P
+ PS=0.675U PD=1.6U
M$1141 \$2146 \$2145 VDD VDD pfet_03v3 L=0.28U W=0.36U AS=0.1764P AD=0.1584P
+ PS=1.26U PD=1.6U
M$1142 \$2147 \$2145 VDD VDD pfet_03v3 L=0.28U W=0.72U AS=0.1764P AD=0.36P
+ PS=1.26U PD=2.44U
M$1143 \$2254 RA9 VDD VDD pfet_03v3 L=0.28U W=0.72U AS=0.3312P AD=0.3888P
+ PS=2.36U PD=2.52U
M$1144 \$2147 \$2254 \$370 VDD pfet_03v3 L=0.28U W=0.36U AS=0.1584P AD=0.1152P
+ PS=1.6U PD=1U
M$1145 \$371 \$2255 \$2147 VDD pfet_03v3 L=0.28U W=0.36U AS=0.1152P AD=0.1584P
+ PS=1U PD=1.6U
M$1146 VDD RB9 \$2255 VDD pfet_03v3 L=0.28U W=0.72U AS=0.3708P AD=0.3168P
+ PS=2.47U PD=2.32U
M$1147 \$2148 \$53 VDD VDD pfet_03v3 L=0.28U W=0.72U AS=0.3168P AD=0.2097P
+ PS=2.32U PD=1.38U
M$1148 \$2149 \$2135 \$2148 VDD pfet_03v3 L=0.28U W=0.36U AS=0.2097P AD=0.1278P
+ PS=1.38U PD=1.07U
M$1149 \$2369 \$2150 \$2149 VDD pfet_03v3 L=0.28U W=0.36U AS=0.1278P AD=0.0567P
+ PS=1.07U PD=0.675U
M$1150 VDD \$2134 \$2369 VDD pfet_03v3 L=0.28U W=0.36U AS=0.0567P AD=0.1584P
+ PS=0.675U PD=1.6U
M$1151 \$2150 \$2149 VDD VDD pfet_03v3 L=0.28U W=0.36U AS=0.1764P AD=0.1584P
+ PS=1.26U PD=1.6U
M$1152 \$2151 \$2149 VDD VDD pfet_03v3 L=0.28U W=0.72U AS=0.1764P AD=0.36P
+ PS=1.26U PD=2.44U
M$1153 \$2256 RA9 VDD VDD pfet_03v3 L=0.28U W=0.72U AS=0.3312P AD=0.3888P
+ PS=2.36U PD=2.52U
M$1154 \$2151 \$2256 \$375 VDD pfet_03v3 L=0.28U W=0.36U AS=0.1584P AD=0.1152P
+ PS=1.6U PD=1U
M$1155 \$376 \$2257 \$2151 VDD pfet_03v3 L=0.28U W=0.36U AS=0.1152P AD=0.1584P
+ PS=1U PD=1.6U
M$1156 VDD RB9 \$2257 VDD pfet_03v3 L=0.28U W=0.72U AS=0.3708P AD=0.3168P
+ PS=2.47U PD=2.32U
M$1157 \$2152 \$56 VDD VDD pfet_03v3 L=0.28U W=0.72U AS=0.3168P AD=0.2097P
+ PS=2.32U PD=1.38U
M$1158 \$2153 \$2135 \$2152 VDD pfet_03v3 L=0.28U W=0.36U AS=0.2097P AD=0.1278P
+ PS=1.38U PD=1.07U
M$1159 \$2378 \$2154 \$2153 VDD pfet_03v3 L=0.28U W=0.36U AS=0.1278P AD=0.0567P
+ PS=1.07U PD=0.675U
M$1160 VDD \$2134 \$2378 VDD pfet_03v3 L=0.28U W=0.36U AS=0.0567P AD=0.1584P
+ PS=0.675U PD=1.6U
M$1161 \$2154 \$2153 VDD VDD pfet_03v3 L=0.28U W=0.36U AS=0.1764P AD=0.1584P
+ PS=1.26U PD=1.6U
M$1162 \$2155 \$2153 VDD VDD pfet_03v3 L=0.28U W=0.72U AS=0.1764P AD=0.36P
+ PS=1.26U PD=2.44U
M$1163 \$2258 RA9 VDD VDD pfet_03v3 L=0.28U W=0.72U AS=0.3312P AD=0.3888P
+ PS=2.36U PD=2.52U
M$1164 \$2155 \$2258 \$380 VDD pfet_03v3 L=0.28U W=0.36U AS=0.1584P AD=0.1152P
+ PS=1.6U PD=1U
M$1165 \$381 \$2259 \$2155 VDD pfet_03v3 L=0.28U W=0.36U AS=0.1152P AD=0.1584P
+ PS=1U PD=1.6U
M$1166 VDD RB9 \$2259 VDD pfet_03v3 L=0.28U W=0.72U AS=0.3708P AD=0.3168P
+ PS=2.47U PD=2.32U
M$1167 \$2156 \$59 VDD VDD pfet_03v3 L=0.28U W=0.72U AS=0.3168P AD=0.2097P
+ PS=2.32U PD=1.38U
M$1168 \$2157 \$2135 \$2156 VDD pfet_03v3 L=0.28U W=0.36U AS=0.2097P AD=0.1278P
+ PS=1.38U PD=1.07U
M$1169 \$2387 \$2158 \$2157 VDD pfet_03v3 L=0.28U W=0.36U AS=0.1278P AD=0.0567P
+ PS=1.07U PD=0.675U
M$1170 VDD \$2134 \$2387 VDD pfet_03v3 L=0.28U W=0.36U AS=0.0567P AD=0.1584P
+ PS=0.675U PD=1.6U
M$1171 \$2158 \$2157 VDD VDD pfet_03v3 L=0.28U W=0.36U AS=0.1764P AD=0.1584P
+ PS=1.26U PD=1.6U
M$1172 \$2159 \$2157 VDD VDD pfet_03v3 L=0.28U W=0.72U AS=0.1764P AD=0.36P
+ PS=1.26U PD=2.44U
M$1173 \$2260 RA9 VDD VDD pfet_03v3 L=0.28U W=0.72U AS=0.3312P AD=0.3888P
+ PS=2.36U PD=2.52U
M$1174 \$2159 \$2260 \$385 VDD pfet_03v3 L=0.28U W=0.36U AS=0.1584P AD=0.1152P
+ PS=1.6U PD=1U
M$1175 \$386 \$2261 \$2159 VDD pfet_03v3 L=0.28U W=0.36U AS=0.1152P AD=0.1584P
+ PS=1U PD=1.6U
M$1176 VDD RB9 \$2261 VDD pfet_03v3 L=0.28U W=0.72U AS=0.3708P AD=0.3168P
+ PS=2.47U PD=2.32U
M$1177 \$2160 \$62 VDD VDD pfet_03v3 L=0.28U W=0.72U AS=0.3168P AD=0.2097P
+ PS=2.32U PD=1.38U
M$1178 \$2161 \$2135 \$2160 VDD pfet_03v3 L=0.28U W=0.36U AS=0.2097P AD=0.1278P
+ PS=1.38U PD=1.07U
M$1179 \$2395 \$2162 \$2161 VDD pfet_03v3 L=0.28U W=0.36U AS=0.1278P AD=0.0567P
+ PS=1.07U PD=0.675U
M$1180 VDD \$2134 \$2395 VDD pfet_03v3 L=0.28U W=0.36U AS=0.0567P AD=0.1584P
+ PS=0.675U PD=1.6U
M$1181 \$2162 \$2161 VDD VDD pfet_03v3 L=0.28U W=0.36U AS=0.1764P AD=0.1584P
+ PS=1.26U PD=1.6U
M$1182 \$2163 \$2161 VDD VDD pfet_03v3 L=0.28U W=0.72U AS=0.1764P AD=0.36P
+ PS=1.26U PD=2.44U
M$1183 \$2262 RA9 VDD VDD pfet_03v3 L=0.28U W=0.72U AS=0.3312P AD=0.3888P
+ PS=2.36U PD=2.52U
M$1184 \$2163 \$2262 \$390 VDD pfet_03v3 L=0.28U W=0.36U AS=0.1584P AD=0.1152P
+ PS=1.6U PD=1U
M$1185 \$391 \$2263 \$2163 VDD pfet_03v3 L=0.28U W=0.36U AS=0.1152P AD=0.1584P
+ PS=1U PD=1.6U
M$1186 VDD RB9 \$2263 VDD pfet_03v3 L=0.28U W=0.72U AS=0.3708P AD=0.3168P
+ PS=2.47U PD=2.32U
M$1187 \$2164 \$65 VDD VDD pfet_03v3 L=0.28U W=0.72U AS=0.3168P AD=0.2097P
+ PS=2.32U PD=1.38U
M$1188 \$2165 \$2135 \$2164 VDD pfet_03v3 L=0.28U W=0.36U AS=0.2097P AD=0.1278P
+ PS=1.38U PD=1.07U
M$1189 \$2404 \$2166 \$2165 VDD pfet_03v3 L=0.28U W=0.36U AS=0.1278P AD=0.0567P
+ PS=1.07U PD=0.675U
M$1190 VDD \$2134 \$2404 VDD pfet_03v3 L=0.28U W=0.36U AS=0.0567P AD=0.1584P
+ PS=0.675U PD=1.6U
M$1191 \$2166 \$2165 VDD VDD pfet_03v3 L=0.28U W=0.36U AS=0.1764P AD=0.1584P
+ PS=1.26U PD=1.6U
M$1192 \$2167 \$2165 VDD VDD pfet_03v3 L=0.28U W=0.72U AS=0.1764P AD=0.36P
+ PS=1.26U PD=2.44U
M$1193 \$2264 RA9 VDD VDD pfet_03v3 L=0.28U W=0.72U AS=0.3312P AD=0.3888P
+ PS=2.36U PD=2.52U
M$1194 \$2167 \$2264 \$395 VDD pfet_03v3 L=0.28U W=0.36U AS=0.1584P AD=0.1152P
+ PS=1.6U PD=1U
M$1195 \$396 \$2265 \$2167 VDD pfet_03v3 L=0.28U W=0.36U AS=0.1152P AD=0.1584P
+ PS=1U PD=1.6U
M$1196 VDD RB9 \$2265 VDD pfet_03v3 L=0.28U W=0.72U AS=0.3708P AD=0.3168P
+ PS=2.47U PD=2.32U
M$1197 \$2168 \$68 VDD VDD pfet_03v3 L=0.28U W=0.72U AS=0.3168P AD=0.2097P
+ PS=2.32U PD=1.38U
M$1198 \$2169 \$2135 \$2168 VDD pfet_03v3 L=0.28U W=0.36U AS=0.2097P AD=0.1278P
+ PS=1.38U PD=1.07U
M$1199 \$2413 \$2170 \$2169 VDD pfet_03v3 L=0.28U W=0.36U AS=0.1278P AD=0.0567P
+ PS=1.07U PD=0.675U
M$1200 VDD \$2134 \$2413 VDD pfet_03v3 L=0.28U W=0.36U AS=0.0567P AD=0.1584P
+ PS=0.675U PD=1.6U
M$1201 \$2170 \$2169 VDD VDD pfet_03v3 L=0.28U W=0.36U AS=0.1764P AD=0.1584P
+ PS=1.26U PD=1.6U
M$1202 \$2171 \$2169 VDD VDD pfet_03v3 L=0.28U W=0.72U AS=0.1764P AD=0.36P
+ PS=1.26U PD=2.44U
M$1203 \$2266 RA9 VDD VDD pfet_03v3 L=0.28U W=0.72U AS=0.3312P AD=0.3888P
+ PS=2.36U PD=2.52U
M$1204 \$2171 \$2266 \$400 VDD pfet_03v3 L=0.28U W=0.36U AS=0.1584P AD=0.1152P
+ PS=1.6U PD=1U
M$1205 \$401 \$2267 \$2171 VDD pfet_03v3 L=0.28U W=0.36U AS=0.1152P AD=0.1584P
+ PS=1U PD=1.6U
M$1206 VDD RB9 \$2267 VDD pfet_03v3 L=0.28U W=0.72U AS=0.3708P AD=0.3168P
+ PS=2.47U PD=2.32U
M$1207 \$2172 \$71 VDD VDD pfet_03v3 L=0.28U W=0.72U AS=0.3168P AD=0.2097P
+ PS=2.32U PD=1.38U
M$1208 \$2173 \$2135 \$2172 VDD pfet_03v3 L=0.28U W=0.36U AS=0.2097P AD=0.1278P
+ PS=1.38U PD=1.07U
M$1209 \$2422 \$2174 \$2173 VDD pfet_03v3 L=0.28U W=0.36U AS=0.1278P AD=0.0567P
+ PS=1.07U PD=0.675U
M$1210 VDD \$2134 \$2422 VDD pfet_03v3 L=0.28U W=0.36U AS=0.0567P AD=0.1584P
+ PS=0.675U PD=1.6U
M$1211 \$2174 \$2173 VDD VDD pfet_03v3 L=0.28U W=0.36U AS=0.1764P AD=0.1584P
+ PS=1.26U PD=1.6U
M$1212 \$2175 \$2173 VDD VDD pfet_03v3 L=0.28U W=0.72U AS=0.1764P AD=0.36P
+ PS=1.26U PD=2.44U
M$1213 \$2268 RA9 VDD VDD pfet_03v3 L=0.28U W=0.72U AS=0.3312P AD=0.3888P
+ PS=2.36U PD=2.52U
M$1214 \$2175 \$2268 \$405 VDD pfet_03v3 L=0.28U W=0.36U AS=0.1584P AD=0.1152P
+ PS=1.6U PD=1U
M$1215 \$406 \$2269 \$2175 VDD pfet_03v3 L=0.28U W=0.36U AS=0.1152P AD=0.1584P
+ PS=1U PD=1.6U
M$1216 VDD RB9 \$2269 VDD pfet_03v3 L=0.28U W=0.72U AS=0.3708P AD=0.3168P
+ PS=2.47U PD=2.32U
M$1217 \$2176 \$74 VDD VDD pfet_03v3 L=0.28U W=0.72U AS=0.3168P AD=0.2097P
+ PS=2.32U PD=1.38U
M$1218 \$2177 \$2135 \$2176 VDD pfet_03v3 L=0.28U W=0.36U AS=0.2097P AD=0.1278P
+ PS=1.38U PD=1.07U
M$1219 \$2431 \$2178 \$2177 VDD pfet_03v3 L=0.28U W=0.36U AS=0.1278P AD=0.0567P
+ PS=1.07U PD=0.675U
M$1220 VDD \$2134 \$2431 VDD pfet_03v3 L=0.28U W=0.36U AS=0.0567P AD=0.1584P
+ PS=0.675U PD=1.6U
M$1221 \$2178 \$2177 VDD VDD pfet_03v3 L=0.28U W=0.36U AS=0.1764P AD=0.1584P
+ PS=1.26U PD=1.6U
M$1222 \$2179 \$2177 VDD VDD pfet_03v3 L=0.28U W=0.72U AS=0.1764P AD=0.36P
+ PS=1.26U PD=2.44U
M$1223 \$2270 RA9 VDD VDD pfet_03v3 L=0.28U W=0.72U AS=0.3312P AD=0.3888P
+ PS=2.36U PD=2.52U
M$1224 \$2179 \$2270 \$410 VDD pfet_03v3 L=0.28U W=0.36U AS=0.1584P AD=0.1152P
+ PS=1.6U PD=1U
M$1225 \$411 \$2271 \$2179 VDD pfet_03v3 L=0.28U W=0.36U AS=0.1152P AD=0.1584P
+ PS=1U PD=1.6U
M$1226 VDD RB9 \$2271 VDD pfet_03v3 L=0.28U W=0.72U AS=0.3708P AD=0.3168P
+ PS=2.47U PD=2.32U
M$1227 \$2180 \$77 VDD VDD pfet_03v3 L=0.28U W=0.72U AS=0.3168P AD=0.2097P
+ PS=2.32U PD=1.38U
M$1228 \$2181 \$2135 \$2180 VDD pfet_03v3 L=0.28U W=0.36U AS=0.2097P AD=0.1278P
+ PS=1.38U PD=1.07U
M$1229 \$2439 \$2182 \$2181 VDD pfet_03v3 L=0.28U W=0.36U AS=0.1278P AD=0.0567P
+ PS=1.07U PD=0.675U
M$1230 VDD \$2134 \$2439 VDD pfet_03v3 L=0.28U W=0.36U AS=0.0567P AD=0.1584P
+ PS=0.675U PD=1.6U
M$1231 \$2182 \$2181 VDD VDD pfet_03v3 L=0.28U W=0.36U AS=0.1764P AD=0.1584P
+ PS=1.26U PD=1.6U
M$1232 \$2183 \$2181 VDD VDD pfet_03v3 L=0.28U W=0.72U AS=0.1764P AD=0.36P
+ PS=1.26U PD=2.44U
M$1233 \$2272 RA9 VDD VDD pfet_03v3 L=0.28U W=0.72U AS=0.3312P AD=0.3888P
+ PS=2.36U PD=2.52U
M$1234 \$2183 \$2272 \$415 VDD pfet_03v3 L=0.28U W=0.36U AS=0.1584P AD=0.1152P
+ PS=1.6U PD=1U
M$1235 \$416 \$2273 \$2183 VDD pfet_03v3 L=0.28U W=0.36U AS=0.1152P AD=0.1584P
+ PS=1U PD=1.6U
M$1236 VDD RB9 \$2273 VDD pfet_03v3 L=0.28U W=0.72U AS=0.3708P AD=0.3168P
+ PS=2.47U PD=2.32U
M$1237 \$2184 \$80 VDD VDD pfet_03v3 L=0.28U W=0.72U AS=0.3168P AD=0.2097P
+ PS=2.32U PD=1.38U
M$1238 \$2185 \$2135 \$2184 VDD pfet_03v3 L=0.28U W=0.36U AS=0.2097P AD=0.1278P
+ PS=1.38U PD=1.07U
M$1239 \$2425 \$2186 \$2185 VDD pfet_03v3 L=0.28U W=0.36U AS=0.1278P AD=0.0567P
+ PS=1.07U PD=0.675U
M$1240 VDD \$2134 \$2425 VDD pfet_03v3 L=0.28U W=0.36U AS=0.0567P AD=0.1584P
+ PS=0.675U PD=1.6U
M$1241 \$2186 \$2185 VDD VDD pfet_03v3 L=0.28U W=0.36U AS=0.1764P AD=0.1584P
+ PS=1.26U PD=1.6U
M$1242 \$2187 \$2185 VDD VDD pfet_03v3 L=0.28U W=0.72U AS=0.1764P AD=0.36P
+ PS=1.26U PD=2.44U
M$1243 \$2274 RA9 VDD VDD pfet_03v3 L=0.28U W=0.72U AS=0.3312P AD=0.3888P
+ PS=2.36U PD=2.52U
M$1244 \$2187 \$2274 \$420 VDD pfet_03v3 L=0.28U W=0.36U AS=0.1584P AD=0.1152P
+ PS=1.6U PD=1U
M$1245 \$421 \$2275 \$2187 VDD pfet_03v3 L=0.28U W=0.36U AS=0.1152P AD=0.1584P
+ PS=1U PD=1.6U
M$1246 VDD RB9 \$2275 VDD pfet_03v3 L=0.28U W=0.72U AS=0.3708P AD=0.3168P
+ PS=2.47U PD=2.32U
M$1247 \$2188 \$83 VDD VDD pfet_03v3 L=0.28U W=0.72U AS=0.3168P AD=0.2097P
+ PS=2.32U PD=1.38U
M$1248 \$2189 \$2135 \$2188 VDD pfet_03v3 L=0.28U W=0.36U AS=0.2097P AD=0.1278P
+ PS=1.38U PD=1.07U
M$1249 \$2397 \$2190 \$2189 VDD pfet_03v3 L=0.28U W=0.36U AS=0.1278P AD=0.0567P
+ PS=1.07U PD=0.675U
M$1250 VDD \$2134 \$2397 VDD pfet_03v3 L=0.28U W=0.36U AS=0.0567P AD=0.1584P
+ PS=0.675U PD=1.6U
M$1251 \$2190 \$2189 VDD VDD pfet_03v3 L=0.28U W=0.36U AS=0.1764P AD=0.1584P
+ PS=1.26U PD=1.6U
M$1252 \$2191 \$2189 VDD VDD pfet_03v3 L=0.28U W=0.72U AS=0.1764P AD=0.36P
+ PS=1.26U PD=2.44U
M$1253 \$2276 RA9 VDD VDD pfet_03v3 L=0.28U W=0.72U AS=0.3312P AD=0.3888P
+ PS=2.36U PD=2.52U
M$1254 \$2191 \$2276 \$425 VDD pfet_03v3 L=0.28U W=0.36U AS=0.1584P AD=0.1152P
+ PS=1.6U PD=1U
M$1255 \$426 \$2277 \$2191 VDD pfet_03v3 L=0.28U W=0.36U AS=0.1152P AD=0.1584P
+ PS=1U PD=1.6U
M$1256 VDD RB9 \$2277 VDD pfet_03v3 L=0.28U W=0.72U AS=0.3708P AD=0.3168P
+ PS=2.47U PD=2.32U
M$1257 \$2192 \$86 VDD VDD pfet_03v3 L=0.28U W=0.72U AS=0.3168P AD=0.2097P
+ PS=2.32U PD=1.38U
M$1258 \$2193 \$2135 \$2192 VDD pfet_03v3 L=0.28U W=0.36U AS=0.2097P AD=0.1278P
+ PS=1.38U PD=1.07U
M$1259 \$2379 \$2194 \$2193 VDD pfet_03v3 L=0.28U W=0.36U AS=0.1278P AD=0.0567P
+ PS=1.07U PD=0.675U
M$1260 VDD \$2134 \$2379 VDD pfet_03v3 L=0.28U W=0.36U AS=0.0567P AD=0.1584P
+ PS=0.675U PD=1.6U
M$1261 \$2194 \$2193 VDD VDD pfet_03v3 L=0.28U W=0.36U AS=0.1764P AD=0.1584P
+ PS=1.26U PD=1.6U
M$1262 \$2195 \$2193 VDD VDD pfet_03v3 L=0.28U W=0.72U AS=0.1764P AD=0.36P
+ PS=1.26U PD=2.44U
M$1263 \$2278 RA9 VDD VDD pfet_03v3 L=0.28U W=0.72U AS=0.3312P AD=0.3888P
+ PS=2.36U PD=2.52U
M$1264 \$2195 \$2278 \$430 VDD pfet_03v3 L=0.28U W=0.36U AS=0.1584P AD=0.1152P
+ PS=1.6U PD=1U
M$1265 \$431 \$2279 \$2195 VDD pfet_03v3 L=0.28U W=0.36U AS=0.1152P AD=0.1584P
+ PS=1U PD=1.6U
M$1266 VDD RB9 \$2279 VDD pfet_03v3 L=0.28U W=0.72U AS=0.3708P AD=0.3168P
+ PS=2.47U PD=2.32U
M$1267 \$2196 \$89 VDD VDD pfet_03v3 L=0.28U W=0.72U AS=0.3168P AD=0.2097P
+ PS=2.32U PD=1.38U
M$1268 \$2197 \$2135 \$2196 VDD pfet_03v3 L=0.28U W=0.36U AS=0.2097P AD=0.1278P
+ PS=1.38U PD=1.07U
M$1269 \$2351 \$2198 \$2197 VDD pfet_03v3 L=0.28U W=0.36U AS=0.1278P AD=0.0567P
+ PS=1.07U PD=0.675U
M$1270 VDD \$2134 \$2351 VDD pfet_03v3 L=0.28U W=0.36U AS=0.0567P AD=0.1584P
+ PS=0.675U PD=1.6U
M$1271 \$2198 \$2197 VDD VDD pfet_03v3 L=0.28U W=0.36U AS=0.1764P AD=0.1584P
+ PS=1.26U PD=1.6U
M$1272 \$2199 \$2197 VDD VDD pfet_03v3 L=0.28U W=0.72U AS=0.1764P AD=0.36P
+ PS=1.26U PD=2.44U
M$1273 \$2280 RA9 VDD VDD pfet_03v3 L=0.28U W=0.72U AS=0.3312P AD=0.3888P
+ PS=2.36U PD=2.52U
M$1274 \$2199 \$2280 \$435 VDD pfet_03v3 L=0.28U W=0.36U AS=0.1584P AD=0.1152P
+ PS=1.6U PD=1U
M$1275 \$436 \$2281 \$2199 VDD pfet_03v3 L=0.28U W=0.36U AS=0.1152P AD=0.1584P
+ PS=1U PD=1.6U
M$1276 VDD RB9 \$2281 VDD pfet_03v3 L=0.28U W=0.72U AS=0.3708P AD=0.3168P
+ PS=2.47U PD=2.32U
M$1277 \$2443 WE8 VDD VDD pfet_03v3 L=0.28U W=0.72U AS=0.3168P AD=0.1872P
+ PS=2.32U PD=1.24U
M$1278 VDD CLK \$2443 VDD pfet_03v3 L=0.28U W=0.72U AS=0.1872P AD=0.3168P
+ PS=1.24U PD=2.32U
M$1279 \$2445 \$2443 VDD VDD pfet_03v3 L=0.28U W=2.54U AS=0.889P AD=0.6688P
+ PS=5.21U PD=3.65U
M$1281 RB8 \$2445 VDD VDD pfet_03v3 L=0.28U W=2.68U AS=0.7272P AD=0.9782P
+ PS=3.78U PD=5.48U
M$1283 \$2449 RB8 \$2448 VDD pfet_03v3 L=0.28U W=0.36U AS=0.2097P AD=0.1278P
+ PS=1.38U PD=1.07U
M$1284 \$2550 \$2450 \$2449 VDD pfet_03v3 L=0.28U W=0.36U AS=0.1278P AD=0.0567P
+ PS=1.07U PD=0.675U
M$1285 VDD \$2445 \$2550 VDD pfet_03v3 L=0.28U W=0.36U AS=0.0567P AD=0.1584P
+ PS=0.675U PD=1.6U
M$1286 \$2448 \$44 VDD VDD pfet_03v3 L=0.28U W=0.72U AS=0.3168P AD=0.2097P
+ PS=2.32U PD=1.38U
M$1287 VDD \$2449 \$2450 VDD pfet_03v3 L=0.28U W=0.36U AS=0.1584P AD=0.1764P
+ PS=1.6U PD=1.26U
M$1288 \$2451 \$2449 VDD VDD pfet_03v3 L=0.28U W=0.72U AS=0.1764P AD=0.36P
+ PS=1.26U PD=2.44U
M$1289 \$2452 RA8 VDD VDD pfet_03v3 L=0.28U W=0.72U AS=0.3312P AD=0.3888P
+ PS=2.36U PD=2.52U
M$1290 \$2451 \$2452 \$360 VDD pfet_03v3 L=0.28U W=0.36U AS=0.1584P AD=0.1152P
+ PS=1.6U PD=1U
M$1291 \$361 \$2453 \$2451 VDD pfet_03v3 L=0.28U W=0.36U AS=0.1152P AD=0.1584P
+ PS=1U PD=1.6U
M$1292 VDD \$2454 \$2453 VDD pfet_03v3 L=0.28U W=0.72U AS=0.3708P AD=0.3168P
+ PS=2.47U PD=2.32U
M$1293 \$2456 RB8 \$2455 VDD pfet_03v3 L=0.28U W=0.36U AS=0.2097P AD=0.1278P
+ PS=1.38U PD=1.07U
M$1294 \$2558 \$2457 \$2456 VDD pfet_03v3 L=0.28U W=0.36U AS=0.1278P AD=0.0567P
+ PS=1.07U PD=0.675U
M$1295 VDD \$2445 \$2558 VDD pfet_03v3 L=0.28U W=0.36U AS=0.0567P AD=0.1584P
+ PS=0.675U PD=1.6U
M$1296 \$2455 \$47 VDD VDD pfet_03v3 L=0.28U W=0.72U AS=0.3168P AD=0.2097P
+ PS=2.32U PD=1.38U
M$1297 VDD \$2456 \$2457 VDD pfet_03v3 L=0.28U W=0.36U AS=0.1584P AD=0.1764P
+ PS=1.6U PD=1.26U
M$1298 \$2458 \$2456 VDD VDD pfet_03v3 L=0.28U W=0.72U AS=0.1764P AD=0.36P
+ PS=1.26U PD=2.44U
M$1299 \$2459 RA8 VDD VDD pfet_03v3 L=0.28U W=0.72U AS=0.3312P AD=0.3888P
+ PS=2.36U PD=2.52U
M$1300 \$2458 \$2459 \$365 VDD pfet_03v3 L=0.28U W=0.36U AS=0.1584P AD=0.1152P
+ PS=1.6U PD=1U
M$1301 \$366 \$2460 \$2458 VDD pfet_03v3 L=0.28U W=0.36U AS=0.1152P AD=0.1584P
+ PS=1U PD=1.6U
M$1302 VDD \$2454 \$2460 VDD pfet_03v3 L=0.28U W=0.72U AS=0.3708P AD=0.3168P
+ PS=2.47U PD=2.32U
M$1303 \$2462 RB8 \$2461 VDD pfet_03v3 L=0.28U W=0.36U AS=0.2097P AD=0.1278P
+ PS=1.38U PD=1.07U
M$1304 \$2565 \$2463 \$2462 VDD pfet_03v3 L=0.28U W=0.36U AS=0.1278P AD=0.0567P
+ PS=1.07U PD=0.675U
M$1305 VDD \$2445 \$2565 VDD pfet_03v3 L=0.28U W=0.36U AS=0.0567P AD=0.1584P
+ PS=0.675U PD=1.6U
M$1306 \$2461 \$50 VDD VDD pfet_03v3 L=0.28U W=0.72U AS=0.3168P AD=0.2097P
+ PS=2.32U PD=1.38U
M$1307 VDD \$2462 \$2463 VDD pfet_03v3 L=0.28U W=0.36U AS=0.1584P AD=0.1764P
+ PS=1.6U PD=1.26U
M$1308 \$2464 \$2462 VDD VDD pfet_03v3 L=0.28U W=0.72U AS=0.1764P AD=0.36P
+ PS=1.26U PD=2.44U
M$1309 \$2465 RA8 VDD VDD pfet_03v3 L=0.28U W=0.72U AS=0.3312P AD=0.3888P
+ PS=2.36U PD=2.52U
M$1310 \$2464 \$2465 \$370 VDD pfet_03v3 L=0.28U W=0.36U AS=0.1584P AD=0.1152P
+ PS=1.6U PD=1U
M$1311 \$371 \$2466 \$2464 VDD pfet_03v3 L=0.28U W=0.36U AS=0.1152P AD=0.1584P
+ PS=1U PD=1.6U
M$1312 VDD \$2454 \$2466 VDD pfet_03v3 L=0.28U W=0.72U AS=0.3708P AD=0.3168P
+ PS=2.47U PD=2.32U
M$1313 \$2468 RB8 \$2467 VDD pfet_03v3 L=0.28U W=0.36U AS=0.2097P AD=0.1278P
+ PS=1.38U PD=1.07U
M$1314 \$2573 \$2469 \$2468 VDD pfet_03v3 L=0.28U W=0.36U AS=0.1278P AD=0.0567P
+ PS=1.07U PD=0.675U
M$1315 VDD \$2445 \$2573 VDD pfet_03v3 L=0.28U W=0.36U AS=0.0567P AD=0.1584P
+ PS=0.675U PD=1.6U
M$1316 \$2467 \$53 VDD VDD pfet_03v3 L=0.28U W=0.72U AS=0.3168P AD=0.2097P
+ PS=2.32U PD=1.38U
M$1317 VDD \$2468 \$2469 VDD pfet_03v3 L=0.28U W=0.36U AS=0.1584P AD=0.1764P
+ PS=1.6U PD=1.26U
M$1318 \$2470 \$2468 VDD VDD pfet_03v3 L=0.28U W=0.72U AS=0.1764P AD=0.36P
+ PS=1.26U PD=2.44U
M$1319 \$2471 RA8 VDD VDD pfet_03v3 L=0.28U W=0.72U AS=0.3312P AD=0.3888P
+ PS=2.36U PD=2.52U
M$1320 \$2470 \$2471 \$375 VDD pfet_03v3 L=0.28U W=0.36U AS=0.1584P AD=0.1152P
+ PS=1.6U PD=1U
M$1321 \$376 \$2472 \$2470 VDD pfet_03v3 L=0.28U W=0.36U AS=0.1152P AD=0.1584P
+ PS=1U PD=1.6U
M$1322 VDD \$2454 \$2472 VDD pfet_03v3 L=0.28U W=0.72U AS=0.3708P AD=0.3168P
+ PS=2.47U PD=2.32U
M$1323 \$2474 RB8 \$2473 VDD pfet_03v3 L=0.28U W=0.36U AS=0.2097P AD=0.1278P
+ PS=1.38U PD=1.07U
M$1324 \$2582 \$2475 \$2474 VDD pfet_03v3 L=0.28U W=0.36U AS=0.1278P AD=0.0567P
+ PS=1.07U PD=0.675U
M$1325 VDD \$2445 \$2582 VDD pfet_03v3 L=0.28U W=0.36U AS=0.0567P AD=0.1584P
+ PS=0.675U PD=1.6U
M$1326 \$2473 \$56 VDD VDD pfet_03v3 L=0.28U W=0.72U AS=0.3168P AD=0.2097P
+ PS=2.32U PD=1.38U
M$1327 VDD \$2474 \$2475 VDD pfet_03v3 L=0.28U W=0.36U AS=0.1584P AD=0.1764P
+ PS=1.6U PD=1.26U
M$1328 \$2476 \$2474 VDD VDD pfet_03v3 L=0.28U W=0.72U AS=0.1764P AD=0.36P
+ PS=1.26U PD=2.44U
M$1329 \$2477 RA8 VDD VDD pfet_03v3 L=0.28U W=0.72U AS=0.3312P AD=0.3888P
+ PS=2.36U PD=2.52U
M$1330 \$2476 \$2477 \$380 VDD pfet_03v3 L=0.28U W=0.36U AS=0.1584P AD=0.1152P
+ PS=1.6U PD=1U
M$1331 \$381 \$2478 \$2476 VDD pfet_03v3 L=0.28U W=0.36U AS=0.1152P AD=0.1584P
+ PS=1U PD=1.6U
M$1332 VDD \$2454 \$2478 VDD pfet_03v3 L=0.28U W=0.72U AS=0.3708P AD=0.3168P
+ PS=2.47U PD=2.32U
M$1333 \$2480 RB8 \$2479 VDD pfet_03v3 L=0.28U W=0.36U AS=0.2097P AD=0.1278P
+ PS=1.38U PD=1.07U
M$1334 \$2588 \$2481 \$2480 VDD pfet_03v3 L=0.28U W=0.36U AS=0.1278P AD=0.0567P
+ PS=1.07U PD=0.675U
M$1335 VDD \$2445 \$2588 VDD pfet_03v3 L=0.28U W=0.36U AS=0.0567P AD=0.1584P
+ PS=0.675U PD=1.6U
M$1336 \$2479 \$59 VDD VDD pfet_03v3 L=0.28U W=0.72U AS=0.3168P AD=0.2097P
+ PS=2.32U PD=1.38U
M$1337 VDD \$2480 \$2481 VDD pfet_03v3 L=0.28U W=0.36U AS=0.1584P AD=0.1764P
+ PS=1.6U PD=1.26U
M$1338 \$2482 \$2480 VDD VDD pfet_03v3 L=0.28U W=0.72U AS=0.1764P AD=0.36P
+ PS=1.26U PD=2.44U
M$1339 \$2483 RA8 VDD VDD pfet_03v3 L=0.28U W=0.72U AS=0.3312P AD=0.3888P
+ PS=2.36U PD=2.52U
M$1340 \$2482 \$2483 \$385 VDD pfet_03v3 L=0.28U W=0.36U AS=0.1584P AD=0.1152P
+ PS=1.6U PD=1U
M$1341 \$386 \$2484 \$2482 VDD pfet_03v3 L=0.28U W=0.36U AS=0.1152P AD=0.1584P
+ PS=1U PD=1.6U
M$1342 VDD \$2454 \$2484 VDD pfet_03v3 L=0.28U W=0.72U AS=0.3708P AD=0.3168P
+ PS=2.47U PD=2.32U
M$1343 \$2486 RB8 \$2485 VDD pfet_03v3 L=0.28U W=0.36U AS=0.2097P AD=0.1278P
+ PS=1.38U PD=1.07U
M$1344 \$2595 \$2487 \$2486 VDD pfet_03v3 L=0.28U W=0.36U AS=0.1278P AD=0.0567P
+ PS=1.07U PD=0.675U
M$1345 VDD \$2445 \$2595 VDD pfet_03v3 L=0.28U W=0.36U AS=0.0567P AD=0.1584P
+ PS=0.675U PD=1.6U
M$1346 \$2485 \$62 VDD VDD pfet_03v3 L=0.28U W=0.72U AS=0.3168P AD=0.2097P
+ PS=2.32U PD=1.38U
M$1347 VDD \$2486 \$2487 VDD pfet_03v3 L=0.28U W=0.36U AS=0.1584P AD=0.1764P
+ PS=1.6U PD=1.26U
M$1348 \$2488 \$2486 VDD VDD pfet_03v3 L=0.28U W=0.72U AS=0.1764P AD=0.36P
+ PS=1.26U PD=2.44U
M$1349 \$2489 RA8 VDD VDD pfet_03v3 L=0.28U W=0.72U AS=0.3312P AD=0.3888P
+ PS=2.36U PD=2.52U
M$1350 \$2488 \$2489 \$390 VDD pfet_03v3 L=0.28U W=0.36U AS=0.1584P AD=0.1152P
+ PS=1.6U PD=1U
M$1351 \$391 \$2490 \$2488 VDD pfet_03v3 L=0.28U W=0.36U AS=0.1152P AD=0.1584P
+ PS=1U PD=1.6U
M$1352 VDD \$2454 \$2490 VDD pfet_03v3 L=0.28U W=0.72U AS=0.3708P AD=0.3168P
+ PS=2.47U PD=2.32U
M$1353 \$2492 RB8 \$2491 VDD pfet_03v3 L=0.28U W=0.36U AS=0.2097P AD=0.1278P
+ PS=1.38U PD=1.07U
M$1354 \$2604 \$2493 \$2492 VDD pfet_03v3 L=0.28U W=0.36U AS=0.1278P AD=0.0567P
+ PS=1.07U PD=0.675U
M$1355 VDD \$2445 \$2604 VDD pfet_03v3 L=0.28U W=0.36U AS=0.0567P AD=0.1584P
+ PS=0.675U PD=1.6U
M$1356 \$2491 \$65 VDD VDD pfet_03v3 L=0.28U W=0.72U AS=0.3168P AD=0.2097P
+ PS=2.32U PD=1.38U
M$1357 VDD \$2492 \$2493 VDD pfet_03v3 L=0.28U W=0.36U AS=0.1584P AD=0.1764P
+ PS=1.6U PD=1.26U
M$1358 \$2494 \$2492 VDD VDD pfet_03v3 L=0.28U W=0.72U AS=0.1764P AD=0.36P
+ PS=1.26U PD=2.44U
M$1359 \$2495 RA8 VDD VDD pfet_03v3 L=0.28U W=0.72U AS=0.3312P AD=0.3888P
+ PS=2.36U PD=2.52U
M$1360 \$2494 \$2495 \$395 VDD pfet_03v3 L=0.28U W=0.36U AS=0.1584P AD=0.1152P
+ PS=1.6U PD=1U
M$1361 \$396 \$2496 \$2494 VDD pfet_03v3 L=0.28U W=0.36U AS=0.1152P AD=0.1584P
+ PS=1U PD=1.6U
M$1362 VDD \$2454 \$2496 VDD pfet_03v3 L=0.28U W=0.72U AS=0.3708P AD=0.3168P
+ PS=2.47U PD=2.32U
M$1363 \$2498 RB8 \$2497 VDD pfet_03v3 L=0.28U W=0.36U AS=0.2097P AD=0.1278P
+ PS=1.38U PD=1.07U
M$1364 \$2610 \$2499 \$2498 VDD pfet_03v3 L=0.28U W=0.36U AS=0.1278P AD=0.0567P
+ PS=1.07U PD=0.675U
M$1365 VDD \$2445 \$2610 VDD pfet_03v3 L=0.28U W=0.36U AS=0.0567P AD=0.1584P
+ PS=0.675U PD=1.6U
M$1366 \$2497 \$68 VDD VDD pfet_03v3 L=0.28U W=0.72U AS=0.3168P AD=0.2097P
+ PS=2.32U PD=1.38U
M$1367 VDD \$2498 \$2499 VDD pfet_03v3 L=0.28U W=0.36U AS=0.1584P AD=0.1764P
+ PS=1.6U PD=1.26U
M$1368 \$2500 \$2498 VDD VDD pfet_03v3 L=0.28U W=0.72U AS=0.1764P AD=0.36P
+ PS=1.26U PD=2.44U
M$1369 \$2501 RA8 VDD VDD pfet_03v3 L=0.28U W=0.72U AS=0.3312P AD=0.3888P
+ PS=2.36U PD=2.52U
M$1370 \$2500 \$2501 \$400 VDD pfet_03v3 L=0.28U W=0.36U AS=0.1584P AD=0.1152P
+ PS=1.6U PD=1U
M$1371 \$401 \$2502 \$2500 VDD pfet_03v3 L=0.28U W=0.36U AS=0.1152P AD=0.1584P
+ PS=1U PD=1.6U
M$1372 VDD \$2454 \$2502 VDD pfet_03v3 L=0.28U W=0.72U AS=0.3708P AD=0.3168P
+ PS=2.47U PD=2.32U
M$1373 \$2504 RB8 \$2503 VDD pfet_03v3 L=0.28U W=0.36U AS=0.2097P AD=0.1278P
+ PS=1.38U PD=1.07U
M$1374 \$2617 \$2505 \$2504 VDD pfet_03v3 L=0.28U W=0.36U AS=0.1278P AD=0.0567P
+ PS=1.07U PD=0.675U
M$1375 VDD \$2445 \$2617 VDD pfet_03v3 L=0.28U W=0.36U AS=0.0567P AD=0.1584P
+ PS=0.675U PD=1.6U
M$1376 \$2503 \$71 VDD VDD pfet_03v3 L=0.28U W=0.72U AS=0.3168P AD=0.2097P
+ PS=2.32U PD=1.38U
M$1377 VDD \$2504 \$2505 VDD pfet_03v3 L=0.28U W=0.36U AS=0.1584P AD=0.1764P
+ PS=1.6U PD=1.26U
M$1378 \$2506 \$2504 VDD VDD pfet_03v3 L=0.28U W=0.72U AS=0.1764P AD=0.36P
+ PS=1.26U PD=2.44U
M$1379 \$2507 RA8 VDD VDD pfet_03v3 L=0.28U W=0.72U AS=0.3312P AD=0.3888P
+ PS=2.36U PD=2.52U
M$1380 \$2506 \$2507 \$405 VDD pfet_03v3 L=0.28U W=0.36U AS=0.1584P AD=0.1152P
+ PS=1.6U PD=1U
M$1381 \$406 \$2508 \$2506 VDD pfet_03v3 L=0.28U W=0.36U AS=0.1152P AD=0.1584P
+ PS=1U PD=1.6U
M$1382 VDD \$2454 \$2508 VDD pfet_03v3 L=0.28U W=0.72U AS=0.3708P AD=0.3168P
+ PS=2.47U PD=2.32U
M$1383 \$2510 RB8 \$2509 VDD pfet_03v3 L=0.28U W=0.36U AS=0.2097P AD=0.1278P
+ PS=1.38U PD=1.07U
M$1384 \$2625 \$2511 \$2510 VDD pfet_03v3 L=0.28U W=0.36U AS=0.1278P AD=0.0567P
+ PS=1.07U PD=0.675U
M$1385 VDD \$2445 \$2625 VDD pfet_03v3 L=0.28U W=0.36U AS=0.0567P AD=0.1584P
+ PS=0.675U PD=1.6U
M$1386 \$2509 \$74 VDD VDD pfet_03v3 L=0.28U W=0.72U AS=0.3168P AD=0.2097P
+ PS=2.32U PD=1.38U
M$1387 VDD \$2510 \$2511 VDD pfet_03v3 L=0.28U W=0.36U AS=0.1584P AD=0.1764P
+ PS=1.6U PD=1.26U
M$1388 \$2512 \$2510 VDD VDD pfet_03v3 L=0.28U W=0.72U AS=0.1764P AD=0.36P
+ PS=1.26U PD=2.44U
M$1389 \$2513 RA8 VDD VDD pfet_03v3 L=0.28U W=0.72U AS=0.3312P AD=0.3888P
+ PS=2.36U PD=2.52U
M$1390 \$2512 \$2513 \$410 VDD pfet_03v3 L=0.28U W=0.36U AS=0.1584P AD=0.1152P
+ PS=1.6U PD=1U
M$1391 \$411 \$2514 \$2512 VDD pfet_03v3 L=0.28U W=0.36U AS=0.1152P AD=0.1584P
+ PS=1U PD=1.6U
M$1392 VDD \$2454 \$2514 VDD pfet_03v3 L=0.28U W=0.72U AS=0.3708P AD=0.3168P
+ PS=2.47U PD=2.32U
M$1393 \$2516 RB8 \$2515 VDD pfet_03v3 L=0.28U W=0.36U AS=0.2097P AD=0.1278P
+ PS=1.38U PD=1.07U
M$1394 \$2633 \$2517 \$2516 VDD pfet_03v3 L=0.28U W=0.36U AS=0.1278P AD=0.0567P
+ PS=1.07U PD=0.675U
M$1395 VDD \$2445 \$2633 VDD pfet_03v3 L=0.28U W=0.36U AS=0.0567P AD=0.1584P
+ PS=0.675U PD=1.6U
M$1396 \$2515 \$77 VDD VDD pfet_03v3 L=0.28U W=0.72U AS=0.3168P AD=0.2097P
+ PS=2.32U PD=1.38U
M$1397 VDD \$2516 \$2517 VDD pfet_03v3 L=0.28U W=0.36U AS=0.1584P AD=0.1764P
+ PS=1.6U PD=1.26U
M$1398 \$2518 \$2516 VDD VDD pfet_03v3 L=0.28U W=0.72U AS=0.1764P AD=0.36P
+ PS=1.26U PD=2.44U
M$1399 \$2519 RA8 VDD VDD pfet_03v3 L=0.28U W=0.72U AS=0.3312P AD=0.3888P
+ PS=2.36U PD=2.52U
M$1400 \$2518 \$2519 \$415 VDD pfet_03v3 L=0.28U W=0.36U AS=0.1584P AD=0.1152P
+ PS=1.6U PD=1U
M$1401 \$416 \$2520 \$2518 VDD pfet_03v3 L=0.28U W=0.36U AS=0.1152P AD=0.1584P
+ PS=1U PD=1.6U
M$1402 VDD \$2454 \$2520 VDD pfet_03v3 L=0.28U W=0.72U AS=0.3708P AD=0.3168P
+ PS=2.47U PD=2.32U
M$1403 \$2522 RB8 \$2521 VDD pfet_03v3 L=0.28U W=0.36U AS=0.2097P AD=0.1278P
+ PS=1.38U PD=1.07U
M$1404 \$2640 \$2523 \$2522 VDD pfet_03v3 L=0.28U W=0.36U AS=0.1278P AD=0.0567P
+ PS=1.07U PD=0.675U
M$1405 VDD \$2445 \$2640 VDD pfet_03v3 L=0.28U W=0.36U AS=0.0567P AD=0.1584P
+ PS=0.675U PD=1.6U
M$1406 \$2521 \$80 VDD VDD pfet_03v3 L=0.28U W=0.72U AS=0.3168P AD=0.2097P
+ PS=2.32U PD=1.38U
M$1407 VDD \$2522 \$2523 VDD pfet_03v3 L=0.28U W=0.36U AS=0.1584P AD=0.1764P
+ PS=1.6U PD=1.26U
M$1408 \$2524 \$2522 VDD VDD pfet_03v3 L=0.28U W=0.72U AS=0.1764P AD=0.36P
+ PS=1.26U PD=2.44U
M$1409 \$2525 RA8 VDD VDD pfet_03v3 L=0.28U W=0.72U AS=0.3312P AD=0.3888P
+ PS=2.36U PD=2.52U
M$1410 \$2524 \$2525 \$420 VDD pfet_03v3 L=0.28U W=0.36U AS=0.1584P AD=0.1152P
+ PS=1.6U PD=1U
M$1411 \$421 \$2526 \$2524 VDD pfet_03v3 L=0.28U W=0.36U AS=0.1152P AD=0.1584P
+ PS=1U PD=1.6U
M$1412 VDD \$2454 \$2526 VDD pfet_03v3 L=0.28U W=0.72U AS=0.3708P AD=0.3168P
+ PS=2.47U PD=2.32U
M$1413 \$2528 RB8 \$2527 VDD pfet_03v3 L=0.28U W=0.36U AS=0.2097P AD=0.1278P
+ PS=1.38U PD=1.07U
M$1414 \$2639 \$2529 \$2528 VDD pfet_03v3 L=0.28U W=0.36U AS=0.1278P AD=0.0567P
+ PS=1.07U PD=0.675U
M$1415 VDD \$2445 \$2639 VDD pfet_03v3 L=0.28U W=0.36U AS=0.0567P AD=0.1584P
+ PS=0.675U PD=1.6U
M$1416 \$2527 \$83 VDD VDD pfet_03v3 L=0.28U W=0.72U AS=0.3168P AD=0.2097P
+ PS=2.32U PD=1.38U
M$1417 VDD \$2528 \$2529 VDD pfet_03v3 L=0.28U W=0.36U AS=0.1584P AD=0.1764P
+ PS=1.6U PD=1.26U
M$1418 \$2530 \$2528 VDD VDD pfet_03v3 L=0.28U W=0.72U AS=0.1764P AD=0.36P
+ PS=1.26U PD=2.44U
M$1419 \$2531 RA8 VDD VDD pfet_03v3 L=0.28U W=0.72U AS=0.3312P AD=0.3888P
+ PS=2.36U PD=2.52U
M$1420 \$2530 \$2531 \$425 VDD pfet_03v3 L=0.28U W=0.36U AS=0.1584P AD=0.1152P
+ PS=1.6U PD=1U
M$1421 \$426 \$2532 \$2530 VDD pfet_03v3 L=0.28U W=0.36U AS=0.1152P AD=0.1584P
+ PS=1U PD=1.6U
M$1422 VDD \$2454 \$2532 VDD pfet_03v3 L=0.28U W=0.72U AS=0.3708P AD=0.3168P
+ PS=2.47U PD=2.32U
M$1423 \$2534 RB8 \$2533 VDD pfet_03v3 L=0.28U W=0.36U AS=0.2097P AD=0.1278P
+ PS=1.38U PD=1.07U
M$1424 \$2606 \$2535 \$2534 VDD pfet_03v3 L=0.28U W=0.36U AS=0.1278P AD=0.0567P
+ PS=1.07U PD=0.675U
M$1425 VDD \$2445 \$2606 VDD pfet_03v3 L=0.28U W=0.36U AS=0.0567P AD=0.1584P
+ PS=0.675U PD=1.6U
M$1426 \$2533 \$86 VDD VDD pfet_03v3 L=0.28U W=0.72U AS=0.3168P AD=0.2097P
+ PS=2.32U PD=1.38U
M$1427 VDD \$2534 \$2535 VDD pfet_03v3 L=0.28U W=0.36U AS=0.1584P AD=0.1764P
+ PS=1.6U PD=1.26U
M$1428 \$2536 \$2534 VDD VDD pfet_03v3 L=0.28U W=0.72U AS=0.1764P AD=0.36P
+ PS=1.26U PD=2.44U
M$1429 \$2537 RA8 VDD VDD pfet_03v3 L=0.28U W=0.72U AS=0.3312P AD=0.3888P
+ PS=2.36U PD=2.52U
M$1430 \$2536 \$2537 \$430 VDD pfet_03v3 L=0.28U W=0.36U AS=0.1584P AD=0.1152P
+ PS=1.6U PD=1U
M$1431 \$431 \$2538 \$2536 VDD pfet_03v3 L=0.28U W=0.36U AS=0.1152P AD=0.1584P
+ PS=1U PD=1.6U
M$1432 VDD \$2454 \$2538 VDD pfet_03v3 L=0.28U W=0.72U AS=0.3708P AD=0.3168P
+ PS=2.47U PD=2.32U
M$1433 \$2540 RB8 \$2539 VDD pfet_03v3 L=0.28U W=0.36U AS=0.2097P AD=0.1278P
+ PS=1.38U PD=1.07U
M$1434 \$2574 \$2541 \$2540 VDD pfet_03v3 L=0.28U W=0.36U AS=0.1278P AD=0.0567P
+ PS=1.07U PD=0.675U
M$1435 VDD \$2445 \$2574 VDD pfet_03v3 L=0.28U W=0.36U AS=0.0567P AD=0.1584P
+ PS=0.675U PD=1.6U
M$1436 \$2539 \$89 VDD VDD pfet_03v3 L=0.28U W=0.72U AS=0.3168P AD=0.2097P
+ PS=2.32U PD=1.38U
M$1437 VDD \$2540 \$2541 VDD pfet_03v3 L=0.28U W=0.36U AS=0.1584P AD=0.1764P
+ PS=1.6U PD=1.26U
M$1438 \$2542 \$2540 VDD VDD pfet_03v3 L=0.28U W=0.72U AS=0.1764P AD=0.36P
+ PS=1.26U PD=2.44U
M$1439 \$2543 RA8 VDD VDD pfet_03v3 L=0.28U W=0.72U AS=0.3312P AD=0.3888P
+ PS=2.36U PD=2.52U
M$1440 \$2542 \$2543 \$435 VDD pfet_03v3 L=0.28U W=0.36U AS=0.1584P AD=0.1152P
+ PS=1.6U PD=1U
M$1441 \$436 \$2544 \$2542 VDD pfet_03v3 L=0.28U W=0.36U AS=0.1152P AD=0.1584P
+ PS=1U PD=1.6U
M$1442 VDD \$2454 \$2544 VDD pfet_03v3 L=0.28U W=0.72U AS=0.3708P AD=0.3168P
+ PS=2.47U PD=2.32U
M$1443 \$2746 WE7 VDD VDD pfet_03v3 L=0.28U W=0.72U AS=0.3168P AD=0.1872P
+ PS=2.32U PD=1.24U
M$1444 VDD CLK \$2746 VDD pfet_03v3 L=0.28U W=0.72U AS=0.1872P AD=0.3168P
+ PS=1.24U PD=2.32U
M$1445 \$2747 \$2746 VDD VDD pfet_03v3 L=0.28U W=2.54U AS=0.8974P AD=0.6604P
+ PS=5.28U PD=3.58U
M$1447 \$2748 \$2747 VDD VDD pfet_03v3 L=0.28U W=2.68U AS=0.7272P AD=0.9782P
+ PS=3.78U PD=5.48U
M$1449 \$2749 \$44 VDD VDD pfet_03v3 L=0.28U W=0.72U AS=0.3168P AD=0.2097P
+ PS=2.32U PD=1.38U
M$1450 \$2750 \$2748 \$2749 VDD pfet_03v3 L=0.28U W=0.36U AS=0.2097P AD=0.1278P
+ PS=1.38U PD=1.07U
M$1451 \$2962 \$2751 \$2750 VDD pfet_03v3 L=0.28U W=0.36U AS=0.1278P AD=0.0567P
+ PS=1.07U PD=0.675U
M$1452 VDD \$2747 \$2962 VDD pfet_03v3 L=0.28U W=0.36U AS=0.0567P AD=0.1584P
+ PS=0.675U PD=1.6U
M$1453 \$2751 \$2750 VDD VDD pfet_03v3 L=0.28U W=0.36U AS=0.1764P AD=0.1584P
+ PS=1.26U PD=1.6U
M$1454 \$2752 \$2750 VDD VDD pfet_03v3 L=0.28U W=0.72U AS=0.1764P AD=0.36P
+ PS=1.26U PD=2.44U
M$1455 \$2869 RA7 VDD VDD pfet_03v3 L=0.28U W=0.72U AS=0.3312P AD=0.3888P
+ PS=2.36U PD=2.52U
M$1456 \$2752 \$2869 \$360 VDD pfet_03v3 L=0.28U W=0.36U AS=0.1584P AD=0.1152P
+ PS=1.6U PD=1U
M$1457 \$361 \$2870 \$2752 VDD pfet_03v3 L=0.28U W=0.36U AS=0.1152P AD=0.1584P
+ PS=1U PD=1.6U
M$1458 VDD RB7 \$2870 VDD pfet_03v3 L=0.28U W=0.72U AS=0.3708P AD=0.3168P
+ PS=2.47U PD=2.32U
M$1459 \$2753 \$47 VDD VDD pfet_03v3 L=0.28U W=0.72U AS=0.3168P AD=0.2097P
+ PS=2.32U PD=1.38U
M$1460 \$2754 \$2748 \$2753 VDD pfet_03v3 L=0.28U W=0.36U AS=0.2097P AD=0.1278P
+ PS=1.38U PD=1.07U
M$1461 \$2972 \$2755 \$2754 VDD pfet_03v3 L=0.28U W=0.36U AS=0.1278P AD=0.0567P
+ PS=1.07U PD=0.675U
M$1462 VDD \$2747 \$2972 VDD pfet_03v3 L=0.28U W=0.36U AS=0.0567P AD=0.1584P
+ PS=0.675U PD=1.6U
M$1463 \$2755 \$2754 VDD VDD pfet_03v3 L=0.28U W=0.36U AS=0.1764P AD=0.1584P
+ PS=1.26U PD=1.6U
M$1464 \$2756 \$2754 VDD VDD pfet_03v3 L=0.28U W=0.72U AS=0.1764P AD=0.36P
+ PS=1.26U PD=2.44U
M$1465 \$2871 RA7 VDD VDD pfet_03v3 L=0.28U W=0.72U AS=0.3312P AD=0.3888P
+ PS=2.36U PD=2.52U
M$1466 \$2756 \$2871 \$365 VDD pfet_03v3 L=0.28U W=0.36U AS=0.1584P AD=0.1152P
+ PS=1.6U PD=1U
M$1467 \$366 \$2872 \$2756 VDD pfet_03v3 L=0.28U W=0.36U AS=0.1152P AD=0.1584P
+ PS=1U PD=1.6U
M$1468 VDD RB7 \$2872 VDD pfet_03v3 L=0.28U W=0.72U AS=0.3708P AD=0.3168P
+ PS=2.47U PD=2.32U
M$1469 \$2757 \$50 VDD VDD pfet_03v3 L=0.28U W=0.72U AS=0.3168P AD=0.2097P
+ PS=2.32U PD=1.38U
M$1470 \$2758 \$2748 \$2757 VDD pfet_03v3 L=0.28U W=0.36U AS=0.2097P AD=0.1278P
+ PS=1.38U PD=1.07U
M$1471 \$2978 \$2759 \$2758 VDD pfet_03v3 L=0.28U W=0.36U AS=0.1278P AD=0.0567P
+ PS=1.07U PD=0.675U
M$1472 VDD \$2747 \$2978 VDD pfet_03v3 L=0.28U W=0.36U AS=0.0567P AD=0.1584P
+ PS=0.675U PD=1.6U
M$1473 \$2759 \$2758 VDD VDD pfet_03v3 L=0.28U W=0.36U AS=0.1764P AD=0.1584P
+ PS=1.26U PD=1.6U
M$1474 \$2760 \$2758 VDD VDD pfet_03v3 L=0.28U W=0.72U AS=0.1764P AD=0.36P
+ PS=1.26U PD=2.44U
M$1475 \$2873 RA7 VDD VDD pfet_03v3 L=0.28U W=0.72U AS=0.3312P AD=0.3888P
+ PS=2.36U PD=2.52U
M$1476 \$2760 \$2873 \$370 VDD pfet_03v3 L=0.28U W=0.36U AS=0.1584P AD=0.1152P
+ PS=1.6U PD=1U
M$1477 \$371 \$2874 \$2760 VDD pfet_03v3 L=0.28U W=0.36U AS=0.1152P AD=0.1584P
+ PS=1U PD=1.6U
M$1478 VDD RB7 \$2874 VDD pfet_03v3 L=0.28U W=0.72U AS=0.3708P AD=0.3168P
+ PS=2.47U PD=2.32U
M$1479 \$2761 \$53 VDD VDD pfet_03v3 L=0.28U W=0.72U AS=0.3168P AD=0.2097P
+ PS=2.32U PD=1.38U
M$1480 \$2762 \$2748 \$2761 VDD pfet_03v3 L=0.28U W=0.36U AS=0.2097P AD=0.1278P
+ PS=1.38U PD=1.07U
M$1481 \$2988 \$2763 \$2762 VDD pfet_03v3 L=0.28U W=0.36U AS=0.1278P AD=0.0567P
+ PS=1.07U PD=0.675U
M$1482 VDD \$2747 \$2988 VDD pfet_03v3 L=0.28U W=0.36U AS=0.0567P AD=0.1584P
+ PS=0.675U PD=1.6U
M$1483 \$2763 \$2762 VDD VDD pfet_03v3 L=0.28U W=0.36U AS=0.1764P AD=0.1584P
+ PS=1.26U PD=1.6U
M$1484 \$2764 \$2762 VDD VDD pfet_03v3 L=0.28U W=0.72U AS=0.1764P AD=0.36P
+ PS=1.26U PD=2.44U
M$1485 \$2875 RA7 VDD VDD pfet_03v3 L=0.28U W=0.72U AS=0.3312P AD=0.3888P
+ PS=2.36U PD=2.52U
M$1486 \$2764 \$2875 \$375 VDD pfet_03v3 L=0.28U W=0.36U AS=0.1584P AD=0.1152P
+ PS=1.6U PD=1U
M$1487 \$376 \$2876 \$2764 VDD pfet_03v3 L=0.28U W=0.36U AS=0.1152P AD=0.1584P
+ PS=1U PD=1.6U
M$1488 VDD RB7 \$2876 VDD pfet_03v3 L=0.28U W=0.72U AS=0.3708P AD=0.3168P
+ PS=2.47U PD=2.32U
M$1489 \$2765 \$56 VDD VDD pfet_03v3 L=0.28U W=0.72U AS=0.3168P AD=0.2097P
+ PS=2.32U PD=1.38U
M$1490 \$2766 \$2748 \$2765 VDD pfet_03v3 L=0.28U W=0.36U AS=0.2097P AD=0.1278P
+ PS=1.38U PD=1.07U
M$1491 \$2997 \$2767 \$2766 VDD pfet_03v3 L=0.28U W=0.36U AS=0.1278P AD=0.0567P
+ PS=1.07U PD=0.675U
M$1492 VDD \$2747 \$2997 VDD pfet_03v3 L=0.28U W=0.36U AS=0.0567P AD=0.1584P
+ PS=0.675U PD=1.6U
M$1493 \$2767 \$2766 VDD VDD pfet_03v3 L=0.28U W=0.36U AS=0.1764P AD=0.1584P
+ PS=1.26U PD=1.6U
M$1494 \$2768 \$2766 VDD VDD pfet_03v3 L=0.28U W=0.72U AS=0.1764P AD=0.36P
+ PS=1.26U PD=2.44U
M$1495 \$2877 RA7 VDD VDD pfet_03v3 L=0.28U W=0.72U AS=0.3312P AD=0.3888P
+ PS=2.36U PD=2.52U
M$1496 \$2768 \$2877 \$380 VDD pfet_03v3 L=0.28U W=0.36U AS=0.1584P AD=0.1152P
+ PS=1.6U PD=1U
M$1497 \$381 \$2878 \$2768 VDD pfet_03v3 L=0.28U W=0.36U AS=0.1152P AD=0.1584P
+ PS=1U PD=1.6U
M$1498 VDD RB7 \$2878 VDD pfet_03v3 L=0.28U W=0.72U AS=0.3708P AD=0.3168P
+ PS=2.47U PD=2.32U
M$1499 \$2769 \$59 VDD VDD pfet_03v3 L=0.28U W=0.72U AS=0.3168P AD=0.2097P
+ PS=2.32U PD=1.38U
M$1500 \$2770 \$2748 \$2769 VDD pfet_03v3 L=0.28U W=0.36U AS=0.2097P AD=0.1278P
+ PS=1.38U PD=1.07U
M$1501 \$3006 \$2771 \$2770 VDD pfet_03v3 L=0.28U W=0.36U AS=0.1278P AD=0.0567P
+ PS=1.07U PD=0.675U
M$1502 VDD \$2747 \$3006 VDD pfet_03v3 L=0.28U W=0.36U AS=0.0567P AD=0.1584P
+ PS=0.675U PD=1.6U
M$1503 \$2771 \$2770 VDD VDD pfet_03v3 L=0.28U W=0.36U AS=0.1764P AD=0.1584P
+ PS=1.26U PD=1.6U
M$1504 \$2772 \$2770 VDD VDD pfet_03v3 L=0.28U W=0.72U AS=0.1764P AD=0.36P
+ PS=1.26U PD=2.44U
M$1505 \$2879 RA7 VDD VDD pfet_03v3 L=0.28U W=0.72U AS=0.3312P AD=0.3888P
+ PS=2.36U PD=2.52U
M$1506 \$2772 \$2879 \$385 VDD pfet_03v3 L=0.28U W=0.36U AS=0.1584P AD=0.1152P
+ PS=1.6U PD=1U
M$1507 \$386 \$2880 \$2772 VDD pfet_03v3 L=0.28U W=0.36U AS=0.1152P AD=0.1584P
+ PS=1U PD=1.6U
M$1508 VDD RB7 \$2880 VDD pfet_03v3 L=0.28U W=0.72U AS=0.3708P AD=0.3168P
+ PS=2.47U PD=2.32U
M$1509 \$2773 \$62 VDD VDD pfet_03v3 L=0.28U W=0.72U AS=0.3168P AD=0.2097P
+ PS=2.32U PD=1.38U
M$1510 \$2774 \$2748 \$2773 VDD pfet_03v3 L=0.28U W=0.36U AS=0.2097P AD=0.1278P
+ PS=1.38U PD=1.07U
M$1511 \$3014 \$2775 \$2774 VDD pfet_03v3 L=0.28U W=0.36U AS=0.1278P AD=0.0567P
+ PS=1.07U PD=0.675U
M$1512 VDD \$2747 \$3014 VDD pfet_03v3 L=0.28U W=0.36U AS=0.0567P AD=0.1584P
+ PS=0.675U PD=1.6U
M$1513 \$2775 \$2774 VDD VDD pfet_03v3 L=0.28U W=0.36U AS=0.1764P AD=0.1584P
+ PS=1.26U PD=1.6U
M$1514 \$2776 \$2774 VDD VDD pfet_03v3 L=0.28U W=0.72U AS=0.1764P AD=0.36P
+ PS=1.26U PD=2.44U
M$1515 \$2881 RA7 VDD VDD pfet_03v3 L=0.28U W=0.72U AS=0.3312P AD=0.3888P
+ PS=2.36U PD=2.52U
M$1516 \$2776 \$2881 \$390 VDD pfet_03v3 L=0.28U W=0.36U AS=0.1584P AD=0.1152P
+ PS=1.6U PD=1U
M$1517 \$391 \$2882 \$2776 VDD pfet_03v3 L=0.28U W=0.36U AS=0.1152P AD=0.1584P
+ PS=1U PD=1.6U
M$1518 VDD RB7 \$2882 VDD pfet_03v3 L=0.28U W=0.72U AS=0.3708P AD=0.3168P
+ PS=2.47U PD=2.32U
M$1519 \$2777 \$65 VDD VDD pfet_03v3 L=0.28U W=0.72U AS=0.3168P AD=0.2097P
+ PS=2.32U PD=1.38U
M$1520 \$2778 \$2748 \$2777 VDD pfet_03v3 L=0.28U W=0.36U AS=0.2097P AD=0.1278P
+ PS=1.38U PD=1.07U
M$1521 \$3023 \$2779 \$2778 VDD pfet_03v3 L=0.28U W=0.36U AS=0.1278P AD=0.0567P
+ PS=1.07U PD=0.675U
M$1522 VDD \$2747 \$3023 VDD pfet_03v3 L=0.28U W=0.36U AS=0.0567P AD=0.1584P
+ PS=0.675U PD=1.6U
M$1523 \$2779 \$2778 VDD VDD pfet_03v3 L=0.28U W=0.36U AS=0.1764P AD=0.1584P
+ PS=1.26U PD=1.6U
M$1524 \$2780 \$2778 VDD VDD pfet_03v3 L=0.28U W=0.72U AS=0.1764P AD=0.36P
+ PS=1.26U PD=2.44U
M$1525 \$2883 RA7 VDD VDD pfet_03v3 L=0.28U W=0.72U AS=0.3312P AD=0.3888P
+ PS=2.36U PD=2.52U
M$1526 \$2780 \$2883 \$395 VDD pfet_03v3 L=0.28U W=0.36U AS=0.1584P AD=0.1152P
+ PS=1.6U PD=1U
M$1527 \$396 \$2884 \$2780 VDD pfet_03v3 L=0.28U W=0.36U AS=0.1152P AD=0.1584P
+ PS=1U PD=1.6U
M$1528 VDD RB7 \$2884 VDD pfet_03v3 L=0.28U W=0.72U AS=0.3708P AD=0.3168P
+ PS=2.47U PD=2.32U
M$1529 \$2781 \$68 VDD VDD pfet_03v3 L=0.28U W=0.72U AS=0.3168P AD=0.2097P
+ PS=2.32U PD=1.38U
M$1530 \$2782 \$2748 \$2781 VDD pfet_03v3 L=0.28U W=0.36U AS=0.2097P AD=0.1278P
+ PS=1.38U PD=1.07U
M$1531 \$3032 \$2783 \$2782 VDD pfet_03v3 L=0.28U W=0.36U AS=0.1278P AD=0.0567P
+ PS=1.07U PD=0.675U
M$1532 VDD \$2747 \$3032 VDD pfet_03v3 L=0.28U W=0.36U AS=0.0567P AD=0.1584P
+ PS=0.675U PD=1.6U
M$1533 \$2783 \$2782 VDD VDD pfet_03v3 L=0.28U W=0.36U AS=0.1764P AD=0.1584P
+ PS=1.26U PD=1.6U
M$1534 \$2784 \$2782 VDD VDD pfet_03v3 L=0.28U W=0.72U AS=0.1764P AD=0.36P
+ PS=1.26U PD=2.44U
M$1535 \$2885 RA7 VDD VDD pfet_03v3 L=0.28U W=0.72U AS=0.3312P AD=0.3888P
+ PS=2.36U PD=2.52U
M$1536 \$2784 \$2885 \$400 VDD pfet_03v3 L=0.28U W=0.36U AS=0.1584P AD=0.1152P
+ PS=1.6U PD=1U
M$1537 \$401 \$2886 \$2784 VDD pfet_03v3 L=0.28U W=0.36U AS=0.1152P AD=0.1584P
+ PS=1U PD=1.6U
M$1538 VDD RB7 \$2886 VDD pfet_03v3 L=0.28U W=0.72U AS=0.3708P AD=0.3168P
+ PS=2.47U PD=2.32U
M$1539 \$2785 \$71 VDD VDD pfet_03v3 L=0.28U W=0.72U AS=0.3168P AD=0.2097P
+ PS=2.32U PD=1.38U
M$1540 \$2786 \$2748 \$2785 VDD pfet_03v3 L=0.28U W=0.36U AS=0.2097P AD=0.1278P
+ PS=1.38U PD=1.07U
M$1541 \$3041 \$2787 \$2786 VDD pfet_03v3 L=0.28U W=0.36U AS=0.1278P AD=0.0567P
+ PS=1.07U PD=0.675U
M$1542 VDD \$2747 \$3041 VDD pfet_03v3 L=0.28U W=0.36U AS=0.0567P AD=0.1584P
+ PS=0.675U PD=1.6U
M$1543 \$2787 \$2786 VDD VDD pfet_03v3 L=0.28U W=0.36U AS=0.1764P AD=0.1584P
+ PS=1.26U PD=1.6U
M$1544 \$2788 \$2786 VDD VDD pfet_03v3 L=0.28U W=0.72U AS=0.1764P AD=0.36P
+ PS=1.26U PD=2.44U
M$1545 \$2887 RA7 VDD VDD pfet_03v3 L=0.28U W=0.72U AS=0.3312P AD=0.3888P
+ PS=2.36U PD=2.52U
M$1546 \$2788 \$2887 \$405 VDD pfet_03v3 L=0.28U W=0.36U AS=0.1584P AD=0.1152P
+ PS=1.6U PD=1U
M$1547 \$406 \$2888 \$2788 VDD pfet_03v3 L=0.28U W=0.36U AS=0.1152P AD=0.1584P
+ PS=1U PD=1.6U
M$1548 VDD RB7 \$2888 VDD pfet_03v3 L=0.28U W=0.72U AS=0.3708P AD=0.3168P
+ PS=2.47U PD=2.32U
M$1549 \$2789 \$74 VDD VDD pfet_03v3 L=0.28U W=0.72U AS=0.3168P AD=0.2097P
+ PS=2.32U PD=1.38U
M$1550 \$2790 \$2748 \$2789 VDD pfet_03v3 L=0.28U W=0.36U AS=0.2097P AD=0.1278P
+ PS=1.38U PD=1.07U
M$1551 \$3050 \$2791 \$2790 VDD pfet_03v3 L=0.28U W=0.36U AS=0.1278P AD=0.0567P
+ PS=1.07U PD=0.675U
M$1552 VDD \$2747 \$3050 VDD pfet_03v3 L=0.28U W=0.36U AS=0.0567P AD=0.1584P
+ PS=0.675U PD=1.6U
M$1553 \$2791 \$2790 VDD VDD pfet_03v3 L=0.28U W=0.36U AS=0.1764P AD=0.1584P
+ PS=1.26U PD=1.6U
M$1554 \$2792 \$2790 VDD VDD pfet_03v3 L=0.28U W=0.72U AS=0.1764P AD=0.36P
+ PS=1.26U PD=2.44U
M$1555 \$2889 RA7 VDD VDD pfet_03v3 L=0.28U W=0.72U AS=0.3312P AD=0.3888P
+ PS=2.36U PD=2.52U
M$1556 \$2792 \$2889 \$410 VDD pfet_03v3 L=0.28U W=0.36U AS=0.1584P AD=0.1152P
+ PS=1.6U PD=1U
M$1557 \$411 \$2890 \$2792 VDD pfet_03v3 L=0.28U W=0.36U AS=0.1152P AD=0.1584P
+ PS=1U PD=1.6U
M$1558 VDD RB7 \$2890 VDD pfet_03v3 L=0.28U W=0.72U AS=0.3708P AD=0.3168P
+ PS=2.47U PD=2.32U
M$1559 \$2793 \$77 VDD VDD pfet_03v3 L=0.28U W=0.72U AS=0.3168P AD=0.2097P
+ PS=2.32U PD=1.38U
M$1560 \$2794 \$2748 \$2793 VDD pfet_03v3 L=0.28U W=0.36U AS=0.2097P AD=0.1278P
+ PS=1.38U PD=1.07U
M$1561 \$3058 \$2795 \$2794 VDD pfet_03v3 L=0.28U W=0.36U AS=0.1278P AD=0.0567P
+ PS=1.07U PD=0.675U
M$1562 VDD \$2747 \$3058 VDD pfet_03v3 L=0.28U W=0.36U AS=0.0567P AD=0.1584P
+ PS=0.675U PD=1.6U
M$1563 \$2795 \$2794 VDD VDD pfet_03v3 L=0.28U W=0.36U AS=0.1764P AD=0.1584P
+ PS=1.26U PD=1.6U
M$1564 \$2796 \$2794 VDD VDD pfet_03v3 L=0.28U W=0.72U AS=0.1764P AD=0.36P
+ PS=1.26U PD=2.44U
M$1565 \$2891 RA7 VDD VDD pfet_03v3 L=0.28U W=0.72U AS=0.3312P AD=0.3888P
+ PS=2.36U PD=2.52U
M$1566 \$2796 \$2891 \$415 VDD pfet_03v3 L=0.28U W=0.36U AS=0.1584P AD=0.1152P
+ PS=1.6U PD=1U
M$1567 \$416 \$2892 \$2796 VDD pfet_03v3 L=0.28U W=0.36U AS=0.1152P AD=0.1584P
+ PS=1U PD=1.6U
M$1568 VDD RB7 \$2892 VDD pfet_03v3 L=0.28U W=0.72U AS=0.3708P AD=0.3168P
+ PS=2.47U PD=2.32U
M$1569 \$2797 \$80 VDD VDD pfet_03v3 L=0.28U W=0.72U AS=0.3168P AD=0.2097P
+ PS=2.32U PD=1.38U
M$1570 \$2798 \$2748 \$2797 VDD pfet_03v3 L=0.28U W=0.36U AS=0.2097P AD=0.1278P
+ PS=1.38U PD=1.07U
M$1571 \$3044 \$2799 \$2798 VDD pfet_03v3 L=0.28U W=0.36U AS=0.1278P AD=0.0567P
+ PS=1.07U PD=0.675U
M$1572 VDD \$2747 \$3044 VDD pfet_03v3 L=0.28U W=0.36U AS=0.0567P AD=0.1584P
+ PS=0.675U PD=1.6U
M$1573 \$2799 \$2798 VDD VDD pfet_03v3 L=0.28U W=0.36U AS=0.1764P AD=0.1584P
+ PS=1.26U PD=1.6U
M$1574 \$2800 \$2798 VDD VDD pfet_03v3 L=0.28U W=0.72U AS=0.1764P AD=0.36P
+ PS=1.26U PD=2.44U
M$1575 \$2893 RA7 VDD VDD pfet_03v3 L=0.28U W=0.72U AS=0.3312P AD=0.3888P
+ PS=2.36U PD=2.52U
M$1576 \$2800 \$2893 \$420 VDD pfet_03v3 L=0.28U W=0.36U AS=0.1584P AD=0.1152P
+ PS=1.6U PD=1U
M$1577 \$421 \$2894 \$2800 VDD pfet_03v3 L=0.28U W=0.36U AS=0.1152P AD=0.1584P
+ PS=1U PD=1.6U
M$1578 VDD RB7 \$2894 VDD pfet_03v3 L=0.28U W=0.72U AS=0.3708P AD=0.3168P
+ PS=2.47U PD=2.32U
M$1579 \$2801 \$83 VDD VDD pfet_03v3 L=0.28U W=0.72U AS=0.3168P AD=0.2097P
+ PS=2.32U PD=1.38U
M$1580 \$2802 \$2748 \$2801 VDD pfet_03v3 L=0.28U W=0.36U AS=0.2097P AD=0.1278P
+ PS=1.38U PD=1.07U
M$1581 \$3016 \$2803 \$2802 VDD pfet_03v3 L=0.28U W=0.36U AS=0.1278P AD=0.0567P
+ PS=1.07U PD=0.675U
M$1582 VDD \$2747 \$3016 VDD pfet_03v3 L=0.28U W=0.36U AS=0.0567P AD=0.1584P
+ PS=0.675U PD=1.6U
M$1583 \$2803 \$2802 VDD VDD pfet_03v3 L=0.28U W=0.36U AS=0.1764P AD=0.1584P
+ PS=1.26U PD=1.6U
M$1584 \$2804 \$2802 VDD VDD pfet_03v3 L=0.28U W=0.72U AS=0.1764P AD=0.36P
+ PS=1.26U PD=2.44U
M$1585 \$2895 RA7 VDD VDD pfet_03v3 L=0.28U W=0.72U AS=0.3312P AD=0.3888P
+ PS=2.36U PD=2.52U
M$1586 \$2804 \$2895 \$425 VDD pfet_03v3 L=0.28U W=0.36U AS=0.1584P AD=0.1152P
+ PS=1.6U PD=1U
M$1587 \$426 \$2896 \$2804 VDD pfet_03v3 L=0.28U W=0.36U AS=0.1152P AD=0.1584P
+ PS=1U PD=1.6U
M$1588 VDD RB7 \$2896 VDD pfet_03v3 L=0.28U W=0.72U AS=0.3708P AD=0.3168P
+ PS=2.47U PD=2.32U
M$1589 \$2805 \$86 VDD VDD pfet_03v3 L=0.28U W=0.72U AS=0.3168P AD=0.2097P
+ PS=2.32U PD=1.38U
M$1590 \$2806 \$2748 \$2805 VDD pfet_03v3 L=0.28U W=0.36U AS=0.2097P AD=0.1278P
+ PS=1.38U PD=1.07U
M$1591 \$2998 \$2807 \$2806 VDD pfet_03v3 L=0.28U W=0.36U AS=0.1278P AD=0.0567P
+ PS=1.07U PD=0.675U
M$1592 VDD \$2747 \$2998 VDD pfet_03v3 L=0.28U W=0.36U AS=0.0567P AD=0.1584P
+ PS=0.675U PD=1.6U
M$1593 \$2807 \$2806 VDD VDD pfet_03v3 L=0.28U W=0.36U AS=0.1764P AD=0.1584P
+ PS=1.26U PD=1.6U
M$1594 \$2808 \$2806 VDD VDD pfet_03v3 L=0.28U W=0.72U AS=0.1764P AD=0.36P
+ PS=1.26U PD=2.44U
M$1595 \$2897 RA7 VDD VDD pfet_03v3 L=0.28U W=0.72U AS=0.3312P AD=0.3888P
+ PS=2.36U PD=2.52U
M$1596 \$2808 \$2897 \$430 VDD pfet_03v3 L=0.28U W=0.36U AS=0.1584P AD=0.1152P
+ PS=1.6U PD=1U
M$1597 \$431 \$2898 \$2808 VDD pfet_03v3 L=0.28U W=0.36U AS=0.1152P AD=0.1584P
+ PS=1U PD=1.6U
M$1598 VDD RB7 \$2898 VDD pfet_03v3 L=0.28U W=0.72U AS=0.3708P AD=0.3168P
+ PS=2.47U PD=2.32U
M$1599 \$2809 \$89 VDD VDD pfet_03v3 L=0.28U W=0.72U AS=0.3168P AD=0.2097P
+ PS=2.32U PD=1.38U
M$1600 \$2810 \$2748 \$2809 VDD pfet_03v3 L=0.28U W=0.36U AS=0.2097P AD=0.1278P
+ PS=1.38U PD=1.07U
M$1601 \$2970 \$2811 \$2810 VDD pfet_03v3 L=0.28U W=0.36U AS=0.1278P AD=0.0567P
+ PS=1.07U PD=0.675U
M$1602 VDD \$2747 \$2970 VDD pfet_03v3 L=0.28U W=0.36U AS=0.0567P AD=0.1584P
+ PS=0.675U PD=1.6U
M$1603 \$2811 \$2810 VDD VDD pfet_03v3 L=0.28U W=0.36U AS=0.1764P AD=0.1584P
+ PS=1.26U PD=1.6U
M$1604 \$2812 \$2810 VDD VDD pfet_03v3 L=0.28U W=0.72U AS=0.1764P AD=0.36P
+ PS=1.26U PD=2.44U
M$1605 \$2899 RA7 VDD VDD pfet_03v3 L=0.28U W=0.72U AS=0.3312P AD=0.3888P
+ PS=2.36U PD=2.52U
M$1606 \$2812 \$2899 \$435 VDD pfet_03v3 L=0.28U W=0.36U AS=0.1584P AD=0.1152P
+ PS=1.6U PD=1U
M$1607 \$436 \$2900 \$2812 VDD pfet_03v3 L=0.28U W=0.36U AS=0.1152P AD=0.1584P
+ PS=1U PD=1.6U
M$1608 VDD RB7 \$2900 VDD pfet_03v3 L=0.28U W=0.72U AS=0.3708P AD=0.3168P
+ PS=2.47U PD=2.32U
M$1609 \$3062 WE6 VDD VDD pfet_03v3 L=0.28U W=0.72U AS=0.3168P AD=0.1872P
+ PS=2.32U PD=1.24U
M$1610 VDD CLK \$3062 VDD pfet_03v3 L=0.28U W=0.72U AS=0.1872P AD=0.3168P
+ PS=1.24U PD=2.32U
M$1611 \$3064 \$3062 VDD VDD pfet_03v3 L=0.28U W=2.54U AS=0.889P AD=0.6688P
+ PS=5.21U PD=3.65U
M$1613 \$3065 \$3064 VDD VDD pfet_03v3 L=0.28U W=2.68U AS=0.7272P AD=0.9782P
+ PS=3.78U PD=5.48U
M$1615 \$3069 \$3065 \$3068 VDD pfet_03v3 L=0.28U W=0.36U AS=0.2097P AD=0.1278P
+ PS=1.38U PD=1.07U
M$1616 \$3169 \$3070 \$3069 VDD pfet_03v3 L=0.28U W=0.36U AS=0.1278P AD=0.0567P
+ PS=1.07U PD=0.675U
M$1617 VDD \$3064 \$3169 VDD pfet_03v3 L=0.28U W=0.36U AS=0.0567P AD=0.1584P
+ PS=0.675U PD=1.6U
M$1618 \$3068 \$44 VDD VDD pfet_03v3 L=0.28U W=0.72U AS=0.3168P AD=0.2097P
+ PS=2.32U PD=1.38U
M$1619 VDD \$3069 \$3070 VDD pfet_03v3 L=0.28U W=0.36U AS=0.1584P AD=0.1764P
+ PS=1.6U PD=1.26U
M$1620 \$3071 \$3069 VDD VDD pfet_03v3 L=0.28U W=0.72U AS=0.1764P AD=0.36P
+ PS=1.26U PD=2.44U
M$1621 \$3072 RB6 VDD VDD pfet_03v3 L=0.28U W=0.72U AS=0.3312P AD=0.3888P
+ PS=2.36U PD=2.52U
M$1622 \$3071 \$3072 \$360 VDD pfet_03v3 L=0.28U W=0.36U AS=0.1584P AD=0.1152P
+ PS=1.6U PD=1U
M$1623 \$361 \$3073 \$3071 VDD pfet_03v3 L=0.28U W=0.36U AS=0.1152P AD=0.1584P
+ PS=1U PD=1.6U
M$1624 VDD RA6 \$3073 VDD pfet_03v3 L=0.28U W=0.72U AS=0.3708P AD=0.3168P
+ PS=2.47U PD=2.32U
M$1625 \$3075 \$3065 \$3074 VDD pfet_03v3 L=0.28U W=0.36U AS=0.2097P AD=0.1278P
+ PS=1.38U PD=1.07U
M$1626 \$3177 \$3076 \$3075 VDD pfet_03v3 L=0.28U W=0.36U AS=0.1278P AD=0.0567P
+ PS=1.07U PD=0.675U
M$1627 VDD \$3064 \$3177 VDD pfet_03v3 L=0.28U W=0.36U AS=0.0567P AD=0.1584P
+ PS=0.675U PD=1.6U
M$1628 \$3074 \$47 VDD VDD pfet_03v3 L=0.28U W=0.72U AS=0.3168P AD=0.2097P
+ PS=2.32U PD=1.38U
M$1629 VDD \$3075 \$3076 VDD pfet_03v3 L=0.28U W=0.36U AS=0.1584P AD=0.1764P
+ PS=1.6U PD=1.26U
M$1630 \$3077 \$3075 VDD VDD pfet_03v3 L=0.28U W=0.72U AS=0.1764P AD=0.36P
+ PS=1.26U PD=2.44U
M$1631 \$3078 RB6 VDD VDD pfet_03v3 L=0.28U W=0.72U AS=0.3312P AD=0.3888P
+ PS=2.36U PD=2.52U
M$1632 \$3077 \$3078 \$365 VDD pfet_03v3 L=0.28U W=0.36U AS=0.1584P AD=0.1152P
+ PS=1.6U PD=1U
M$1633 \$366 \$3079 \$3077 VDD pfet_03v3 L=0.28U W=0.36U AS=0.1152P AD=0.1584P
+ PS=1U PD=1.6U
M$1634 VDD RA6 \$3079 VDD pfet_03v3 L=0.28U W=0.72U AS=0.3708P AD=0.3168P
+ PS=2.47U PD=2.32U
M$1635 \$3081 \$3065 \$3080 VDD pfet_03v3 L=0.28U W=0.36U AS=0.2097P AD=0.1278P
+ PS=1.38U PD=1.07U
M$1636 \$3184 \$3082 \$3081 VDD pfet_03v3 L=0.28U W=0.36U AS=0.1278P AD=0.0567P
+ PS=1.07U PD=0.675U
M$1637 VDD \$3064 \$3184 VDD pfet_03v3 L=0.28U W=0.36U AS=0.0567P AD=0.1584P
+ PS=0.675U PD=1.6U
M$1638 \$3080 \$50 VDD VDD pfet_03v3 L=0.28U W=0.72U AS=0.3168P AD=0.2097P
+ PS=2.32U PD=1.38U
M$1639 VDD \$3081 \$3082 VDD pfet_03v3 L=0.28U W=0.36U AS=0.1584P AD=0.1764P
+ PS=1.6U PD=1.26U
M$1640 \$3083 \$3081 VDD VDD pfet_03v3 L=0.28U W=0.72U AS=0.1764P AD=0.36P
+ PS=1.26U PD=2.44U
M$1641 \$3084 RB6 VDD VDD pfet_03v3 L=0.28U W=0.72U AS=0.3312P AD=0.3888P
+ PS=2.36U PD=2.52U
M$1642 \$3083 \$3084 \$370 VDD pfet_03v3 L=0.28U W=0.36U AS=0.1584P AD=0.1152P
+ PS=1.6U PD=1U
M$1643 \$371 \$3085 \$3083 VDD pfet_03v3 L=0.28U W=0.36U AS=0.1152P AD=0.1584P
+ PS=1U PD=1.6U
M$1644 VDD RA6 \$3085 VDD pfet_03v3 L=0.28U W=0.72U AS=0.3708P AD=0.3168P
+ PS=2.47U PD=2.32U
M$1645 \$3087 \$3065 \$3086 VDD pfet_03v3 L=0.28U W=0.36U AS=0.2097P AD=0.1278P
+ PS=1.38U PD=1.07U
M$1646 \$3192 \$3088 \$3087 VDD pfet_03v3 L=0.28U W=0.36U AS=0.1278P AD=0.0567P
+ PS=1.07U PD=0.675U
M$1647 VDD \$3064 \$3192 VDD pfet_03v3 L=0.28U W=0.36U AS=0.0567P AD=0.1584P
+ PS=0.675U PD=1.6U
M$1648 \$3086 \$53 VDD VDD pfet_03v3 L=0.28U W=0.72U AS=0.3168P AD=0.2097P
+ PS=2.32U PD=1.38U
M$1649 VDD \$3087 \$3088 VDD pfet_03v3 L=0.28U W=0.36U AS=0.1584P AD=0.1764P
+ PS=1.6U PD=1.26U
M$1650 \$3089 \$3087 VDD VDD pfet_03v3 L=0.28U W=0.72U AS=0.1764P AD=0.36P
+ PS=1.26U PD=2.44U
M$1651 \$3090 RB6 VDD VDD pfet_03v3 L=0.28U W=0.72U AS=0.3312P AD=0.3888P
+ PS=2.36U PD=2.52U
M$1652 \$3089 \$3090 \$375 VDD pfet_03v3 L=0.28U W=0.36U AS=0.1584P AD=0.1152P
+ PS=1.6U PD=1U
M$1653 \$376 \$3091 \$3089 VDD pfet_03v3 L=0.28U W=0.36U AS=0.1152P AD=0.1584P
+ PS=1U PD=1.6U
M$1654 VDD RA6 \$3091 VDD pfet_03v3 L=0.28U W=0.72U AS=0.3708P AD=0.3168P
+ PS=2.47U PD=2.32U
M$1655 \$3093 \$3065 \$3092 VDD pfet_03v3 L=0.28U W=0.36U AS=0.2097P AD=0.1278P
+ PS=1.38U PD=1.07U
M$1656 \$3201 \$3094 \$3093 VDD pfet_03v3 L=0.28U W=0.36U AS=0.1278P AD=0.0567P
+ PS=1.07U PD=0.675U
M$1657 VDD \$3064 \$3201 VDD pfet_03v3 L=0.28U W=0.36U AS=0.0567P AD=0.1584P
+ PS=0.675U PD=1.6U
M$1658 \$3092 \$56 VDD VDD pfet_03v3 L=0.28U W=0.72U AS=0.3168P AD=0.2097P
+ PS=2.32U PD=1.38U
M$1659 VDD \$3093 \$3094 VDD pfet_03v3 L=0.28U W=0.36U AS=0.1584P AD=0.1764P
+ PS=1.6U PD=1.26U
M$1660 \$3095 \$3093 VDD VDD pfet_03v3 L=0.28U W=0.72U AS=0.1764P AD=0.36P
+ PS=1.26U PD=2.44U
M$1661 \$3096 RB6 VDD VDD pfet_03v3 L=0.28U W=0.72U AS=0.3312P AD=0.3888P
+ PS=2.36U PD=2.52U
M$1662 \$3095 \$3096 \$380 VDD pfet_03v3 L=0.28U W=0.36U AS=0.1584P AD=0.1152P
+ PS=1.6U PD=1U
M$1663 \$381 \$3097 \$3095 VDD pfet_03v3 L=0.28U W=0.36U AS=0.1152P AD=0.1584P
+ PS=1U PD=1.6U
M$1664 VDD RA6 \$3097 VDD pfet_03v3 L=0.28U W=0.72U AS=0.3708P AD=0.3168P
+ PS=2.47U PD=2.32U
M$1665 \$3099 \$3065 \$3098 VDD pfet_03v3 L=0.28U W=0.36U AS=0.2097P AD=0.1278P
+ PS=1.38U PD=1.07U
M$1666 \$3207 \$3100 \$3099 VDD pfet_03v3 L=0.28U W=0.36U AS=0.1278P AD=0.0567P
+ PS=1.07U PD=0.675U
M$1667 VDD \$3064 \$3207 VDD pfet_03v3 L=0.28U W=0.36U AS=0.0567P AD=0.1584P
+ PS=0.675U PD=1.6U
M$1668 \$3098 \$59 VDD VDD pfet_03v3 L=0.28U W=0.72U AS=0.3168P AD=0.2097P
+ PS=2.32U PD=1.38U
M$1669 VDD \$3099 \$3100 VDD pfet_03v3 L=0.28U W=0.36U AS=0.1584P AD=0.1764P
+ PS=1.6U PD=1.26U
M$1670 \$3101 \$3099 VDD VDD pfet_03v3 L=0.28U W=0.72U AS=0.1764P AD=0.36P
+ PS=1.26U PD=2.44U
M$1671 \$3102 RB6 VDD VDD pfet_03v3 L=0.28U W=0.72U AS=0.3312P AD=0.3888P
+ PS=2.36U PD=2.52U
M$1672 \$3101 \$3102 \$385 VDD pfet_03v3 L=0.28U W=0.36U AS=0.1584P AD=0.1152P
+ PS=1.6U PD=1U
M$1673 \$386 \$3103 \$3101 VDD pfet_03v3 L=0.28U W=0.36U AS=0.1152P AD=0.1584P
+ PS=1U PD=1.6U
M$1674 VDD RA6 \$3103 VDD pfet_03v3 L=0.28U W=0.72U AS=0.3708P AD=0.3168P
+ PS=2.47U PD=2.32U
M$1675 \$3105 \$3065 \$3104 VDD pfet_03v3 L=0.28U W=0.36U AS=0.2097P AD=0.1278P
+ PS=1.38U PD=1.07U
M$1676 \$3214 \$3106 \$3105 VDD pfet_03v3 L=0.28U W=0.36U AS=0.1278P AD=0.0567P
+ PS=1.07U PD=0.675U
M$1677 VDD \$3064 \$3214 VDD pfet_03v3 L=0.28U W=0.36U AS=0.0567P AD=0.1584P
+ PS=0.675U PD=1.6U
M$1678 \$3104 \$62 VDD VDD pfet_03v3 L=0.28U W=0.72U AS=0.3168P AD=0.2097P
+ PS=2.32U PD=1.38U
M$1679 VDD \$3105 \$3106 VDD pfet_03v3 L=0.28U W=0.36U AS=0.1584P AD=0.1764P
+ PS=1.6U PD=1.26U
M$1680 \$3107 \$3105 VDD VDD pfet_03v3 L=0.28U W=0.72U AS=0.1764P AD=0.36P
+ PS=1.26U PD=2.44U
M$1681 \$3108 RB6 VDD VDD pfet_03v3 L=0.28U W=0.72U AS=0.3312P AD=0.3888P
+ PS=2.36U PD=2.52U
M$1682 \$3107 \$3108 \$390 VDD pfet_03v3 L=0.28U W=0.36U AS=0.1584P AD=0.1152P
+ PS=1.6U PD=1U
M$1683 \$391 \$3109 \$3107 VDD pfet_03v3 L=0.28U W=0.36U AS=0.1152P AD=0.1584P
+ PS=1U PD=1.6U
M$1684 VDD RA6 \$3109 VDD pfet_03v3 L=0.28U W=0.72U AS=0.3708P AD=0.3168P
+ PS=2.47U PD=2.32U
M$1685 \$3111 \$3065 \$3110 VDD pfet_03v3 L=0.28U W=0.36U AS=0.2097P AD=0.1278P
+ PS=1.38U PD=1.07U
M$1686 \$3223 \$3112 \$3111 VDD pfet_03v3 L=0.28U W=0.36U AS=0.1278P AD=0.0567P
+ PS=1.07U PD=0.675U
M$1687 VDD \$3064 \$3223 VDD pfet_03v3 L=0.28U W=0.36U AS=0.0567P AD=0.1584P
+ PS=0.675U PD=1.6U
M$1688 \$3110 \$65 VDD VDD pfet_03v3 L=0.28U W=0.72U AS=0.3168P AD=0.2097P
+ PS=2.32U PD=1.38U
M$1689 VDD \$3111 \$3112 VDD pfet_03v3 L=0.28U W=0.36U AS=0.1584P AD=0.1764P
+ PS=1.6U PD=1.26U
M$1690 \$3113 \$3111 VDD VDD pfet_03v3 L=0.28U W=0.72U AS=0.1764P AD=0.36P
+ PS=1.26U PD=2.44U
M$1691 \$3114 RB6 VDD VDD pfet_03v3 L=0.28U W=0.72U AS=0.3312P AD=0.3888P
+ PS=2.36U PD=2.52U
M$1692 \$3113 \$3114 \$395 VDD pfet_03v3 L=0.28U W=0.36U AS=0.1584P AD=0.1152P
+ PS=1.6U PD=1U
M$1693 \$396 \$3115 \$3113 VDD pfet_03v3 L=0.28U W=0.36U AS=0.1152P AD=0.1584P
+ PS=1U PD=1.6U
M$1694 VDD RA6 \$3115 VDD pfet_03v3 L=0.28U W=0.72U AS=0.3708P AD=0.3168P
+ PS=2.47U PD=2.32U
M$1695 \$3117 \$3065 \$3116 VDD pfet_03v3 L=0.28U W=0.36U AS=0.2097P AD=0.1278P
+ PS=1.38U PD=1.07U
M$1696 \$3229 \$3118 \$3117 VDD pfet_03v3 L=0.28U W=0.36U AS=0.1278P AD=0.0567P
+ PS=1.07U PD=0.675U
M$1697 VDD \$3064 \$3229 VDD pfet_03v3 L=0.28U W=0.36U AS=0.0567P AD=0.1584P
+ PS=0.675U PD=1.6U
M$1698 \$3116 \$68 VDD VDD pfet_03v3 L=0.28U W=0.72U AS=0.3168P AD=0.2097P
+ PS=2.32U PD=1.38U
M$1699 VDD \$3117 \$3118 VDD pfet_03v3 L=0.28U W=0.36U AS=0.1584P AD=0.1764P
+ PS=1.6U PD=1.26U
M$1700 \$3119 \$3117 VDD VDD pfet_03v3 L=0.28U W=0.72U AS=0.1764P AD=0.36P
+ PS=1.26U PD=2.44U
M$1701 \$3120 RB6 VDD VDD pfet_03v3 L=0.28U W=0.72U AS=0.3312P AD=0.3888P
+ PS=2.36U PD=2.52U
M$1702 \$3119 \$3120 \$400 VDD pfet_03v3 L=0.28U W=0.36U AS=0.1584P AD=0.1152P
+ PS=1.6U PD=1U
M$1703 \$401 \$3121 \$3119 VDD pfet_03v3 L=0.28U W=0.36U AS=0.1152P AD=0.1584P
+ PS=1U PD=1.6U
M$1704 VDD RA6 \$3121 VDD pfet_03v3 L=0.28U W=0.72U AS=0.3708P AD=0.3168P
+ PS=2.47U PD=2.32U
M$1705 \$3123 \$3065 \$3122 VDD pfet_03v3 L=0.28U W=0.36U AS=0.2097P AD=0.1278P
+ PS=1.38U PD=1.07U
M$1706 \$3236 \$3124 \$3123 VDD pfet_03v3 L=0.28U W=0.36U AS=0.1278P AD=0.0567P
+ PS=1.07U PD=0.675U
M$1707 VDD \$3064 \$3236 VDD pfet_03v3 L=0.28U W=0.36U AS=0.0567P AD=0.1584P
+ PS=0.675U PD=1.6U
M$1708 \$3122 \$71 VDD VDD pfet_03v3 L=0.28U W=0.72U AS=0.3168P AD=0.2097P
+ PS=2.32U PD=1.38U
M$1709 VDD \$3123 \$3124 VDD pfet_03v3 L=0.28U W=0.36U AS=0.1584P AD=0.1764P
+ PS=1.6U PD=1.26U
M$1710 \$3125 \$3123 VDD VDD pfet_03v3 L=0.28U W=0.72U AS=0.1764P AD=0.36P
+ PS=1.26U PD=2.44U
M$1711 \$3126 RB6 VDD VDD pfet_03v3 L=0.28U W=0.72U AS=0.3312P AD=0.3888P
+ PS=2.36U PD=2.52U
M$1712 \$3125 \$3126 \$405 VDD pfet_03v3 L=0.28U W=0.36U AS=0.1584P AD=0.1152P
+ PS=1.6U PD=1U
M$1713 \$406 \$3127 \$3125 VDD pfet_03v3 L=0.28U W=0.36U AS=0.1152P AD=0.1584P
+ PS=1U PD=1.6U
M$1714 VDD RA6 \$3127 VDD pfet_03v3 L=0.28U W=0.72U AS=0.3708P AD=0.3168P
+ PS=2.47U PD=2.32U
M$1715 \$3129 \$3065 \$3128 VDD pfet_03v3 L=0.28U W=0.36U AS=0.2097P AD=0.1278P
+ PS=1.38U PD=1.07U
M$1716 \$3244 \$3130 \$3129 VDD pfet_03v3 L=0.28U W=0.36U AS=0.1278P AD=0.0567P
+ PS=1.07U PD=0.675U
M$1717 VDD \$3064 \$3244 VDD pfet_03v3 L=0.28U W=0.36U AS=0.0567P AD=0.1584P
+ PS=0.675U PD=1.6U
M$1718 \$3128 \$74 VDD VDD pfet_03v3 L=0.28U W=0.72U AS=0.3168P AD=0.2097P
+ PS=2.32U PD=1.38U
M$1719 VDD \$3129 \$3130 VDD pfet_03v3 L=0.28U W=0.36U AS=0.1584P AD=0.1764P
+ PS=1.6U PD=1.26U
M$1720 \$3131 \$3129 VDD VDD pfet_03v3 L=0.28U W=0.72U AS=0.1764P AD=0.36P
+ PS=1.26U PD=2.44U
M$1721 \$3132 RB6 VDD VDD pfet_03v3 L=0.28U W=0.72U AS=0.3312P AD=0.3888P
+ PS=2.36U PD=2.52U
M$1722 \$3131 \$3132 \$410 VDD pfet_03v3 L=0.28U W=0.36U AS=0.1584P AD=0.1152P
+ PS=1.6U PD=1U
M$1723 \$411 \$3133 \$3131 VDD pfet_03v3 L=0.28U W=0.36U AS=0.1152P AD=0.1584P
+ PS=1U PD=1.6U
M$1724 VDD RA6 \$3133 VDD pfet_03v3 L=0.28U W=0.72U AS=0.3708P AD=0.3168P
+ PS=2.47U PD=2.32U
M$1725 \$3135 \$3065 \$3134 VDD pfet_03v3 L=0.28U W=0.36U AS=0.2097P AD=0.1278P
+ PS=1.38U PD=1.07U
M$1726 \$3252 \$3136 \$3135 VDD pfet_03v3 L=0.28U W=0.36U AS=0.1278P AD=0.0567P
+ PS=1.07U PD=0.675U
M$1727 VDD \$3064 \$3252 VDD pfet_03v3 L=0.28U W=0.36U AS=0.0567P AD=0.1584P
+ PS=0.675U PD=1.6U
M$1728 \$3134 \$77 VDD VDD pfet_03v3 L=0.28U W=0.72U AS=0.3168P AD=0.2097P
+ PS=2.32U PD=1.38U
M$1729 VDD \$3135 \$3136 VDD pfet_03v3 L=0.28U W=0.36U AS=0.1584P AD=0.1764P
+ PS=1.6U PD=1.26U
M$1730 \$3137 \$3135 VDD VDD pfet_03v3 L=0.28U W=0.72U AS=0.1764P AD=0.36P
+ PS=1.26U PD=2.44U
M$1731 \$3138 RB6 VDD VDD pfet_03v3 L=0.28U W=0.72U AS=0.3312P AD=0.3888P
+ PS=2.36U PD=2.52U
M$1732 \$3137 \$3138 \$415 VDD pfet_03v3 L=0.28U W=0.36U AS=0.1584P AD=0.1152P
+ PS=1.6U PD=1U
M$1733 \$416 \$3139 \$3137 VDD pfet_03v3 L=0.28U W=0.36U AS=0.1152P AD=0.1584P
+ PS=1U PD=1.6U
M$1734 VDD RA6 \$3139 VDD pfet_03v3 L=0.28U W=0.72U AS=0.3708P AD=0.3168P
+ PS=2.47U PD=2.32U
M$1735 \$3141 \$3065 \$3140 VDD pfet_03v3 L=0.28U W=0.36U AS=0.2097P AD=0.1278P
+ PS=1.38U PD=1.07U
M$1736 \$3259 \$3142 \$3141 VDD pfet_03v3 L=0.28U W=0.36U AS=0.1278P AD=0.0567P
+ PS=1.07U PD=0.675U
M$1737 VDD \$3064 \$3259 VDD pfet_03v3 L=0.28U W=0.36U AS=0.0567P AD=0.1584P
+ PS=0.675U PD=1.6U
M$1738 \$3140 \$80 VDD VDD pfet_03v3 L=0.28U W=0.72U AS=0.3168P AD=0.2097P
+ PS=2.32U PD=1.38U
M$1739 VDD \$3141 \$3142 VDD pfet_03v3 L=0.28U W=0.36U AS=0.1584P AD=0.1764P
+ PS=1.6U PD=1.26U
M$1740 \$3143 \$3141 VDD VDD pfet_03v3 L=0.28U W=0.72U AS=0.1764P AD=0.36P
+ PS=1.26U PD=2.44U
M$1741 \$3144 RB6 VDD VDD pfet_03v3 L=0.28U W=0.72U AS=0.3312P AD=0.3888P
+ PS=2.36U PD=2.52U
M$1742 \$3143 \$3144 \$420 VDD pfet_03v3 L=0.28U W=0.36U AS=0.1584P AD=0.1152P
+ PS=1.6U PD=1U
M$1743 \$421 \$3145 \$3143 VDD pfet_03v3 L=0.28U W=0.36U AS=0.1152P AD=0.1584P
+ PS=1U PD=1.6U
M$1744 VDD RA6 \$3145 VDD pfet_03v3 L=0.28U W=0.72U AS=0.3708P AD=0.3168P
+ PS=2.47U PD=2.32U
M$1745 \$3147 \$3065 \$3146 VDD pfet_03v3 L=0.28U W=0.36U AS=0.2097P AD=0.1278P
+ PS=1.38U PD=1.07U
M$1746 \$3258 \$3148 \$3147 VDD pfet_03v3 L=0.28U W=0.36U AS=0.1278P AD=0.0567P
+ PS=1.07U PD=0.675U
M$1747 VDD \$3064 \$3258 VDD pfet_03v3 L=0.28U W=0.36U AS=0.0567P AD=0.1584P
+ PS=0.675U PD=1.6U
M$1748 \$3146 \$83 VDD VDD pfet_03v3 L=0.28U W=0.72U AS=0.3168P AD=0.2097P
+ PS=2.32U PD=1.38U
M$1749 VDD \$3147 \$3148 VDD pfet_03v3 L=0.28U W=0.36U AS=0.1584P AD=0.1764P
+ PS=1.6U PD=1.26U
M$1750 \$3149 \$3147 VDD VDD pfet_03v3 L=0.28U W=0.72U AS=0.1764P AD=0.36P
+ PS=1.26U PD=2.44U
M$1751 \$3150 RB6 VDD VDD pfet_03v3 L=0.28U W=0.72U AS=0.3312P AD=0.3888P
+ PS=2.36U PD=2.52U
M$1752 \$3149 \$3150 \$425 VDD pfet_03v3 L=0.28U W=0.36U AS=0.1584P AD=0.1152P
+ PS=1.6U PD=1U
M$1753 \$426 \$3151 \$3149 VDD pfet_03v3 L=0.28U W=0.36U AS=0.1152P AD=0.1584P
+ PS=1U PD=1.6U
M$1754 VDD RA6 \$3151 VDD pfet_03v3 L=0.28U W=0.72U AS=0.3708P AD=0.3168P
+ PS=2.47U PD=2.32U
M$1755 \$3153 \$3065 \$3152 VDD pfet_03v3 L=0.28U W=0.36U AS=0.2097P AD=0.1278P
+ PS=1.38U PD=1.07U
M$1756 \$3225 \$3154 \$3153 VDD pfet_03v3 L=0.28U W=0.36U AS=0.1278P AD=0.0567P
+ PS=1.07U PD=0.675U
M$1757 VDD \$3064 \$3225 VDD pfet_03v3 L=0.28U W=0.36U AS=0.0567P AD=0.1584P
+ PS=0.675U PD=1.6U
M$1758 \$3152 \$86 VDD VDD pfet_03v3 L=0.28U W=0.72U AS=0.3168P AD=0.2097P
+ PS=2.32U PD=1.38U
M$1759 VDD \$3153 \$3154 VDD pfet_03v3 L=0.28U W=0.36U AS=0.1584P AD=0.1764P
+ PS=1.6U PD=1.26U
M$1760 \$3155 \$3153 VDD VDD pfet_03v3 L=0.28U W=0.72U AS=0.1764P AD=0.36P
+ PS=1.26U PD=2.44U
M$1761 \$3156 RB6 VDD VDD pfet_03v3 L=0.28U W=0.72U AS=0.3312P AD=0.3888P
+ PS=2.36U PD=2.52U
M$1762 \$3155 \$3156 \$430 VDD pfet_03v3 L=0.28U W=0.36U AS=0.1584P AD=0.1152P
+ PS=1.6U PD=1U
M$1763 \$431 \$3157 \$3155 VDD pfet_03v3 L=0.28U W=0.36U AS=0.1152P AD=0.1584P
+ PS=1U PD=1.6U
M$1764 VDD RA6 \$3157 VDD pfet_03v3 L=0.28U W=0.72U AS=0.3708P AD=0.3168P
+ PS=2.47U PD=2.32U
M$1765 \$3159 \$3065 \$3158 VDD pfet_03v3 L=0.28U W=0.36U AS=0.2097P AD=0.1278P
+ PS=1.38U PD=1.07U
M$1766 \$3193 \$3160 \$3159 VDD pfet_03v3 L=0.28U W=0.36U AS=0.1278P AD=0.0567P
+ PS=1.07U PD=0.675U
M$1767 VDD \$3064 \$3193 VDD pfet_03v3 L=0.28U W=0.36U AS=0.0567P AD=0.1584P
+ PS=0.675U PD=1.6U
M$1768 \$3158 \$89 VDD VDD pfet_03v3 L=0.28U W=0.72U AS=0.3168P AD=0.2097P
+ PS=2.32U PD=1.38U
M$1769 VDD \$3159 \$3160 VDD pfet_03v3 L=0.28U W=0.36U AS=0.1584P AD=0.1764P
+ PS=1.6U PD=1.26U
M$1770 \$3161 \$3159 VDD VDD pfet_03v3 L=0.28U W=0.72U AS=0.1764P AD=0.36P
+ PS=1.26U PD=2.44U
M$1771 \$3162 RB6 VDD VDD pfet_03v3 L=0.28U W=0.72U AS=0.3312P AD=0.3888P
+ PS=2.36U PD=2.52U
M$1772 \$3161 \$3162 \$435 VDD pfet_03v3 L=0.28U W=0.36U AS=0.1584P AD=0.1152P
+ PS=1.6U PD=1U
M$1773 \$436 \$3163 \$3161 VDD pfet_03v3 L=0.28U W=0.36U AS=0.1152P AD=0.1584P
+ PS=1U PD=1.6U
M$1774 VDD RA6 \$3163 VDD pfet_03v3 L=0.28U W=0.72U AS=0.3708P AD=0.3168P
+ PS=2.47U PD=2.32U
M$1775 \$3365 WE5 VDD VDD pfet_03v3 L=0.28U W=0.72U AS=0.3168P AD=0.1872P
+ PS=2.32U PD=1.24U
M$1776 VDD CLK \$3365 VDD pfet_03v3 L=0.28U W=0.72U AS=0.1872P AD=0.3168P
+ PS=1.24U PD=2.32U
M$1777 \$3366 \$3365 VDD VDD pfet_03v3 L=0.28U W=2.54U AS=0.8974P AD=0.6604P
+ PS=5.28U PD=3.58U
M$1779 \$3367 \$3366 VDD VDD pfet_03v3 L=0.28U W=2.68U AS=0.7272P AD=0.9782P
+ PS=3.78U PD=5.48U
M$1781 \$3368 \$44 VDD VDD pfet_03v3 L=0.28U W=0.72U AS=0.3168P AD=0.2097P
+ PS=2.32U PD=1.38U
M$1782 \$3369 \$3367 \$3368 VDD pfet_03v3 L=0.28U W=0.36U AS=0.2097P AD=0.1278P
+ PS=1.38U PD=1.07U
M$1783 \$3575 \$3370 \$3369 VDD pfet_03v3 L=0.28U W=0.36U AS=0.1278P AD=0.0567P
+ PS=1.07U PD=0.675U
M$1784 VDD \$3366 \$3575 VDD pfet_03v3 L=0.28U W=0.36U AS=0.0567P AD=0.1584P
+ PS=0.675U PD=1.6U
M$1785 \$3370 \$3369 VDD VDD pfet_03v3 L=0.28U W=0.36U AS=0.1764P AD=0.1584P
+ PS=1.26U PD=1.6U
M$1786 \$3371 \$3369 VDD VDD pfet_03v3 L=0.28U W=0.72U AS=0.1764P AD=0.36P
+ PS=1.26U PD=2.44U
M$1787 \$3482 RA5 VDD VDD pfet_03v3 L=0.28U W=0.72U AS=0.3312P AD=0.3888P
+ PS=2.36U PD=2.52U
M$1788 \$3371 \$3482 \$360 VDD pfet_03v3 L=0.28U W=0.36U AS=0.1584P AD=0.1152P
+ PS=1.6U PD=1U
M$1789 \$361 \$3483 \$3371 VDD pfet_03v3 L=0.28U W=0.36U AS=0.1152P AD=0.1584P
+ PS=1U PD=1.6U
M$1790 VDD RB5 \$3483 VDD pfet_03v3 L=0.28U W=0.72U AS=0.3708P AD=0.3168P
+ PS=2.47U PD=2.32U
M$1791 \$3372 \$47 VDD VDD pfet_03v3 L=0.28U W=0.72U AS=0.3168P AD=0.2097P
+ PS=2.32U PD=1.38U
M$1792 \$3373 \$3367 \$3372 VDD pfet_03v3 L=0.28U W=0.36U AS=0.2097P AD=0.1278P
+ PS=1.38U PD=1.07U
M$1793 \$3585 \$3374 \$3373 VDD pfet_03v3 L=0.28U W=0.36U AS=0.1278P AD=0.0567P
+ PS=1.07U PD=0.675U
M$1794 VDD \$3366 \$3585 VDD pfet_03v3 L=0.28U W=0.36U AS=0.0567P AD=0.1584P
+ PS=0.675U PD=1.6U
M$1795 \$3374 \$3373 VDD VDD pfet_03v3 L=0.28U W=0.36U AS=0.1764P AD=0.1584P
+ PS=1.26U PD=1.6U
M$1796 \$3375 \$3373 VDD VDD pfet_03v3 L=0.28U W=0.72U AS=0.1764P AD=0.36P
+ PS=1.26U PD=2.44U
M$1797 \$3484 RA5 VDD VDD pfet_03v3 L=0.28U W=0.72U AS=0.3312P AD=0.3888P
+ PS=2.36U PD=2.52U
M$1798 \$3375 \$3484 \$365 VDD pfet_03v3 L=0.28U W=0.36U AS=0.1584P AD=0.1152P
+ PS=1.6U PD=1U
M$1799 \$366 \$3485 \$3375 VDD pfet_03v3 L=0.28U W=0.36U AS=0.1152P AD=0.1584P
+ PS=1U PD=1.6U
M$1800 VDD RB5 \$3485 VDD pfet_03v3 L=0.28U W=0.72U AS=0.3708P AD=0.3168P
+ PS=2.47U PD=2.32U
M$1801 \$3376 \$50 VDD VDD pfet_03v3 L=0.28U W=0.72U AS=0.3168P AD=0.2097P
+ PS=2.32U PD=1.38U
M$1802 \$3377 \$3367 \$3376 VDD pfet_03v3 L=0.28U W=0.36U AS=0.2097P AD=0.1278P
+ PS=1.38U PD=1.07U
M$1803 \$3591 \$3378 \$3377 VDD pfet_03v3 L=0.28U W=0.36U AS=0.1278P AD=0.0567P
+ PS=1.07U PD=0.675U
M$1804 VDD \$3366 \$3591 VDD pfet_03v3 L=0.28U W=0.36U AS=0.0567P AD=0.1584P
+ PS=0.675U PD=1.6U
M$1805 \$3378 \$3377 VDD VDD pfet_03v3 L=0.28U W=0.36U AS=0.1764P AD=0.1584P
+ PS=1.26U PD=1.6U
M$1806 \$3379 \$3377 VDD VDD pfet_03v3 L=0.28U W=0.72U AS=0.1764P AD=0.36P
+ PS=1.26U PD=2.44U
M$1807 \$3486 RA5 VDD VDD pfet_03v3 L=0.28U W=0.72U AS=0.3312P AD=0.3888P
+ PS=2.36U PD=2.52U
M$1808 \$3379 \$3486 \$370 VDD pfet_03v3 L=0.28U W=0.36U AS=0.1584P AD=0.1152P
+ PS=1.6U PD=1U
M$1809 \$371 \$3487 \$3379 VDD pfet_03v3 L=0.28U W=0.36U AS=0.1152P AD=0.1584P
+ PS=1U PD=1.6U
M$1810 VDD RB5 \$3487 VDD pfet_03v3 L=0.28U W=0.72U AS=0.3708P AD=0.3168P
+ PS=2.47U PD=2.32U
M$1811 \$3380 \$53 VDD VDD pfet_03v3 L=0.28U W=0.72U AS=0.3168P AD=0.2097P
+ PS=2.32U PD=1.38U
M$1812 \$3381 \$3367 \$3380 VDD pfet_03v3 L=0.28U W=0.36U AS=0.2097P AD=0.1278P
+ PS=1.38U PD=1.07U
M$1813 \$3600 \$3382 \$3381 VDD pfet_03v3 L=0.28U W=0.36U AS=0.1278P AD=0.0567P
+ PS=1.07U PD=0.675U
M$1814 VDD \$3366 \$3600 VDD pfet_03v3 L=0.28U W=0.36U AS=0.0567P AD=0.1584P
+ PS=0.675U PD=1.6U
M$1815 \$3382 \$3381 VDD VDD pfet_03v3 L=0.28U W=0.36U AS=0.1764P AD=0.1584P
+ PS=1.26U PD=1.6U
M$1816 \$3383 \$3381 VDD VDD pfet_03v3 L=0.28U W=0.72U AS=0.1764P AD=0.36P
+ PS=1.26U PD=2.44U
M$1817 \$3488 RA5 VDD VDD pfet_03v3 L=0.28U W=0.72U AS=0.3312P AD=0.3888P
+ PS=2.36U PD=2.52U
M$1818 \$3383 \$3488 \$375 VDD pfet_03v3 L=0.28U W=0.36U AS=0.1584P AD=0.1152P
+ PS=1.6U PD=1U
M$1819 \$376 \$3489 \$3383 VDD pfet_03v3 L=0.28U W=0.36U AS=0.1152P AD=0.1584P
+ PS=1U PD=1.6U
M$1820 VDD RB5 \$3489 VDD pfet_03v3 L=0.28U W=0.72U AS=0.3708P AD=0.3168P
+ PS=2.47U PD=2.32U
M$1821 \$3384 \$56 VDD VDD pfet_03v3 L=0.28U W=0.72U AS=0.3168P AD=0.2097P
+ PS=2.32U PD=1.38U
M$1822 \$3385 \$3367 \$3384 VDD pfet_03v3 L=0.28U W=0.36U AS=0.2097P AD=0.1278P
+ PS=1.38U PD=1.07U
M$1823 \$3610 \$3386 \$3385 VDD pfet_03v3 L=0.28U W=0.36U AS=0.1278P AD=0.0567P
+ PS=1.07U PD=0.675U
M$1824 VDD \$3366 \$3610 VDD pfet_03v3 L=0.28U W=0.36U AS=0.0567P AD=0.1584P
+ PS=0.675U PD=1.6U
M$1825 \$3386 \$3385 VDD VDD pfet_03v3 L=0.28U W=0.36U AS=0.1764P AD=0.1584P
+ PS=1.26U PD=1.6U
M$1826 \$3387 \$3385 VDD VDD pfet_03v3 L=0.28U W=0.72U AS=0.1764P AD=0.36P
+ PS=1.26U PD=2.44U
M$1827 \$3490 RA5 VDD VDD pfet_03v3 L=0.28U W=0.72U AS=0.3312P AD=0.3888P
+ PS=2.36U PD=2.52U
M$1828 \$3387 \$3490 \$380 VDD pfet_03v3 L=0.28U W=0.36U AS=0.1584P AD=0.1152P
+ PS=1.6U PD=1U
M$1829 \$381 \$3491 \$3387 VDD pfet_03v3 L=0.28U W=0.36U AS=0.1152P AD=0.1584P
+ PS=1U PD=1.6U
M$1830 VDD RB5 \$3491 VDD pfet_03v3 L=0.28U W=0.72U AS=0.3708P AD=0.3168P
+ PS=2.47U PD=2.32U
M$1831 \$3388 \$59 VDD VDD pfet_03v3 L=0.28U W=0.72U AS=0.3168P AD=0.2097P
+ PS=2.32U PD=1.38U
M$1832 \$3389 \$3367 \$3388 VDD pfet_03v3 L=0.28U W=0.36U AS=0.2097P AD=0.1278P
+ PS=1.38U PD=1.07U
M$1833 \$3619 \$3390 \$3389 VDD pfet_03v3 L=0.28U W=0.36U AS=0.1278P AD=0.0567P
+ PS=1.07U PD=0.675U
M$1834 VDD \$3366 \$3619 VDD pfet_03v3 L=0.28U W=0.36U AS=0.0567P AD=0.1584P
+ PS=0.675U PD=1.6U
M$1835 \$3390 \$3389 VDD VDD pfet_03v3 L=0.28U W=0.36U AS=0.1764P AD=0.1584P
+ PS=1.26U PD=1.6U
M$1836 \$3391 \$3389 VDD VDD pfet_03v3 L=0.28U W=0.72U AS=0.1764P AD=0.36P
+ PS=1.26U PD=2.44U
M$1837 \$3492 RA5 VDD VDD pfet_03v3 L=0.28U W=0.72U AS=0.3312P AD=0.3888P
+ PS=2.36U PD=2.52U
M$1838 \$3391 \$3492 \$385 VDD pfet_03v3 L=0.28U W=0.36U AS=0.1584P AD=0.1152P
+ PS=1.6U PD=1U
M$1839 \$386 \$3493 \$3391 VDD pfet_03v3 L=0.28U W=0.36U AS=0.1152P AD=0.1584P
+ PS=1U PD=1.6U
M$1840 VDD RB5 \$3493 VDD pfet_03v3 L=0.28U W=0.72U AS=0.3708P AD=0.3168P
+ PS=2.47U PD=2.32U
M$1841 \$3392 \$62 VDD VDD pfet_03v3 L=0.28U W=0.72U AS=0.3168P AD=0.2097P
+ PS=2.32U PD=1.38U
M$1842 \$3393 \$3367 \$3392 VDD pfet_03v3 L=0.28U W=0.36U AS=0.2097P AD=0.1278P
+ PS=1.38U PD=1.07U
M$1843 \$3627 \$3394 \$3393 VDD pfet_03v3 L=0.28U W=0.36U AS=0.1278P AD=0.0567P
+ PS=1.07U PD=0.675U
M$1844 VDD \$3366 \$3627 VDD pfet_03v3 L=0.28U W=0.36U AS=0.0567P AD=0.1584P
+ PS=0.675U PD=1.6U
M$1845 \$3394 \$3393 VDD VDD pfet_03v3 L=0.28U W=0.36U AS=0.1764P AD=0.1584P
+ PS=1.26U PD=1.6U
M$1846 \$3395 \$3393 VDD VDD pfet_03v3 L=0.28U W=0.72U AS=0.1764P AD=0.36P
+ PS=1.26U PD=2.44U
M$1847 \$3494 RA5 VDD VDD pfet_03v3 L=0.28U W=0.72U AS=0.3312P AD=0.3888P
+ PS=2.36U PD=2.52U
M$1848 \$3395 \$3494 \$390 VDD pfet_03v3 L=0.28U W=0.36U AS=0.1584P AD=0.1152P
+ PS=1.6U PD=1U
M$1849 \$391 \$3495 \$3395 VDD pfet_03v3 L=0.28U W=0.36U AS=0.1152P AD=0.1584P
+ PS=1U PD=1.6U
M$1850 VDD RB5 \$3495 VDD pfet_03v3 L=0.28U W=0.72U AS=0.3708P AD=0.3168P
+ PS=2.47U PD=2.32U
M$1851 \$3396 \$65 VDD VDD pfet_03v3 L=0.28U W=0.72U AS=0.3168P AD=0.2097P
+ PS=2.32U PD=1.38U
M$1852 \$3397 \$3367 \$3396 VDD pfet_03v3 L=0.28U W=0.36U AS=0.2097P AD=0.1278P
+ PS=1.38U PD=1.07U
M$1853 \$3636 \$3398 \$3397 VDD pfet_03v3 L=0.28U W=0.36U AS=0.1278P AD=0.0567P
+ PS=1.07U PD=0.675U
M$1854 VDD \$3366 \$3636 VDD pfet_03v3 L=0.28U W=0.36U AS=0.0567P AD=0.1584P
+ PS=0.675U PD=1.6U
M$1855 \$3398 \$3397 VDD VDD pfet_03v3 L=0.28U W=0.36U AS=0.1764P AD=0.1584P
+ PS=1.26U PD=1.6U
M$1856 \$3399 \$3397 VDD VDD pfet_03v3 L=0.28U W=0.72U AS=0.1764P AD=0.36P
+ PS=1.26U PD=2.44U
M$1857 \$3496 RA5 VDD VDD pfet_03v3 L=0.28U W=0.72U AS=0.3312P AD=0.3888P
+ PS=2.36U PD=2.52U
M$1858 \$3399 \$3496 \$395 VDD pfet_03v3 L=0.28U W=0.36U AS=0.1584P AD=0.1152P
+ PS=1.6U PD=1U
M$1859 \$396 \$3497 \$3399 VDD pfet_03v3 L=0.28U W=0.36U AS=0.1152P AD=0.1584P
+ PS=1U PD=1.6U
M$1860 VDD RB5 \$3497 VDD pfet_03v3 L=0.28U W=0.72U AS=0.3708P AD=0.3168P
+ PS=2.47U PD=2.32U
M$1861 \$3400 \$68 VDD VDD pfet_03v3 L=0.28U W=0.72U AS=0.3168P AD=0.2097P
+ PS=2.32U PD=1.38U
M$1862 \$3401 \$3367 \$3400 VDD pfet_03v3 L=0.28U W=0.36U AS=0.2097P AD=0.1278P
+ PS=1.38U PD=1.07U
M$1863 \$3645 \$3402 \$3401 VDD pfet_03v3 L=0.28U W=0.36U AS=0.1278P AD=0.0567P
+ PS=1.07U PD=0.675U
M$1864 VDD \$3366 \$3645 VDD pfet_03v3 L=0.28U W=0.36U AS=0.0567P AD=0.1584P
+ PS=0.675U PD=1.6U
M$1865 \$3402 \$3401 VDD VDD pfet_03v3 L=0.28U W=0.36U AS=0.1764P AD=0.1584P
+ PS=1.26U PD=1.6U
M$1866 \$3403 \$3401 VDD VDD pfet_03v3 L=0.28U W=0.72U AS=0.1764P AD=0.36P
+ PS=1.26U PD=2.44U
M$1867 \$3498 RA5 VDD VDD pfet_03v3 L=0.28U W=0.72U AS=0.3312P AD=0.3888P
+ PS=2.36U PD=2.52U
M$1868 \$3403 \$3498 \$400 VDD pfet_03v3 L=0.28U W=0.36U AS=0.1584P AD=0.1152P
+ PS=1.6U PD=1U
M$1869 \$401 \$3499 \$3403 VDD pfet_03v3 L=0.28U W=0.36U AS=0.1152P AD=0.1584P
+ PS=1U PD=1.6U
M$1870 VDD RB5 \$3499 VDD pfet_03v3 L=0.28U W=0.72U AS=0.3708P AD=0.3168P
+ PS=2.47U PD=2.32U
M$1871 \$3404 \$71 VDD VDD pfet_03v3 L=0.28U W=0.72U AS=0.3168P AD=0.2097P
+ PS=2.32U PD=1.38U
M$1872 \$3405 \$3367 \$3404 VDD pfet_03v3 L=0.28U W=0.36U AS=0.2097P AD=0.1278P
+ PS=1.38U PD=1.07U
M$1873 \$3654 \$3406 \$3405 VDD pfet_03v3 L=0.28U W=0.36U AS=0.1278P AD=0.0567P
+ PS=1.07U PD=0.675U
M$1874 VDD \$3366 \$3654 VDD pfet_03v3 L=0.28U W=0.36U AS=0.0567P AD=0.1584P
+ PS=0.675U PD=1.6U
M$1875 \$3406 \$3405 VDD VDD pfet_03v3 L=0.28U W=0.36U AS=0.1764P AD=0.1584P
+ PS=1.26U PD=1.6U
M$1876 \$3407 \$3405 VDD VDD pfet_03v3 L=0.28U W=0.72U AS=0.1764P AD=0.36P
+ PS=1.26U PD=2.44U
M$1877 \$3500 RA5 VDD VDD pfet_03v3 L=0.28U W=0.72U AS=0.3312P AD=0.3888P
+ PS=2.36U PD=2.52U
M$1878 \$3407 \$3500 \$405 VDD pfet_03v3 L=0.28U W=0.36U AS=0.1584P AD=0.1152P
+ PS=1.6U PD=1U
M$1879 \$406 \$3501 \$3407 VDD pfet_03v3 L=0.28U W=0.36U AS=0.1152P AD=0.1584P
+ PS=1U PD=1.6U
M$1880 VDD RB5 \$3501 VDD pfet_03v3 L=0.28U W=0.72U AS=0.3708P AD=0.3168P
+ PS=2.47U PD=2.32U
M$1881 \$3408 \$74 VDD VDD pfet_03v3 L=0.28U W=0.72U AS=0.3168P AD=0.2097P
+ PS=2.32U PD=1.38U
M$1882 \$3409 \$3367 \$3408 VDD pfet_03v3 L=0.28U W=0.36U AS=0.2097P AD=0.1278P
+ PS=1.38U PD=1.07U
M$1883 \$3663 \$3410 \$3409 VDD pfet_03v3 L=0.28U W=0.36U AS=0.1278P AD=0.0567P
+ PS=1.07U PD=0.675U
M$1884 VDD \$3366 \$3663 VDD pfet_03v3 L=0.28U W=0.36U AS=0.0567P AD=0.1584P
+ PS=0.675U PD=1.6U
M$1885 \$3410 \$3409 VDD VDD pfet_03v3 L=0.28U W=0.36U AS=0.1764P AD=0.1584P
+ PS=1.26U PD=1.6U
M$1886 \$3411 \$3409 VDD VDD pfet_03v3 L=0.28U W=0.72U AS=0.1764P AD=0.36P
+ PS=1.26U PD=2.44U
M$1887 \$3502 RA5 VDD VDD pfet_03v3 L=0.28U W=0.72U AS=0.3312P AD=0.3888P
+ PS=2.36U PD=2.52U
M$1888 \$3411 \$3502 \$410 VDD pfet_03v3 L=0.28U W=0.36U AS=0.1584P AD=0.1152P
+ PS=1.6U PD=1U
M$1889 \$411 \$3503 \$3411 VDD pfet_03v3 L=0.28U W=0.36U AS=0.1152P AD=0.1584P
+ PS=1U PD=1.6U
M$1890 VDD RB5 \$3503 VDD pfet_03v3 L=0.28U W=0.72U AS=0.3708P AD=0.3168P
+ PS=2.47U PD=2.32U
M$1891 \$3412 \$77 VDD VDD pfet_03v3 L=0.28U W=0.72U AS=0.3168P AD=0.2097P
+ PS=2.32U PD=1.38U
M$1892 \$3413 \$3367 \$3412 VDD pfet_03v3 L=0.28U W=0.36U AS=0.2097P AD=0.1278P
+ PS=1.38U PD=1.07U
M$1893 \$3671 \$3414 \$3413 VDD pfet_03v3 L=0.28U W=0.36U AS=0.1278P AD=0.0567P
+ PS=1.07U PD=0.675U
M$1894 VDD \$3366 \$3671 VDD pfet_03v3 L=0.28U W=0.36U AS=0.0567P AD=0.1584P
+ PS=0.675U PD=1.6U
M$1895 \$3414 \$3413 VDD VDD pfet_03v3 L=0.28U W=0.36U AS=0.1764P AD=0.1584P
+ PS=1.26U PD=1.6U
M$1896 \$3415 \$3413 VDD VDD pfet_03v3 L=0.28U W=0.72U AS=0.1764P AD=0.36P
+ PS=1.26U PD=2.44U
M$1897 \$3504 RA5 VDD VDD pfet_03v3 L=0.28U W=0.72U AS=0.3312P AD=0.3888P
+ PS=2.36U PD=2.52U
M$1898 \$3415 \$3504 \$415 VDD pfet_03v3 L=0.28U W=0.36U AS=0.1584P AD=0.1152P
+ PS=1.6U PD=1U
M$1899 \$416 \$3505 \$3415 VDD pfet_03v3 L=0.28U W=0.36U AS=0.1152P AD=0.1584P
+ PS=1U PD=1.6U
M$1900 VDD RB5 \$3505 VDD pfet_03v3 L=0.28U W=0.72U AS=0.3708P AD=0.3168P
+ PS=2.47U PD=2.32U
M$1901 \$3416 \$80 VDD VDD pfet_03v3 L=0.28U W=0.72U AS=0.3168P AD=0.2097P
+ PS=2.32U PD=1.38U
M$1902 \$3417 \$3367 \$3416 VDD pfet_03v3 L=0.28U W=0.36U AS=0.2097P AD=0.1278P
+ PS=1.38U PD=1.07U
M$1903 \$3657 \$3418 \$3417 VDD pfet_03v3 L=0.28U W=0.36U AS=0.1278P AD=0.0567P
+ PS=1.07U PD=0.675U
M$1904 VDD \$3366 \$3657 VDD pfet_03v3 L=0.28U W=0.36U AS=0.0567P AD=0.1584P
+ PS=0.675U PD=1.6U
M$1905 \$3418 \$3417 VDD VDD pfet_03v3 L=0.28U W=0.36U AS=0.1764P AD=0.1584P
+ PS=1.26U PD=1.6U
M$1906 \$3419 \$3417 VDD VDD pfet_03v3 L=0.28U W=0.72U AS=0.1764P AD=0.36P
+ PS=1.26U PD=2.44U
M$1907 \$3506 RA5 VDD VDD pfet_03v3 L=0.28U W=0.72U AS=0.3312P AD=0.3888P
+ PS=2.36U PD=2.52U
M$1908 \$3419 \$3506 \$420 VDD pfet_03v3 L=0.28U W=0.36U AS=0.1584P AD=0.1152P
+ PS=1.6U PD=1U
M$1909 \$421 \$3507 \$3419 VDD pfet_03v3 L=0.28U W=0.36U AS=0.1152P AD=0.1584P
+ PS=1U PD=1.6U
M$1910 VDD RB5 \$3507 VDD pfet_03v3 L=0.28U W=0.72U AS=0.3708P AD=0.3168P
+ PS=2.47U PD=2.32U
M$1911 \$3420 \$83 VDD VDD pfet_03v3 L=0.28U W=0.72U AS=0.3168P AD=0.2097P
+ PS=2.32U PD=1.38U
M$1912 \$3421 \$3367 \$3420 VDD pfet_03v3 L=0.28U W=0.36U AS=0.2097P AD=0.1278P
+ PS=1.38U PD=1.07U
M$1913 \$3629 \$3422 \$3421 VDD pfet_03v3 L=0.28U W=0.36U AS=0.1278P AD=0.0567P
+ PS=1.07U PD=0.675U
M$1914 VDD \$3366 \$3629 VDD pfet_03v3 L=0.28U W=0.36U AS=0.0567P AD=0.1584P
+ PS=0.675U PD=1.6U
M$1915 \$3422 \$3421 VDD VDD pfet_03v3 L=0.28U W=0.36U AS=0.1764P AD=0.1584P
+ PS=1.26U PD=1.6U
M$1916 \$3423 \$3421 VDD VDD pfet_03v3 L=0.28U W=0.72U AS=0.1764P AD=0.36P
+ PS=1.26U PD=2.44U
M$1917 \$3508 RA5 VDD VDD pfet_03v3 L=0.28U W=0.72U AS=0.3312P AD=0.3888P
+ PS=2.36U PD=2.52U
M$1918 \$3423 \$3508 \$425 VDD pfet_03v3 L=0.28U W=0.36U AS=0.1584P AD=0.1152P
+ PS=1.6U PD=1U
M$1919 \$426 \$3509 \$3423 VDD pfet_03v3 L=0.28U W=0.36U AS=0.1152P AD=0.1584P
+ PS=1U PD=1.6U
M$1920 VDD RB5 \$3509 VDD pfet_03v3 L=0.28U W=0.72U AS=0.3708P AD=0.3168P
+ PS=2.47U PD=2.32U
M$1921 \$3424 \$86 VDD VDD pfet_03v3 L=0.28U W=0.72U AS=0.3168P AD=0.2097P
+ PS=2.32U PD=1.38U
M$1922 \$3425 \$3367 \$3424 VDD pfet_03v3 L=0.28U W=0.36U AS=0.2097P AD=0.1278P
+ PS=1.38U PD=1.07U
M$1923 \$3611 \$3426 \$3425 VDD pfet_03v3 L=0.28U W=0.36U AS=0.1278P AD=0.0567P
+ PS=1.07U PD=0.675U
M$1924 VDD \$3366 \$3611 VDD pfet_03v3 L=0.28U W=0.36U AS=0.0567P AD=0.1584P
+ PS=0.675U PD=1.6U
M$1925 \$3426 \$3425 VDD VDD pfet_03v3 L=0.28U W=0.36U AS=0.1764P AD=0.1584P
+ PS=1.26U PD=1.6U
M$1926 \$3427 \$3425 VDD VDD pfet_03v3 L=0.28U W=0.72U AS=0.1764P AD=0.36P
+ PS=1.26U PD=2.44U
M$1927 \$3510 RA5 VDD VDD pfet_03v3 L=0.28U W=0.72U AS=0.3312P AD=0.3888P
+ PS=2.36U PD=2.52U
M$1928 \$3427 \$3510 \$430 VDD pfet_03v3 L=0.28U W=0.36U AS=0.1584P AD=0.1152P
+ PS=1.6U PD=1U
M$1929 \$431 \$3511 \$3427 VDD pfet_03v3 L=0.28U W=0.36U AS=0.1152P AD=0.1584P
+ PS=1U PD=1.6U
M$1930 VDD RB5 \$3511 VDD pfet_03v3 L=0.28U W=0.72U AS=0.3708P AD=0.3168P
+ PS=2.47U PD=2.32U
M$1931 \$3428 \$89 VDD VDD pfet_03v3 L=0.28U W=0.72U AS=0.3168P AD=0.2097P
+ PS=2.32U PD=1.38U
M$1932 \$3429 \$3367 \$3428 VDD pfet_03v3 L=0.28U W=0.36U AS=0.2097P AD=0.1278P
+ PS=1.38U PD=1.07U
M$1933 \$3583 \$3430 \$3429 VDD pfet_03v3 L=0.28U W=0.36U AS=0.1278P AD=0.0567P
+ PS=1.07U PD=0.675U
M$1934 VDD \$3366 \$3583 VDD pfet_03v3 L=0.28U W=0.36U AS=0.0567P AD=0.1584P
+ PS=0.675U PD=1.6U
M$1935 \$3430 \$3429 VDD VDD pfet_03v3 L=0.28U W=0.36U AS=0.1764P AD=0.1584P
+ PS=1.26U PD=1.6U
M$1936 \$3431 \$3429 VDD VDD pfet_03v3 L=0.28U W=0.72U AS=0.1764P AD=0.36P
+ PS=1.26U PD=2.44U
M$1937 \$3512 RA5 VDD VDD pfet_03v3 L=0.28U W=0.72U AS=0.3312P AD=0.3888P
+ PS=2.36U PD=2.52U
M$1938 \$3431 \$3512 \$435 VDD pfet_03v3 L=0.28U W=0.36U AS=0.1584P AD=0.1152P
+ PS=1.6U PD=1U
M$1939 \$436 \$3513 \$3431 VDD pfet_03v3 L=0.28U W=0.36U AS=0.1152P AD=0.1584P
+ PS=1U PD=1.6U
M$1940 VDD RB5 \$3513 VDD pfet_03v3 L=0.28U W=0.72U AS=0.3708P AD=0.3168P
+ PS=2.47U PD=2.32U
M$1941 \$3675 WE4 VDD VDD pfet_03v3 L=0.28U W=0.72U AS=0.3168P AD=0.1872P
+ PS=2.32U PD=1.24U
M$1942 VDD CLK \$3675 VDD pfet_03v3 L=0.28U W=0.72U AS=0.1872P AD=0.3168P
+ PS=1.24U PD=2.32U
M$1943 \$3677 \$3675 VDD VDD pfet_03v3 L=0.28U W=2.54U AS=0.889P AD=0.6688P
+ PS=5.21U PD=3.65U
M$1945 \$3678 \$3677 VDD VDD pfet_03v3 L=0.28U W=2.68U AS=0.7272P AD=0.9782P
+ PS=3.78U PD=5.48U
M$1947 \$3682 \$3678 \$3681 VDD pfet_03v3 L=0.28U W=0.36U AS=0.2097P AD=0.1278P
+ PS=1.38U PD=1.07U
M$1948 \$3782 \$3683 \$3682 VDD pfet_03v3 L=0.28U W=0.36U AS=0.1278P AD=0.0567P
+ PS=1.07U PD=0.675U
M$1949 VDD \$3677 \$3782 VDD pfet_03v3 L=0.28U W=0.36U AS=0.0567P AD=0.1584P
+ PS=0.675U PD=1.6U
M$1950 \$3681 \$44 VDD VDD pfet_03v3 L=0.28U W=0.72U AS=0.3168P AD=0.2097P
+ PS=2.32U PD=1.38U
M$1951 VDD \$3682 \$3683 VDD pfet_03v3 L=0.28U W=0.36U AS=0.1584P AD=0.1764P
+ PS=1.6U PD=1.26U
M$1952 \$3684 \$3682 VDD VDD pfet_03v3 L=0.28U W=0.72U AS=0.1764P AD=0.36P
+ PS=1.26U PD=2.44U
M$1953 \$3685 RB4 VDD VDD pfet_03v3 L=0.28U W=0.72U AS=0.3312P AD=0.3888P
+ PS=2.36U PD=2.52U
M$1954 \$3684 \$3685 \$360 VDD pfet_03v3 L=0.28U W=0.36U AS=0.1584P AD=0.1152P
+ PS=1.6U PD=1U
M$1955 \$361 \$3686 \$3684 VDD pfet_03v3 L=0.28U W=0.36U AS=0.1152P AD=0.1584P
+ PS=1U PD=1.6U
M$1956 VDD RA4 \$3686 VDD pfet_03v3 L=0.28U W=0.72U AS=0.3708P AD=0.3168P
+ PS=2.47U PD=2.32U
M$1957 \$3688 \$3678 \$3687 VDD pfet_03v3 L=0.28U W=0.36U AS=0.2097P AD=0.1278P
+ PS=1.38U PD=1.07U
M$1958 \$3790 \$3689 \$3688 VDD pfet_03v3 L=0.28U W=0.36U AS=0.1278P AD=0.0567P
+ PS=1.07U PD=0.675U
M$1959 VDD \$3677 \$3790 VDD pfet_03v3 L=0.28U W=0.36U AS=0.0567P AD=0.1584P
+ PS=0.675U PD=1.6U
M$1960 \$3687 \$47 VDD VDD pfet_03v3 L=0.28U W=0.72U AS=0.3168P AD=0.2097P
+ PS=2.32U PD=1.38U
M$1961 VDD \$3688 \$3689 VDD pfet_03v3 L=0.28U W=0.36U AS=0.1584P AD=0.1764P
+ PS=1.6U PD=1.26U
M$1962 \$3690 \$3688 VDD VDD pfet_03v3 L=0.28U W=0.72U AS=0.1764P AD=0.36P
+ PS=1.26U PD=2.44U
M$1963 \$3691 RB4 VDD VDD pfet_03v3 L=0.28U W=0.72U AS=0.3312P AD=0.3888P
+ PS=2.36U PD=2.52U
M$1964 \$3690 \$3691 \$365 VDD pfet_03v3 L=0.28U W=0.36U AS=0.1584P AD=0.1152P
+ PS=1.6U PD=1U
M$1965 \$366 \$3692 \$3690 VDD pfet_03v3 L=0.28U W=0.36U AS=0.1152P AD=0.1584P
+ PS=1U PD=1.6U
M$1966 VDD RA4 \$3692 VDD pfet_03v3 L=0.28U W=0.72U AS=0.3708P AD=0.3168P
+ PS=2.47U PD=2.32U
M$1967 \$3694 \$3678 \$3693 VDD pfet_03v3 L=0.28U W=0.36U AS=0.2097P AD=0.1278P
+ PS=1.38U PD=1.07U
M$1968 \$3797 \$3695 \$3694 VDD pfet_03v3 L=0.28U W=0.36U AS=0.1278P AD=0.0567P
+ PS=1.07U PD=0.675U
M$1969 VDD \$3677 \$3797 VDD pfet_03v3 L=0.28U W=0.36U AS=0.0567P AD=0.1584P
+ PS=0.675U PD=1.6U
M$1970 \$3693 \$50 VDD VDD pfet_03v3 L=0.28U W=0.72U AS=0.3168P AD=0.2097P
+ PS=2.32U PD=1.38U
M$1971 VDD \$3694 \$3695 VDD pfet_03v3 L=0.28U W=0.36U AS=0.1584P AD=0.1764P
+ PS=1.6U PD=1.26U
M$1972 \$3696 \$3694 VDD VDD pfet_03v3 L=0.28U W=0.72U AS=0.1764P AD=0.36P
+ PS=1.26U PD=2.44U
M$1973 \$3697 RB4 VDD VDD pfet_03v3 L=0.28U W=0.72U AS=0.3312P AD=0.3888P
+ PS=2.36U PD=2.52U
M$1974 \$3696 \$3697 \$370 VDD pfet_03v3 L=0.28U W=0.36U AS=0.1584P AD=0.1152P
+ PS=1.6U PD=1U
M$1975 \$371 \$3698 \$3696 VDD pfet_03v3 L=0.28U W=0.36U AS=0.1152P AD=0.1584P
+ PS=1U PD=1.6U
M$1976 VDD RA4 \$3698 VDD pfet_03v3 L=0.28U W=0.72U AS=0.3708P AD=0.3168P
+ PS=2.47U PD=2.32U
M$1977 \$3700 \$3678 \$3699 VDD pfet_03v3 L=0.28U W=0.36U AS=0.2097P AD=0.1278P
+ PS=1.38U PD=1.07U
M$1978 \$3805 \$3701 \$3700 VDD pfet_03v3 L=0.28U W=0.36U AS=0.1278P AD=0.0567P
+ PS=1.07U PD=0.675U
M$1979 VDD \$3677 \$3805 VDD pfet_03v3 L=0.28U W=0.36U AS=0.0567P AD=0.1584P
+ PS=0.675U PD=1.6U
M$1980 \$3699 \$53 VDD VDD pfet_03v3 L=0.28U W=0.72U AS=0.3168P AD=0.2097P
+ PS=2.32U PD=1.38U
M$1981 VDD \$3700 \$3701 VDD pfet_03v3 L=0.28U W=0.36U AS=0.1584P AD=0.1764P
+ PS=1.6U PD=1.26U
M$1982 \$3702 \$3700 VDD VDD pfet_03v3 L=0.28U W=0.72U AS=0.1764P AD=0.36P
+ PS=1.26U PD=2.44U
M$1983 \$3703 RB4 VDD VDD pfet_03v3 L=0.28U W=0.72U AS=0.3312P AD=0.3888P
+ PS=2.36U PD=2.52U
M$1984 \$3702 \$3703 \$375 VDD pfet_03v3 L=0.28U W=0.36U AS=0.1584P AD=0.1152P
+ PS=1.6U PD=1U
M$1985 \$376 \$3704 \$3702 VDD pfet_03v3 L=0.28U W=0.36U AS=0.1152P AD=0.1584P
+ PS=1U PD=1.6U
M$1986 VDD RA4 \$3704 VDD pfet_03v3 L=0.28U W=0.72U AS=0.3708P AD=0.3168P
+ PS=2.47U PD=2.32U
M$1987 \$3706 \$3678 \$3705 VDD pfet_03v3 L=0.28U W=0.36U AS=0.2097P AD=0.1278P
+ PS=1.38U PD=1.07U
M$1988 \$3814 \$3707 \$3706 VDD pfet_03v3 L=0.28U W=0.36U AS=0.1278P AD=0.0567P
+ PS=1.07U PD=0.675U
M$1989 VDD \$3677 \$3814 VDD pfet_03v3 L=0.28U W=0.36U AS=0.0567P AD=0.1584P
+ PS=0.675U PD=1.6U
M$1990 \$3705 \$56 VDD VDD pfet_03v3 L=0.28U W=0.72U AS=0.3168P AD=0.2097P
+ PS=2.32U PD=1.38U
M$1991 VDD \$3706 \$3707 VDD pfet_03v3 L=0.28U W=0.36U AS=0.1584P AD=0.1764P
+ PS=1.6U PD=1.26U
M$1992 \$3708 \$3706 VDD VDD pfet_03v3 L=0.28U W=0.72U AS=0.1764P AD=0.36P
+ PS=1.26U PD=2.44U
M$1993 \$3709 RB4 VDD VDD pfet_03v3 L=0.28U W=0.72U AS=0.3312P AD=0.3888P
+ PS=2.36U PD=2.52U
M$1994 \$3708 \$3709 \$380 VDD pfet_03v3 L=0.28U W=0.36U AS=0.1584P AD=0.1152P
+ PS=1.6U PD=1U
M$1995 \$381 \$3710 \$3708 VDD pfet_03v3 L=0.28U W=0.36U AS=0.1152P AD=0.1584P
+ PS=1U PD=1.6U
M$1996 VDD RA4 \$3710 VDD pfet_03v3 L=0.28U W=0.72U AS=0.3708P AD=0.3168P
+ PS=2.47U PD=2.32U
M$1997 \$3712 \$3678 \$3711 VDD pfet_03v3 L=0.28U W=0.36U AS=0.2097P AD=0.1278P
+ PS=1.38U PD=1.07U
M$1998 \$3820 \$3713 \$3712 VDD pfet_03v3 L=0.28U W=0.36U AS=0.1278P AD=0.0567P
+ PS=1.07U PD=0.675U
M$1999 VDD \$3677 \$3820 VDD pfet_03v3 L=0.28U W=0.36U AS=0.0567P AD=0.1584P
+ PS=0.675U PD=1.6U
M$2000 \$3711 \$59 VDD VDD pfet_03v3 L=0.28U W=0.72U AS=0.3168P AD=0.2097P
+ PS=2.32U PD=1.38U
M$2001 VDD \$3712 \$3713 VDD pfet_03v3 L=0.28U W=0.36U AS=0.1584P AD=0.1764P
+ PS=1.6U PD=1.26U
M$2002 \$3714 \$3712 VDD VDD pfet_03v3 L=0.28U W=0.72U AS=0.1764P AD=0.36P
+ PS=1.26U PD=2.44U
M$2003 \$3715 RB4 VDD VDD pfet_03v3 L=0.28U W=0.72U AS=0.3312P AD=0.3888P
+ PS=2.36U PD=2.52U
M$2004 \$3714 \$3715 \$385 VDD pfet_03v3 L=0.28U W=0.36U AS=0.1584P AD=0.1152P
+ PS=1.6U PD=1U
M$2005 \$386 \$3716 \$3714 VDD pfet_03v3 L=0.28U W=0.36U AS=0.1152P AD=0.1584P
+ PS=1U PD=1.6U
M$2006 VDD RA4 \$3716 VDD pfet_03v3 L=0.28U W=0.72U AS=0.3708P AD=0.3168P
+ PS=2.47U PD=2.32U
M$2007 \$3718 \$3678 \$3717 VDD pfet_03v3 L=0.28U W=0.36U AS=0.2097P AD=0.1278P
+ PS=1.38U PD=1.07U
M$2008 \$3827 \$3719 \$3718 VDD pfet_03v3 L=0.28U W=0.36U AS=0.1278P AD=0.0567P
+ PS=1.07U PD=0.675U
M$2009 VDD \$3677 \$3827 VDD pfet_03v3 L=0.28U W=0.36U AS=0.0567P AD=0.1584P
+ PS=0.675U PD=1.6U
M$2010 \$3717 \$62 VDD VDD pfet_03v3 L=0.28U W=0.72U AS=0.3168P AD=0.2097P
+ PS=2.32U PD=1.38U
M$2011 VDD \$3718 \$3719 VDD pfet_03v3 L=0.28U W=0.36U AS=0.1584P AD=0.1764P
+ PS=1.6U PD=1.26U
M$2012 \$3720 \$3718 VDD VDD pfet_03v3 L=0.28U W=0.72U AS=0.1764P AD=0.36P
+ PS=1.26U PD=2.44U
M$2013 \$3721 RB4 VDD VDD pfet_03v3 L=0.28U W=0.72U AS=0.3312P AD=0.3888P
+ PS=2.36U PD=2.52U
M$2014 \$3720 \$3721 \$390 VDD pfet_03v3 L=0.28U W=0.36U AS=0.1584P AD=0.1152P
+ PS=1.6U PD=1U
M$2015 \$391 \$3722 \$3720 VDD pfet_03v3 L=0.28U W=0.36U AS=0.1152P AD=0.1584P
+ PS=1U PD=1.6U
M$2016 VDD RA4 \$3722 VDD pfet_03v3 L=0.28U W=0.72U AS=0.3708P AD=0.3168P
+ PS=2.47U PD=2.32U
M$2017 \$3724 \$3678 \$3723 VDD pfet_03v3 L=0.28U W=0.36U AS=0.2097P AD=0.1278P
+ PS=1.38U PD=1.07U
M$2018 \$3836 \$3725 \$3724 VDD pfet_03v3 L=0.28U W=0.36U AS=0.1278P AD=0.0567P
+ PS=1.07U PD=0.675U
M$2019 VDD \$3677 \$3836 VDD pfet_03v3 L=0.28U W=0.36U AS=0.0567P AD=0.1584P
+ PS=0.675U PD=1.6U
M$2020 \$3723 \$65 VDD VDD pfet_03v3 L=0.28U W=0.72U AS=0.3168P AD=0.2097P
+ PS=2.32U PD=1.38U
M$2021 VDD \$3724 \$3725 VDD pfet_03v3 L=0.28U W=0.36U AS=0.1584P AD=0.1764P
+ PS=1.6U PD=1.26U
M$2022 \$3726 \$3724 VDD VDD pfet_03v3 L=0.28U W=0.72U AS=0.1764P AD=0.36P
+ PS=1.26U PD=2.44U
M$2023 \$3727 RB4 VDD VDD pfet_03v3 L=0.28U W=0.72U AS=0.3312P AD=0.3888P
+ PS=2.36U PD=2.52U
M$2024 \$3726 \$3727 \$395 VDD pfet_03v3 L=0.28U W=0.36U AS=0.1584P AD=0.1152P
+ PS=1.6U PD=1U
M$2025 \$396 \$3728 \$3726 VDD pfet_03v3 L=0.28U W=0.36U AS=0.1152P AD=0.1584P
+ PS=1U PD=1.6U
M$2026 VDD RA4 \$3728 VDD pfet_03v3 L=0.28U W=0.72U AS=0.3708P AD=0.3168P
+ PS=2.47U PD=2.32U
M$2027 \$3730 \$3678 \$3729 VDD pfet_03v3 L=0.28U W=0.36U AS=0.2097P AD=0.1278P
+ PS=1.38U PD=1.07U
M$2028 \$3842 \$3731 \$3730 VDD pfet_03v3 L=0.28U W=0.36U AS=0.1278P AD=0.0567P
+ PS=1.07U PD=0.675U
M$2029 VDD \$3677 \$3842 VDD pfet_03v3 L=0.28U W=0.36U AS=0.0567P AD=0.1584P
+ PS=0.675U PD=1.6U
M$2030 \$3729 \$68 VDD VDD pfet_03v3 L=0.28U W=0.72U AS=0.3168P AD=0.2097P
+ PS=2.32U PD=1.38U
M$2031 VDD \$3730 \$3731 VDD pfet_03v3 L=0.28U W=0.36U AS=0.1584P AD=0.1764P
+ PS=1.6U PD=1.26U
M$2032 \$3732 \$3730 VDD VDD pfet_03v3 L=0.28U W=0.72U AS=0.1764P AD=0.36P
+ PS=1.26U PD=2.44U
M$2033 \$3733 RB4 VDD VDD pfet_03v3 L=0.28U W=0.72U AS=0.3312P AD=0.3888P
+ PS=2.36U PD=2.52U
M$2034 \$3732 \$3733 \$400 VDD pfet_03v3 L=0.28U W=0.36U AS=0.1584P AD=0.1152P
+ PS=1.6U PD=1U
M$2035 \$401 \$3734 \$3732 VDD pfet_03v3 L=0.28U W=0.36U AS=0.1152P AD=0.1584P
+ PS=1U PD=1.6U
M$2036 VDD RA4 \$3734 VDD pfet_03v3 L=0.28U W=0.72U AS=0.3708P AD=0.3168P
+ PS=2.47U PD=2.32U
M$2037 \$3736 \$3678 \$3735 VDD pfet_03v3 L=0.28U W=0.36U AS=0.2097P AD=0.1278P
+ PS=1.38U PD=1.07U
M$2038 \$3849 \$3737 \$3736 VDD pfet_03v3 L=0.28U W=0.36U AS=0.1278P AD=0.0567P
+ PS=1.07U PD=0.675U
M$2039 VDD \$3677 \$3849 VDD pfet_03v3 L=0.28U W=0.36U AS=0.0567P AD=0.1584P
+ PS=0.675U PD=1.6U
M$2040 \$3735 \$71 VDD VDD pfet_03v3 L=0.28U W=0.72U AS=0.3168P AD=0.2097P
+ PS=2.32U PD=1.38U
M$2041 VDD \$3736 \$3737 VDD pfet_03v3 L=0.28U W=0.36U AS=0.1584P AD=0.1764P
+ PS=1.6U PD=1.26U
M$2042 \$3738 \$3736 VDD VDD pfet_03v3 L=0.28U W=0.72U AS=0.1764P AD=0.36P
+ PS=1.26U PD=2.44U
M$2043 \$3739 RB4 VDD VDD pfet_03v3 L=0.28U W=0.72U AS=0.3312P AD=0.3888P
+ PS=2.36U PD=2.52U
M$2044 \$3738 \$3739 \$405 VDD pfet_03v3 L=0.28U W=0.36U AS=0.1584P AD=0.1152P
+ PS=1.6U PD=1U
M$2045 \$406 \$3740 \$3738 VDD pfet_03v3 L=0.28U W=0.36U AS=0.1152P AD=0.1584P
+ PS=1U PD=1.6U
M$2046 VDD RA4 \$3740 VDD pfet_03v3 L=0.28U W=0.72U AS=0.3708P AD=0.3168P
+ PS=2.47U PD=2.32U
M$2047 \$3742 \$3678 \$3741 VDD pfet_03v3 L=0.28U W=0.36U AS=0.2097P AD=0.1278P
+ PS=1.38U PD=1.07U
M$2048 \$3857 \$3743 \$3742 VDD pfet_03v3 L=0.28U W=0.36U AS=0.1278P AD=0.0567P
+ PS=1.07U PD=0.675U
M$2049 VDD \$3677 \$3857 VDD pfet_03v3 L=0.28U W=0.36U AS=0.0567P AD=0.1584P
+ PS=0.675U PD=1.6U
M$2050 \$3741 \$74 VDD VDD pfet_03v3 L=0.28U W=0.72U AS=0.3168P AD=0.2097P
+ PS=2.32U PD=1.38U
M$2051 VDD \$3742 \$3743 VDD pfet_03v3 L=0.28U W=0.36U AS=0.1584P AD=0.1764P
+ PS=1.6U PD=1.26U
M$2052 \$3744 \$3742 VDD VDD pfet_03v3 L=0.28U W=0.72U AS=0.1764P AD=0.36P
+ PS=1.26U PD=2.44U
M$2053 \$3745 RB4 VDD VDD pfet_03v3 L=0.28U W=0.72U AS=0.3312P AD=0.3888P
+ PS=2.36U PD=2.52U
M$2054 \$3744 \$3745 \$410 VDD pfet_03v3 L=0.28U W=0.36U AS=0.1584P AD=0.1152P
+ PS=1.6U PD=1U
M$2055 \$411 \$3746 \$3744 VDD pfet_03v3 L=0.28U W=0.36U AS=0.1152P AD=0.1584P
+ PS=1U PD=1.6U
M$2056 VDD RA4 \$3746 VDD pfet_03v3 L=0.28U W=0.72U AS=0.3708P AD=0.3168P
+ PS=2.47U PD=2.32U
M$2057 \$3748 \$3678 \$3747 VDD pfet_03v3 L=0.28U W=0.36U AS=0.2097P AD=0.1278P
+ PS=1.38U PD=1.07U
M$2058 \$3865 \$3749 \$3748 VDD pfet_03v3 L=0.28U W=0.36U AS=0.1278P AD=0.0567P
+ PS=1.07U PD=0.675U
M$2059 VDD \$3677 \$3865 VDD pfet_03v3 L=0.28U W=0.36U AS=0.0567P AD=0.1584P
+ PS=0.675U PD=1.6U
M$2060 \$3747 \$77 VDD VDD pfet_03v3 L=0.28U W=0.72U AS=0.3168P AD=0.2097P
+ PS=2.32U PD=1.38U
M$2061 VDD \$3748 \$3749 VDD pfet_03v3 L=0.28U W=0.36U AS=0.1584P AD=0.1764P
+ PS=1.6U PD=1.26U
M$2062 \$3750 \$3748 VDD VDD pfet_03v3 L=0.28U W=0.72U AS=0.1764P AD=0.36P
+ PS=1.26U PD=2.44U
M$2063 \$3751 RB4 VDD VDD pfet_03v3 L=0.28U W=0.72U AS=0.3312P AD=0.3888P
+ PS=2.36U PD=2.52U
M$2064 \$3750 \$3751 \$415 VDD pfet_03v3 L=0.28U W=0.36U AS=0.1584P AD=0.1152P
+ PS=1.6U PD=1U
M$2065 \$416 \$3752 \$3750 VDD pfet_03v3 L=0.28U W=0.36U AS=0.1152P AD=0.1584P
+ PS=1U PD=1.6U
M$2066 VDD RA4 \$3752 VDD pfet_03v3 L=0.28U W=0.72U AS=0.3708P AD=0.3168P
+ PS=2.47U PD=2.32U
M$2067 \$3754 \$3678 \$3753 VDD pfet_03v3 L=0.28U W=0.36U AS=0.2097P AD=0.1278P
+ PS=1.38U PD=1.07U
M$2068 \$3872 \$3755 \$3754 VDD pfet_03v3 L=0.28U W=0.36U AS=0.1278P AD=0.0567P
+ PS=1.07U PD=0.675U
M$2069 VDD \$3677 \$3872 VDD pfet_03v3 L=0.28U W=0.36U AS=0.0567P AD=0.1584P
+ PS=0.675U PD=1.6U
M$2070 \$3753 \$80 VDD VDD pfet_03v3 L=0.28U W=0.72U AS=0.3168P AD=0.2097P
+ PS=2.32U PD=1.38U
M$2071 VDD \$3754 \$3755 VDD pfet_03v3 L=0.28U W=0.36U AS=0.1584P AD=0.1764P
+ PS=1.6U PD=1.26U
M$2072 \$3756 \$3754 VDD VDD pfet_03v3 L=0.28U W=0.72U AS=0.1764P AD=0.36P
+ PS=1.26U PD=2.44U
M$2073 \$3757 RB4 VDD VDD pfet_03v3 L=0.28U W=0.72U AS=0.3312P AD=0.3888P
+ PS=2.36U PD=2.52U
M$2074 \$3756 \$3757 \$420 VDD pfet_03v3 L=0.28U W=0.36U AS=0.1584P AD=0.1152P
+ PS=1.6U PD=1U
M$2075 \$421 \$3758 \$3756 VDD pfet_03v3 L=0.28U W=0.36U AS=0.1152P AD=0.1584P
+ PS=1U PD=1.6U
M$2076 VDD RA4 \$3758 VDD pfet_03v3 L=0.28U W=0.72U AS=0.3708P AD=0.3168P
+ PS=2.47U PD=2.32U
M$2077 \$3760 \$3678 \$3759 VDD pfet_03v3 L=0.28U W=0.36U AS=0.2097P AD=0.1278P
+ PS=1.38U PD=1.07U
M$2078 \$3871 \$3761 \$3760 VDD pfet_03v3 L=0.28U W=0.36U AS=0.1278P AD=0.0567P
+ PS=1.07U PD=0.675U
M$2079 VDD \$3677 \$3871 VDD pfet_03v3 L=0.28U W=0.36U AS=0.0567P AD=0.1584P
+ PS=0.675U PD=1.6U
M$2080 \$3759 \$83 VDD VDD pfet_03v3 L=0.28U W=0.72U AS=0.3168P AD=0.2097P
+ PS=2.32U PD=1.38U
M$2081 VDD \$3760 \$3761 VDD pfet_03v3 L=0.28U W=0.36U AS=0.1584P AD=0.1764P
+ PS=1.6U PD=1.26U
M$2082 \$3762 \$3760 VDD VDD pfet_03v3 L=0.28U W=0.72U AS=0.1764P AD=0.36P
+ PS=1.26U PD=2.44U
M$2083 \$3763 RB4 VDD VDD pfet_03v3 L=0.28U W=0.72U AS=0.3312P AD=0.3888P
+ PS=2.36U PD=2.52U
M$2084 \$3762 \$3763 \$425 VDD pfet_03v3 L=0.28U W=0.36U AS=0.1584P AD=0.1152P
+ PS=1.6U PD=1U
M$2085 \$426 \$3764 \$3762 VDD pfet_03v3 L=0.28U W=0.36U AS=0.1152P AD=0.1584P
+ PS=1U PD=1.6U
M$2086 VDD RA4 \$3764 VDD pfet_03v3 L=0.28U W=0.72U AS=0.3708P AD=0.3168P
+ PS=2.47U PD=2.32U
M$2087 \$3766 \$3678 \$3765 VDD pfet_03v3 L=0.28U W=0.36U AS=0.2097P AD=0.1278P
+ PS=1.38U PD=1.07U
M$2088 \$3838 \$3767 \$3766 VDD pfet_03v3 L=0.28U W=0.36U AS=0.1278P AD=0.0567P
+ PS=1.07U PD=0.675U
M$2089 VDD \$3677 \$3838 VDD pfet_03v3 L=0.28U W=0.36U AS=0.0567P AD=0.1584P
+ PS=0.675U PD=1.6U
M$2090 \$3765 \$86 VDD VDD pfet_03v3 L=0.28U W=0.72U AS=0.3168P AD=0.2097P
+ PS=2.32U PD=1.38U
M$2091 VDD \$3766 \$3767 VDD pfet_03v3 L=0.28U W=0.36U AS=0.1584P AD=0.1764P
+ PS=1.6U PD=1.26U
M$2092 \$3768 \$3766 VDD VDD pfet_03v3 L=0.28U W=0.72U AS=0.1764P AD=0.36P
+ PS=1.26U PD=2.44U
M$2093 \$3769 RB4 VDD VDD pfet_03v3 L=0.28U W=0.72U AS=0.3312P AD=0.3888P
+ PS=2.36U PD=2.52U
M$2094 \$3768 \$3769 \$430 VDD pfet_03v3 L=0.28U W=0.36U AS=0.1584P AD=0.1152P
+ PS=1.6U PD=1U
M$2095 \$431 \$3770 \$3768 VDD pfet_03v3 L=0.28U W=0.36U AS=0.1152P AD=0.1584P
+ PS=1U PD=1.6U
M$2096 VDD RA4 \$3770 VDD pfet_03v3 L=0.28U W=0.72U AS=0.3708P AD=0.3168P
+ PS=2.47U PD=2.32U
M$2097 \$3772 \$3678 \$3771 VDD pfet_03v3 L=0.28U W=0.36U AS=0.2097P AD=0.1278P
+ PS=1.38U PD=1.07U
M$2098 \$3806 \$3773 \$3772 VDD pfet_03v3 L=0.28U W=0.36U AS=0.1278P AD=0.0567P
+ PS=1.07U PD=0.675U
M$2099 VDD \$3677 \$3806 VDD pfet_03v3 L=0.28U W=0.36U AS=0.0567P AD=0.1584P
+ PS=0.675U PD=1.6U
M$2100 \$3771 \$89 VDD VDD pfet_03v3 L=0.28U W=0.72U AS=0.3168P AD=0.2097P
+ PS=2.32U PD=1.38U
M$2101 VDD \$3772 \$3773 VDD pfet_03v3 L=0.28U W=0.36U AS=0.1584P AD=0.1764P
+ PS=1.6U PD=1.26U
M$2102 \$3774 \$3772 VDD VDD pfet_03v3 L=0.28U W=0.72U AS=0.1764P AD=0.36P
+ PS=1.26U PD=2.44U
M$2103 \$3775 RB4 VDD VDD pfet_03v3 L=0.28U W=0.72U AS=0.3312P AD=0.3888P
+ PS=2.36U PD=2.52U
M$2104 \$3774 \$3775 \$435 VDD pfet_03v3 L=0.28U W=0.36U AS=0.1584P AD=0.1152P
+ PS=1.6U PD=1U
M$2105 \$436 \$3776 \$3774 VDD pfet_03v3 L=0.28U W=0.36U AS=0.1152P AD=0.1584P
+ PS=1U PD=1.6U
M$2106 VDD RA4 \$3776 VDD pfet_03v3 L=0.28U W=0.72U AS=0.3708P AD=0.3168P
+ PS=2.47U PD=2.32U
M$2107 \$3978 WE3 VDD VDD pfet_03v3 L=0.28U W=0.72U AS=0.3168P AD=0.1872P
+ PS=2.32U PD=1.24U
M$2108 VDD CLK \$3978 VDD pfet_03v3 L=0.28U W=0.72U AS=0.1872P AD=0.3168P
+ PS=1.24U PD=2.32U
M$2109 \$3979 \$3978 VDD VDD pfet_03v3 L=0.28U W=2.54U AS=0.8974P AD=0.6604P
+ PS=5.28U PD=3.58U
M$2111 \$3980 \$3979 VDD VDD pfet_03v3 L=0.28U W=2.68U AS=0.7272P AD=0.9782P
+ PS=3.78U PD=5.48U
M$2113 \$3981 \$44 VDD VDD pfet_03v3 L=0.28U W=0.72U AS=0.3168P AD=0.2097P
+ PS=2.32U PD=1.38U
M$2114 \$3982 \$3980 \$3981 VDD pfet_03v3 L=0.28U W=0.36U AS=0.2097P AD=0.1278P
+ PS=1.38U PD=1.07U
M$2115 \$4188 \$3983 \$3982 VDD pfet_03v3 L=0.28U W=0.36U AS=0.1278P AD=0.0567P
+ PS=1.07U PD=0.675U
M$2116 VDD \$3979 \$4188 VDD pfet_03v3 L=0.28U W=0.36U AS=0.0567P AD=0.1584P
+ PS=0.675U PD=1.6U
M$2117 \$3983 \$3982 VDD VDD pfet_03v3 L=0.28U W=0.36U AS=0.1764P AD=0.1584P
+ PS=1.26U PD=1.6U
M$2118 \$3984 \$3982 VDD VDD pfet_03v3 L=0.28U W=0.72U AS=0.1764P AD=0.36P
+ PS=1.26U PD=2.44U
M$2119 \$4095 RA3 VDD VDD pfet_03v3 L=0.28U W=0.72U AS=0.3312P AD=0.3888P
+ PS=2.36U PD=2.52U
M$2120 \$3984 \$4095 \$360 VDD pfet_03v3 L=0.28U W=0.36U AS=0.1584P AD=0.1152P
+ PS=1.6U PD=1U
M$2121 \$361 \$4096 \$3984 VDD pfet_03v3 L=0.28U W=0.36U AS=0.1152P AD=0.1584P
+ PS=1U PD=1.6U
M$2122 VDD RB3 \$4096 VDD pfet_03v3 L=0.28U W=0.72U AS=0.3708P AD=0.3168P
+ PS=2.47U PD=2.32U
M$2123 \$3985 \$47 VDD VDD pfet_03v3 L=0.28U W=0.72U AS=0.3168P AD=0.2097P
+ PS=2.32U PD=1.38U
M$2124 \$3986 \$3980 \$3985 VDD pfet_03v3 L=0.28U W=0.36U AS=0.2097P AD=0.1278P
+ PS=1.38U PD=1.07U
M$2125 \$4198 \$3987 \$3986 VDD pfet_03v3 L=0.28U W=0.36U AS=0.1278P AD=0.0567P
+ PS=1.07U PD=0.675U
M$2126 VDD \$3979 \$4198 VDD pfet_03v3 L=0.28U W=0.36U AS=0.0567P AD=0.1584P
+ PS=0.675U PD=1.6U
M$2127 \$3987 \$3986 VDD VDD pfet_03v3 L=0.28U W=0.36U AS=0.1764P AD=0.1584P
+ PS=1.26U PD=1.6U
M$2128 \$3988 \$3986 VDD VDD pfet_03v3 L=0.28U W=0.72U AS=0.1764P AD=0.36P
+ PS=1.26U PD=2.44U
M$2129 \$4097 RA3 VDD VDD pfet_03v3 L=0.28U W=0.72U AS=0.3312P AD=0.3888P
+ PS=2.36U PD=2.52U
M$2130 \$3988 \$4097 \$365 VDD pfet_03v3 L=0.28U W=0.36U AS=0.1584P AD=0.1152P
+ PS=1.6U PD=1U
M$2131 \$366 \$4098 \$3988 VDD pfet_03v3 L=0.28U W=0.36U AS=0.1152P AD=0.1584P
+ PS=1U PD=1.6U
M$2132 VDD RB3 \$4098 VDD pfet_03v3 L=0.28U W=0.72U AS=0.3708P AD=0.3168P
+ PS=2.47U PD=2.32U
M$2133 \$3989 \$50 VDD VDD pfet_03v3 L=0.28U W=0.72U AS=0.3168P AD=0.2097P
+ PS=2.32U PD=1.38U
M$2134 \$3990 \$3980 \$3989 VDD pfet_03v3 L=0.28U W=0.36U AS=0.2097P AD=0.1278P
+ PS=1.38U PD=1.07U
M$2135 \$4204 \$3991 \$3990 VDD pfet_03v3 L=0.28U W=0.36U AS=0.1278P AD=0.0567P
+ PS=1.07U PD=0.675U
M$2136 VDD \$3979 \$4204 VDD pfet_03v3 L=0.28U W=0.36U AS=0.0567P AD=0.1584P
+ PS=0.675U PD=1.6U
M$2137 \$3991 \$3990 VDD VDD pfet_03v3 L=0.28U W=0.36U AS=0.1764P AD=0.1584P
+ PS=1.26U PD=1.6U
M$2138 \$3992 \$3990 VDD VDD pfet_03v3 L=0.28U W=0.72U AS=0.1764P AD=0.36P
+ PS=1.26U PD=2.44U
M$2139 \$4099 RA3 VDD VDD pfet_03v3 L=0.28U W=0.72U AS=0.3312P AD=0.3888P
+ PS=2.36U PD=2.52U
M$2140 \$3992 \$4099 \$370 VDD pfet_03v3 L=0.28U W=0.36U AS=0.1584P AD=0.1152P
+ PS=1.6U PD=1U
M$2141 \$371 \$4100 \$3992 VDD pfet_03v3 L=0.28U W=0.36U AS=0.1152P AD=0.1584P
+ PS=1U PD=1.6U
M$2142 VDD RB3 \$4100 VDD pfet_03v3 L=0.28U W=0.72U AS=0.3708P AD=0.3168P
+ PS=2.47U PD=2.32U
M$2143 \$3993 \$53 VDD VDD pfet_03v3 L=0.28U W=0.72U AS=0.3168P AD=0.2097P
+ PS=2.32U PD=1.38U
M$2144 \$3994 \$3980 \$3993 VDD pfet_03v3 L=0.28U W=0.36U AS=0.2097P AD=0.1278P
+ PS=1.38U PD=1.07U
M$2145 \$4213 \$3995 \$3994 VDD pfet_03v3 L=0.28U W=0.36U AS=0.1278P AD=0.0567P
+ PS=1.07U PD=0.675U
M$2146 VDD \$3979 \$4213 VDD pfet_03v3 L=0.28U W=0.36U AS=0.0567P AD=0.1584P
+ PS=0.675U PD=1.6U
M$2147 \$3995 \$3994 VDD VDD pfet_03v3 L=0.28U W=0.36U AS=0.1764P AD=0.1584P
+ PS=1.26U PD=1.6U
M$2148 \$3996 \$3994 VDD VDD pfet_03v3 L=0.28U W=0.72U AS=0.1764P AD=0.36P
+ PS=1.26U PD=2.44U
M$2149 \$4101 RA3 VDD VDD pfet_03v3 L=0.28U W=0.72U AS=0.3312P AD=0.3888P
+ PS=2.36U PD=2.52U
M$2150 \$3996 \$4101 \$375 VDD pfet_03v3 L=0.28U W=0.36U AS=0.1584P AD=0.1152P
+ PS=1.6U PD=1U
M$2151 \$376 \$4102 \$3996 VDD pfet_03v3 L=0.28U W=0.36U AS=0.1152P AD=0.1584P
+ PS=1U PD=1.6U
M$2152 VDD RB3 \$4102 VDD pfet_03v3 L=0.28U W=0.72U AS=0.3708P AD=0.3168P
+ PS=2.47U PD=2.32U
M$2153 \$3997 \$56 VDD VDD pfet_03v3 L=0.28U W=0.72U AS=0.3168P AD=0.2097P
+ PS=2.32U PD=1.38U
M$2154 \$3998 \$3980 \$3997 VDD pfet_03v3 L=0.28U W=0.36U AS=0.2097P AD=0.1278P
+ PS=1.38U PD=1.07U
M$2155 \$4223 \$3999 \$3998 VDD pfet_03v3 L=0.28U W=0.36U AS=0.1278P AD=0.0567P
+ PS=1.07U PD=0.675U
M$2156 VDD \$3979 \$4223 VDD pfet_03v3 L=0.28U W=0.36U AS=0.0567P AD=0.1584P
+ PS=0.675U PD=1.6U
M$2157 \$3999 \$3998 VDD VDD pfet_03v3 L=0.28U W=0.36U AS=0.1764P AD=0.1584P
+ PS=1.26U PD=1.6U
M$2158 \$4000 \$3998 VDD VDD pfet_03v3 L=0.28U W=0.72U AS=0.1764P AD=0.36P
+ PS=1.26U PD=2.44U
M$2159 \$4103 RA3 VDD VDD pfet_03v3 L=0.28U W=0.72U AS=0.3312P AD=0.3888P
+ PS=2.36U PD=2.52U
M$2160 \$4000 \$4103 \$380 VDD pfet_03v3 L=0.28U W=0.36U AS=0.1584P AD=0.1152P
+ PS=1.6U PD=1U
M$2161 \$381 \$4104 \$4000 VDD pfet_03v3 L=0.28U W=0.36U AS=0.1152P AD=0.1584P
+ PS=1U PD=1.6U
M$2162 VDD RB3 \$4104 VDD pfet_03v3 L=0.28U W=0.72U AS=0.3708P AD=0.3168P
+ PS=2.47U PD=2.32U
M$2163 \$4001 \$59 VDD VDD pfet_03v3 L=0.28U W=0.72U AS=0.3168P AD=0.2097P
+ PS=2.32U PD=1.38U
M$2164 \$4002 \$3980 \$4001 VDD pfet_03v3 L=0.28U W=0.36U AS=0.2097P AD=0.1278P
+ PS=1.38U PD=1.07U
M$2165 \$4232 \$4003 \$4002 VDD pfet_03v3 L=0.28U W=0.36U AS=0.1278P AD=0.0567P
+ PS=1.07U PD=0.675U
M$2166 VDD \$3979 \$4232 VDD pfet_03v3 L=0.28U W=0.36U AS=0.0567P AD=0.1584P
+ PS=0.675U PD=1.6U
M$2167 \$4003 \$4002 VDD VDD pfet_03v3 L=0.28U W=0.36U AS=0.1764P AD=0.1584P
+ PS=1.26U PD=1.6U
M$2168 \$4004 \$4002 VDD VDD pfet_03v3 L=0.28U W=0.72U AS=0.1764P AD=0.36P
+ PS=1.26U PD=2.44U
M$2169 \$4105 RA3 VDD VDD pfet_03v3 L=0.28U W=0.72U AS=0.3312P AD=0.3888P
+ PS=2.36U PD=2.52U
M$2170 \$4004 \$4105 \$385 VDD pfet_03v3 L=0.28U W=0.36U AS=0.1584P AD=0.1152P
+ PS=1.6U PD=1U
M$2171 \$386 \$4106 \$4004 VDD pfet_03v3 L=0.28U W=0.36U AS=0.1152P AD=0.1584P
+ PS=1U PD=1.6U
M$2172 VDD RB3 \$4106 VDD pfet_03v3 L=0.28U W=0.72U AS=0.3708P AD=0.3168P
+ PS=2.47U PD=2.32U
M$2173 \$4005 \$62 VDD VDD pfet_03v3 L=0.28U W=0.72U AS=0.3168P AD=0.2097P
+ PS=2.32U PD=1.38U
M$2174 \$4006 \$3980 \$4005 VDD pfet_03v3 L=0.28U W=0.36U AS=0.2097P AD=0.1278P
+ PS=1.38U PD=1.07U
M$2175 \$4240 \$4007 \$4006 VDD pfet_03v3 L=0.28U W=0.36U AS=0.1278P AD=0.0567P
+ PS=1.07U PD=0.675U
M$2176 VDD \$3979 \$4240 VDD pfet_03v3 L=0.28U W=0.36U AS=0.0567P AD=0.1584P
+ PS=0.675U PD=1.6U
M$2177 \$4007 \$4006 VDD VDD pfet_03v3 L=0.28U W=0.36U AS=0.1764P AD=0.1584P
+ PS=1.26U PD=1.6U
M$2178 \$4008 \$4006 VDD VDD pfet_03v3 L=0.28U W=0.72U AS=0.1764P AD=0.36P
+ PS=1.26U PD=2.44U
M$2179 \$4107 RA3 VDD VDD pfet_03v3 L=0.28U W=0.72U AS=0.3312P AD=0.3888P
+ PS=2.36U PD=2.52U
M$2180 \$4008 \$4107 \$390 VDD pfet_03v3 L=0.28U W=0.36U AS=0.1584P AD=0.1152P
+ PS=1.6U PD=1U
M$2181 \$391 \$4108 \$4008 VDD pfet_03v3 L=0.28U W=0.36U AS=0.1152P AD=0.1584P
+ PS=1U PD=1.6U
M$2182 VDD RB3 \$4108 VDD pfet_03v3 L=0.28U W=0.72U AS=0.3708P AD=0.3168P
+ PS=2.47U PD=2.32U
M$2183 \$4009 \$65 VDD VDD pfet_03v3 L=0.28U W=0.72U AS=0.3168P AD=0.2097P
+ PS=2.32U PD=1.38U
M$2184 \$4010 \$3980 \$4009 VDD pfet_03v3 L=0.28U W=0.36U AS=0.2097P AD=0.1278P
+ PS=1.38U PD=1.07U
M$2185 \$4249 \$4011 \$4010 VDD pfet_03v3 L=0.28U W=0.36U AS=0.1278P AD=0.0567P
+ PS=1.07U PD=0.675U
M$2186 VDD \$3979 \$4249 VDD pfet_03v3 L=0.28U W=0.36U AS=0.0567P AD=0.1584P
+ PS=0.675U PD=1.6U
M$2187 \$4011 \$4010 VDD VDD pfet_03v3 L=0.28U W=0.36U AS=0.1764P AD=0.1584P
+ PS=1.26U PD=1.6U
M$2188 \$4012 \$4010 VDD VDD pfet_03v3 L=0.28U W=0.72U AS=0.1764P AD=0.36P
+ PS=1.26U PD=2.44U
M$2189 \$4109 RA3 VDD VDD pfet_03v3 L=0.28U W=0.72U AS=0.3312P AD=0.3888P
+ PS=2.36U PD=2.52U
M$2190 \$4012 \$4109 \$395 VDD pfet_03v3 L=0.28U W=0.36U AS=0.1584P AD=0.1152P
+ PS=1.6U PD=1U
M$2191 \$396 \$4110 \$4012 VDD pfet_03v3 L=0.28U W=0.36U AS=0.1152P AD=0.1584P
+ PS=1U PD=1.6U
M$2192 VDD RB3 \$4110 VDD pfet_03v3 L=0.28U W=0.72U AS=0.3708P AD=0.3168P
+ PS=2.47U PD=2.32U
M$2193 \$4013 \$68 VDD VDD pfet_03v3 L=0.28U W=0.72U AS=0.3168P AD=0.2097P
+ PS=2.32U PD=1.38U
M$2194 \$4014 \$3980 \$4013 VDD pfet_03v3 L=0.28U W=0.36U AS=0.2097P AD=0.1278P
+ PS=1.38U PD=1.07U
M$2195 \$4258 \$4015 \$4014 VDD pfet_03v3 L=0.28U W=0.36U AS=0.1278P AD=0.0567P
+ PS=1.07U PD=0.675U
M$2196 VDD \$3979 \$4258 VDD pfet_03v3 L=0.28U W=0.36U AS=0.0567P AD=0.1584P
+ PS=0.675U PD=1.6U
M$2197 \$4015 \$4014 VDD VDD pfet_03v3 L=0.28U W=0.36U AS=0.1764P AD=0.1584P
+ PS=1.26U PD=1.6U
M$2198 \$4016 \$4014 VDD VDD pfet_03v3 L=0.28U W=0.72U AS=0.1764P AD=0.36P
+ PS=1.26U PD=2.44U
M$2199 \$4111 RA3 VDD VDD pfet_03v3 L=0.28U W=0.72U AS=0.3312P AD=0.3888P
+ PS=2.36U PD=2.52U
M$2200 \$4016 \$4111 \$400 VDD pfet_03v3 L=0.28U W=0.36U AS=0.1584P AD=0.1152P
+ PS=1.6U PD=1U
M$2201 \$401 \$4112 \$4016 VDD pfet_03v3 L=0.28U W=0.36U AS=0.1152P AD=0.1584P
+ PS=1U PD=1.6U
M$2202 VDD RB3 \$4112 VDD pfet_03v3 L=0.28U W=0.72U AS=0.3708P AD=0.3168P
+ PS=2.47U PD=2.32U
M$2203 \$4017 \$71 VDD VDD pfet_03v3 L=0.28U W=0.72U AS=0.3168P AD=0.2097P
+ PS=2.32U PD=1.38U
M$2204 \$4018 \$3980 \$4017 VDD pfet_03v3 L=0.28U W=0.36U AS=0.2097P AD=0.1278P
+ PS=1.38U PD=1.07U
M$2205 \$4267 \$4019 \$4018 VDD pfet_03v3 L=0.28U W=0.36U AS=0.1278P AD=0.0567P
+ PS=1.07U PD=0.675U
M$2206 VDD \$3979 \$4267 VDD pfet_03v3 L=0.28U W=0.36U AS=0.0567P AD=0.1584P
+ PS=0.675U PD=1.6U
M$2207 \$4019 \$4018 VDD VDD pfet_03v3 L=0.28U W=0.36U AS=0.1764P AD=0.1584P
+ PS=1.26U PD=1.6U
M$2208 \$4020 \$4018 VDD VDD pfet_03v3 L=0.28U W=0.72U AS=0.1764P AD=0.36P
+ PS=1.26U PD=2.44U
M$2209 \$4113 RA3 VDD VDD pfet_03v3 L=0.28U W=0.72U AS=0.3312P AD=0.3888P
+ PS=2.36U PD=2.52U
M$2210 \$4020 \$4113 \$405 VDD pfet_03v3 L=0.28U W=0.36U AS=0.1584P AD=0.1152P
+ PS=1.6U PD=1U
M$2211 \$406 \$4114 \$4020 VDD pfet_03v3 L=0.28U W=0.36U AS=0.1152P AD=0.1584P
+ PS=1U PD=1.6U
M$2212 VDD RB3 \$4114 VDD pfet_03v3 L=0.28U W=0.72U AS=0.3708P AD=0.3168P
+ PS=2.47U PD=2.32U
M$2213 \$4021 \$74 VDD VDD pfet_03v3 L=0.28U W=0.72U AS=0.3168P AD=0.2097P
+ PS=2.32U PD=1.38U
M$2214 \$4022 \$3980 \$4021 VDD pfet_03v3 L=0.28U W=0.36U AS=0.2097P AD=0.1278P
+ PS=1.38U PD=1.07U
M$2215 \$4276 \$4023 \$4022 VDD pfet_03v3 L=0.28U W=0.36U AS=0.1278P AD=0.0567P
+ PS=1.07U PD=0.675U
M$2216 VDD \$3979 \$4276 VDD pfet_03v3 L=0.28U W=0.36U AS=0.0567P AD=0.1584P
+ PS=0.675U PD=1.6U
M$2217 \$4023 \$4022 VDD VDD pfet_03v3 L=0.28U W=0.36U AS=0.1764P AD=0.1584P
+ PS=1.26U PD=1.6U
M$2218 \$4024 \$4022 VDD VDD pfet_03v3 L=0.28U W=0.72U AS=0.1764P AD=0.36P
+ PS=1.26U PD=2.44U
M$2219 \$4115 RA3 VDD VDD pfet_03v3 L=0.28U W=0.72U AS=0.3312P AD=0.3888P
+ PS=2.36U PD=2.52U
M$2220 \$4024 \$4115 \$410 VDD pfet_03v3 L=0.28U W=0.36U AS=0.1584P AD=0.1152P
+ PS=1.6U PD=1U
M$2221 \$411 \$4116 \$4024 VDD pfet_03v3 L=0.28U W=0.36U AS=0.1152P AD=0.1584P
+ PS=1U PD=1.6U
M$2222 VDD RB3 \$4116 VDD pfet_03v3 L=0.28U W=0.72U AS=0.3708P AD=0.3168P
+ PS=2.47U PD=2.32U
M$2223 \$4025 \$77 VDD VDD pfet_03v3 L=0.28U W=0.72U AS=0.3168P AD=0.2097P
+ PS=2.32U PD=1.38U
M$2224 \$4026 \$3980 \$4025 VDD pfet_03v3 L=0.28U W=0.36U AS=0.2097P AD=0.1278P
+ PS=1.38U PD=1.07U
M$2225 \$4284 \$4027 \$4026 VDD pfet_03v3 L=0.28U W=0.36U AS=0.1278P AD=0.0567P
+ PS=1.07U PD=0.675U
M$2226 VDD \$3979 \$4284 VDD pfet_03v3 L=0.28U W=0.36U AS=0.0567P AD=0.1584P
+ PS=0.675U PD=1.6U
M$2227 \$4027 \$4026 VDD VDD pfet_03v3 L=0.28U W=0.36U AS=0.1764P AD=0.1584P
+ PS=1.26U PD=1.6U
M$2228 \$4028 \$4026 VDD VDD pfet_03v3 L=0.28U W=0.72U AS=0.1764P AD=0.36P
+ PS=1.26U PD=2.44U
M$2229 \$4117 RA3 VDD VDD pfet_03v3 L=0.28U W=0.72U AS=0.3312P AD=0.3888P
+ PS=2.36U PD=2.52U
M$2230 \$4028 \$4117 \$415 VDD pfet_03v3 L=0.28U W=0.36U AS=0.1584P AD=0.1152P
+ PS=1.6U PD=1U
M$2231 \$416 \$4118 \$4028 VDD pfet_03v3 L=0.28U W=0.36U AS=0.1152P AD=0.1584P
+ PS=1U PD=1.6U
M$2232 VDD RB3 \$4118 VDD pfet_03v3 L=0.28U W=0.72U AS=0.3708P AD=0.3168P
+ PS=2.47U PD=2.32U
M$2233 \$4029 \$80 VDD VDD pfet_03v3 L=0.28U W=0.72U AS=0.3168P AD=0.2097P
+ PS=2.32U PD=1.38U
M$2234 \$4030 \$3980 \$4029 VDD pfet_03v3 L=0.28U W=0.36U AS=0.2097P AD=0.1278P
+ PS=1.38U PD=1.07U
M$2235 \$4270 \$4031 \$4030 VDD pfet_03v3 L=0.28U W=0.36U AS=0.1278P AD=0.0567P
+ PS=1.07U PD=0.675U
M$2236 VDD \$3979 \$4270 VDD pfet_03v3 L=0.28U W=0.36U AS=0.0567P AD=0.1584P
+ PS=0.675U PD=1.6U
M$2237 \$4031 \$4030 VDD VDD pfet_03v3 L=0.28U W=0.36U AS=0.1764P AD=0.1584P
+ PS=1.26U PD=1.6U
M$2238 \$4032 \$4030 VDD VDD pfet_03v3 L=0.28U W=0.72U AS=0.1764P AD=0.36P
+ PS=1.26U PD=2.44U
M$2239 \$4119 RA3 VDD VDD pfet_03v3 L=0.28U W=0.72U AS=0.3312P AD=0.3888P
+ PS=2.36U PD=2.52U
M$2240 \$4032 \$4119 \$420 VDD pfet_03v3 L=0.28U W=0.36U AS=0.1584P AD=0.1152P
+ PS=1.6U PD=1U
M$2241 \$421 \$4120 \$4032 VDD pfet_03v3 L=0.28U W=0.36U AS=0.1152P AD=0.1584P
+ PS=1U PD=1.6U
M$2242 VDD RB3 \$4120 VDD pfet_03v3 L=0.28U W=0.72U AS=0.3708P AD=0.3168P
+ PS=2.47U PD=2.32U
M$2243 \$4033 \$83 VDD VDD pfet_03v3 L=0.28U W=0.72U AS=0.3168P AD=0.2097P
+ PS=2.32U PD=1.38U
M$2244 \$4034 \$3980 \$4033 VDD pfet_03v3 L=0.28U W=0.36U AS=0.2097P AD=0.1278P
+ PS=1.38U PD=1.07U
M$2245 \$4242 \$4035 \$4034 VDD pfet_03v3 L=0.28U W=0.36U AS=0.1278P AD=0.0567P
+ PS=1.07U PD=0.675U
M$2246 VDD \$3979 \$4242 VDD pfet_03v3 L=0.28U W=0.36U AS=0.0567P AD=0.1584P
+ PS=0.675U PD=1.6U
M$2247 \$4035 \$4034 VDD VDD pfet_03v3 L=0.28U W=0.36U AS=0.1764P AD=0.1584P
+ PS=1.26U PD=1.6U
M$2248 \$4036 \$4034 VDD VDD pfet_03v3 L=0.28U W=0.72U AS=0.1764P AD=0.36P
+ PS=1.26U PD=2.44U
M$2249 \$4121 RA3 VDD VDD pfet_03v3 L=0.28U W=0.72U AS=0.3312P AD=0.3888P
+ PS=2.36U PD=2.52U
M$2250 \$4036 \$4121 \$425 VDD pfet_03v3 L=0.28U W=0.36U AS=0.1584P AD=0.1152P
+ PS=1.6U PD=1U
M$2251 \$426 \$4122 \$4036 VDD pfet_03v3 L=0.28U W=0.36U AS=0.1152P AD=0.1584P
+ PS=1U PD=1.6U
M$2252 VDD RB3 \$4122 VDD pfet_03v3 L=0.28U W=0.72U AS=0.3708P AD=0.3168P
+ PS=2.47U PD=2.32U
M$2253 \$4037 \$86 VDD VDD pfet_03v3 L=0.28U W=0.72U AS=0.3168P AD=0.2097P
+ PS=2.32U PD=1.38U
M$2254 \$4038 \$3980 \$4037 VDD pfet_03v3 L=0.28U W=0.36U AS=0.2097P AD=0.1278P
+ PS=1.38U PD=1.07U
M$2255 \$4224 \$4039 \$4038 VDD pfet_03v3 L=0.28U W=0.36U AS=0.1278P AD=0.0567P
+ PS=1.07U PD=0.675U
M$2256 VDD \$3979 \$4224 VDD pfet_03v3 L=0.28U W=0.36U AS=0.0567P AD=0.1584P
+ PS=0.675U PD=1.6U
M$2257 \$4039 \$4038 VDD VDD pfet_03v3 L=0.28U W=0.36U AS=0.1764P AD=0.1584P
+ PS=1.26U PD=1.6U
M$2258 \$4040 \$4038 VDD VDD pfet_03v3 L=0.28U W=0.72U AS=0.1764P AD=0.36P
+ PS=1.26U PD=2.44U
M$2259 \$4123 RA3 VDD VDD pfet_03v3 L=0.28U W=0.72U AS=0.3312P AD=0.3888P
+ PS=2.36U PD=2.52U
M$2260 \$4040 \$4123 \$430 VDD pfet_03v3 L=0.28U W=0.36U AS=0.1584P AD=0.1152P
+ PS=1.6U PD=1U
M$2261 \$431 \$4124 \$4040 VDD pfet_03v3 L=0.28U W=0.36U AS=0.1152P AD=0.1584P
+ PS=1U PD=1.6U
M$2262 VDD RB3 \$4124 VDD pfet_03v3 L=0.28U W=0.72U AS=0.3708P AD=0.3168P
+ PS=2.47U PD=2.32U
M$2263 \$4041 \$89 VDD VDD pfet_03v3 L=0.28U W=0.72U AS=0.3168P AD=0.2097P
+ PS=2.32U PD=1.38U
M$2264 \$4042 \$3980 \$4041 VDD pfet_03v3 L=0.28U W=0.36U AS=0.2097P AD=0.1278P
+ PS=1.38U PD=1.07U
M$2265 \$4196 \$4043 \$4042 VDD pfet_03v3 L=0.28U W=0.36U AS=0.1278P AD=0.0567P
+ PS=1.07U PD=0.675U
M$2266 VDD \$3979 \$4196 VDD pfet_03v3 L=0.28U W=0.36U AS=0.0567P AD=0.1584P
+ PS=0.675U PD=1.6U
M$2267 \$4043 \$4042 VDD VDD pfet_03v3 L=0.28U W=0.36U AS=0.1764P AD=0.1584P
+ PS=1.26U PD=1.6U
M$2268 \$4044 \$4042 VDD VDD pfet_03v3 L=0.28U W=0.72U AS=0.1764P AD=0.36P
+ PS=1.26U PD=2.44U
M$2269 \$4125 RA3 VDD VDD pfet_03v3 L=0.28U W=0.72U AS=0.3312P AD=0.3888P
+ PS=2.36U PD=2.52U
M$2270 \$4044 \$4125 \$435 VDD pfet_03v3 L=0.28U W=0.36U AS=0.1584P AD=0.1152P
+ PS=1.6U PD=1U
M$2271 \$436 \$4126 \$4044 VDD pfet_03v3 L=0.28U W=0.36U AS=0.1152P AD=0.1584P
+ PS=1U PD=1.6U
M$2272 VDD RB3 \$4126 VDD pfet_03v3 L=0.28U W=0.72U AS=0.3708P AD=0.3168P
+ PS=2.47U PD=2.32U
M$2273 \$4288 WE2 VDD VDD pfet_03v3 L=0.28U W=0.72U AS=0.3168P AD=0.1872P
+ PS=2.32U PD=1.24U
M$2274 VDD CLK \$4288 VDD pfet_03v3 L=0.28U W=0.72U AS=0.1872P AD=0.3168P
+ PS=1.24U PD=2.32U
M$2275 \$4290 \$4288 VDD VDD pfet_03v3 L=0.28U W=2.54U AS=0.889P AD=0.6688P
+ PS=5.21U PD=3.65U
M$2277 \$4291 \$4290 VDD VDD pfet_03v3 L=0.28U W=2.68U AS=0.7272P AD=0.9782P
+ PS=3.78U PD=5.48U
M$2279 \$4295 \$4291 \$4294 VDD pfet_03v3 L=0.28U W=0.36U AS=0.2097P AD=0.1278P
+ PS=1.38U PD=1.07U
M$2280 \$4395 \$4296 \$4295 VDD pfet_03v3 L=0.28U W=0.36U AS=0.1278P AD=0.0567P
+ PS=1.07U PD=0.675U
M$2281 VDD \$4290 \$4395 VDD pfet_03v3 L=0.28U W=0.36U AS=0.0567P AD=0.1584P
+ PS=0.675U PD=1.6U
M$2282 \$4294 \$44 VDD VDD pfet_03v3 L=0.28U W=0.72U AS=0.3168P AD=0.2097P
+ PS=2.32U PD=1.38U
M$2283 VDD \$4295 \$4296 VDD pfet_03v3 L=0.28U W=0.36U AS=0.1584P AD=0.1764P
+ PS=1.6U PD=1.26U
M$2284 \$4297 \$4295 VDD VDD pfet_03v3 L=0.28U W=0.72U AS=0.1764P AD=0.36P
+ PS=1.26U PD=2.44U
M$2285 \$4298 RB2 VDD VDD pfet_03v3 L=0.28U W=0.72U AS=0.3312P AD=0.3888P
+ PS=2.36U PD=2.52U
M$2286 \$4297 \$4298 \$360 VDD pfet_03v3 L=0.28U W=0.36U AS=0.1584P AD=0.1152P
+ PS=1.6U PD=1U
M$2287 \$361 \$4299 \$4297 VDD pfet_03v3 L=0.28U W=0.36U AS=0.1152P AD=0.1584P
+ PS=1U PD=1.6U
M$2288 VDD RA2 \$4299 VDD pfet_03v3 L=0.28U W=0.72U AS=0.3708P AD=0.3168P
+ PS=2.47U PD=2.32U
M$2289 \$4301 \$4291 \$4300 VDD pfet_03v3 L=0.28U W=0.36U AS=0.2097P AD=0.1278P
+ PS=1.38U PD=1.07U
M$2290 \$4403 \$4302 \$4301 VDD pfet_03v3 L=0.28U W=0.36U AS=0.1278P AD=0.0567P
+ PS=1.07U PD=0.675U
M$2291 VDD \$4290 \$4403 VDD pfet_03v3 L=0.28U W=0.36U AS=0.0567P AD=0.1584P
+ PS=0.675U PD=1.6U
M$2292 \$4300 \$47 VDD VDD pfet_03v3 L=0.28U W=0.72U AS=0.3168P AD=0.2097P
+ PS=2.32U PD=1.38U
M$2293 VDD \$4301 \$4302 VDD pfet_03v3 L=0.28U W=0.36U AS=0.1584P AD=0.1764P
+ PS=1.6U PD=1.26U
M$2294 \$4303 \$4301 VDD VDD pfet_03v3 L=0.28U W=0.72U AS=0.1764P AD=0.36P
+ PS=1.26U PD=2.44U
M$2295 \$4304 RB2 VDD VDD pfet_03v3 L=0.28U W=0.72U AS=0.3312P AD=0.3888P
+ PS=2.36U PD=2.52U
M$2296 \$4303 \$4304 \$365 VDD pfet_03v3 L=0.28U W=0.36U AS=0.1584P AD=0.1152P
+ PS=1.6U PD=1U
M$2297 \$366 \$4305 \$4303 VDD pfet_03v3 L=0.28U W=0.36U AS=0.1152P AD=0.1584P
+ PS=1U PD=1.6U
M$2298 VDD RA2 \$4305 VDD pfet_03v3 L=0.28U W=0.72U AS=0.3708P AD=0.3168P
+ PS=2.47U PD=2.32U
M$2299 \$4307 \$4291 \$4306 VDD pfet_03v3 L=0.28U W=0.36U AS=0.2097P AD=0.1278P
+ PS=1.38U PD=1.07U
M$2300 \$4410 \$4308 \$4307 VDD pfet_03v3 L=0.28U W=0.36U AS=0.1278P AD=0.0567P
+ PS=1.07U PD=0.675U
M$2301 VDD \$4290 \$4410 VDD pfet_03v3 L=0.28U W=0.36U AS=0.0567P AD=0.1584P
+ PS=0.675U PD=1.6U
M$2302 \$4306 \$50 VDD VDD pfet_03v3 L=0.28U W=0.72U AS=0.3168P AD=0.2097P
+ PS=2.32U PD=1.38U
M$2303 VDD \$4307 \$4308 VDD pfet_03v3 L=0.28U W=0.36U AS=0.1584P AD=0.1764P
+ PS=1.6U PD=1.26U
M$2304 \$4309 \$4307 VDD VDD pfet_03v3 L=0.28U W=0.72U AS=0.1764P AD=0.36P
+ PS=1.26U PD=2.44U
M$2305 \$4310 RB2 VDD VDD pfet_03v3 L=0.28U W=0.72U AS=0.3312P AD=0.3888P
+ PS=2.36U PD=2.52U
M$2306 \$4309 \$4310 \$370 VDD pfet_03v3 L=0.28U W=0.36U AS=0.1584P AD=0.1152P
+ PS=1.6U PD=1U
M$2307 \$371 \$4311 \$4309 VDD pfet_03v3 L=0.28U W=0.36U AS=0.1152P AD=0.1584P
+ PS=1U PD=1.6U
M$2308 VDD RA2 \$4311 VDD pfet_03v3 L=0.28U W=0.72U AS=0.3708P AD=0.3168P
+ PS=2.47U PD=2.32U
M$2309 \$4313 \$4291 \$4312 VDD pfet_03v3 L=0.28U W=0.36U AS=0.2097P AD=0.1278P
+ PS=1.38U PD=1.07U
M$2310 \$4418 \$4314 \$4313 VDD pfet_03v3 L=0.28U W=0.36U AS=0.1278P AD=0.0567P
+ PS=1.07U PD=0.675U
M$2311 VDD \$4290 \$4418 VDD pfet_03v3 L=0.28U W=0.36U AS=0.0567P AD=0.1584P
+ PS=0.675U PD=1.6U
M$2312 \$4312 \$53 VDD VDD pfet_03v3 L=0.28U W=0.72U AS=0.3168P AD=0.2097P
+ PS=2.32U PD=1.38U
M$2313 VDD \$4313 \$4314 VDD pfet_03v3 L=0.28U W=0.36U AS=0.1584P AD=0.1764P
+ PS=1.6U PD=1.26U
M$2314 \$4315 \$4313 VDD VDD pfet_03v3 L=0.28U W=0.72U AS=0.1764P AD=0.36P
+ PS=1.26U PD=2.44U
M$2315 \$4316 RB2 VDD VDD pfet_03v3 L=0.28U W=0.72U AS=0.3312P AD=0.3888P
+ PS=2.36U PD=2.52U
M$2316 \$4315 \$4316 \$375 VDD pfet_03v3 L=0.28U W=0.36U AS=0.1584P AD=0.1152P
+ PS=1.6U PD=1U
M$2317 \$376 \$4317 \$4315 VDD pfet_03v3 L=0.28U W=0.36U AS=0.1152P AD=0.1584P
+ PS=1U PD=1.6U
M$2318 VDD RA2 \$4317 VDD pfet_03v3 L=0.28U W=0.72U AS=0.3708P AD=0.3168P
+ PS=2.47U PD=2.32U
M$2319 \$4319 \$4291 \$4318 VDD pfet_03v3 L=0.28U W=0.36U AS=0.2097P AD=0.1278P
+ PS=1.38U PD=1.07U
M$2320 \$4427 \$4320 \$4319 VDD pfet_03v3 L=0.28U W=0.36U AS=0.1278P AD=0.0567P
+ PS=1.07U PD=0.675U
M$2321 VDD \$4290 \$4427 VDD pfet_03v3 L=0.28U W=0.36U AS=0.0567P AD=0.1584P
+ PS=0.675U PD=1.6U
M$2322 \$4318 \$56 VDD VDD pfet_03v3 L=0.28U W=0.72U AS=0.3168P AD=0.2097P
+ PS=2.32U PD=1.38U
M$2323 VDD \$4319 \$4320 VDD pfet_03v3 L=0.28U W=0.36U AS=0.1584P AD=0.1764P
+ PS=1.6U PD=1.26U
M$2324 \$4321 \$4319 VDD VDD pfet_03v3 L=0.28U W=0.72U AS=0.1764P AD=0.36P
+ PS=1.26U PD=2.44U
M$2325 \$4322 RB2 VDD VDD pfet_03v3 L=0.28U W=0.72U AS=0.3312P AD=0.3888P
+ PS=2.36U PD=2.52U
M$2326 \$4321 \$4322 \$380 VDD pfet_03v3 L=0.28U W=0.36U AS=0.1584P AD=0.1152P
+ PS=1.6U PD=1U
M$2327 \$381 \$4323 \$4321 VDD pfet_03v3 L=0.28U W=0.36U AS=0.1152P AD=0.1584P
+ PS=1U PD=1.6U
M$2328 VDD RA2 \$4323 VDD pfet_03v3 L=0.28U W=0.72U AS=0.3708P AD=0.3168P
+ PS=2.47U PD=2.32U
M$2329 \$4325 \$4291 \$4324 VDD pfet_03v3 L=0.28U W=0.36U AS=0.2097P AD=0.1278P
+ PS=1.38U PD=1.07U
M$2330 \$4433 \$4326 \$4325 VDD pfet_03v3 L=0.28U W=0.36U AS=0.1278P AD=0.0567P
+ PS=1.07U PD=0.675U
M$2331 VDD \$4290 \$4433 VDD pfet_03v3 L=0.28U W=0.36U AS=0.0567P AD=0.1584P
+ PS=0.675U PD=1.6U
M$2332 \$4324 \$59 VDD VDD pfet_03v3 L=0.28U W=0.72U AS=0.3168P AD=0.2097P
+ PS=2.32U PD=1.38U
M$2333 VDD \$4325 \$4326 VDD pfet_03v3 L=0.28U W=0.36U AS=0.1584P AD=0.1764P
+ PS=1.6U PD=1.26U
M$2334 \$4327 \$4325 VDD VDD pfet_03v3 L=0.28U W=0.72U AS=0.1764P AD=0.36P
+ PS=1.26U PD=2.44U
M$2335 \$4328 RB2 VDD VDD pfet_03v3 L=0.28U W=0.72U AS=0.3312P AD=0.3888P
+ PS=2.36U PD=2.52U
M$2336 \$4327 \$4328 \$385 VDD pfet_03v3 L=0.28U W=0.36U AS=0.1584P AD=0.1152P
+ PS=1.6U PD=1U
M$2337 \$386 \$4329 \$4327 VDD pfet_03v3 L=0.28U W=0.36U AS=0.1152P AD=0.1584P
+ PS=1U PD=1.6U
M$2338 VDD RA2 \$4329 VDD pfet_03v3 L=0.28U W=0.72U AS=0.3708P AD=0.3168P
+ PS=2.47U PD=2.32U
M$2339 \$4331 \$4291 \$4330 VDD pfet_03v3 L=0.28U W=0.36U AS=0.2097P AD=0.1278P
+ PS=1.38U PD=1.07U
M$2340 \$4440 \$4332 \$4331 VDD pfet_03v3 L=0.28U W=0.36U AS=0.1278P AD=0.0567P
+ PS=1.07U PD=0.675U
M$2341 VDD \$4290 \$4440 VDD pfet_03v3 L=0.28U W=0.36U AS=0.0567P AD=0.1584P
+ PS=0.675U PD=1.6U
M$2342 \$4330 \$62 VDD VDD pfet_03v3 L=0.28U W=0.72U AS=0.3168P AD=0.2097P
+ PS=2.32U PD=1.38U
M$2343 VDD \$4331 \$4332 VDD pfet_03v3 L=0.28U W=0.36U AS=0.1584P AD=0.1764P
+ PS=1.6U PD=1.26U
M$2344 \$4333 \$4331 VDD VDD pfet_03v3 L=0.28U W=0.72U AS=0.1764P AD=0.36P
+ PS=1.26U PD=2.44U
M$2345 \$4334 RB2 VDD VDD pfet_03v3 L=0.28U W=0.72U AS=0.3312P AD=0.3888P
+ PS=2.36U PD=2.52U
M$2346 \$4333 \$4334 \$390 VDD pfet_03v3 L=0.28U W=0.36U AS=0.1584P AD=0.1152P
+ PS=1.6U PD=1U
M$2347 \$391 \$4335 \$4333 VDD pfet_03v3 L=0.28U W=0.36U AS=0.1152P AD=0.1584P
+ PS=1U PD=1.6U
M$2348 VDD RA2 \$4335 VDD pfet_03v3 L=0.28U W=0.72U AS=0.3708P AD=0.3168P
+ PS=2.47U PD=2.32U
M$2349 \$4337 \$4291 \$4336 VDD pfet_03v3 L=0.28U W=0.36U AS=0.2097P AD=0.1278P
+ PS=1.38U PD=1.07U
M$2350 \$4449 \$4338 \$4337 VDD pfet_03v3 L=0.28U W=0.36U AS=0.1278P AD=0.0567P
+ PS=1.07U PD=0.675U
M$2351 VDD \$4290 \$4449 VDD pfet_03v3 L=0.28U W=0.36U AS=0.0567P AD=0.1584P
+ PS=0.675U PD=1.6U
M$2352 \$4336 \$65 VDD VDD pfet_03v3 L=0.28U W=0.72U AS=0.3168P AD=0.2097P
+ PS=2.32U PD=1.38U
M$2353 VDD \$4337 \$4338 VDD pfet_03v3 L=0.28U W=0.36U AS=0.1584P AD=0.1764P
+ PS=1.6U PD=1.26U
M$2354 \$4339 \$4337 VDD VDD pfet_03v3 L=0.28U W=0.72U AS=0.1764P AD=0.36P
+ PS=1.26U PD=2.44U
M$2355 \$4340 RB2 VDD VDD pfet_03v3 L=0.28U W=0.72U AS=0.3312P AD=0.3888P
+ PS=2.36U PD=2.52U
M$2356 \$4339 \$4340 \$395 VDD pfet_03v3 L=0.28U W=0.36U AS=0.1584P AD=0.1152P
+ PS=1.6U PD=1U
M$2357 \$396 \$4341 \$4339 VDD pfet_03v3 L=0.28U W=0.36U AS=0.1152P AD=0.1584P
+ PS=1U PD=1.6U
M$2358 VDD RA2 \$4341 VDD pfet_03v3 L=0.28U W=0.72U AS=0.3708P AD=0.3168P
+ PS=2.47U PD=2.32U
M$2359 \$4343 \$4291 \$4342 VDD pfet_03v3 L=0.28U W=0.36U AS=0.2097P AD=0.1278P
+ PS=1.38U PD=1.07U
M$2360 \$4455 \$4344 \$4343 VDD pfet_03v3 L=0.28U W=0.36U AS=0.1278P AD=0.0567P
+ PS=1.07U PD=0.675U
M$2361 VDD \$4290 \$4455 VDD pfet_03v3 L=0.28U W=0.36U AS=0.0567P AD=0.1584P
+ PS=0.675U PD=1.6U
M$2362 \$4342 \$68 VDD VDD pfet_03v3 L=0.28U W=0.72U AS=0.3168P AD=0.2097P
+ PS=2.32U PD=1.38U
M$2363 VDD \$4343 \$4344 VDD pfet_03v3 L=0.28U W=0.36U AS=0.1584P AD=0.1764P
+ PS=1.6U PD=1.26U
M$2364 \$4345 \$4343 VDD VDD pfet_03v3 L=0.28U W=0.72U AS=0.1764P AD=0.36P
+ PS=1.26U PD=2.44U
M$2365 \$4346 RB2 VDD VDD pfet_03v3 L=0.28U W=0.72U AS=0.3312P AD=0.3888P
+ PS=2.36U PD=2.52U
M$2366 \$4345 \$4346 \$400 VDD pfet_03v3 L=0.28U W=0.36U AS=0.1584P AD=0.1152P
+ PS=1.6U PD=1U
M$2367 \$401 \$4347 \$4345 VDD pfet_03v3 L=0.28U W=0.36U AS=0.1152P AD=0.1584P
+ PS=1U PD=1.6U
M$2368 VDD RA2 \$4347 VDD pfet_03v3 L=0.28U W=0.72U AS=0.3708P AD=0.3168P
+ PS=2.47U PD=2.32U
M$2369 \$4349 \$4291 \$4348 VDD pfet_03v3 L=0.28U W=0.36U AS=0.2097P AD=0.1278P
+ PS=1.38U PD=1.07U
M$2370 \$4462 \$4350 \$4349 VDD pfet_03v3 L=0.28U W=0.36U AS=0.1278P AD=0.0567P
+ PS=1.07U PD=0.675U
M$2371 VDD \$4290 \$4462 VDD pfet_03v3 L=0.28U W=0.36U AS=0.0567P AD=0.1584P
+ PS=0.675U PD=1.6U
M$2372 \$4348 \$71 VDD VDD pfet_03v3 L=0.28U W=0.72U AS=0.3168P AD=0.2097P
+ PS=2.32U PD=1.38U
M$2373 VDD \$4349 \$4350 VDD pfet_03v3 L=0.28U W=0.36U AS=0.1584P AD=0.1764P
+ PS=1.6U PD=1.26U
M$2374 \$4351 \$4349 VDD VDD pfet_03v3 L=0.28U W=0.72U AS=0.1764P AD=0.36P
+ PS=1.26U PD=2.44U
M$2375 \$4352 RB2 VDD VDD pfet_03v3 L=0.28U W=0.72U AS=0.3312P AD=0.3888P
+ PS=2.36U PD=2.52U
M$2376 \$4351 \$4352 \$405 VDD pfet_03v3 L=0.28U W=0.36U AS=0.1584P AD=0.1152P
+ PS=1.6U PD=1U
M$2377 \$406 \$4353 \$4351 VDD pfet_03v3 L=0.28U W=0.36U AS=0.1152P AD=0.1584P
+ PS=1U PD=1.6U
M$2378 VDD RA2 \$4353 VDD pfet_03v3 L=0.28U W=0.72U AS=0.3708P AD=0.3168P
+ PS=2.47U PD=2.32U
M$2379 \$4355 \$4291 \$4354 VDD pfet_03v3 L=0.28U W=0.36U AS=0.2097P AD=0.1278P
+ PS=1.38U PD=1.07U
M$2380 \$4470 \$4356 \$4355 VDD pfet_03v3 L=0.28U W=0.36U AS=0.1278P AD=0.0567P
+ PS=1.07U PD=0.675U
M$2381 VDD \$4290 \$4470 VDD pfet_03v3 L=0.28U W=0.36U AS=0.0567P AD=0.1584P
+ PS=0.675U PD=1.6U
M$2382 \$4354 \$74 VDD VDD pfet_03v3 L=0.28U W=0.72U AS=0.3168P AD=0.2097P
+ PS=2.32U PD=1.38U
M$2383 VDD \$4355 \$4356 VDD pfet_03v3 L=0.28U W=0.36U AS=0.1584P AD=0.1764P
+ PS=1.6U PD=1.26U
M$2384 \$4357 \$4355 VDD VDD pfet_03v3 L=0.28U W=0.72U AS=0.1764P AD=0.36P
+ PS=1.26U PD=2.44U
M$2385 \$4358 RB2 VDD VDD pfet_03v3 L=0.28U W=0.72U AS=0.3312P AD=0.3888P
+ PS=2.36U PD=2.52U
M$2386 \$4357 \$4358 \$410 VDD pfet_03v3 L=0.28U W=0.36U AS=0.1584P AD=0.1152P
+ PS=1.6U PD=1U
M$2387 \$411 \$4359 \$4357 VDD pfet_03v3 L=0.28U W=0.36U AS=0.1152P AD=0.1584P
+ PS=1U PD=1.6U
M$2388 VDD RA2 \$4359 VDD pfet_03v3 L=0.28U W=0.72U AS=0.3708P AD=0.3168P
+ PS=2.47U PD=2.32U
M$2389 \$4361 \$4291 \$4360 VDD pfet_03v3 L=0.28U W=0.36U AS=0.2097P AD=0.1278P
+ PS=1.38U PD=1.07U
M$2390 \$4478 \$4362 \$4361 VDD pfet_03v3 L=0.28U W=0.36U AS=0.1278P AD=0.0567P
+ PS=1.07U PD=0.675U
M$2391 VDD \$4290 \$4478 VDD pfet_03v3 L=0.28U W=0.36U AS=0.0567P AD=0.1584P
+ PS=0.675U PD=1.6U
M$2392 \$4360 \$77 VDD VDD pfet_03v3 L=0.28U W=0.72U AS=0.3168P AD=0.2097P
+ PS=2.32U PD=1.38U
M$2393 VDD \$4361 \$4362 VDD pfet_03v3 L=0.28U W=0.36U AS=0.1584P AD=0.1764P
+ PS=1.6U PD=1.26U
M$2394 \$4363 \$4361 VDD VDD pfet_03v3 L=0.28U W=0.72U AS=0.1764P AD=0.36P
+ PS=1.26U PD=2.44U
M$2395 \$4364 RB2 VDD VDD pfet_03v3 L=0.28U W=0.72U AS=0.3312P AD=0.3888P
+ PS=2.36U PD=2.52U
M$2396 \$4363 \$4364 \$415 VDD pfet_03v3 L=0.28U W=0.36U AS=0.1584P AD=0.1152P
+ PS=1.6U PD=1U
M$2397 \$416 \$4365 \$4363 VDD pfet_03v3 L=0.28U W=0.36U AS=0.1152P AD=0.1584P
+ PS=1U PD=1.6U
M$2398 VDD RA2 \$4365 VDD pfet_03v3 L=0.28U W=0.72U AS=0.3708P AD=0.3168P
+ PS=2.47U PD=2.32U
M$2399 \$4367 \$4291 \$4366 VDD pfet_03v3 L=0.28U W=0.36U AS=0.2097P AD=0.1278P
+ PS=1.38U PD=1.07U
M$2400 \$4485 \$4368 \$4367 VDD pfet_03v3 L=0.28U W=0.36U AS=0.1278P AD=0.0567P
+ PS=1.07U PD=0.675U
M$2401 VDD \$4290 \$4485 VDD pfet_03v3 L=0.28U W=0.36U AS=0.0567P AD=0.1584P
+ PS=0.675U PD=1.6U
M$2402 \$4366 \$80 VDD VDD pfet_03v3 L=0.28U W=0.72U AS=0.3168P AD=0.2097P
+ PS=2.32U PD=1.38U
M$2403 VDD \$4367 \$4368 VDD pfet_03v3 L=0.28U W=0.36U AS=0.1584P AD=0.1764P
+ PS=1.6U PD=1.26U
M$2404 \$4369 \$4367 VDD VDD pfet_03v3 L=0.28U W=0.72U AS=0.1764P AD=0.36P
+ PS=1.26U PD=2.44U
M$2405 \$4370 RB2 VDD VDD pfet_03v3 L=0.28U W=0.72U AS=0.3312P AD=0.3888P
+ PS=2.36U PD=2.52U
M$2406 \$4369 \$4370 \$420 VDD pfet_03v3 L=0.28U W=0.36U AS=0.1584P AD=0.1152P
+ PS=1.6U PD=1U
M$2407 \$421 \$4371 \$4369 VDD pfet_03v3 L=0.28U W=0.36U AS=0.1152P AD=0.1584P
+ PS=1U PD=1.6U
M$2408 VDD RA2 \$4371 VDD pfet_03v3 L=0.28U W=0.72U AS=0.3708P AD=0.3168P
+ PS=2.47U PD=2.32U
M$2409 \$4373 \$4291 \$4372 VDD pfet_03v3 L=0.28U W=0.36U AS=0.2097P AD=0.1278P
+ PS=1.38U PD=1.07U
M$2410 \$4484 \$4374 \$4373 VDD pfet_03v3 L=0.28U W=0.36U AS=0.1278P AD=0.0567P
+ PS=1.07U PD=0.675U
M$2411 VDD \$4290 \$4484 VDD pfet_03v3 L=0.28U W=0.36U AS=0.0567P AD=0.1584P
+ PS=0.675U PD=1.6U
M$2412 \$4372 \$83 VDD VDD pfet_03v3 L=0.28U W=0.72U AS=0.3168P AD=0.2097P
+ PS=2.32U PD=1.38U
M$2413 VDD \$4373 \$4374 VDD pfet_03v3 L=0.28U W=0.36U AS=0.1584P AD=0.1764P
+ PS=1.6U PD=1.26U
M$2414 \$4375 \$4373 VDD VDD pfet_03v3 L=0.28U W=0.72U AS=0.1764P AD=0.36P
+ PS=1.26U PD=2.44U
M$2415 \$4376 RB2 VDD VDD pfet_03v3 L=0.28U W=0.72U AS=0.3312P AD=0.3888P
+ PS=2.36U PD=2.52U
M$2416 \$4375 \$4376 \$425 VDD pfet_03v3 L=0.28U W=0.36U AS=0.1584P AD=0.1152P
+ PS=1.6U PD=1U
M$2417 \$426 \$4377 \$4375 VDD pfet_03v3 L=0.28U W=0.36U AS=0.1152P AD=0.1584P
+ PS=1U PD=1.6U
M$2418 VDD RA2 \$4377 VDD pfet_03v3 L=0.28U W=0.72U AS=0.3708P AD=0.3168P
+ PS=2.47U PD=2.32U
M$2419 \$4379 \$4291 \$4378 VDD pfet_03v3 L=0.28U W=0.36U AS=0.2097P AD=0.1278P
+ PS=1.38U PD=1.07U
M$2420 \$4452 \$4380 \$4379 VDD pfet_03v3 L=0.28U W=0.36U AS=0.1278P AD=0.0567P
+ PS=1.07U PD=0.675U
M$2421 VDD \$4290 \$4452 VDD pfet_03v3 L=0.28U W=0.36U AS=0.0567P AD=0.1584P
+ PS=0.675U PD=1.6U
M$2422 \$4378 \$86 VDD VDD pfet_03v3 L=0.28U W=0.72U AS=0.3168P AD=0.2097P
+ PS=2.32U PD=1.38U
M$2423 VDD \$4379 \$4380 VDD pfet_03v3 L=0.28U W=0.36U AS=0.1584P AD=0.1764P
+ PS=1.6U PD=1.26U
M$2424 \$4381 \$4379 VDD VDD pfet_03v3 L=0.28U W=0.72U AS=0.1764P AD=0.36P
+ PS=1.26U PD=2.44U
M$2425 \$4382 RB2 VDD VDD pfet_03v3 L=0.28U W=0.72U AS=0.3312P AD=0.3888P
+ PS=2.36U PD=2.52U
M$2426 \$4381 \$4382 \$430 VDD pfet_03v3 L=0.28U W=0.36U AS=0.1584P AD=0.1152P
+ PS=1.6U PD=1U
M$2427 \$431 \$4383 \$4381 VDD pfet_03v3 L=0.28U W=0.36U AS=0.1152P AD=0.1584P
+ PS=1U PD=1.6U
M$2428 VDD RA2 \$4383 VDD pfet_03v3 L=0.28U W=0.72U AS=0.3708P AD=0.3168P
+ PS=2.47U PD=2.32U
M$2429 \$4385 \$4291 \$4384 VDD pfet_03v3 L=0.28U W=0.36U AS=0.2097P AD=0.1278P
+ PS=1.38U PD=1.07U
M$2430 \$4419 \$4386 \$4385 VDD pfet_03v3 L=0.28U W=0.36U AS=0.1278P AD=0.0567P
+ PS=1.07U PD=0.675U
M$2431 VDD \$4290 \$4419 VDD pfet_03v3 L=0.28U W=0.36U AS=0.0567P AD=0.1584P
+ PS=0.675U PD=1.6U
M$2432 \$4384 \$89 VDD VDD pfet_03v3 L=0.28U W=0.72U AS=0.3168P AD=0.2097P
+ PS=2.32U PD=1.38U
M$2433 VDD \$4385 \$4386 VDD pfet_03v3 L=0.28U W=0.36U AS=0.1584P AD=0.1764P
+ PS=1.6U PD=1.26U
M$2434 \$4387 \$4385 VDD VDD pfet_03v3 L=0.28U W=0.72U AS=0.1764P AD=0.36P
+ PS=1.26U PD=2.44U
M$2435 \$4388 RB2 VDD VDD pfet_03v3 L=0.28U W=0.72U AS=0.3312P AD=0.3888P
+ PS=2.36U PD=2.52U
M$2436 \$4387 \$4388 \$435 VDD pfet_03v3 L=0.28U W=0.36U AS=0.1584P AD=0.1152P
+ PS=1.6U PD=1U
M$2437 \$436 \$4389 \$4387 VDD pfet_03v3 L=0.28U W=0.36U AS=0.1152P AD=0.1584P
+ PS=1U PD=1.6U
M$2438 VDD RA2 \$4389 VDD pfet_03v3 L=0.28U W=0.72U AS=0.3708P AD=0.3168P
+ PS=2.47U PD=2.32U
M$2439 \$4591 WE1 VDD VDD pfet_03v3 L=0.28U W=0.72U AS=0.3168P AD=0.1872P
+ PS=2.32U PD=1.24U
M$2440 VDD CLK \$4591 VDD pfet_03v3 L=0.28U W=0.72U AS=0.1872P AD=0.3168P
+ PS=1.24U PD=2.32U
M$2441 \$4592 \$4591 VDD VDD pfet_03v3 L=0.28U W=2.54U AS=0.8974P AD=0.6604P
+ PS=5.28U PD=3.58U
M$2443 \$4593 \$4592 VDD VDD pfet_03v3 L=0.28U W=2.68U AS=0.7272P AD=0.9782P
+ PS=3.78U PD=5.48U
M$2445 \$4594 \$44 VDD VDD pfet_03v3 L=0.28U W=0.72U AS=0.3168P AD=0.2097P
+ PS=2.32U PD=1.38U
M$2446 \$4595 \$4593 \$4594 VDD pfet_03v3 L=0.28U W=0.36U AS=0.2097P AD=0.1278P
+ PS=1.38U PD=1.07U
M$2447 \$4807 \$4596 \$4595 VDD pfet_03v3 L=0.28U W=0.36U AS=0.1278P AD=0.0567P
+ PS=1.07U PD=0.675U
M$2448 VDD \$4592 \$4807 VDD pfet_03v3 L=0.28U W=0.36U AS=0.0567P AD=0.1584P
+ PS=0.675U PD=1.6U
M$2449 \$4596 \$4595 VDD VDD pfet_03v3 L=0.28U W=0.36U AS=0.1764P AD=0.1584P
+ PS=1.26U PD=1.6U
M$2450 \$4597 \$4595 VDD VDD pfet_03v3 L=0.28U W=0.72U AS=0.1764P AD=0.36P
+ PS=1.26U PD=2.44U
M$2451 \$4714 RA1 VDD VDD pfet_03v3 L=0.28U W=0.72U AS=0.3312P AD=0.3888P
+ PS=2.36U PD=2.52U
M$2452 \$4597 \$4714 \$360 VDD pfet_03v3 L=0.28U W=0.36U AS=0.1584P AD=0.1152P
+ PS=1.6U PD=1U
M$2453 \$361 \$4715 \$4597 VDD pfet_03v3 L=0.28U W=0.36U AS=0.1152P AD=0.1584P
+ PS=1U PD=1.6U
M$2454 VDD RB1 \$4715 VDD pfet_03v3 L=0.28U W=0.72U AS=0.3708P AD=0.3168P
+ PS=2.47U PD=2.32U
M$2455 \$4598 \$47 VDD VDD pfet_03v3 L=0.28U W=0.72U AS=0.3168P AD=0.2097P
+ PS=2.32U PD=1.38U
M$2456 \$4599 \$4593 \$4598 VDD pfet_03v3 L=0.28U W=0.36U AS=0.2097P AD=0.1278P
+ PS=1.38U PD=1.07U
M$2457 \$4817 \$4600 \$4599 VDD pfet_03v3 L=0.28U W=0.36U AS=0.1278P AD=0.0567P
+ PS=1.07U PD=0.675U
M$2458 VDD \$4592 \$4817 VDD pfet_03v3 L=0.28U W=0.36U AS=0.0567P AD=0.1584P
+ PS=0.675U PD=1.6U
M$2459 \$4600 \$4599 VDD VDD pfet_03v3 L=0.28U W=0.36U AS=0.1764P AD=0.1584P
+ PS=1.26U PD=1.6U
M$2460 \$4601 \$4599 VDD VDD pfet_03v3 L=0.28U W=0.72U AS=0.1764P AD=0.36P
+ PS=1.26U PD=2.44U
M$2461 \$4716 RA1 VDD VDD pfet_03v3 L=0.28U W=0.72U AS=0.3312P AD=0.3888P
+ PS=2.36U PD=2.52U
M$2462 \$4601 \$4716 \$365 VDD pfet_03v3 L=0.28U W=0.36U AS=0.1584P AD=0.1152P
+ PS=1.6U PD=1U
M$2463 \$366 \$4717 \$4601 VDD pfet_03v3 L=0.28U W=0.36U AS=0.1152P AD=0.1584P
+ PS=1U PD=1.6U
M$2464 VDD RB1 \$4717 VDD pfet_03v3 L=0.28U W=0.72U AS=0.3708P AD=0.3168P
+ PS=2.47U PD=2.32U
M$2465 \$4602 \$50 VDD VDD pfet_03v3 L=0.28U W=0.72U AS=0.3168P AD=0.2097P
+ PS=2.32U PD=1.38U
M$2466 \$4603 \$4593 \$4602 VDD pfet_03v3 L=0.28U W=0.36U AS=0.2097P AD=0.1278P
+ PS=1.38U PD=1.07U
M$2467 \$4823 \$4604 \$4603 VDD pfet_03v3 L=0.28U W=0.36U AS=0.1278P AD=0.0567P
+ PS=1.07U PD=0.675U
M$2468 VDD \$4592 \$4823 VDD pfet_03v3 L=0.28U W=0.36U AS=0.0567P AD=0.1584P
+ PS=0.675U PD=1.6U
M$2469 \$4604 \$4603 VDD VDD pfet_03v3 L=0.28U W=0.36U AS=0.1764P AD=0.1584P
+ PS=1.26U PD=1.6U
M$2470 \$4605 \$4603 VDD VDD pfet_03v3 L=0.28U W=0.72U AS=0.1764P AD=0.36P
+ PS=1.26U PD=2.44U
M$2471 \$4718 RA1 VDD VDD pfet_03v3 L=0.28U W=0.72U AS=0.3312P AD=0.3888P
+ PS=2.36U PD=2.52U
M$2472 \$4605 \$4718 \$370 VDD pfet_03v3 L=0.28U W=0.36U AS=0.1584P AD=0.1152P
+ PS=1.6U PD=1U
M$2473 \$371 \$4719 \$4605 VDD pfet_03v3 L=0.28U W=0.36U AS=0.1152P AD=0.1584P
+ PS=1U PD=1.6U
M$2474 VDD RB1 \$4719 VDD pfet_03v3 L=0.28U W=0.72U AS=0.3708P AD=0.3168P
+ PS=2.47U PD=2.32U
M$2475 \$4606 \$53 VDD VDD pfet_03v3 L=0.28U W=0.72U AS=0.3168P AD=0.2097P
+ PS=2.32U PD=1.38U
M$2476 \$4607 \$4593 \$4606 VDD pfet_03v3 L=0.28U W=0.36U AS=0.2097P AD=0.1278P
+ PS=1.38U PD=1.07U
M$2477 \$4832 \$4608 \$4607 VDD pfet_03v3 L=0.28U W=0.36U AS=0.1278P AD=0.0567P
+ PS=1.07U PD=0.675U
M$2478 VDD \$4592 \$4832 VDD pfet_03v3 L=0.28U W=0.36U AS=0.0567P AD=0.1584P
+ PS=0.675U PD=1.6U
M$2479 \$4608 \$4607 VDD VDD pfet_03v3 L=0.28U W=0.36U AS=0.1764P AD=0.1584P
+ PS=1.26U PD=1.6U
M$2480 \$4609 \$4607 VDD VDD pfet_03v3 L=0.28U W=0.72U AS=0.1764P AD=0.36P
+ PS=1.26U PD=2.44U
M$2481 \$4720 RA1 VDD VDD pfet_03v3 L=0.28U W=0.72U AS=0.3312P AD=0.3888P
+ PS=2.36U PD=2.52U
M$2482 \$4609 \$4720 \$375 VDD pfet_03v3 L=0.28U W=0.36U AS=0.1584P AD=0.1152P
+ PS=1.6U PD=1U
M$2483 \$376 \$4721 \$4609 VDD pfet_03v3 L=0.28U W=0.36U AS=0.1152P AD=0.1584P
+ PS=1U PD=1.6U
M$2484 VDD RB1 \$4721 VDD pfet_03v3 L=0.28U W=0.72U AS=0.3708P AD=0.3168P
+ PS=2.47U PD=2.32U
M$2485 \$4610 \$56 VDD VDD pfet_03v3 L=0.28U W=0.72U AS=0.3168P AD=0.2097P
+ PS=2.32U PD=1.38U
M$2486 \$4611 \$4593 \$4610 VDD pfet_03v3 L=0.28U W=0.36U AS=0.2097P AD=0.1278P
+ PS=1.38U PD=1.07U
M$2487 \$4842 \$4612 \$4611 VDD pfet_03v3 L=0.28U W=0.36U AS=0.1278P AD=0.0567P
+ PS=1.07U PD=0.675U
M$2488 VDD \$4592 \$4842 VDD pfet_03v3 L=0.28U W=0.36U AS=0.0567P AD=0.1584P
+ PS=0.675U PD=1.6U
M$2489 \$4612 \$4611 VDD VDD pfet_03v3 L=0.28U W=0.36U AS=0.1764P AD=0.1584P
+ PS=1.26U PD=1.6U
M$2490 \$4613 \$4611 VDD VDD pfet_03v3 L=0.28U W=0.72U AS=0.1764P AD=0.36P
+ PS=1.26U PD=2.44U
M$2491 \$4722 RA1 VDD VDD pfet_03v3 L=0.28U W=0.72U AS=0.3312P AD=0.3888P
+ PS=2.36U PD=2.52U
M$2492 \$4613 \$4722 \$380 VDD pfet_03v3 L=0.28U W=0.36U AS=0.1584P AD=0.1152P
+ PS=1.6U PD=1U
M$2493 \$381 \$4723 \$4613 VDD pfet_03v3 L=0.28U W=0.36U AS=0.1152P AD=0.1584P
+ PS=1U PD=1.6U
M$2494 VDD RB1 \$4723 VDD pfet_03v3 L=0.28U W=0.72U AS=0.3708P AD=0.3168P
+ PS=2.47U PD=2.32U
M$2495 \$4614 \$59 VDD VDD pfet_03v3 L=0.28U W=0.72U AS=0.3168P AD=0.2097P
+ PS=2.32U PD=1.38U
M$2496 \$4615 \$4593 \$4614 VDD pfet_03v3 L=0.28U W=0.36U AS=0.2097P AD=0.1278P
+ PS=1.38U PD=1.07U
M$2497 \$4851 \$4616 \$4615 VDD pfet_03v3 L=0.28U W=0.36U AS=0.1278P AD=0.0567P
+ PS=1.07U PD=0.675U
M$2498 VDD \$4592 \$4851 VDD pfet_03v3 L=0.28U W=0.36U AS=0.0567P AD=0.1584P
+ PS=0.675U PD=1.6U
M$2499 \$4616 \$4615 VDD VDD pfet_03v3 L=0.28U W=0.36U AS=0.1764P AD=0.1584P
+ PS=1.26U PD=1.6U
M$2500 \$4617 \$4615 VDD VDD pfet_03v3 L=0.28U W=0.72U AS=0.1764P AD=0.36P
+ PS=1.26U PD=2.44U
M$2501 \$4724 RA1 VDD VDD pfet_03v3 L=0.28U W=0.72U AS=0.3312P AD=0.3888P
+ PS=2.36U PD=2.52U
M$2502 \$4617 \$4724 \$385 VDD pfet_03v3 L=0.28U W=0.36U AS=0.1584P AD=0.1152P
+ PS=1.6U PD=1U
M$2503 \$386 \$4725 \$4617 VDD pfet_03v3 L=0.28U W=0.36U AS=0.1152P AD=0.1584P
+ PS=1U PD=1.6U
M$2504 VDD RB1 \$4725 VDD pfet_03v3 L=0.28U W=0.72U AS=0.3708P AD=0.3168P
+ PS=2.47U PD=2.32U
M$2505 \$4618 \$62 VDD VDD pfet_03v3 L=0.28U W=0.72U AS=0.3168P AD=0.2097P
+ PS=2.32U PD=1.38U
M$2506 \$4619 \$4593 \$4618 VDD pfet_03v3 L=0.28U W=0.36U AS=0.2097P AD=0.1278P
+ PS=1.38U PD=1.07U
M$2507 \$4859 \$4620 \$4619 VDD pfet_03v3 L=0.28U W=0.36U AS=0.1278P AD=0.0567P
+ PS=1.07U PD=0.675U
M$2508 VDD \$4592 \$4859 VDD pfet_03v3 L=0.28U W=0.36U AS=0.0567P AD=0.1584P
+ PS=0.675U PD=1.6U
M$2509 \$4620 \$4619 VDD VDD pfet_03v3 L=0.28U W=0.36U AS=0.1764P AD=0.1584P
+ PS=1.26U PD=1.6U
M$2510 \$4621 \$4619 VDD VDD pfet_03v3 L=0.28U W=0.72U AS=0.1764P AD=0.36P
+ PS=1.26U PD=2.44U
M$2511 \$4726 RA1 VDD VDD pfet_03v3 L=0.28U W=0.72U AS=0.3312P AD=0.3888P
+ PS=2.36U PD=2.52U
M$2512 \$4621 \$4726 \$390 VDD pfet_03v3 L=0.28U W=0.36U AS=0.1584P AD=0.1152P
+ PS=1.6U PD=1U
M$2513 \$391 \$4727 \$4621 VDD pfet_03v3 L=0.28U W=0.36U AS=0.1152P AD=0.1584P
+ PS=1U PD=1.6U
M$2514 VDD RB1 \$4727 VDD pfet_03v3 L=0.28U W=0.72U AS=0.3708P AD=0.3168P
+ PS=2.47U PD=2.32U
M$2515 \$4622 \$65 VDD VDD pfet_03v3 L=0.28U W=0.72U AS=0.3168P AD=0.2097P
+ PS=2.32U PD=1.38U
M$2516 \$4623 \$4593 \$4622 VDD pfet_03v3 L=0.28U W=0.36U AS=0.2097P AD=0.1278P
+ PS=1.38U PD=1.07U
M$2517 \$4868 \$4624 \$4623 VDD pfet_03v3 L=0.28U W=0.36U AS=0.1278P AD=0.0567P
+ PS=1.07U PD=0.675U
M$2518 VDD \$4592 \$4868 VDD pfet_03v3 L=0.28U W=0.36U AS=0.0567P AD=0.1584P
+ PS=0.675U PD=1.6U
M$2519 \$4624 \$4623 VDD VDD pfet_03v3 L=0.28U W=0.36U AS=0.1764P AD=0.1584P
+ PS=1.26U PD=1.6U
M$2520 \$4625 \$4623 VDD VDD pfet_03v3 L=0.28U W=0.72U AS=0.1764P AD=0.36P
+ PS=1.26U PD=2.44U
M$2521 \$4728 RA1 VDD VDD pfet_03v3 L=0.28U W=0.72U AS=0.3312P AD=0.3888P
+ PS=2.36U PD=2.52U
M$2522 \$4625 \$4728 \$395 VDD pfet_03v3 L=0.28U W=0.36U AS=0.1584P AD=0.1152P
+ PS=1.6U PD=1U
M$2523 \$396 \$4729 \$4625 VDD pfet_03v3 L=0.28U W=0.36U AS=0.1152P AD=0.1584P
+ PS=1U PD=1.6U
M$2524 VDD RB1 \$4729 VDD pfet_03v3 L=0.28U W=0.72U AS=0.3708P AD=0.3168P
+ PS=2.47U PD=2.32U
M$2525 \$4626 \$68 VDD VDD pfet_03v3 L=0.28U W=0.72U AS=0.3168P AD=0.2097P
+ PS=2.32U PD=1.38U
M$2526 \$4627 \$4593 \$4626 VDD pfet_03v3 L=0.28U W=0.36U AS=0.2097P AD=0.1278P
+ PS=1.38U PD=1.07U
M$2527 \$4877 \$4628 \$4627 VDD pfet_03v3 L=0.28U W=0.36U AS=0.1278P AD=0.0567P
+ PS=1.07U PD=0.675U
M$2528 VDD \$4592 \$4877 VDD pfet_03v3 L=0.28U W=0.36U AS=0.0567P AD=0.1584P
+ PS=0.675U PD=1.6U
M$2529 \$4628 \$4627 VDD VDD pfet_03v3 L=0.28U W=0.36U AS=0.1764P AD=0.1584P
+ PS=1.26U PD=1.6U
M$2530 \$4629 \$4627 VDD VDD pfet_03v3 L=0.28U W=0.72U AS=0.1764P AD=0.36P
+ PS=1.26U PD=2.44U
M$2531 \$4730 RA1 VDD VDD pfet_03v3 L=0.28U W=0.72U AS=0.3312P AD=0.3888P
+ PS=2.36U PD=2.52U
M$2532 \$4629 \$4730 \$400 VDD pfet_03v3 L=0.28U W=0.36U AS=0.1584P AD=0.1152P
+ PS=1.6U PD=1U
M$2533 \$401 \$4731 \$4629 VDD pfet_03v3 L=0.28U W=0.36U AS=0.1152P AD=0.1584P
+ PS=1U PD=1.6U
M$2534 VDD RB1 \$4731 VDD pfet_03v3 L=0.28U W=0.72U AS=0.3708P AD=0.3168P
+ PS=2.47U PD=2.32U
M$2535 \$4630 \$71 VDD VDD pfet_03v3 L=0.28U W=0.72U AS=0.3168P AD=0.2097P
+ PS=2.32U PD=1.38U
M$2536 \$4631 \$4593 \$4630 VDD pfet_03v3 L=0.28U W=0.36U AS=0.2097P AD=0.1278P
+ PS=1.38U PD=1.07U
M$2537 \$4886 \$4632 \$4631 VDD pfet_03v3 L=0.28U W=0.36U AS=0.1278P AD=0.0567P
+ PS=1.07U PD=0.675U
M$2538 VDD \$4592 \$4886 VDD pfet_03v3 L=0.28U W=0.36U AS=0.0567P AD=0.1584P
+ PS=0.675U PD=1.6U
M$2539 \$4632 \$4631 VDD VDD pfet_03v3 L=0.28U W=0.36U AS=0.1764P AD=0.1584P
+ PS=1.26U PD=1.6U
M$2540 \$4633 \$4631 VDD VDD pfet_03v3 L=0.28U W=0.72U AS=0.1764P AD=0.36P
+ PS=1.26U PD=2.44U
M$2541 \$4732 RA1 VDD VDD pfet_03v3 L=0.28U W=0.72U AS=0.3312P AD=0.3888P
+ PS=2.36U PD=2.52U
M$2542 \$4633 \$4732 \$405 VDD pfet_03v3 L=0.28U W=0.36U AS=0.1584P AD=0.1152P
+ PS=1.6U PD=1U
M$2543 \$406 \$4733 \$4633 VDD pfet_03v3 L=0.28U W=0.36U AS=0.1152P AD=0.1584P
+ PS=1U PD=1.6U
M$2544 VDD RB1 \$4733 VDD pfet_03v3 L=0.28U W=0.72U AS=0.3708P AD=0.3168P
+ PS=2.47U PD=2.32U
M$2545 \$4634 \$74 VDD VDD pfet_03v3 L=0.28U W=0.72U AS=0.3168P AD=0.2097P
+ PS=2.32U PD=1.38U
M$2546 \$4635 \$4593 \$4634 VDD pfet_03v3 L=0.28U W=0.36U AS=0.2097P AD=0.1278P
+ PS=1.38U PD=1.07U
M$2547 \$4895 \$4636 \$4635 VDD pfet_03v3 L=0.28U W=0.36U AS=0.1278P AD=0.0567P
+ PS=1.07U PD=0.675U
M$2548 VDD \$4592 \$4895 VDD pfet_03v3 L=0.28U W=0.36U AS=0.0567P AD=0.1584P
+ PS=0.675U PD=1.6U
M$2549 \$4636 \$4635 VDD VDD pfet_03v3 L=0.28U W=0.36U AS=0.1764P AD=0.1584P
+ PS=1.26U PD=1.6U
M$2550 \$4637 \$4635 VDD VDD pfet_03v3 L=0.28U W=0.72U AS=0.1764P AD=0.36P
+ PS=1.26U PD=2.44U
M$2551 \$4734 RA1 VDD VDD pfet_03v3 L=0.28U W=0.72U AS=0.3312P AD=0.3888P
+ PS=2.36U PD=2.52U
M$2552 \$4637 \$4734 \$410 VDD pfet_03v3 L=0.28U W=0.36U AS=0.1584P AD=0.1152P
+ PS=1.6U PD=1U
M$2553 \$411 \$4735 \$4637 VDD pfet_03v3 L=0.28U W=0.36U AS=0.1152P AD=0.1584P
+ PS=1U PD=1.6U
M$2554 VDD RB1 \$4735 VDD pfet_03v3 L=0.28U W=0.72U AS=0.3708P AD=0.3168P
+ PS=2.47U PD=2.32U
M$2555 \$4638 \$77 VDD VDD pfet_03v3 L=0.28U W=0.72U AS=0.3168P AD=0.2097P
+ PS=2.32U PD=1.38U
M$2556 \$4639 \$4593 \$4638 VDD pfet_03v3 L=0.28U W=0.36U AS=0.2097P AD=0.1278P
+ PS=1.38U PD=1.07U
M$2557 \$4903 \$4640 \$4639 VDD pfet_03v3 L=0.28U W=0.36U AS=0.1278P AD=0.0567P
+ PS=1.07U PD=0.675U
M$2558 VDD \$4592 \$4903 VDD pfet_03v3 L=0.28U W=0.36U AS=0.0567P AD=0.1584P
+ PS=0.675U PD=1.6U
M$2559 \$4640 \$4639 VDD VDD pfet_03v3 L=0.28U W=0.36U AS=0.1764P AD=0.1584P
+ PS=1.26U PD=1.6U
M$2560 \$4641 \$4639 VDD VDD pfet_03v3 L=0.28U W=0.72U AS=0.1764P AD=0.36P
+ PS=1.26U PD=2.44U
M$2561 \$4736 RA1 VDD VDD pfet_03v3 L=0.28U W=0.72U AS=0.3312P AD=0.3888P
+ PS=2.36U PD=2.52U
M$2562 \$4641 \$4736 \$415 VDD pfet_03v3 L=0.28U W=0.36U AS=0.1584P AD=0.1152P
+ PS=1.6U PD=1U
M$2563 \$416 \$4737 \$4641 VDD pfet_03v3 L=0.28U W=0.36U AS=0.1152P AD=0.1584P
+ PS=1U PD=1.6U
M$2564 VDD RB1 \$4737 VDD pfet_03v3 L=0.28U W=0.72U AS=0.3708P AD=0.3168P
+ PS=2.47U PD=2.32U
M$2565 \$4642 \$80 VDD VDD pfet_03v3 L=0.28U W=0.72U AS=0.3168P AD=0.2097P
+ PS=2.32U PD=1.38U
M$2566 \$4643 \$4593 \$4642 VDD pfet_03v3 L=0.28U W=0.36U AS=0.2097P AD=0.1278P
+ PS=1.38U PD=1.07U
M$2567 \$4889 \$4644 \$4643 VDD pfet_03v3 L=0.28U W=0.36U AS=0.1278P AD=0.0567P
+ PS=1.07U PD=0.675U
M$2568 VDD \$4592 \$4889 VDD pfet_03v3 L=0.28U W=0.36U AS=0.0567P AD=0.1584P
+ PS=0.675U PD=1.6U
M$2569 \$4644 \$4643 VDD VDD pfet_03v3 L=0.28U W=0.36U AS=0.1764P AD=0.1584P
+ PS=1.26U PD=1.6U
M$2570 \$4645 \$4643 VDD VDD pfet_03v3 L=0.28U W=0.72U AS=0.1764P AD=0.36P
+ PS=1.26U PD=2.44U
M$2571 \$4738 RA1 VDD VDD pfet_03v3 L=0.28U W=0.72U AS=0.3312P AD=0.3888P
+ PS=2.36U PD=2.52U
M$2572 \$4645 \$4738 \$420 VDD pfet_03v3 L=0.28U W=0.36U AS=0.1584P AD=0.1152P
+ PS=1.6U PD=1U
M$2573 \$421 \$4739 \$4645 VDD pfet_03v3 L=0.28U W=0.36U AS=0.1152P AD=0.1584P
+ PS=1U PD=1.6U
M$2574 VDD RB1 \$4739 VDD pfet_03v3 L=0.28U W=0.72U AS=0.3708P AD=0.3168P
+ PS=2.47U PD=2.32U
M$2575 \$4646 \$83 VDD VDD pfet_03v3 L=0.28U W=0.72U AS=0.3168P AD=0.2097P
+ PS=2.32U PD=1.38U
M$2576 \$4647 \$4593 \$4646 VDD pfet_03v3 L=0.28U W=0.36U AS=0.2097P AD=0.1278P
+ PS=1.38U PD=1.07U
M$2577 \$4861 \$4648 \$4647 VDD pfet_03v3 L=0.28U W=0.36U AS=0.1278P AD=0.0567P
+ PS=1.07U PD=0.675U
M$2578 VDD \$4592 \$4861 VDD pfet_03v3 L=0.28U W=0.36U AS=0.0567P AD=0.1584P
+ PS=0.675U PD=1.6U
M$2579 \$4648 \$4647 VDD VDD pfet_03v3 L=0.28U W=0.36U AS=0.1764P AD=0.1584P
+ PS=1.26U PD=1.6U
M$2580 \$4649 \$4647 VDD VDD pfet_03v3 L=0.28U W=0.72U AS=0.1764P AD=0.36P
+ PS=1.26U PD=2.44U
M$2581 \$4740 RA1 VDD VDD pfet_03v3 L=0.28U W=0.72U AS=0.3312P AD=0.3888P
+ PS=2.36U PD=2.52U
M$2582 \$4649 \$4740 \$425 VDD pfet_03v3 L=0.28U W=0.36U AS=0.1584P AD=0.1152P
+ PS=1.6U PD=1U
M$2583 \$426 \$4741 \$4649 VDD pfet_03v3 L=0.28U W=0.36U AS=0.1152P AD=0.1584P
+ PS=1U PD=1.6U
M$2584 VDD RB1 \$4741 VDD pfet_03v3 L=0.28U W=0.72U AS=0.3708P AD=0.3168P
+ PS=2.47U PD=2.32U
M$2585 \$4650 \$86 VDD VDD pfet_03v3 L=0.28U W=0.72U AS=0.3168P AD=0.2097P
+ PS=2.32U PD=1.38U
M$2586 \$4651 \$4593 \$4650 VDD pfet_03v3 L=0.28U W=0.36U AS=0.2097P AD=0.1278P
+ PS=1.38U PD=1.07U
M$2587 \$4843 \$4652 \$4651 VDD pfet_03v3 L=0.28U W=0.36U AS=0.1278P AD=0.0567P
+ PS=1.07U PD=0.675U
M$2588 VDD \$4592 \$4843 VDD pfet_03v3 L=0.28U W=0.36U AS=0.0567P AD=0.1584P
+ PS=0.675U PD=1.6U
M$2589 \$4652 \$4651 VDD VDD pfet_03v3 L=0.28U W=0.36U AS=0.1764P AD=0.1584P
+ PS=1.26U PD=1.6U
M$2590 \$4653 \$4651 VDD VDD pfet_03v3 L=0.28U W=0.72U AS=0.1764P AD=0.36P
+ PS=1.26U PD=2.44U
M$2591 \$4742 RA1 VDD VDD pfet_03v3 L=0.28U W=0.72U AS=0.3312P AD=0.3888P
+ PS=2.36U PD=2.52U
M$2592 \$4653 \$4742 \$430 VDD pfet_03v3 L=0.28U W=0.36U AS=0.1584P AD=0.1152P
+ PS=1.6U PD=1U
M$2593 \$431 \$4743 \$4653 VDD pfet_03v3 L=0.28U W=0.36U AS=0.1152P AD=0.1584P
+ PS=1U PD=1.6U
M$2594 VDD RB1 \$4743 VDD pfet_03v3 L=0.28U W=0.72U AS=0.3708P AD=0.3168P
+ PS=2.47U PD=2.32U
M$2595 \$4654 \$89 VDD VDD pfet_03v3 L=0.28U W=0.72U AS=0.3168P AD=0.2097P
+ PS=2.32U PD=1.38U
M$2596 \$4655 \$4593 \$4654 VDD pfet_03v3 L=0.28U W=0.36U AS=0.2097P AD=0.1278P
+ PS=1.38U PD=1.07U
M$2597 \$4815 \$4656 \$4655 VDD pfet_03v3 L=0.28U W=0.36U AS=0.1278P AD=0.0567P
+ PS=1.07U PD=0.675U
M$2598 VDD \$4592 \$4815 VDD pfet_03v3 L=0.28U W=0.36U AS=0.0567P AD=0.1584P
+ PS=0.675U PD=1.6U
M$2599 \$4656 \$4655 VDD VDD pfet_03v3 L=0.28U W=0.36U AS=0.1764P AD=0.1584P
+ PS=1.26U PD=1.6U
M$2600 \$4657 \$4655 VDD VDD pfet_03v3 L=0.28U W=0.72U AS=0.1764P AD=0.36P
+ PS=1.26U PD=2.44U
M$2601 \$4744 RA1 VDD VDD pfet_03v3 L=0.28U W=0.72U AS=0.3312P AD=0.3888P
+ PS=2.36U PD=2.52U
M$2602 \$4657 \$4744 \$435 VDD pfet_03v3 L=0.28U W=0.36U AS=0.1584P AD=0.1152P
+ PS=1.6U PD=1U
M$2603 \$436 \$4745 \$4657 VDD pfet_03v3 L=0.28U W=0.36U AS=0.1152P AD=0.1584P
+ PS=1U PD=1.6U
M$2604 VDD RB1 \$4745 VDD pfet_03v3 L=0.28U W=0.72U AS=0.3708P AD=0.3168P
+ PS=2.47U PD=2.32U
M$2605 \$4907 WE0 VDD VDD pfet_03v3 L=0.28U W=0.72U AS=0.3168P AD=0.1872P
+ PS=2.32U PD=1.24U
M$2606 VDD CLK \$4907 VDD pfet_03v3 L=0.28U W=0.72U AS=0.1872P AD=0.3168P
+ PS=1.24U PD=2.32U
M$2607 \$4909 \$4907 VDD VDD pfet_03v3 L=0.28U W=2.54U AS=0.889P AD=0.6688P
+ PS=5.21U PD=3.65U
M$2609 \$4910 \$4909 VDD VDD pfet_03v3 L=0.28U W=2.68U AS=0.7272P AD=0.9782P
+ PS=3.78U PD=5.48U
M$2611 \$4914 \$4910 \$4913 VDD pfet_03v3 L=0.28U W=0.36U AS=0.2097P AD=0.1278P
+ PS=1.38U PD=1.07U
M$2612 \$5014 \$4915 \$4914 VDD pfet_03v3 L=0.28U W=0.36U AS=0.1278P AD=0.0567P
+ PS=1.07U PD=0.675U
M$2613 VDD \$4909 \$5014 VDD pfet_03v3 L=0.28U W=0.36U AS=0.0567P AD=0.1584P
+ PS=0.675U PD=1.6U
M$2614 \$4913 \$44 VDD VDD pfet_03v3 L=0.28U W=0.72U AS=0.3168P AD=0.2097P
+ PS=2.32U PD=1.38U
M$2615 VDD \$4914 \$4915 VDD pfet_03v3 L=0.28U W=0.36U AS=0.1584P AD=0.1764P
+ PS=1.6U PD=1.26U
M$2616 \$4916 \$4914 VDD VDD pfet_03v3 L=0.28U W=0.72U AS=0.1764P AD=0.36P
+ PS=1.26U PD=2.44U
M$2617 \$4917 RB0 VDD VDD pfet_03v3 L=0.28U W=0.72U AS=0.3312P AD=0.3888P
+ PS=2.36U PD=2.52U
M$2618 \$4916 \$4917 \$360 VDD pfet_03v3 L=0.28U W=0.36U AS=0.1584P AD=0.1152P
+ PS=1.6U PD=1U
M$2619 \$361 \$4918 \$4916 VDD pfet_03v3 L=0.28U W=0.36U AS=0.1152P AD=0.1584P
+ PS=1U PD=1.6U
M$2620 VDD RA0 \$4918 VDD pfet_03v3 L=0.28U W=0.72U AS=0.3708P AD=0.3168P
+ PS=2.47U PD=2.32U
M$2621 \$4920 \$4910 \$4919 VDD pfet_03v3 L=0.28U W=0.36U AS=0.2097P AD=0.1278P
+ PS=1.38U PD=1.07U
M$2622 \$5022 \$4921 \$4920 VDD pfet_03v3 L=0.28U W=0.36U AS=0.1278P AD=0.0567P
+ PS=1.07U PD=0.675U
M$2623 VDD \$4909 \$5022 VDD pfet_03v3 L=0.28U W=0.36U AS=0.0567P AD=0.1584P
+ PS=0.675U PD=1.6U
M$2624 \$4919 \$47 VDD VDD pfet_03v3 L=0.28U W=0.72U AS=0.3168P AD=0.2097P
+ PS=2.32U PD=1.38U
M$2625 VDD \$4920 \$4921 VDD pfet_03v3 L=0.28U W=0.36U AS=0.1584P AD=0.1764P
+ PS=1.6U PD=1.26U
M$2626 \$4922 \$4920 VDD VDD pfet_03v3 L=0.28U W=0.72U AS=0.1764P AD=0.36P
+ PS=1.26U PD=2.44U
M$2627 \$4923 RB0 VDD VDD pfet_03v3 L=0.28U W=0.72U AS=0.3312P AD=0.3888P
+ PS=2.36U PD=2.52U
M$2628 \$4922 \$4923 \$365 VDD pfet_03v3 L=0.28U W=0.36U AS=0.1584P AD=0.1152P
+ PS=1.6U PD=1U
M$2629 \$366 \$4924 \$4922 VDD pfet_03v3 L=0.28U W=0.36U AS=0.1152P AD=0.1584P
+ PS=1U PD=1.6U
M$2630 VDD RA0 \$4924 VDD pfet_03v3 L=0.28U W=0.72U AS=0.3708P AD=0.3168P
+ PS=2.47U PD=2.32U
M$2631 \$4926 \$4910 \$4925 VDD pfet_03v3 L=0.28U W=0.36U AS=0.2097P AD=0.1278P
+ PS=1.38U PD=1.07U
M$2632 \$5029 \$4927 \$4926 VDD pfet_03v3 L=0.28U W=0.36U AS=0.1278P AD=0.0567P
+ PS=1.07U PD=0.675U
M$2633 VDD \$4909 \$5029 VDD pfet_03v3 L=0.28U W=0.36U AS=0.0567P AD=0.1584P
+ PS=0.675U PD=1.6U
M$2634 \$4925 \$50 VDD VDD pfet_03v3 L=0.28U W=0.72U AS=0.3168P AD=0.2097P
+ PS=2.32U PD=1.38U
M$2635 VDD \$4926 \$4927 VDD pfet_03v3 L=0.28U W=0.36U AS=0.1584P AD=0.1764P
+ PS=1.6U PD=1.26U
M$2636 \$4928 \$4926 VDD VDD pfet_03v3 L=0.28U W=0.72U AS=0.1764P AD=0.36P
+ PS=1.26U PD=2.44U
M$2637 \$4929 RB0 VDD VDD pfet_03v3 L=0.28U W=0.72U AS=0.3312P AD=0.3888P
+ PS=2.36U PD=2.52U
M$2638 \$4928 \$4929 \$370 VDD pfet_03v3 L=0.28U W=0.36U AS=0.1584P AD=0.1152P
+ PS=1.6U PD=1U
M$2639 \$371 \$4930 \$4928 VDD pfet_03v3 L=0.28U W=0.36U AS=0.1152P AD=0.1584P
+ PS=1U PD=1.6U
M$2640 VDD RA0 \$4930 VDD pfet_03v3 L=0.28U W=0.72U AS=0.3708P AD=0.3168P
+ PS=2.47U PD=2.32U
M$2641 \$4932 \$4910 \$4931 VDD pfet_03v3 L=0.28U W=0.36U AS=0.2097P AD=0.1278P
+ PS=1.38U PD=1.07U
M$2642 \$5037 \$4933 \$4932 VDD pfet_03v3 L=0.28U W=0.36U AS=0.1278P AD=0.0567P
+ PS=1.07U PD=0.675U
M$2643 VDD \$4909 \$5037 VDD pfet_03v3 L=0.28U W=0.36U AS=0.0567P AD=0.1584P
+ PS=0.675U PD=1.6U
M$2644 \$4931 \$53 VDD VDD pfet_03v3 L=0.28U W=0.72U AS=0.3168P AD=0.2097P
+ PS=2.32U PD=1.38U
M$2645 VDD \$4932 \$4933 VDD pfet_03v3 L=0.28U W=0.36U AS=0.1584P AD=0.1764P
+ PS=1.6U PD=1.26U
M$2646 \$4934 \$4932 VDD VDD pfet_03v3 L=0.28U W=0.72U AS=0.1764P AD=0.36P
+ PS=1.26U PD=2.44U
M$2647 \$4935 RB0 VDD VDD pfet_03v3 L=0.28U W=0.72U AS=0.3312P AD=0.3888P
+ PS=2.36U PD=2.52U
M$2648 \$4934 \$4935 \$375 VDD pfet_03v3 L=0.28U W=0.36U AS=0.1584P AD=0.1152P
+ PS=1.6U PD=1U
M$2649 \$376 \$4936 \$4934 VDD pfet_03v3 L=0.28U W=0.36U AS=0.1152P AD=0.1584P
+ PS=1U PD=1.6U
M$2650 VDD RA0 \$4936 VDD pfet_03v3 L=0.28U W=0.72U AS=0.3708P AD=0.3168P
+ PS=2.47U PD=2.32U
M$2651 \$4938 \$4910 \$4937 VDD pfet_03v3 L=0.28U W=0.36U AS=0.2097P AD=0.1278P
+ PS=1.38U PD=1.07U
M$2652 \$5046 \$4939 \$4938 VDD pfet_03v3 L=0.28U W=0.36U AS=0.1278P AD=0.0567P
+ PS=1.07U PD=0.675U
M$2653 VDD \$4909 \$5046 VDD pfet_03v3 L=0.28U W=0.36U AS=0.0567P AD=0.1584P
+ PS=0.675U PD=1.6U
M$2654 \$4937 \$56 VDD VDD pfet_03v3 L=0.28U W=0.72U AS=0.3168P AD=0.2097P
+ PS=2.32U PD=1.38U
M$2655 VDD \$4938 \$4939 VDD pfet_03v3 L=0.28U W=0.36U AS=0.1584P AD=0.1764P
+ PS=1.6U PD=1.26U
M$2656 \$4940 \$4938 VDD VDD pfet_03v3 L=0.28U W=0.72U AS=0.1764P AD=0.36P
+ PS=1.26U PD=2.44U
M$2657 \$4941 RB0 VDD VDD pfet_03v3 L=0.28U W=0.72U AS=0.3312P AD=0.3888P
+ PS=2.36U PD=2.52U
M$2658 \$4940 \$4941 \$380 VDD pfet_03v3 L=0.28U W=0.36U AS=0.1584P AD=0.1152P
+ PS=1.6U PD=1U
M$2659 \$381 \$4942 \$4940 VDD pfet_03v3 L=0.28U W=0.36U AS=0.1152P AD=0.1584P
+ PS=1U PD=1.6U
M$2660 VDD RA0 \$4942 VDD pfet_03v3 L=0.28U W=0.72U AS=0.3708P AD=0.3168P
+ PS=2.47U PD=2.32U
M$2661 \$4944 \$4910 \$4943 VDD pfet_03v3 L=0.28U W=0.36U AS=0.2097P AD=0.1278P
+ PS=1.38U PD=1.07U
M$2662 \$5052 \$4945 \$4944 VDD pfet_03v3 L=0.28U W=0.36U AS=0.1278P AD=0.0567P
+ PS=1.07U PD=0.675U
M$2663 VDD \$4909 \$5052 VDD pfet_03v3 L=0.28U W=0.36U AS=0.0567P AD=0.1584P
+ PS=0.675U PD=1.6U
M$2664 \$4943 \$59 VDD VDD pfet_03v3 L=0.28U W=0.72U AS=0.3168P AD=0.2097P
+ PS=2.32U PD=1.38U
M$2665 VDD \$4944 \$4945 VDD pfet_03v3 L=0.28U W=0.36U AS=0.1584P AD=0.1764P
+ PS=1.6U PD=1.26U
M$2666 \$4946 \$4944 VDD VDD pfet_03v3 L=0.28U W=0.72U AS=0.1764P AD=0.36P
+ PS=1.26U PD=2.44U
M$2667 \$4947 RB0 VDD VDD pfet_03v3 L=0.28U W=0.72U AS=0.3312P AD=0.3888P
+ PS=2.36U PD=2.52U
M$2668 \$4946 \$4947 \$385 VDD pfet_03v3 L=0.28U W=0.36U AS=0.1584P AD=0.1152P
+ PS=1.6U PD=1U
M$2669 \$386 \$4948 \$4946 VDD pfet_03v3 L=0.28U W=0.36U AS=0.1152P AD=0.1584P
+ PS=1U PD=1.6U
M$2670 VDD RA0 \$4948 VDD pfet_03v3 L=0.28U W=0.72U AS=0.3708P AD=0.3168P
+ PS=2.47U PD=2.32U
M$2671 \$4950 \$4910 \$4949 VDD pfet_03v3 L=0.28U W=0.36U AS=0.2097P AD=0.1278P
+ PS=1.38U PD=1.07U
M$2672 \$5059 \$4951 \$4950 VDD pfet_03v3 L=0.28U W=0.36U AS=0.1278P AD=0.0567P
+ PS=1.07U PD=0.675U
M$2673 VDD \$4909 \$5059 VDD pfet_03v3 L=0.28U W=0.36U AS=0.0567P AD=0.1584P
+ PS=0.675U PD=1.6U
M$2674 \$4949 \$62 VDD VDD pfet_03v3 L=0.28U W=0.72U AS=0.3168P AD=0.2097P
+ PS=2.32U PD=1.38U
M$2675 VDD \$4950 \$4951 VDD pfet_03v3 L=0.28U W=0.36U AS=0.1584P AD=0.1764P
+ PS=1.6U PD=1.26U
M$2676 \$4952 \$4950 VDD VDD pfet_03v3 L=0.28U W=0.72U AS=0.1764P AD=0.36P
+ PS=1.26U PD=2.44U
M$2677 \$4953 RB0 VDD VDD pfet_03v3 L=0.28U W=0.72U AS=0.3312P AD=0.3888P
+ PS=2.36U PD=2.52U
M$2678 \$4952 \$4953 \$390 VDD pfet_03v3 L=0.28U W=0.36U AS=0.1584P AD=0.1152P
+ PS=1.6U PD=1U
M$2679 \$391 \$4954 \$4952 VDD pfet_03v3 L=0.28U W=0.36U AS=0.1152P AD=0.1584P
+ PS=1U PD=1.6U
M$2680 VDD RA0 \$4954 VDD pfet_03v3 L=0.28U W=0.72U AS=0.3708P AD=0.3168P
+ PS=2.47U PD=2.32U
M$2681 \$4956 \$4910 \$4955 VDD pfet_03v3 L=0.28U W=0.36U AS=0.2097P AD=0.1278P
+ PS=1.38U PD=1.07U
M$2682 \$5068 \$4957 \$4956 VDD pfet_03v3 L=0.28U W=0.36U AS=0.1278P AD=0.0567P
+ PS=1.07U PD=0.675U
M$2683 VDD \$4909 \$5068 VDD pfet_03v3 L=0.28U W=0.36U AS=0.0567P AD=0.1584P
+ PS=0.675U PD=1.6U
M$2684 \$4955 \$65 VDD VDD pfet_03v3 L=0.28U W=0.72U AS=0.3168P AD=0.2097P
+ PS=2.32U PD=1.38U
M$2685 VDD \$4956 \$4957 VDD pfet_03v3 L=0.28U W=0.36U AS=0.1584P AD=0.1764P
+ PS=1.6U PD=1.26U
M$2686 \$4958 \$4956 VDD VDD pfet_03v3 L=0.28U W=0.72U AS=0.1764P AD=0.36P
+ PS=1.26U PD=2.44U
M$2687 \$4959 RB0 VDD VDD pfet_03v3 L=0.28U W=0.72U AS=0.3312P AD=0.3888P
+ PS=2.36U PD=2.52U
M$2688 \$4958 \$4959 \$395 VDD pfet_03v3 L=0.28U W=0.36U AS=0.1584P AD=0.1152P
+ PS=1.6U PD=1U
M$2689 \$396 \$4960 \$4958 VDD pfet_03v3 L=0.28U W=0.36U AS=0.1152P AD=0.1584P
+ PS=1U PD=1.6U
M$2690 VDD RA0 \$4960 VDD pfet_03v3 L=0.28U W=0.72U AS=0.3708P AD=0.3168P
+ PS=2.47U PD=2.32U
M$2691 \$4962 \$4910 \$4961 VDD pfet_03v3 L=0.28U W=0.36U AS=0.2097P AD=0.1278P
+ PS=1.38U PD=1.07U
M$2692 \$5074 \$4963 \$4962 VDD pfet_03v3 L=0.28U W=0.36U AS=0.1278P AD=0.0567P
+ PS=1.07U PD=0.675U
M$2693 VDD \$4909 \$5074 VDD pfet_03v3 L=0.28U W=0.36U AS=0.0567P AD=0.1584P
+ PS=0.675U PD=1.6U
M$2694 \$4961 \$68 VDD VDD pfet_03v3 L=0.28U W=0.72U AS=0.3168P AD=0.2097P
+ PS=2.32U PD=1.38U
M$2695 VDD \$4962 \$4963 VDD pfet_03v3 L=0.28U W=0.36U AS=0.1584P AD=0.1764P
+ PS=1.6U PD=1.26U
M$2696 \$4964 \$4962 VDD VDD pfet_03v3 L=0.28U W=0.72U AS=0.1764P AD=0.36P
+ PS=1.26U PD=2.44U
M$2697 \$4965 RB0 VDD VDD pfet_03v3 L=0.28U W=0.72U AS=0.3312P AD=0.3888P
+ PS=2.36U PD=2.52U
M$2698 \$4964 \$4965 \$400 VDD pfet_03v3 L=0.28U W=0.36U AS=0.1584P AD=0.1152P
+ PS=1.6U PD=1U
M$2699 \$401 \$4966 \$4964 VDD pfet_03v3 L=0.28U W=0.36U AS=0.1152P AD=0.1584P
+ PS=1U PD=1.6U
M$2700 VDD RA0 \$4966 VDD pfet_03v3 L=0.28U W=0.72U AS=0.3708P AD=0.3168P
+ PS=2.47U PD=2.32U
M$2701 \$4968 \$4910 \$4967 VDD pfet_03v3 L=0.28U W=0.36U AS=0.2097P AD=0.1278P
+ PS=1.38U PD=1.07U
M$2702 \$5081 \$4969 \$4968 VDD pfet_03v3 L=0.28U W=0.36U AS=0.1278P AD=0.0567P
+ PS=1.07U PD=0.675U
M$2703 VDD \$4909 \$5081 VDD pfet_03v3 L=0.28U W=0.36U AS=0.0567P AD=0.1584P
+ PS=0.675U PD=1.6U
M$2704 \$4967 \$71 VDD VDD pfet_03v3 L=0.28U W=0.72U AS=0.3168P AD=0.2097P
+ PS=2.32U PD=1.38U
M$2705 VDD \$4968 \$4969 VDD pfet_03v3 L=0.28U W=0.36U AS=0.1584P AD=0.1764P
+ PS=1.6U PD=1.26U
M$2706 \$4970 \$4968 VDD VDD pfet_03v3 L=0.28U W=0.72U AS=0.1764P AD=0.36P
+ PS=1.26U PD=2.44U
M$2707 \$4971 RB0 VDD VDD pfet_03v3 L=0.28U W=0.72U AS=0.3312P AD=0.3888P
+ PS=2.36U PD=2.52U
M$2708 \$4970 \$4971 \$405 VDD pfet_03v3 L=0.28U W=0.36U AS=0.1584P AD=0.1152P
+ PS=1.6U PD=1U
M$2709 \$406 \$4972 \$4970 VDD pfet_03v3 L=0.28U W=0.36U AS=0.1152P AD=0.1584P
+ PS=1U PD=1.6U
M$2710 VDD RA0 \$4972 VDD pfet_03v3 L=0.28U W=0.72U AS=0.3708P AD=0.3168P
+ PS=2.47U PD=2.32U
M$2711 \$4974 \$4910 \$4973 VDD pfet_03v3 L=0.28U W=0.36U AS=0.2097P AD=0.1278P
+ PS=1.38U PD=1.07U
M$2712 \$5089 \$4975 \$4974 VDD pfet_03v3 L=0.28U W=0.36U AS=0.1278P AD=0.0567P
+ PS=1.07U PD=0.675U
M$2713 VDD \$4909 \$5089 VDD pfet_03v3 L=0.28U W=0.36U AS=0.0567P AD=0.1584P
+ PS=0.675U PD=1.6U
M$2714 \$4973 \$74 VDD VDD pfet_03v3 L=0.28U W=0.72U AS=0.3168P AD=0.2097P
+ PS=2.32U PD=1.38U
M$2715 VDD \$4974 \$4975 VDD pfet_03v3 L=0.28U W=0.36U AS=0.1584P AD=0.1764P
+ PS=1.6U PD=1.26U
M$2716 \$4976 \$4974 VDD VDD pfet_03v3 L=0.28U W=0.72U AS=0.1764P AD=0.36P
+ PS=1.26U PD=2.44U
M$2717 \$4977 RB0 VDD VDD pfet_03v3 L=0.28U W=0.72U AS=0.3312P AD=0.3888P
+ PS=2.36U PD=2.52U
M$2718 \$4976 \$4977 \$410 VDD pfet_03v3 L=0.28U W=0.36U AS=0.1584P AD=0.1152P
+ PS=1.6U PD=1U
M$2719 \$411 \$4978 \$4976 VDD pfet_03v3 L=0.28U W=0.36U AS=0.1152P AD=0.1584P
+ PS=1U PD=1.6U
M$2720 VDD RA0 \$4978 VDD pfet_03v3 L=0.28U W=0.72U AS=0.3708P AD=0.3168P
+ PS=2.47U PD=2.32U
M$2721 \$4980 \$4910 \$4979 VDD pfet_03v3 L=0.28U W=0.36U AS=0.2097P AD=0.1278P
+ PS=1.38U PD=1.07U
M$2722 \$5097 \$4981 \$4980 VDD pfet_03v3 L=0.28U W=0.36U AS=0.1278P AD=0.0567P
+ PS=1.07U PD=0.675U
M$2723 VDD \$4909 \$5097 VDD pfet_03v3 L=0.28U W=0.36U AS=0.0567P AD=0.1584P
+ PS=0.675U PD=1.6U
M$2724 \$4979 \$77 VDD VDD pfet_03v3 L=0.28U W=0.72U AS=0.3168P AD=0.2097P
+ PS=2.32U PD=1.38U
M$2725 VDD \$4980 \$4981 VDD pfet_03v3 L=0.28U W=0.36U AS=0.1584P AD=0.1764P
+ PS=1.6U PD=1.26U
M$2726 \$4982 \$4980 VDD VDD pfet_03v3 L=0.28U W=0.72U AS=0.1764P AD=0.36P
+ PS=1.26U PD=2.44U
M$2727 \$4983 RB0 VDD VDD pfet_03v3 L=0.28U W=0.72U AS=0.3312P AD=0.3888P
+ PS=2.36U PD=2.52U
M$2728 \$4982 \$4983 \$415 VDD pfet_03v3 L=0.28U W=0.36U AS=0.1584P AD=0.1152P
+ PS=1.6U PD=1U
M$2729 \$416 \$4984 \$4982 VDD pfet_03v3 L=0.28U W=0.36U AS=0.1152P AD=0.1584P
+ PS=1U PD=1.6U
M$2730 VDD RA0 \$4984 VDD pfet_03v3 L=0.28U W=0.72U AS=0.3708P AD=0.3168P
+ PS=2.47U PD=2.32U
M$2731 \$4986 \$4910 \$4985 VDD pfet_03v3 L=0.28U W=0.36U AS=0.2097P AD=0.1278P
+ PS=1.38U PD=1.07U
M$2732 \$5104 \$4987 \$4986 VDD pfet_03v3 L=0.28U W=0.36U AS=0.1278P AD=0.0567P
+ PS=1.07U PD=0.675U
M$2733 VDD \$4909 \$5104 VDD pfet_03v3 L=0.28U W=0.36U AS=0.0567P AD=0.1584P
+ PS=0.675U PD=1.6U
M$2734 \$4985 \$80 VDD VDD pfet_03v3 L=0.28U W=0.72U AS=0.3168P AD=0.2097P
+ PS=2.32U PD=1.38U
M$2735 VDD \$4986 \$4987 VDD pfet_03v3 L=0.28U W=0.36U AS=0.1584P AD=0.1764P
+ PS=1.6U PD=1.26U
M$2736 \$4988 \$4986 VDD VDD pfet_03v3 L=0.28U W=0.72U AS=0.1764P AD=0.36P
+ PS=1.26U PD=2.44U
M$2737 \$4989 RB0 VDD VDD pfet_03v3 L=0.28U W=0.72U AS=0.3312P AD=0.3888P
+ PS=2.36U PD=2.52U
M$2738 \$4988 \$4989 \$420 VDD pfet_03v3 L=0.28U W=0.36U AS=0.1584P AD=0.1152P
+ PS=1.6U PD=1U
M$2739 \$421 \$4990 \$4988 VDD pfet_03v3 L=0.28U W=0.36U AS=0.1152P AD=0.1584P
+ PS=1U PD=1.6U
M$2740 VDD RA0 \$4990 VDD pfet_03v3 L=0.28U W=0.72U AS=0.3708P AD=0.3168P
+ PS=2.47U PD=2.32U
M$2741 \$4992 \$4910 \$4991 VDD pfet_03v3 L=0.28U W=0.36U AS=0.2097P AD=0.1278P
+ PS=1.38U PD=1.07U
M$2742 \$5103 \$4993 \$4992 VDD pfet_03v3 L=0.28U W=0.36U AS=0.1278P AD=0.0567P
+ PS=1.07U PD=0.675U
M$2743 VDD \$4909 \$5103 VDD pfet_03v3 L=0.28U W=0.36U AS=0.0567P AD=0.1584P
+ PS=0.675U PD=1.6U
M$2744 \$4991 \$83 VDD VDD pfet_03v3 L=0.28U W=0.72U AS=0.3168P AD=0.2097P
+ PS=2.32U PD=1.38U
M$2745 VDD \$4992 \$4993 VDD pfet_03v3 L=0.28U W=0.36U AS=0.1584P AD=0.1764P
+ PS=1.6U PD=1.26U
M$2746 \$4994 \$4992 VDD VDD pfet_03v3 L=0.28U W=0.72U AS=0.1764P AD=0.36P
+ PS=1.26U PD=2.44U
M$2747 \$4995 RB0 VDD VDD pfet_03v3 L=0.28U W=0.72U AS=0.3312P AD=0.3888P
+ PS=2.36U PD=2.52U
M$2748 \$4994 \$4995 \$425 VDD pfet_03v3 L=0.28U W=0.36U AS=0.1584P AD=0.1152P
+ PS=1.6U PD=1U
M$2749 \$426 \$4996 \$4994 VDD pfet_03v3 L=0.28U W=0.36U AS=0.1152P AD=0.1584P
+ PS=1U PD=1.6U
M$2750 VDD RA0 \$4996 VDD pfet_03v3 L=0.28U W=0.72U AS=0.3708P AD=0.3168P
+ PS=2.47U PD=2.32U
M$2751 \$4998 \$4910 \$4997 VDD pfet_03v3 L=0.28U W=0.36U AS=0.2097P AD=0.1278P
+ PS=1.38U PD=1.07U
M$2752 \$5071 \$4999 \$4998 VDD pfet_03v3 L=0.28U W=0.36U AS=0.1278P AD=0.0567P
+ PS=1.07U PD=0.675U
M$2753 VDD \$4909 \$5071 VDD pfet_03v3 L=0.28U W=0.36U AS=0.0567P AD=0.1584P
+ PS=0.675U PD=1.6U
M$2754 \$4997 \$86 VDD VDD pfet_03v3 L=0.28U W=0.72U AS=0.3168P AD=0.2097P
+ PS=2.32U PD=1.38U
M$2755 VDD \$4998 \$4999 VDD pfet_03v3 L=0.28U W=0.36U AS=0.1584P AD=0.1764P
+ PS=1.6U PD=1.26U
M$2756 \$5000 \$4998 VDD VDD pfet_03v3 L=0.28U W=0.72U AS=0.1764P AD=0.36P
+ PS=1.26U PD=2.44U
M$2757 \$5001 RB0 VDD VDD pfet_03v3 L=0.28U W=0.72U AS=0.3312P AD=0.3888P
+ PS=2.36U PD=2.52U
M$2758 \$5000 \$5001 \$430 VDD pfet_03v3 L=0.28U W=0.36U AS=0.1584P AD=0.1152P
+ PS=1.6U PD=1U
M$2759 \$431 \$5002 \$5000 VDD pfet_03v3 L=0.28U W=0.36U AS=0.1152P AD=0.1584P
+ PS=1U PD=1.6U
M$2760 VDD RA0 \$5002 VDD pfet_03v3 L=0.28U W=0.72U AS=0.3708P AD=0.3168P
+ PS=2.47U PD=2.32U
M$2761 \$5004 \$4910 \$5003 VDD pfet_03v3 L=0.28U W=0.36U AS=0.2097P AD=0.1278P
+ PS=1.38U PD=1.07U
M$2762 \$5038 \$5005 \$5004 VDD pfet_03v3 L=0.28U W=0.36U AS=0.1278P AD=0.0567P
+ PS=1.07U PD=0.675U
M$2763 VDD \$4909 \$5038 VDD pfet_03v3 L=0.28U W=0.36U AS=0.0567P AD=0.1584P
+ PS=0.675U PD=1.6U
M$2764 \$5003 \$89 VDD VDD pfet_03v3 L=0.28U W=0.72U AS=0.3168P AD=0.2097P
+ PS=2.32U PD=1.38U
M$2765 VDD \$5004 \$5005 VDD pfet_03v3 L=0.28U W=0.36U AS=0.1584P AD=0.1764P
+ PS=1.6U PD=1.26U
M$2766 \$5006 \$5004 VDD VDD pfet_03v3 L=0.28U W=0.72U AS=0.1764P AD=0.36P
+ PS=1.26U PD=2.44U
M$2767 \$5007 RB0 VDD VDD pfet_03v3 L=0.28U W=0.72U AS=0.3312P AD=0.3888P
+ PS=2.36U PD=2.52U
M$2768 \$5006 \$5007 \$435 VDD pfet_03v3 L=0.28U W=0.36U AS=0.1584P AD=0.1152P
+ PS=1.6U PD=1U
M$2769 \$436 \$5008 \$5006 VDD pfet_03v3 L=0.28U W=0.36U AS=0.1152P AD=0.1584P
+ PS=1U PD=1.6U
M$2770 VDD RA0 \$5008 VDD pfet_03v3 L=0.28U W=0.72U AS=0.3708P AD=0.3168P
+ PS=2.47U PD=2.32U
M$2771 WEMb WEM VSS VSS nfet_03v3 L=0.28U W=1.26U AS=0.4599P AD=0.4599P
+ PS=3.35U PD=3.35U
M$2773 \$44 \$141 VSS VSS nfet_03v3 L=0.28U W=1.24U AS=0.434P AD=0.434P
+ PS=3.26U PD=3.26U
M$2775 \$47 \$143 VSS VSS nfet_03v3 L=0.28U W=1.24U AS=0.434P AD=0.434P
+ PS=3.26U PD=3.26U
M$2777 \$50 \$145 VSS VSS nfet_03v3 L=0.28U W=1.24U AS=0.434P AD=0.434P
+ PS=3.26U PD=3.26U
M$2779 \$53 \$147 VSS VSS nfet_03v3 L=0.28U W=1.24U AS=0.434P AD=0.434P
+ PS=3.26U PD=3.26U
M$2781 \$56 \$149 VSS VSS nfet_03v3 L=0.28U W=1.24U AS=0.434P AD=0.434P
+ PS=3.26U PD=3.26U
M$2783 \$59 \$151 VSS VSS nfet_03v3 L=0.28U W=1.24U AS=0.434P AD=0.434P
+ PS=3.26U PD=3.26U
M$2785 \$62 \$153 VSS VSS nfet_03v3 L=0.28U W=1.24U AS=0.434P AD=0.434P
+ PS=3.26U PD=3.26U
M$2787 \$65 \$155 VSS VSS nfet_03v3 L=0.28U W=1.24U AS=0.434P AD=0.434P
+ PS=3.26U PD=3.26U
M$2789 \$68 \$157 VSS VSS nfet_03v3 L=0.28U W=1.24U AS=0.434P AD=0.434P
+ PS=3.26U PD=3.26U
M$2791 \$71 \$159 VSS VSS nfet_03v3 L=0.28U W=1.24U AS=0.434P AD=0.434P
+ PS=3.26U PD=3.26U
M$2793 \$74 \$161 VSS VSS nfet_03v3 L=0.28U W=1.24U AS=0.434P AD=0.434P
+ PS=3.26U PD=3.26U
M$2795 \$77 \$163 VSS VSS nfet_03v3 L=0.28U W=1.24U AS=0.434P AD=0.434P
+ PS=3.26U PD=3.26U
M$2797 \$80 \$165 VSS VSS nfet_03v3 L=0.28U W=1.24U AS=0.434P AD=0.434P
+ PS=3.26U PD=3.26U
M$2799 \$83 \$167 VSS VSS nfet_03v3 L=0.28U W=1.24U AS=0.434P AD=0.434P
+ PS=3.26U PD=3.26U
M$2801 \$86 \$169 VSS VSS nfet_03v3 L=0.28U W=1.24U AS=0.434P AD=0.434P
+ PS=3.26U PD=3.26U
M$2803 \$89 \$171 VSS VSS nfet_03v3 L=0.28U W=1.24U AS=0.434P AD=0.434P
+ PS=3.26U PD=3.26U
M$2805 \$45 \$141 VSS VSS nfet_03v3 L=0.28U W=0.36U AS=0.1584P AD=0.1584P
+ PS=1.6U PD=1.6U
M$2806 \$195 WEMb VSS VSS nfet_03v3 L=0.28U W=0.36U AS=0.1584P AD=0.0567P
+ PS=1.6U PD=0.675U
M$2807 \$141 \$45 \$195 VSS nfet_03v3 L=0.28U W=0.36U AS=0.0567P AD=0.1278P
+ PS=0.675U PD=1.07U
M$2808 \$46 WEM \$141 VSS nfet_03v3 L=0.28U W=0.36U AS=0.1278P AD=0.1188P
+ PS=1.07U PD=1.02U
M$2809 VSS D0 \$46 VSS nfet_03v3 L=0.28U W=0.36U AS=0.1188P AD=0.1584P PS=1.02U
+ PD=1.6U
M$2810 \$48 \$143 VSS VSS nfet_03v3 L=0.28U W=0.36U AS=0.1584P AD=0.1584P
+ PS=1.6U PD=1.6U
M$2811 \$200 WEMb VSS VSS nfet_03v3 L=0.28U W=0.36U AS=0.1584P AD=0.0567P
+ PS=1.6U PD=0.675U
M$2812 \$143 \$48 \$200 VSS nfet_03v3 L=0.28U W=0.36U AS=0.0567P AD=0.1278P
+ PS=0.675U PD=1.07U
M$2813 \$49 WEM \$143 VSS nfet_03v3 L=0.28U W=0.36U AS=0.1278P AD=0.1188P
+ PS=1.07U PD=1.02U
M$2814 VSS D1 \$49 VSS nfet_03v3 L=0.28U W=0.36U AS=0.1188P AD=0.1584P PS=1.02U
+ PD=1.6U
M$2815 \$51 \$145 VSS VSS nfet_03v3 L=0.28U W=0.36U AS=0.1584P AD=0.1584P
+ PS=1.6U PD=1.6U
M$2816 \$206 WEMb VSS VSS nfet_03v3 L=0.28U W=0.36U AS=0.1584P AD=0.0567P
+ PS=1.6U PD=0.675U
M$2817 \$145 \$51 \$206 VSS nfet_03v3 L=0.28U W=0.36U AS=0.0567P AD=0.1278P
+ PS=0.675U PD=1.07U
M$2818 \$52 WEM \$145 VSS nfet_03v3 L=0.28U W=0.36U AS=0.1278P AD=0.1188P
+ PS=1.07U PD=1.02U
M$2819 VSS D2 \$52 VSS nfet_03v3 L=0.28U W=0.36U AS=0.1188P AD=0.1584P PS=1.02U
+ PD=1.6U
M$2820 \$54 \$147 VSS VSS nfet_03v3 L=0.28U W=0.36U AS=0.1584P AD=0.1584P
+ PS=1.6U PD=1.6U
M$2821 \$211 WEMb VSS VSS nfet_03v3 L=0.28U W=0.36U AS=0.1584P AD=0.0567P
+ PS=1.6U PD=0.675U
M$2822 \$147 \$54 \$211 VSS nfet_03v3 L=0.28U W=0.36U AS=0.0567P AD=0.1278P
+ PS=0.675U PD=1.07U
M$2823 \$55 WEM \$147 VSS nfet_03v3 L=0.28U W=0.36U AS=0.1278P AD=0.1188P
+ PS=1.07U PD=1.02U
M$2824 VSS D3 \$55 VSS nfet_03v3 L=0.28U W=0.36U AS=0.1188P AD=0.1584P PS=1.02U
+ PD=1.6U
M$2825 \$57 \$149 VSS VSS nfet_03v3 L=0.28U W=0.36U AS=0.1584P AD=0.1584P
+ PS=1.6U PD=1.6U
M$2826 \$216 WEMb VSS VSS nfet_03v3 L=0.28U W=0.36U AS=0.1584P AD=0.0567P
+ PS=1.6U PD=0.675U
M$2827 \$149 \$57 \$216 VSS nfet_03v3 L=0.28U W=0.36U AS=0.0567P AD=0.1278P
+ PS=0.675U PD=1.07U
M$2828 \$58 WEM \$149 VSS nfet_03v3 L=0.28U W=0.36U AS=0.1278P AD=0.1188P
+ PS=1.07U PD=1.02U
M$2829 VSS D4 \$58 VSS nfet_03v3 L=0.28U W=0.36U AS=0.1188P AD=0.1584P PS=1.02U
+ PD=1.6U
M$2830 \$60 \$151 VSS VSS nfet_03v3 L=0.28U W=0.36U AS=0.1584P AD=0.1584P
+ PS=1.6U PD=1.6U
M$2831 \$221 WEMb VSS VSS nfet_03v3 L=0.28U W=0.36U AS=0.1584P AD=0.0567P
+ PS=1.6U PD=0.675U
M$2832 \$151 \$60 \$221 VSS nfet_03v3 L=0.28U W=0.36U AS=0.0567P AD=0.1278P
+ PS=0.675U PD=1.07U
M$2833 \$61 WEM \$151 VSS nfet_03v3 L=0.28U W=0.36U AS=0.1278P AD=0.1188P
+ PS=1.07U PD=1.02U
M$2834 VSS D5 \$61 VSS nfet_03v3 L=0.28U W=0.36U AS=0.1188P AD=0.1584P PS=1.02U
+ PD=1.6U
M$2835 \$63 \$153 VSS VSS nfet_03v3 L=0.28U W=0.36U AS=0.1584P AD=0.1584P
+ PS=1.6U PD=1.6U
M$2836 \$227 WEMb VSS VSS nfet_03v3 L=0.28U W=0.36U AS=0.1584P AD=0.0567P
+ PS=1.6U PD=0.675U
M$2837 \$153 \$63 \$227 VSS nfet_03v3 L=0.28U W=0.36U AS=0.0567P AD=0.1278P
+ PS=0.675U PD=1.07U
M$2838 \$64 WEM \$153 VSS nfet_03v3 L=0.28U W=0.36U AS=0.1278P AD=0.1188P
+ PS=1.07U PD=1.02U
M$2839 VSS D6 \$64 VSS nfet_03v3 L=0.28U W=0.36U AS=0.1188P AD=0.1584P PS=1.02U
+ PD=1.6U
M$2840 \$66 \$155 VSS VSS nfet_03v3 L=0.28U W=0.36U AS=0.1584P AD=0.1584P
+ PS=1.6U PD=1.6U
M$2841 \$232 WEMb VSS VSS nfet_03v3 L=0.28U W=0.36U AS=0.1584P AD=0.0567P
+ PS=1.6U PD=0.675U
M$2842 \$155 \$66 \$232 VSS nfet_03v3 L=0.28U W=0.36U AS=0.0567P AD=0.1278P
+ PS=0.675U PD=1.07U
M$2843 \$67 WEM \$155 VSS nfet_03v3 L=0.28U W=0.36U AS=0.1278P AD=0.1188P
+ PS=1.07U PD=1.02U
M$2844 VSS D7 \$67 VSS nfet_03v3 L=0.28U W=0.36U AS=0.1188P AD=0.1584P PS=1.02U
+ PD=1.6U
M$2845 \$69 \$157 VSS VSS nfet_03v3 L=0.28U W=0.36U AS=0.1584P AD=0.1584P
+ PS=1.6U PD=1.6U
M$2846 \$237 WEMb VSS VSS nfet_03v3 L=0.28U W=0.36U AS=0.1584P AD=0.0567P
+ PS=1.6U PD=0.675U
M$2847 \$157 \$69 \$237 VSS nfet_03v3 L=0.28U W=0.36U AS=0.0567P AD=0.1278P
+ PS=0.675U PD=1.07U
M$2848 \$70 WEM \$157 VSS nfet_03v3 L=0.28U W=0.36U AS=0.1278P AD=0.1188P
+ PS=1.07U PD=1.02U
M$2849 VSS D8 \$70 VSS nfet_03v3 L=0.28U W=0.36U AS=0.1188P AD=0.1584P PS=1.02U
+ PD=1.6U
M$2850 \$72 \$159 VSS VSS nfet_03v3 L=0.28U W=0.36U AS=0.1584P AD=0.1584P
+ PS=1.6U PD=1.6U
M$2851 \$242 WEMb VSS VSS nfet_03v3 L=0.28U W=0.36U AS=0.1584P AD=0.0567P
+ PS=1.6U PD=0.675U
M$2852 \$159 \$72 \$242 VSS nfet_03v3 L=0.28U W=0.36U AS=0.0567P AD=0.1278P
+ PS=0.675U PD=1.07U
M$2853 \$73 WEM \$159 VSS nfet_03v3 L=0.28U W=0.36U AS=0.1278P AD=0.1188P
+ PS=1.07U PD=1.02U
M$2854 VSS D9 \$73 VSS nfet_03v3 L=0.28U W=0.36U AS=0.1188P AD=0.1584P PS=1.02U
+ PD=1.6U
M$2855 \$75 \$161 VSS VSS nfet_03v3 L=0.28U W=0.36U AS=0.1584P AD=0.1584P
+ PS=1.6U PD=1.6U
M$2856 \$247 WEMb VSS VSS nfet_03v3 L=0.28U W=0.36U AS=0.1584P AD=0.0567P
+ PS=1.6U PD=0.675U
M$2857 \$161 \$75 \$247 VSS nfet_03v3 L=0.28U W=0.36U AS=0.0567P AD=0.1278P
+ PS=0.675U PD=1.07U
M$2858 \$76 WEM \$161 VSS nfet_03v3 L=0.28U W=0.36U AS=0.1278P AD=0.1188P
+ PS=1.07U PD=1.02U
M$2859 VSS D10 \$76 VSS nfet_03v3 L=0.28U W=0.36U AS=0.1188P AD=0.1584P
+ PS=1.02U PD=1.6U
M$2860 \$78 \$163 VSS VSS nfet_03v3 L=0.28U W=0.36U AS=0.1584P AD=0.1584P
+ PS=1.6U PD=1.6U
M$2861 \$253 WEMb VSS VSS nfet_03v3 L=0.28U W=0.36U AS=0.1584P AD=0.0567P
+ PS=1.6U PD=0.675U
M$2862 \$163 \$78 \$253 VSS nfet_03v3 L=0.28U W=0.36U AS=0.0567P AD=0.1278P
+ PS=0.675U PD=1.07U
M$2863 \$79 WEM \$163 VSS nfet_03v3 L=0.28U W=0.36U AS=0.1278P AD=0.1188P
+ PS=1.07U PD=1.02U
M$2864 VSS D11 \$79 VSS nfet_03v3 L=0.28U W=0.36U AS=0.1188P AD=0.1584P
+ PS=1.02U PD=1.6U
M$2865 \$81 \$165 VSS VSS nfet_03v3 L=0.28U W=0.36U AS=0.1584P AD=0.1584P
+ PS=1.6U PD=1.6U
M$2866 \$249 WEMb VSS VSS nfet_03v3 L=0.28U W=0.36U AS=0.1584P AD=0.0567P
+ PS=1.6U PD=0.675U
M$2867 \$165 \$81 \$249 VSS nfet_03v3 L=0.28U W=0.36U AS=0.0567P AD=0.1278P
+ PS=0.675U PD=1.07U
M$2868 \$82 WEM \$165 VSS nfet_03v3 L=0.28U W=0.36U AS=0.1278P AD=0.1188P
+ PS=1.07U PD=1.02U
M$2869 VSS D12 \$82 VSS nfet_03v3 L=0.28U W=0.36U AS=0.1188P AD=0.1584P
+ PS=1.02U PD=1.6U
M$2870 \$84 \$167 VSS VSS nfet_03v3 L=0.28U W=0.36U AS=0.1584P AD=0.1584P
+ PS=1.6U PD=1.6U
M$2871 \$231 WEMb VSS VSS nfet_03v3 L=0.28U W=0.36U AS=0.1584P AD=0.0567P
+ PS=1.6U PD=0.675U
M$2872 \$167 \$84 \$231 VSS nfet_03v3 L=0.28U W=0.36U AS=0.0567P AD=0.1278P
+ PS=0.675U PD=1.07U
M$2873 \$85 WEM \$167 VSS nfet_03v3 L=0.28U W=0.36U AS=0.1278P AD=0.1188P
+ PS=1.07U PD=1.02U
M$2874 VSS D13 \$85 VSS nfet_03v3 L=0.28U W=0.36U AS=0.1188P AD=0.1584P
+ PS=1.02U PD=1.6U
M$2875 \$87 \$169 VSS VSS nfet_03v3 L=0.28U W=0.36U AS=0.1584P AD=0.1584P
+ PS=1.6U PD=1.6U
M$2876 \$214 WEMb VSS VSS nfet_03v3 L=0.28U W=0.36U AS=0.1584P AD=0.0567P
+ PS=1.6U PD=0.675U
M$2877 \$169 \$87 \$214 VSS nfet_03v3 L=0.28U W=0.36U AS=0.0567P AD=0.1278P
+ PS=0.675U PD=1.07U
M$2878 \$88 WEM \$169 VSS nfet_03v3 L=0.28U W=0.36U AS=0.1278P AD=0.1188P
+ PS=1.07U PD=1.02U
M$2879 VSS D14 \$88 VSS nfet_03v3 L=0.28U W=0.36U AS=0.1188P AD=0.1584P
+ PS=1.02U PD=1.6U
M$2880 \$90 \$171 VSS VSS nfet_03v3 L=0.28U W=0.36U AS=0.1584P AD=0.1584P
+ PS=1.6U PD=1.6U
M$2881 \$196 WEMb VSS VSS nfet_03v3 L=0.28U W=0.36U AS=0.1584P AD=0.0567P
+ PS=1.6U PD=0.675U
M$2882 \$171 \$90 \$196 VSS nfet_03v3 L=0.28U W=0.36U AS=0.0567P AD=0.1278P
+ PS=0.675U PD=1.07U
M$2883 \$91 WEM \$171 VSS nfet_03v3 L=0.28U W=0.36U AS=0.1278P AD=0.1188P
+ PS=1.07U PD=1.02U
M$2884 VSS D15 \$91 VSS nfet_03v3 L=0.28U W=0.36U AS=0.1188P AD=0.1584P
+ PS=1.02U PD=1.6U
M$2885 \$439 WE15 VSS VSS nfet_03v3 L=0.28U W=0.72U AS=0.3168P AD=0.1872P
+ PS=2.32U PD=1.24U
M$2886 \$272 CLK \$439 VSS nfet_03v3 L=0.28U W=0.72U AS=0.1872P AD=0.3168P
+ PS=1.24U PD=2.32U
M$2887 \$273 \$272 VSS VSS nfet_03v3 L=0.28U W=1.27U AS=0.4445P AD=0.3344P
+ PS=3.305U PD=2.345U
M$2889 \$492 \$273 VSS VSS nfet_03v3 L=0.28U W=1.34U AS=0.3636P AD=0.4891P
+ PS=2.44U PD=3.47U
M$2891 \$274 \$44 VSS VSS nfet_03v3 L=0.28U W=0.36U AS=0.1584P AD=0.1188P
+ PS=1.6U PD=1.02U
M$2892 \$275 \$273 \$274 VSS nfet_03v3 L=0.28U W=0.36U AS=0.1188P AD=0.1278P
+ PS=1.02U PD=1.07U
M$2893 \$311 \$357 \$275 VSS nfet_03v3 L=0.28U W=0.36U AS=0.1278P AD=0.0567P
+ PS=1.07U PD=0.675U
M$2894 VSS \$492 \$311 VSS nfet_03v3 L=0.28U W=0.36U AS=0.0567P AD=0.1584P
+ PS=0.675U PD=1.6U
M$2895 VSS \$275 \$357 VSS nfet_03v3 L=0.28U W=0.36U AS=0.1584P AD=0.0972P
+ PS=1.6U PD=0.9U
M$2896 \$256 \$275 VSS VSS nfet_03v3 L=0.28U W=0.36U AS=0.0972P AD=0.18P
+ PS=0.9U PD=1.72U
M$2897 \$359 RA15 VSS VSS nfet_03v3 L=0.28U W=0.36U AS=0.1656P AD=0.1944P
+ PS=1.64U PD=1.8U
M$2898 \$256 RA15 \$360 VSS nfet_03v3 L=0.28U W=0.36U AS=0.1584P AD=0.1152P
+ PS=1.6U PD=1U
M$2899 \$361 RB15 \$256 VSS nfet_03v3 L=0.28U W=0.36U AS=0.1152P AD=0.1584P
+ PS=1U PD=1.6U
M$2900 VSS RB15 \$362 VSS nfet_03v3 L=0.28U W=0.36U AS=0.1854P AD=0.1584P
+ PS=1.75U PD=1.6U
M$2901 \$276 \$47 VSS VSS nfet_03v3 L=0.28U W=0.36U AS=0.1584P AD=0.1188P
+ PS=1.6U PD=1.02U
M$2902 \$277 \$273 \$276 VSS nfet_03v3 L=0.28U W=0.36U AS=0.1188P AD=0.1278P
+ PS=1.02U PD=1.07U
M$2903 \$320 \$363 \$277 VSS nfet_03v3 L=0.28U W=0.36U AS=0.1278P AD=0.0567P
+ PS=1.07U PD=0.675U
M$2904 VSS \$492 \$320 VSS nfet_03v3 L=0.28U W=0.36U AS=0.0567P AD=0.1584P
+ PS=0.675U PD=1.6U
M$2905 VSS \$277 \$363 VSS nfet_03v3 L=0.28U W=0.36U AS=0.1584P AD=0.0972P
+ PS=1.6U PD=0.9U
M$2906 \$257 \$277 VSS VSS nfet_03v3 L=0.28U W=0.36U AS=0.0972P AD=0.18P
+ PS=0.9U PD=1.72U
M$2907 \$364 RA15 VSS VSS nfet_03v3 L=0.28U W=0.36U AS=0.1656P AD=0.1944P
+ PS=1.64U PD=1.8U
M$2908 \$257 RA15 \$365 VSS nfet_03v3 L=0.28U W=0.36U AS=0.1584P AD=0.1152P
+ PS=1.6U PD=1U
M$2909 \$366 RB15 \$257 VSS nfet_03v3 L=0.28U W=0.36U AS=0.1152P AD=0.1584P
+ PS=1U PD=1.6U
M$2910 VSS RB15 \$367 VSS nfet_03v3 L=0.28U W=0.36U AS=0.1854P AD=0.1584P
+ PS=1.75U PD=1.6U
M$2911 \$278 \$50 VSS VSS nfet_03v3 L=0.28U W=0.36U AS=0.1584P AD=0.1188P
+ PS=1.6U PD=1.02U
M$2912 \$279 \$273 \$278 VSS nfet_03v3 L=0.28U W=0.36U AS=0.1188P AD=0.1278P
+ PS=1.02U PD=1.07U
M$2913 \$328 \$368 \$279 VSS nfet_03v3 L=0.28U W=0.36U AS=0.1278P AD=0.0567P
+ PS=1.07U PD=0.675U
M$2914 VSS \$492 \$328 VSS nfet_03v3 L=0.28U W=0.36U AS=0.0567P AD=0.1584P
+ PS=0.675U PD=1.6U
M$2915 VSS \$279 \$368 VSS nfet_03v3 L=0.28U W=0.36U AS=0.1584P AD=0.0972P
+ PS=1.6U PD=0.9U
M$2916 \$258 \$279 VSS VSS nfet_03v3 L=0.28U W=0.36U AS=0.0972P AD=0.18P
+ PS=0.9U PD=1.72U
M$2917 \$369 RA15 VSS VSS nfet_03v3 L=0.28U W=0.36U AS=0.1656P AD=0.1944P
+ PS=1.64U PD=1.8U
M$2918 \$258 RA15 \$370 VSS nfet_03v3 L=0.28U W=0.36U AS=0.1584P AD=0.1152P
+ PS=1.6U PD=1U
M$2919 \$371 RB15 \$258 VSS nfet_03v3 L=0.28U W=0.36U AS=0.1152P AD=0.1584P
+ PS=1U PD=1.6U
M$2920 VSS RB15 \$372 VSS nfet_03v3 L=0.28U W=0.36U AS=0.1854P AD=0.1584P
+ PS=1.75U PD=1.6U
M$2921 \$280 \$53 VSS VSS nfet_03v3 L=0.28U W=0.36U AS=0.1584P AD=0.1188P
+ PS=1.6U PD=1.02U
M$2922 \$281 \$273 \$280 VSS nfet_03v3 L=0.28U W=0.36U AS=0.1188P AD=0.1278P
+ PS=1.02U PD=1.07U
M$2923 \$337 \$373 \$281 VSS nfet_03v3 L=0.28U W=0.36U AS=0.1278P AD=0.0567P
+ PS=1.07U PD=0.675U
M$2924 VSS \$492 \$337 VSS nfet_03v3 L=0.28U W=0.36U AS=0.0567P AD=0.1584P
+ PS=0.675U PD=1.6U
M$2925 VSS \$281 \$373 VSS nfet_03v3 L=0.28U W=0.36U AS=0.1584P AD=0.0972P
+ PS=1.6U PD=0.9U
M$2926 \$259 \$281 VSS VSS nfet_03v3 L=0.28U W=0.36U AS=0.0972P AD=0.18P
+ PS=0.9U PD=1.72U
M$2927 \$374 RA15 VSS VSS nfet_03v3 L=0.28U W=0.36U AS=0.1656P AD=0.1944P
+ PS=1.64U PD=1.8U
M$2928 \$259 RA15 \$375 VSS nfet_03v3 L=0.28U W=0.36U AS=0.1584P AD=0.1152P
+ PS=1.6U PD=1U
M$2929 \$376 RB15 \$259 VSS nfet_03v3 L=0.28U W=0.36U AS=0.1152P AD=0.1584P
+ PS=1U PD=1.6U
M$2930 VSS RB15 \$377 VSS nfet_03v3 L=0.28U W=0.36U AS=0.1854P AD=0.1584P
+ PS=1.75U PD=1.6U
M$2931 \$282 \$56 VSS VSS nfet_03v3 L=0.28U W=0.36U AS=0.1584P AD=0.1188P
+ PS=1.6U PD=1.02U
M$2932 \$283 \$273 \$282 VSS nfet_03v3 L=0.28U W=0.36U AS=0.1188P AD=0.1278P
+ PS=1.02U PD=1.07U
M$2933 \$347 \$378 \$283 VSS nfet_03v3 L=0.28U W=0.36U AS=0.1278P AD=0.0567P
+ PS=1.07U PD=0.675U
M$2934 VSS \$492 \$347 VSS nfet_03v3 L=0.28U W=0.36U AS=0.0567P AD=0.1584P
+ PS=0.675U PD=1.6U
M$2935 VSS \$283 \$378 VSS nfet_03v3 L=0.28U W=0.36U AS=0.1584P AD=0.0972P
+ PS=1.6U PD=0.9U
M$2936 \$260 \$283 VSS VSS nfet_03v3 L=0.28U W=0.36U AS=0.0972P AD=0.18P
+ PS=0.9U PD=1.72U
M$2937 \$379 RA15 VSS VSS nfet_03v3 L=0.28U W=0.36U AS=0.1656P AD=0.1944P
+ PS=1.64U PD=1.8U
M$2938 \$260 RA15 \$380 VSS nfet_03v3 L=0.28U W=0.36U AS=0.1584P AD=0.1152P
+ PS=1.6U PD=1U
M$2939 \$381 RB15 \$260 VSS nfet_03v3 L=0.28U W=0.36U AS=0.1152P AD=0.1584P
+ PS=1U PD=1.6U
M$2940 VSS RB15 \$382 VSS nfet_03v3 L=0.28U W=0.36U AS=0.1854P AD=0.1584P
+ PS=1.75U PD=1.6U
M$2941 \$284 \$59 VSS VSS nfet_03v3 L=0.28U W=0.36U AS=0.1584P AD=0.1188P
+ PS=1.6U PD=1.02U
M$2942 \$285 \$273 \$284 VSS nfet_03v3 L=0.28U W=0.36U AS=0.1188P AD=0.1278P
+ PS=1.02U PD=1.07U
M$2943 \$353 \$383 \$285 VSS nfet_03v3 L=0.28U W=0.36U AS=0.1278P AD=0.0567P
+ PS=1.07U PD=0.675U
M$2944 VSS \$492 \$353 VSS nfet_03v3 L=0.28U W=0.36U AS=0.0567P AD=0.1584P
+ PS=0.675U PD=1.6U
M$2945 VSS \$285 \$383 VSS nfet_03v3 L=0.28U W=0.36U AS=0.1584P AD=0.0972P
+ PS=1.6U PD=0.9U
M$2946 \$261 \$285 VSS VSS nfet_03v3 L=0.28U W=0.36U AS=0.0972P AD=0.18P
+ PS=0.9U PD=1.72U
M$2947 \$384 RA15 VSS VSS nfet_03v3 L=0.28U W=0.36U AS=0.1656P AD=0.1944P
+ PS=1.64U PD=1.8U
M$2948 \$261 RA15 \$385 VSS nfet_03v3 L=0.28U W=0.36U AS=0.1584P AD=0.1152P
+ PS=1.6U PD=1U
M$2949 \$386 RB15 \$261 VSS nfet_03v3 L=0.28U W=0.36U AS=0.1152P AD=0.1584P
+ PS=1U PD=1.6U
M$2950 VSS RB15 \$387 VSS nfet_03v3 L=0.28U W=0.36U AS=0.1854P AD=0.1584P
+ PS=1.75U PD=1.6U
M$2951 \$286 \$62 VSS VSS nfet_03v3 L=0.28U W=0.36U AS=0.1584P AD=0.1188P
+ PS=1.6U PD=1.02U
M$2952 \$287 \$273 \$286 VSS nfet_03v3 L=0.28U W=0.36U AS=0.1188P AD=0.1278P
+ PS=1.02U PD=1.07U
M$2953 \$346 \$388 \$287 VSS nfet_03v3 L=0.28U W=0.36U AS=0.1278P AD=0.0567P
+ PS=1.07U PD=0.675U
M$2954 VSS \$492 \$346 VSS nfet_03v3 L=0.28U W=0.36U AS=0.0567P AD=0.1584P
+ PS=0.675U PD=1.6U
M$2955 VSS \$287 \$388 VSS nfet_03v3 L=0.28U W=0.36U AS=0.1584P AD=0.0972P
+ PS=1.6U PD=0.9U
M$2956 \$262 \$287 VSS VSS nfet_03v3 L=0.28U W=0.36U AS=0.0972P AD=0.18P
+ PS=0.9U PD=1.72U
M$2957 \$389 RA15 VSS VSS nfet_03v3 L=0.28U W=0.36U AS=0.1656P AD=0.1944P
+ PS=1.64U PD=1.8U
M$2958 \$262 RA15 \$390 VSS nfet_03v3 L=0.28U W=0.36U AS=0.1584P AD=0.1152P
+ PS=1.6U PD=1U
M$2959 \$391 RB15 \$262 VSS nfet_03v3 L=0.28U W=0.36U AS=0.1152P AD=0.1584P
+ PS=1U PD=1.6U
M$2960 VSS RB15 \$392 VSS nfet_03v3 L=0.28U W=0.36U AS=0.1854P AD=0.1584P
+ PS=1.75U PD=1.6U
M$2961 \$288 \$65 VSS VSS nfet_03v3 L=0.28U W=0.36U AS=0.1584P AD=0.1188P
+ PS=1.6U PD=1.02U
M$2962 \$289 \$273 \$288 VSS nfet_03v3 L=0.28U W=0.36U AS=0.1188P AD=0.1278P
+ PS=1.02U PD=1.07U
M$2963 \$344 \$393 \$289 VSS nfet_03v3 L=0.28U W=0.36U AS=0.1278P AD=0.0567P
+ PS=1.07U PD=0.675U
M$2964 VSS \$492 \$344 VSS nfet_03v3 L=0.28U W=0.36U AS=0.0567P AD=0.1584P
+ PS=0.675U PD=1.6U
M$2965 VSS \$289 \$393 VSS nfet_03v3 L=0.28U W=0.36U AS=0.1584P AD=0.0972P
+ PS=1.6U PD=0.9U
M$2966 \$263 \$289 VSS VSS nfet_03v3 L=0.28U W=0.36U AS=0.0972P AD=0.18P
+ PS=0.9U PD=1.72U
M$2967 \$394 RA15 VSS VSS nfet_03v3 L=0.28U W=0.36U AS=0.1656P AD=0.1944P
+ PS=1.64U PD=1.8U
M$2968 \$263 RA15 \$395 VSS nfet_03v3 L=0.28U W=0.36U AS=0.1584P AD=0.1152P
+ PS=1.6U PD=1U
M$2969 \$396 RB15 \$263 VSS nfet_03v3 L=0.28U W=0.36U AS=0.1152P AD=0.1584P
+ PS=1U PD=1.6U
M$2970 VSS RB15 \$397 VSS nfet_03v3 L=0.28U W=0.36U AS=0.1854P AD=0.1584P
+ PS=1.75U PD=1.6U
M$2971 \$290 \$68 VSS VSS nfet_03v3 L=0.28U W=0.36U AS=0.1584P AD=0.1188P
+ PS=1.6U PD=1.02U
M$2972 \$291 \$273 \$290 VSS nfet_03v3 L=0.28U W=0.36U AS=0.1188P AD=0.1278P
+ PS=1.02U PD=1.07U
M$2973 \$339 \$398 \$291 VSS nfet_03v3 L=0.28U W=0.36U AS=0.1278P AD=0.0567P
+ PS=1.07U PD=0.675U
M$2974 VSS \$492 \$339 VSS nfet_03v3 L=0.28U W=0.36U AS=0.0567P AD=0.1584P
+ PS=0.675U PD=1.6U
M$2975 VSS \$291 \$398 VSS nfet_03v3 L=0.28U W=0.36U AS=0.1584P AD=0.0972P
+ PS=1.6U PD=0.9U
M$2976 \$264 \$291 VSS VSS nfet_03v3 L=0.28U W=0.36U AS=0.0972P AD=0.18P
+ PS=0.9U PD=1.72U
M$2977 \$399 RA15 VSS VSS nfet_03v3 L=0.28U W=0.36U AS=0.1656P AD=0.1944P
+ PS=1.64U PD=1.8U
M$2978 \$264 RA15 \$400 VSS nfet_03v3 L=0.28U W=0.36U AS=0.1584P AD=0.1152P
+ PS=1.6U PD=1U
M$2979 \$401 RB15 \$264 VSS nfet_03v3 L=0.28U W=0.36U AS=0.1152P AD=0.1584P
+ PS=1U PD=1.6U
M$2980 VSS RB15 \$402 VSS nfet_03v3 L=0.28U W=0.36U AS=0.1854P AD=0.1584P
+ PS=1.75U PD=1.6U
M$2981 \$292 \$71 VSS VSS nfet_03v3 L=0.28U W=0.36U AS=0.1584P AD=0.1188P
+ PS=1.6U PD=1.02U
M$2982 \$293 \$273 \$292 VSS nfet_03v3 L=0.28U W=0.36U AS=0.1188P AD=0.1278P
+ PS=1.02U PD=1.07U
M$2983 \$335 \$403 \$293 VSS nfet_03v3 L=0.28U W=0.36U AS=0.1278P AD=0.0567P
+ PS=1.07U PD=0.675U
M$2984 VSS \$492 \$335 VSS nfet_03v3 L=0.28U W=0.36U AS=0.0567P AD=0.1584P
+ PS=0.675U PD=1.6U
M$2985 VSS \$293 \$403 VSS nfet_03v3 L=0.28U W=0.36U AS=0.1584P AD=0.0972P
+ PS=1.6U PD=0.9U
M$2986 \$265 \$293 VSS VSS nfet_03v3 L=0.28U W=0.36U AS=0.0972P AD=0.18P
+ PS=0.9U PD=1.72U
M$2987 \$404 RA15 VSS VSS nfet_03v3 L=0.28U W=0.36U AS=0.1656P AD=0.1944P
+ PS=1.64U PD=1.8U
M$2988 \$265 RA15 \$405 VSS nfet_03v3 L=0.28U W=0.36U AS=0.1584P AD=0.1152P
+ PS=1.6U PD=1U
M$2989 \$406 RB15 \$265 VSS nfet_03v3 L=0.28U W=0.36U AS=0.1152P AD=0.1584P
+ PS=1U PD=1.6U
M$2990 VSS RB15 \$407 VSS nfet_03v3 L=0.28U W=0.36U AS=0.1854P AD=0.1584P
+ PS=1.75U PD=1.6U
M$2991 \$294 \$74 VSS VSS nfet_03v3 L=0.28U W=0.36U AS=0.1584P AD=0.1188P
+ PS=1.6U PD=1.02U
M$2992 \$295 \$273 \$294 VSS nfet_03v3 L=0.28U W=0.36U AS=0.1188P AD=0.1278P
+ PS=1.02U PD=1.07U
M$2993 \$330 \$408 \$295 VSS nfet_03v3 L=0.28U W=0.36U AS=0.1278P AD=0.0567P
+ PS=1.07U PD=0.675U
M$2994 VSS \$492 \$330 VSS nfet_03v3 L=0.28U W=0.36U AS=0.0567P AD=0.1584P
+ PS=0.675U PD=1.6U
M$2995 VSS \$295 \$408 VSS nfet_03v3 L=0.28U W=0.36U AS=0.1584P AD=0.0972P
+ PS=1.6U PD=0.9U
M$2996 \$266 \$295 VSS VSS nfet_03v3 L=0.28U W=0.36U AS=0.0972P AD=0.18P
+ PS=0.9U PD=1.72U
M$2997 \$409 RA15 VSS VSS nfet_03v3 L=0.28U W=0.36U AS=0.1656P AD=0.1944P
+ PS=1.64U PD=1.8U
M$2998 \$266 RA15 \$410 VSS nfet_03v3 L=0.28U W=0.36U AS=0.1584P AD=0.1152P
+ PS=1.6U PD=1U
M$2999 \$411 RB15 \$266 VSS nfet_03v3 L=0.28U W=0.36U AS=0.1152P AD=0.1584P
+ PS=1U PD=1.6U
M$3000 VSS RB15 \$412 VSS nfet_03v3 L=0.28U W=0.36U AS=0.1854P AD=0.1584P
+ PS=1.75U PD=1.6U
M$3001 \$296 \$77 VSS VSS nfet_03v3 L=0.28U W=0.36U AS=0.1584P AD=0.1188P
+ PS=1.6U PD=1.02U
M$3002 \$297 \$273 \$296 VSS nfet_03v3 L=0.28U W=0.36U AS=0.1188P AD=0.1278P
+ PS=1.02U PD=1.07U
M$3003 \$326 \$413 \$297 VSS nfet_03v3 L=0.28U W=0.36U AS=0.1278P AD=0.0567P
+ PS=1.07U PD=0.675U
M$3004 VSS \$492 \$326 VSS nfet_03v3 L=0.28U W=0.36U AS=0.0567P AD=0.1584P
+ PS=0.675U PD=1.6U
M$3005 VSS \$297 \$413 VSS nfet_03v3 L=0.28U W=0.36U AS=0.1584P AD=0.0972P
+ PS=1.6U PD=0.9U
M$3006 \$267 \$297 VSS VSS nfet_03v3 L=0.28U W=0.36U AS=0.0972P AD=0.18P
+ PS=0.9U PD=1.72U
M$3007 \$414 RA15 VSS VSS nfet_03v3 L=0.28U W=0.36U AS=0.1656P AD=0.1944P
+ PS=1.64U PD=1.8U
M$3008 \$267 RA15 \$415 VSS nfet_03v3 L=0.28U W=0.36U AS=0.1584P AD=0.1152P
+ PS=1.6U PD=1U
M$3009 \$416 RB15 \$267 VSS nfet_03v3 L=0.28U W=0.36U AS=0.1152P AD=0.1584P
+ PS=1U PD=1.6U
M$3010 VSS RB15 \$417 VSS nfet_03v3 L=0.28U W=0.36U AS=0.1854P AD=0.1584P
+ PS=1.75U PD=1.6U
M$3011 \$298 \$80 VSS VSS nfet_03v3 L=0.28U W=0.36U AS=0.1584P AD=0.1188P
+ PS=1.6U PD=1.02U
M$3012 \$299 \$273 \$298 VSS nfet_03v3 L=0.28U W=0.36U AS=0.1188P AD=0.1278P
+ PS=1.02U PD=1.07U
M$3013 \$319 \$418 \$299 VSS nfet_03v3 L=0.28U W=0.36U AS=0.1278P AD=0.0567P
+ PS=1.07U PD=0.675U
M$3014 VSS \$492 \$319 VSS nfet_03v3 L=0.28U W=0.36U AS=0.0567P AD=0.1584P
+ PS=0.675U PD=1.6U
M$3015 VSS \$299 \$418 VSS nfet_03v3 L=0.28U W=0.36U AS=0.1584P AD=0.0972P
+ PS=1.6U PD=0.9U
M$3016 \$268 \$299 VSS VSS nfet_03v3 L=0.28U W=0.36U AS=0.0972P AD=0.18P
+ PS=0.9U PD=1.72U
M$3017 \$419 RA15 VSS VSS nfet_03v3 L=0.28U W=0.36U AS=0.1656P AD=0.1944P
+ PS=1.64U PD=1.8U
M$3018 \$268 RA15 \$420 VSS nfet_03v3 L=0.28U W=0.36U AS=0.1584P AD=0.1152P
+ PS=1.6U PD=1U
M$3019 \$421 RB15 \$268 VSS nfet_03v3 L=0.28U W=0.36U AS=0.1152P AD=0.1584P
+ PS=1U PD=1.6U
M$3020 VSS RB15 \$422 VSS nfet_03v3 L=0.28U W=0.36U AS=0.1854P AD=0.1584P
+ PS=1.75U PD=1.6U
M$3021 \$300 \$83 VSS VSS nfet_03v3 L=0.28U W=0.36U AS=0.1584P AD=0.1188P
+ PS=1.6U PD=1.02U
M$3022 \$301 \$273 \$300 VSS nfet_03v3 L=0.28U W=0.36U AS=0.1188P AD=0.1278P
+ PS=1.02U PD=1.07U
M$3023 \$316 \$423 \$301 VSS nfet_03v3 L=0.28U W=0.36U AS=0.1278P AD=0.0567P
+ PS=1.07U PD=0.675U
M$3024 VSS \$492 \$316 VSS nfet_03v3 L=0.28U W=0.36U AS=0.0567P AD=0.1584P
+ PS=0.675U PD=1.6U
M$3025 VSS \$301 \$423 VSS nfet_03v3 L=0.28U W=0.36U AS=0.1584P AD=0.0972P
+ PS=1.6U PD=0.9U
M$3026 \$269 \$301 VSS VSS nfet_03v3 L=0.28U W=0.36U AS=0.0972P AD=0.18P
+ PS=0.9U PD=1.72U
M$3027 \$424 RA15 VSS VSS nfet_03v3 L=0.28U W=0.36U AS=0.1656P AD=0.1944P
+ PS=1.64U PD=1.8U
M$3028 \$269 RA15 \$425 VSS nfet_03v3 L=0.28U W=0.36U AS=0.1584P AD=0.1152P
+ PS=1.6U PD=1U
M$3029 \$426 RB15 \$269 VSS nfet_03v3 L=0.28U W=0.36U AS=0.1152P AD=0.1584P
+ PS=1U PD=1.6U
M$3030 VSS RB15 \$427 VSS nfet_03v3 L=0.28U W=0.36U AS=0.1854P AD=0.1584P
+ PS=1.75U PD=1.6U
M$3031 \$302 \$86 VSS VSS nfet_03v3 L=0.28U W=0.36U AS=0.1584P AD=0.1188P
+ PS=1.6U PD=1.02U
M$3032 \$303 \$273 \$302 VSS nfet_03v3 L=0.28U W=0.36U AS=0.1188P AD=0.1278P
+ PS=1.02U PD=1.07U
M$3033 \$310 \$428 \$303 VSS nfet_03v3 L=0.28U W=0.36U AS=0.1278P AD=0.0567P
+ PS=1.07U PD=0.675U
M$3034 VSS \$492 \$310 VSS nfet_03v3 L=0.28U W=0.36U AS=0.0567P AD=0.1584P
+ PS=0.675U PD=1.6U
M$3035 VSS \$303 \$428 VSS nfet_03v3 L=0.28U W=0.36U AS=0.1584P AD=0.0972P
+ PS=1.6U PD=0.9U
M$3036 \$270 \$303 VSS VSS nfet_03v3 L=0.28U W=0.36U AS=0.0972P AD=0.18P
+ PS=0.9U PD=1.72U
M$3037 \$429 RA15 VSS VSS nfet_03v3 L=0.28U W=0.36U AS=0.1656P AD=0.1944P
+ PS=1.64U PD=1.8U
M$3038 \$270 RA15 \$430 VSS nfet_03v3 L=0.28U W=0.36U AS=0.1584P AD=0.1152P
+ PS=1.6U PD=1U
M$3039 \$431 RB15 \$270 VSS nfet_03v3 L=0.28U W=0.36U AS=0.1152P AD=0.1584P
+ PS=1U PD=1.6U
M$3040 VSS RB15 \$432 VSS nfet_03v3 L=0.28U W=0.36U AS=0.1854P AD=0.1584P
+ PS=1.75U PD=1.6U
M$3041 \$304 \$89 VSS VSS nfet_03v3 L=0.28U W=0.36U AS=0.1584P AD=0.1188P
+ PS=1.6U PD=1.02U
M$3042 \$305 \$273 \$304 VSS nfet_03v3 L=0.28U W=0.36U AS=0.1188P AD=0.1278P
+ PS=1.02U PD=1.07U
M$3043 \$307 \$433 \$305 VSS nfet_03v3 L=0.28U W=0.36U AS=0.1278P AD=0.0567P
+ PS=1.07U PD=0.675U
M$3044 VSS \$492 \$307 VSS nfet_03v3 L=0.28U W=0.36U AS=0.0567P AD=0.1584P
+ PS=0.675U PD=1.6U
M$3045 VSS \$305 \$433 VSS nfet_03v3 L=0.28U W=0.36U AS=0.1584P AD=0.0972P
+ PS=1.6U PD=0.9U
M$3046 \$271 \$305 VSS VSS nfet_03v3 L=0.28U W=0.36U AS=0.0972P AD=0.18P
+ PS=0.9U PD=1.72U
M$3047 \$434 RA15 VSS VSS nfet_03v3 L=0.28U W=0.36U AS=0.1656P AD=0.1944P
+ PS=1.64U PD=1.8U
M$3048 \$271 RA15 \$435 VSS nfet_03v3 L=0.28U W=0.36U AS=0.1584P AD=0.1152P
+ PS=1.6U PD=1U
M$3049 \$436 RB15 \$271 VSS nfet_03v3 L=0.28U W=0.36U AS=0.1152P AD=0.1584P
+ PS=1U PD=1.6U
M$3050 VSS RB15 \$437 VSS nfet_03v3 L=0.28U W=0.36U AS=0.1854P AD=0.1584P
+ PS=1.75U PD=1.6U
M$3051 \$803 WE14 VSS VSS nfet_03v3 L=0.28U W=0.72U AS=0.3168P AD=0.1872P
+ PS=2.32U PD=1.24U
M$3052 \$598 CLK \$803 VSS nfet_03v3 L=0.28U W=0.72U AS=0.1872P AD=0.3168P
+ PS=1.24U PD=2.32U
M$3053 \$600 \$598 VSS VSS nfet_03v3 L=0.28U W=1.27U AS=0.4487P AD=0.3302P
+ PS=3.34U PD=2.31U
M$3055 \$601 \$600 VSS VSS nfet_03v3 L=0.28U W=1.34U AS=0.3636P AD=0.4891P
+ PS=2.44U PD=3.47U
M$3057 \$608 RB14 VSS VSS nfet_03v3 L=0.28U W=0.36U AS=0.1656P AD=0.1944P
+ PS=1.64U PD=1.8U
M$3058 \$607 RB14 \$360 VSS nfet_03v3 L=0.28U W=0.36U AS=0.1584P AD=0.1152P
+ PS=1.6U PD=1U
M$3059 \$361 RA14 \$607 VSS nfet_03v3 L=0.28U W=0.36U AS=0.1152P AD=0.1584P
+ PS=1U PD=1.6U
M$3060 VSS RA14 \$609 VSS nfet_03v3 L=0.28U W=0.36U AS=0.1854P AD=0.1584P
+ PS=1.75U PD=1.6U
M$3061 \$614 RB14 VSS VSS nfet_03v3 L=0.28U W=0.36U AS=0.1656P AD=0.1944P
+ PS=1.64U PD=1.8U
M$3062 \$613 RB14 \$365 VSS nfet_03v3 L=0.28U W=0.36U AS=0.1584P AD=0.1152P
+ PS=1.6U PD=1U
M$3063 \$366 RA14 \$613 VSS nfet_03v3 L=0.28U W=0.36U AS=0.1152P AD=0.1584P
+ PS=1U PD=1.6U
M$3064 VSS RA14 \$615 VSS nfet_03v3 L=0.28U W=0.36U AS=0.1854P AD=0.1584P
+ PS=1.75U PD=1.6U
M$3065 \$620 RB14 VSS VSS nfet_03v3 L=0.28U W=0.36U AS=0.1656P AD=0.1944P
+ PS=1.64U PD=1.8U
M$3066 \$619 RB14 \$370 VSS nfet_03v3 L=0.28U W=0.36U AS=0.1584P AD=0.1152P
+ PS=1.6U PD=1U
M$3067 \$371 RA14 \$619 VSS nfet_03v3 L=0.28U W=0.36U AS=0.1152P AD=0.1584P
+ PS=1U PD=1.6U
M$3068 VSS RA14 \$621 VSS nfet_03v3 L=0.28U W=0.36U AS=0.1854P AD=0.1584P
+ PS=1.75U PD=1.6U
M$3069 \$626 RB14 VSS VSS nfet_03v3 L=0.28U W=0.36U AS=0.1656P AD=0.1944P
+ PS=1.64U PD=1.8U
M$3070 \$625 RB14 \$375 VSS nfet_03v3 L=0.28U W=0.36U AS=0.1584P AD=0.1152P
+ PS=1.6U PD=1U
M$3071 \$376 RA14 \$625 VSS nfet_03v3 L=0.28U W=0.36U AS=0.1152P AD=0.1584P
+ PS=1U PD=1.6U
M$3072 VSS RA14 \$627 VSS nfet_03v3 L=0.28U W=0.36U AS=0.1854P AD=0.1584P
+ PS=1.75U PD=1.6U
M$3073 \$632 RB14 VSS VSS nfet_03v3 L=0.28U W=0.36U AS=0.1656P AD=0.1944P
+ PS=1.64U PD=1.8U
M$3074 \$631 RB14 \$380 VSS nfet_03v3 L=0.28U W=0.36U AS=0.1584P AD=0.1152P
+ PS=1.6U PD=1U
M$3075 \$381 RA14 \$631 VSS nfet_03v3 L=0.28U W=0.36U AS=0.1152P AD=0.1584P
+ PS=1U PD=1.6U
M$3076 VSS RA14 \$633 VSS nfet_03v3 L=0.28U W=0.36U AS=0.1854P AD=0.1584P
+ PS=1.75U PD=1.6U
M$3077 \$638 RB14 VSS VSS nfet_03v3 L=0.28U W=0.36U AS=0.1656P AD=0.1944P
+ PS=1.64U PD=1.8U
M$3078 \$637 RB14 \$385 VSS nfet_03v3 L=0.28U W=0.36U AS=0.1584P AD=0.1152P
+ PS=1.6U PD=1U
M$3079 \$386 RA14 \$637 VSS nfet_03v3 L=0.28U W=0.36U AS=0.1152P AD=0.1584P
+ PS=1U PD=1.6U
M$3080 VSS RA14 \$639 VSS nfet_03v3 L=0.28U W=0.36U AS=0.1854P AD=0.1584P
+ PS=1.75U PD=1.6U
M$3081 \$644 RB14 VSS VSS nfet_03v3 L=0.28U W=0.36U AS=0.1656P AD=0.1944P
+ PS=1.64U PD=1.8U
M$3082 \$643 RB14 \$390 VSS nfet_03v3 L=0.28U W=0.36U AS=0.1584P AD=0.1152P
+ PS=1.6U PD=1U
M$3083 \$391 RA14 \$643 VSS nfet_03v3 L=0.28U W=0.36U AS=0.1152P AD=0.1584P
+ PS=1U PD=1.6U
M$3084 VSS RA14 \$645 VSS nfet_03v3 L=0.28U W=0.36U AS=0.1854P AD=0.1584P
+ PS=1.75U PD=1.6U
M$3085 \$650 RB14 VSS VSS nfet_03v3 L=0.28U W=0.36U AS=0.1656P AD=0.1944P
+ PS=1.64U PD=1.8U
M$3086 \$649 RB14 \$395 VSS nfet_03v3 L=0.28U W=0.36U AS=0.1584P AD=0.1152P
+ PS=1.6U PD=1U
M$3087 \$396 RA14 \$649 VSS nfet_03v3 L=0.28U W=0.36U AS=0.1152P AD=0.1584P
+ PS=1U PD=1.6U
M$3088 VSS RA14 \$651 VSS nfet_03v3 L=0.28U W=0.36U AS=0.1854P AD=0.1584P
+ PS=1.75U PD=1.6U
M$3089 \$656 RB14 VSS VSS nfet_03v3 L=0.28U W=0.36U AS=0.1656P AD=0.1944P
+ PS=1.64U PD=1.8U
M$3090 \$655 RB14 \$400 VSS nfet_03v3 L=0.28U W=0.36U AS=0.1584P AD=0.1152P
+ PS=1.6U PD=1U
M$3091 \$401 RA14 \$655 VSS nfet_03v3 L=0.28U W=0.36U AS=0.1152P AD=0.1584P
+ PS=1U PD=1.6U
M$3092 VSS RA14 \$657 VSS nfet_03v3 L=0.28U W=0.36U AS=0.1854P AD=0.1584P
+ PS=1.75U PD=1.6U
M$3093 \$662 RB14 VSS VSS nfet_03v3 L=0.28U W=0.36U AS=0.1656P AD=0.1944P
+ PS=1.64U PD=1.8U
M$3094 \$661 RB14 \$405 VSS nfet_03v3 L=0.28U W=0.36U AS=0.1584P AD=0.1152P
+ PS=1.6U PD=1U
M$3095 \$406 RA14 \$661 VSS nfet_03v3 L=0.28U W=0.36U AS=0.1152P AD=0.1584P
+ PS=1U PD=1.6U
M$3096 VSS RA14 \$663 VSS nfet_03v3 L=0.28U W=0.36U AS=0.1854P AD=0.1584P
+ PS=1.75U PD=1.6U
M$3097 \$668 RB14 VSS VSS nfet_03v3 L=0.28U W=0.36U AS=0.1656P AD=0.1944P
+ PS=1.64U PD=1.8U
M$3098 \$667 RB14 \$410 VSS nfet_03v3 L=0.28U W=0.36U AS=0.1584P AD=0.1152P
+ PS=1.6U PD=1U
M$3099 \$411 RA14 \$667 VSS nfet_03v3 L=0.28U W=0.36U AS=0.1152P AD=0.1584P
+ PS=1U PD=1.6U
M$3100 VSS RA14 \$669 VSS nfet_03v3 L=0.28U W=0.36U AS=0.1854P AD=0.1584P
+ PS=1.75U PD=1.6U
M$3101 \$674 RB14 VSS VSS nfet_03v3 L=0.28U W=0.36U AS=0.1656P AD=0.1944P
+ PS=1.64U PD=1.8U
M$3102 \$673 RB14 \$415 VSS nfet_03v3 L=0.28U W=0.36U AS=0.1584P AD=0.1152P
+ PS=1.6U PD=1U
M$3103 \$416 RA14 \$673 VSS nfet_03v3 L=0.28U W=0.36U AS=0.1152P AD=0.1584P
+ PS=1U PD=1.6U
M$3104 VSS RA14 \$675 VSS nfet_03v3 L=0.28U W=0.36U AS=0.1854P AD=0.1584P
+ PS=1.75U PD=1.6U
M$3105 \$680 RB14 VSS VSS nfet_03v3 L=0.28U W=0.36U AS=0.1656P AD=0.1944P
+ PS=1.64U PD=1.8U
M$3106 \$679 RB14 \$420 VSS nfet_03v3 L=0.28U W=0.36U AS=0.1584P AD=0.1152P
+ PS=1.6U PD=1U
M$3107 \$421 RA14 \$679 VSS nfet_03v3 L=0.28U W=0.36U AS=0.1152P AD=0.1584P
+ PS=1U PD=1.6U
M$3108 VSS RA14 \$681 VSS nfet_03v3 L=0.28U W=0.36U AS=0.1854P AD=0.1584P
+ PS=1.75U PD=1.6U
M$3109 \$686 RB14 VSS VSS nfet_03v3 L=0.28U W=0.36U AS=0.1656P AD=0.1944P
+ PS=1.64U PD=1.8U
M$3110 \$685 RB14 \$425 VSS nfet_03v3 L=0.28U W=0.36U AS=0.1584P AD=0.1152P
+ PS=1.6U PD=1U
M$3111 \$426 RA14 \$685 VSS nfet_03v3 L=0.28U W=0.36U AS=0.1152P AD=0.1584P
+ PS=1U PD=1.6U
M$3112 VSS RA14 \$687 VSS nfet_03v3 L=0.28U W=0.36U AS=0.1854P AD=0.1584P
+ PS=1.75U PD=1.6U
M$3113 \$692 RB14 VSS VSS nfet_03v3 L=0.28U W=0.36U AS=0.1656P AD=0.1944P
+ PS=1.64U PD=1.8U
M$3114 \$691 RB14 \$430 VSS nfet_03v3 L=0.28U W=0.36U AS=0.1584P AD=0.1152P
+ PS=1.6U PD=1U
M$3115 \$431 RA14 \$691 VSS nfet_03v3 L=0.28U W=0.36U AS=0.1152P AD=0.1584P
+ PS=1U PD=1.6U
M$3116 VSS RA14 \$693 VSS nfet_03v3 L=0.28U W=0.36U AS=0.1854P AD=0.1584P
+ PS=1.75U PD=1.6U
M$3117 \$698 RB14 VSS VSS nfet_03v3 L=0.28U W=0.36U AS=0.1656P AD=0.1944P
+ PS=1.64U PD=1.8U
M$3118 \$697 RB14 \$435 VSS nfet_03v3 L=0.28U W=0.36U AS=0.1584P AD=0.1152P
+ PS=1.6U PD=1U
M$3119 \$436 RA14 \$697 VSS nfet_03v3 L=0.28U W=0.36U AS=0.1152P AD=0.1584P
+ PS=1U PD=1.6U
M$3120 VSS RA14 \$699 VSS nfet_03v3 L=0.28U W=0.36U AS=0.1854P AD=0.1584P
+ PS=1.75U PD=1.6U
M$3121 \$604 \$44 VSS VSS nfet_03v3 L=0.28U W=0.36U AS=0.1584P AD=0.1188P
+ PS=1.6U PD=1.02U
M$3122 \$605 \$600 \$604 VSS nfet_03v3 L=0.28U W=0.36U AS=0.1188P AD=0.1278P
+ PS=1.02U PD=1.07U
M$3123 \$808 \$606 \$605 VSS nfet_03v3 L=0.28U W=0.36U AS=0.1278P AD=0.0567P
+ PS=1.07U PD=0.675U
M$3124 VSS \$601 \$808 VSS nfet_03v3 L=0.28U W=0.36U AS=0.0567P AD=0.1584P
+ PS=0.675U PD=1.6U
M$3125 VSS \$605 \$606 VSS nfet_03v3 L=0.28U W=0.36U AS=0.1584P AD=0.0972P
+ PS=1.6U PD=0.9U
M$3126 \$607 \$605 VSS VSS nfet_03v3 L=0.28U W=0.36U AS=0.0972P AD=0.18P
+ PS=0.9U PD=1.72U
M$3127 \$610 \$47 VSS VSS nfet_03v3 L=0.28U W=0.36U AS=0.1584P AD=0.1188P
+ PS=1.6U PD=1.02U
M$3128 \$611 \$600 \$610 VSS nfet_03v3 L=0.28U W=0.36U AS=0.1188P AD=0.1278P
+ PS=1.02U PD=1.07U
M$3129 \$817 \$612 \$611 VSS nfet_03v3 L=0.28U W=0.36U AS=0.1278P AD=0.0567P
+ PS=1.07U PD=0.675U
M$3130 VSS \$601 \$817 VSS nfet_03v3 L=0.28U W=0.36U AS=0.0567P AD=0.1584P
+ PS=0.675U PD=1.6U
M$3131 VSS \$611 \$612 VSS nfet_03v3 L=0.28U W=0.36U AS=0.1584P AD=0.0972P
+ PS=1.6U PD=0.9U
M$3132 \$613 \$611 VSS VSS nfet_03v3 L=0.28U W=0.36U AS=0.0972P AD=0.18P
+ PS=0.9U PD=1.72U
M$3133 \$616 \$50 VSS VSS nfet_03v3 L=0.28U W=0.36U AS=0.1584P AD=0.1188P
+ PS=1.6U PD=1.02U
M$3134 \$617 \$600 \$616 VSS nfet_03v3 L=0.28U W=0.36U AS=0.1188P AD=0.1278P
+ PS=1.02U PD=1.07U
M$3135 \$824 \$618 \$617 VSS nfet_03v3 L=0.28U W=0.36U AS=0.1278P AD=0.0567P
+ PS=1.07U PD=0.675U
M$3136 VSS \$601 \$824 VSS nfet_03v3 L=0.28U W=0.36U AS=0.0567P AD=0.1584P
+ PS=0.675U PD=1.6U
M$3137 VSS \$617 \$618 VSS nfet_03v3 L=0.28U W=0.36U AS=0.1584P AD=0.0972P
+ PS=1.6U PD=0.9U
M$3138 \$619 \$617 VSS VSS nfet_03v3 L=0.28U W=0.36U AS=0.0972P AD=0.18P
+ PS=0.9U PD=1.72U
M$3139 \$622 \$53 VSS VSS nfet_03v3 L=0.28U W=0.36U AS=0.1584P AD=0.1188P
+ PS=1.6U PD=1.02U
M$3140 \$623 \$600 \$622 VSS nfet_03v3 L=0.28U W=0.36U AS=0.1188P AD=0.1278P
+ PS=1.02U PD=1.07U
M$3141 \$832 \$624 \$623 VSS nfet_03v3 L=0.28U W=0.36U AS=0.1278P AD=0.0567P
+ PS=1.07U PD=0.675U
M$3142 VSS \$601 \$832 VSS nfet_03v3 L=0.28U W=0.36U AS=0.0567P AD=0.1584P
+ PS=0.675U PD=1.6U
M$3143 VSS \$623 \$624 VSS nfet_03v3 L=0.28U W=0.36U AS=0.1584P AD=0.0972P
+ PS=1.6U PD=0.9U
M$3144 \$625 \$623 VSS VSS nfet_03v3 L=0.28U W=0.36U AS=0.0972P AD=0.18P
+ PS=0.9U PD=1.72U
M$3145 \$628 \$56 VSS VSS nfet_03v3 L=0.28U W=0.36U AS=0.1584P AD=0.1188P
+ PS=1.6U PD=1.02U
M$3146 \$629 \$600 \$628 VSS nfet_03v3 L=0.28U W=0.36U AS=0.1188P AD=0.1278P
+ PS=1.02U PD=1.07U
M$3147 \$841 \$630 \$629 VSS nfet_03v3 L=0.28U W=0.36U AS=0.1278P AD=0.0567P
+ PS=1.07U PD=0.675U
M$3148 VSS \$601 \$841 VSS nfet_03v3 L=0.28U W=0.36U AS=0.0567P AD=0.1584P
+ PS=0.675U PD=1.6U
M$3149 VSS \$629 \$630 VSS nfet_03v3 L=0.28U W=0.36U AS=0.1584P AD=0.0972P
+ PS=1.6U PD=0.9U
M$3150 \$631 \$629 VSS VSS nfet_03v3 L=0.28U W=0.36U AS=0.0972P AD=0.18P
+ PS=0.9U PD=1.72U
M$3151 \$634 \$59 VSS VSS nfet_03v3 L=0.28U W=0.36U AS=0.1584P AD=0.1188P
+ PS=1.6U PD=1.02U
M$3152 \$635 \$600 \$634 VSS nfet_03v3 L=0.28U W=0.36U AS=0.1188P AD=0.1278P
+ PS=1.02U PD=1.07U
M$3153 \$848 \$636 \$635 VSS nfet_03v3 L=0.28U W=0.36U AS=0.1278P AD=0.0567P
+ PS=1.07U PD=0.675U
M$3154 VSS \$601 \$848 VSS nfet_03v3 L=0.28U W=0.36U AS=0.0567P AD=0.1584P
+ PS=0.675U PD=1.6U
M$3155 VSS \$635 \$636 VSS nfet_03v3 L=0.28U W=0.36U AS=0.1584P AD=0.0972P
+ PS=1.6U PD=0.9U
M$3156 \$637 \$635 VSS VSS nfet_03v3 L=0.28U W=0.36U AS=0.0972P AD=0.18P
+ PS=0.9U PD=1.72U
M$3157 \$640 \$62 VSS VSS nfet_03v3 L=0.28U W=0.36U AS=0.1584P AD=0.1188P
+ PS=1.6U PD=1.02U
M$3158 \$641 \$600 \$640 VSS nfet_03v3 L=0.28U W=0.36U AS=0.1188P AD=0.1278P
+ PS=1.02U PD=1.07U
M$3159 \$856 \$642 \$641 VSS nfet_03v3 L=0.28U W=0.36U AS=0.1278P AD=0.0567P
+ PS=1.07U PD=0.675U
M$3160 VSS \$601 \$856 VSS nfet_03v3 L=0.28U W=0.36U AS=0.0567P AD=0.1584P
+ PS=0.675U PD=1.6U
M$3161 VSS \$641 \$642 VSS nfet_03v3 L=0.28U W=0.36U AS=0.1584P AD=0.0972P
+ PS=1.6U PD=0.9U
M$3162 \$643 \$641 VSS VSS nfet_03v3 L=0.28U W=0.36U AS=0.0972P AD=0.18P
+ PS=0.9U PD=1.72U
M$3163 \$646 \$65 VSS VSS nfet_03v3 L=0.28U W=0.36U AS=0.1584P AD=0.1188P
+ PS=1.6U PD=1.02U
M$3164 \$647 \$600 \$646 VSS nfet_03v3 L=0.28U W=0.36U AS=0.1188P AD=0.1278P
+ PS=1.02U PD=1.07U
M$3165 \$865 \$648 \$647 VSS nfet_03v3 L=0.28U W=0.36U AS=0.1278P AD=0.0567P
+ PS=1.07U PD=0.675U
M$3166 VSS \$601 \$865 VSS nfet_03v3 L=0.28U W=0.36U AS=0.0567P AD=0.1584P
+ PS=0.675U PD=1.6U
M$3167 VSS \$647 \$648 VSS nfet_03v3 L=0.28U W=0.36U AS=0.1584P AD=0.0972P
+ PS=1.6U PD=0.9U
M$3168 \$649 \$647 VSS VSS nfet_03v3 L=0.28U W=0.36U AS=0.0972P AD=0.18P
+ PS=0.9U PD=1.72U
M$3169 \$652 \$68 VSS VSS nfet_03v3 L=0.28U W=0.36U AS=0.1584P AD=0.1188P
+ PS=1.6U PD=1.02U
M$3170 \$653 \$600 \$652 VSS nfet_03v3 L=0.28U W=0.36U AS=0.1188P AD=0.1278P
+ PS=1.02U PD=1.07U
M$3171 \$872 \$654 \$653 VSS nfet_03v3 L=0.28U W=0.36U AS=0.1278P AD=0.0567P
+ PS=1.07U PD=0.675U
M$3172 VSS \$601 \$872 VSS nfet_03v3 L=0.28U W=0.36U AS=0.0567P AD=0.1584P
+ PS=0.675U PD=1.6U
M$3173 VSS \$653 \$654 VSS nfet_03v3 L=0.28U W=0.36U AS=0.1584P AD=0.0972P
+ PS=1.6U PD=0.9U
M$3174 \$655 \$653 VSS VSS nfet_03v3 L=0.28U W=0.36U AS=0.0972P AD=0.18P
+ PS=0.9U PD=1.72U
M$3175 \$658 \$71 VSS VSS nfet_03v3 L=0.28U W=0.36U AS=0.1584P AD=0.1188P
+ PS=1.6U PD=1.02U
M$3176 \$659 \$600 \$658 VSS nfet_03v3 L=0.28U W=0.36U AS=0.1188P AD=0.1278P
+ PS=1.02U PD=1.07U
M$3177 \$880 \$660 \$659 VSS nfet_03v3 L=0.28U W=0.36U AS=0.1278P AD=0.0567P
+ PS=1.07U PD=0.675U
M$3178 VSS \$601 \$880 VSS nfet_03v3 L=0.28U W=0.36U AS=0.0567P AD=0.1584P
+ PS=0.675U PD=1.6U
M$3179 VSS \$659 \$660 VSS nfet_03v3 L=0.28U W=0.36U AS=0.1584P AD=0.0972P
+ PS=1.6U PD=0.9U
M$3180 \$661 \$659 VSS VSS nfet_03v3 L=0.28U W=0.36U AS=0.0972P AD=0.18P
+ PS=0.9U PD=1.72U
M$3181 \$664 \$74 VSS VSS nfet_03v3 L=0.28U W=0.36U AS=0.1584P AD=0.1188P
+ PS=1.6U PD=1.02U
M$3182 \$665 \$600 \$664 VSS nfet_03v3 L=0.28U W=0.36U AS=0.1188P AD=0.1278P
+ PS=1.02U PD=1.07U
M$3183 \$889 \$666 \$665 VSS nfet_03v3 L=0.28U W=0.36U AS=0.1278P AD=0.0567P
+ PS=1.07U PD=0.675U
M$3184 VSS \$601 \$889 VSS nfet_03v3 L=0.28U W=0.36U AS=0.0567P AD=0.1584P
+ PS=0.675U PD=1.6U
M$3185 VSS \$665 \$666 VSS nfet_03v3 L=0.28U W=0.36U AS=0.1584P AD=0.0972P
+ PS=1.6U PD=0.9U
M$3186 \$667 \$665 VSS VSS nfet_03v3 L=0.28U W=0.36U AS=0.0972P AD=0.18P
+ PS=0.9U PD=1.72U
M$3187 \$670 \$77 VSS VSS nfet_03v3 L=0.28U W=0.36U AS=0.1584P AD=0.1188P
+ PS=1.6U PD=1.02U
M$3188 \$671 \$600 \$670 VSS nfet_03v3 L=0.28U W=0.36U AS=0.1188P AD=0.1278P
+ PS=1.02U PD=1.07U
M$3189 \$896 \$672 \$671 VSS nfet_03v3 L=0.28U W=0.36U AS=0.1278P AD=0.0567P
+ PS=1.07U PD=0.675U
M$3190 VSS \$601 \$896 VSS nfet_03v3 L=0.28U W=0.36U AS=0.0567P AD=0.1584P
+ PS=0.675U PD=1.6U
M$3191 VSS \$671 \$672 VSS nfet_03v3 L=0.28U W=0.36U AS=0.1584P AD=0.0972P
+ PS=1.6U PD=0.9U
M$3192 \$673 \$671 VSS VSS nfet_03v3 L=0.28U W=0.36U AS=0.0972P AD=0.18P
+ PS=0.9U PD=1.72U
M$3193 \$676 \$80 VSS VSS nfet_03v3 L=0.28U W=0.36U AS=0.1584P AD=0.1188P
+ PS=1.6U PD=1.02U
M$3194 \$677 \$600 \$676 VSS nfet_03v3 L=0.28U W=0.36U AS=0.1188P AD=0.1278P
+ PS=1.02U PD=1.07U
M$3195 \$888 \$678 \$677 VSS nfet_03v3 L=0.28U W=0.36U AS=0.1278P AD=0.0567P
+ PS=1.07U PD=0.675U
M$3196 VSS \$601 \$888 VSS nfet_03v3 L=0.28U W=0.36U AS=0.0567P AD=0.1584P
+ PS=0.675U PD=1.6U
M$3197 VSS \$677 \$678 VSS nfet_03v3 L=0.28U W=0.36U AS=0.1584P AD=0.0972P
+ PS=1.6U PD=0.9U
M$3198 \$679 \$677 VSS VSS nfet_03v3 L=0.28U W=0.36U AS=0.0972P AD=0.18P
+ PS=0.9U PD=1.72U
M$3199 \$682 \$83 VSS VSS nfet_03v3 L=0.28U W=0.36U AS=0.1584P AD=0.1188P
+ PS=1.6U PD=1.02U
M$3200 \$683 \$600 \$682 VSS nfet_03v3 L=0.28U W=0.36U AS=0.1188P AD=0.1278P
+ PS=1.02U PD=1.07U
M$3201 \$864 \$684 \$683 VSS nfet_03v3 L=0.28U W=0.36U AS=0.1278P AD=0.0567P
+ PS=1.07U PD=0.675U
M$3202 VSS \$601 \$864 VSS nfet_03v3 L=0.28U W=0.36U AS=0.0567P AD=0.1584P
+ PS=0.675U PD=1.6U
M$3203 VSS \$683 \$684 VSS nfet_03v3 L=0.28U W=0.36U AS=0.1584P AD=0.0972P
+ PS=1.6U PD=0.9U
M$3204 \$685 \$683 VSS VSS nfet_03v3 L=0.28U W=0.36U AS=0.0972P AD=0.18P
+ PS=0.9U PD=1.72U
M$3205 \$688 \$86 VSS VSS nfet_03v3 L=0.28U W=0.36U AS=0.1584P AD=0.1188P
+ PS=1.6U PD=1.02U
M$3206 \$689 \$600 \$688 VSS nfet_03v3 L=0.28U W=0.36U AS=0.1188P AD=0.1278P
+ PS=1.02U PD=1.07U
M$3207 \$840 \$690 \$689 VSS nfet_03v3 L=0.28U W=0.36U AS=0.1278P AD=0.0567P
+ PS=1.07U PD=0.675U
M$3208 VSS \$601 \$840 VSS nfet_03v3 L=0.28U W=0.36U AS=0.0567P AD=0.1584P
+ PS=0.675U PD=1.6U
M$3209 VSS \$689 \$690 VSS nfet_03v3 L=0.28U W=0.36U AS=0.1584P AD=0.0972P
+ PS=1.6U PD=0.9U
M$3210 \$691 \$689 VSS VSS nfet_03v3 L=0.28U W=0.36U AS=0.0972P AD=0.18P
+ PS=0.9U PD=1.72U
M$3211 \$694 \$89 VSS VSS nfet_03v3 L=0.28U W=0.36U AS=0.1584P AD=0.1188P
+ PS=1.6U PD=1.02U
M$3212 \$695 \$600 \$694 VSS nfet_03v3 L=0.28U W=0.36U AS=0.1188P AD=0.1278P
+ PS=1.02U PD=1.07U
M$3213 \$816 \$696 \$695 VSS nfet_03v3 L=0.28U W=0.36U AS=0.1278P AD=0.0567P
+ PS=1.07U PD=0.675U
M$3214 VSS \$601 \$816 VSS nfet_03v3 L=0.28U W=0.36U AS=0.0567P AD=0.1584P
+ PS=0.675U PD=1.6U
M$3215 VSS \$695 \$696 VSS nfet_03v3 L=0.28U W=0.36U AS=0.1584P AD=0.0972P
+ PS=1.6U PD=0.9U
M$3216 \$697 \$695 VSS VSS nfet_03v3 L=0.28U W=0.36U AS=0.0972P AD=0.18P
+ PS=0.9U PD=1.72U
M$3217 \$1056 WE13 VSS VSS nfet_03v3 L=0.28U W=0.72U AS=0.3168P AD=0.1872P
+ PS=2.32U PD=1.24U
M$3218 \$901 CLK \$1056 VSS nfet_03v3 L=0.28U W=0.72U AS=0.1872P AD=0.3168P
+ PS=1.24U PD=2.32U
M$3219 \$902 \$901 VSS VSS nfet_03v3 L=0.28U W=1.27U AS=0.4445P AD=0.3344P
+ PS=3.305U PD=2.345U
M$3221 \$903 \$902 VSS VSS nfet_03v3 L=0.28U W=1.34U AS=0.3636P AD=0.4891P
+ PS=2.44U PD=3.47U
M$3223 \$904 \$44 VSS VSS nfet_03v3 L=0.28U W=0.36U AS=0.1584P AD=0.1188P
+ PS=1.6U PD=1.02U
M$3224 \$905 \$902 \$904 VSS nfet_03v3 L=0.28U W=0.36U AS=0.1188P AD=0.1278P
+ PS=1.02U PD=1.07U
M$3225 \$973 \$906 \$905 VSS nfet_03v3 L=0.28U W=0.36U AS=0.1278P AD=0.0567P
+ PS=1.07U PD=0.675U
M$3226 VSS \$903 \$973 VSS nfet_03v3 L=0.28U W=0.36U AS=0.0567P AD=0.1584P
+ PS=0.675U PD=1.6U
M$3227 VSS \$905 \$906 VSS nfet_03v3 L=0.28U W=0.36U AS=0.1584P AD=0.0972P
+ PS=1.6U PD=0.9U
M$3228 \$907 \$905 VSS VSS nfet_03v3 L=0.28U W=0.36U AS=0.0972P AD=0.18P
+ PS=0.9U PD=1.72U
M$3229 \$908 \$47 VSS VSS nfet_03v3 L=0.28U W=0.36U AS=0.1584P AD=0.1188P
+ PS=1.6U PD=1.02U
M$3230 \$909 \$902 \$908 VSS nfet_03v3 L=0.28U W=0.36U AS=0.1188P AD=0.1278P
+ PS=1.02U PD=1.07U
M$3231 \$983 \$910 \$909 VSS nfet_03v3 L=0.28U W=0.36U AS=0.1278P AD=0.0567P
+ PS=1.07U PD=0.675U
M$3232 VSS \$903 \$983 VSS nfet_03v3 L=0.28U W=0.36U AS=0.0567P AD=0.1584P
+ PS=0.675U PD=1.6U
M$3233 VSS \$909 \$910 VSS nfet_03v3 L=0.28U W=0.36U AS=0.1584P AD=0.0972P
+ PS=1.6U PD=0.9U
M$3234 \$911 \$909 VSS VSS nfet_03v3 L=0.28U W=0.36U AS=0.0972P AD=0.18P
+ PS=0.9U PD=1.72U
M$3235 \$912 \$50 VSS VSS nfet_03v3 L=0.28U W=0.36U AS=0.1584P AD=0.1188P
+ PS=1.6U PD=1.02U
M$3236 \$913 \$902 \$912 VSS nfet_03v3 L=0.28U W=0.36U AS=0.1188P AD=0.1278P
+ PS=1.02U PD=1.07U
M$3237 \$991 \$914 \$913 VSS nfet_03v3 L=0.28U W=0.36U AS=0.1278P AD=0.0567P
+ PS=1.07U PD=0.675U
M$3238 VSS \$903 \$991 VSS nfet_03v3 L=0.28U W=0.36U AS=0.0567P AD=0.1584P
+ PS=0.675U PD=1.6U
M$3239 VSS \$913 \$914 VSS nfet_03v3 L=0.28U W=0.36U AS=0.1584P AD=0.0972P
+ PS=1.6U PD=0.9U
M$3240 \$915 \$913 VSS VSS nfet_03v3 L=0.28U W=0.36U AS=0.0972P AD=0.18P
+ PS=0.9U PD=1.72U
M$3241 \$916 \$53 VSS VSS nfet_03v3 L=0.28U W=0.36U AS=0.1584P AD=0.1188P
+ PS=1.6U PD=1.02U
M$3242 \$917 \$902 \$916 VSS nfet_03v3 L=0.28U W=0.36U AS=0.1188P AD=0.1278P
+ PS=1.02U PD=1.07U
M$3243 \$1000 \$918 \$917 VSS nfet_03v3 L=0.28U W=0.36U AS=0.1278P AD=0.0567P
+ PS=1.07U PD=0.675U
M$3244 VSS \$903 \$1000 VSS nfet_03v3 L=0.28U W=0.36U AS=0.0567P AD=0.1584P
+ PS=0.675U PD=1.6U
M$3245 VSS \$917 \$918 VSS nfet_03v3 L=0.28U W=0.36U AS=0.1584P AD=0.0972P
+ PS=1.6U PD=0.9U
M$3246 \$919 \$917 VSS VSS nfet_03v3 L=0.28U W=0.36U AS=0.0972P AD=0.18P
+ PS=0.9U PD=1.72U
M$3247 \$920 \$56 VSS VSS nfet_03v3 L=0.28U W=0.36U AS=0.1584P AD=0.1188P
+ PS=1.6U PD=1.02U
M$3248 \$921 \$902 \$920 VSS nfet_03v3 L=0.28U W=0.36U AS=0.1188P AD=0.1278P
+ PS=1.02U PD=1.07U
M$3249 \$1009 \$922 \$921 VSS nfet_03v3 L=0.28U W=0.36U AS=0.1278P AD=0.0567P
+ PS=1.07U PD=0.675U
M$3250 VSS \$903 \$1009 VSS nfet_03v3 L=0.28U W=0.36U AS=0.0567P AD=0.1584P
+ PS=0.675U PD=1.6U
M$3251 VSS \$921 \$922 VSS nfet_03v3 L=0.28U W=0.36U AS=0.1584P AD=0.0972P
+ PS=1.6U PD=0.9U
M$3252 \$923 \$921 VSS VSS nfet_03v3 L=0.28U W=0.36U AS=0.0972P AD=0.18P
+ PS=0.9U PD=1.72U
M$3253 \$924 \$59 VSS VSS nfet_03v3 L=0.28U W=0.36U AS=0.1584P AD=0.1188P
+ PS=1.6U PD=1.02U
M$3254 \$925 \$902 \$924 VSS nfet_03v3 L=0.28U W=0.36U AS=0.1188P AD=0.1278P
+ PS=1.02U PD=1.07U
M$3255 \$1017 \$926 \$925 VSS nfet_03v3 L=0.28U W=0.36U AS=0.1278P AD=0.0567P
+ PS=1.07U PD=0.675U
M$3256 VSS \$903 \$1017 VSS nfet_03v3 L=0.28U W=0.36U AS=0.0567P AD=0.1584P
+ PS=0.675U PD=1.6U
M$3257 VSS \$925 \$926 VSS nfet_03v3 L=0.28U W=0.36U AS=0.1584P AD=0.0972P
+ PS=1.6U PD=0.9U
M$3258 \$927 \$925 VSS VSS nfet_03v3 L=0.28U W=0.36U AS=0.0972P AD=0.18P
+ PS=0.9U PD=1.72U
M$3259 \$928 \$62 VSS VSS nfet_03v3 L=0.28U W=0.36U AS=0.1584P AD=0.1188P
+ PS=1.6U PD=1.02U
M$3260 \$929 \$902 \$928 VSS nfet_03v3 L=0.28U W=0.36U AS=0.1188P AD=0.1278P
+ PS=1.02U PD=1.07U
M$3261 \$1020 \$930 \$929 VSS nfet_03v3 L=0.28U W=0.36U AS=0.1278P AD=0.0567P
+ PS=1.07U PD=0.675U
M$3262 VSS \$903 \$1020 VSS nfet_03v3 L=0.28U W=0.36U AS=0.0567P AD=0.1584P
+ PS=0.675U PD=1.6U
M$3263 VSS \$929 \$930 VSS nfet_03v3 L=0.28U W=0.36U AS=0.1584P AD=0.0972P
+ PS=1.6U PD=0.9U
M$3264 \$931 \$929 VSS VSS nfet_03v3 L=0.28U W=0.36U AS=0.0972P AD=0.18P
+ PS=0.9U PD=1.72U
M$3265 \$932 \$65 VSS VSS nfet_03v3 L=0.28U W=0.36U AS=0.1584P AD=0.1188P
+ PS=1.6U PD=1.02U
M$3266 \$933 \$902 \$932 VSS nfet_03v3 L=0.28U W=0.36U AS=0.1188P AD=0.1278P
+ PS=1.02U PD=1.07U
M$3267 \$1014 \$934 \$933 VSS nfet_03v3 L=0.28U W=0.36U AS=0.1278P AD=0.0567P
+ PS=1.07U PD=0.675U
M$3268 VSS \$903 \$1014 VSS nfet_03v3 L=0.28U W=0.36U AS=0.0567P AD=0.1584P
+ PS=0.675U PD=1.6U
M$3269 VSS \$933 \$934 VSS nfet_03v3 L=0.28U W=0.36U AS=0.1584P AD=0.0972P
+ PS=1.6U PD=0.9U
M$3270 \$935 \$933 VSS VSS nfet_03v3 L=0.28U W=0.36U AS=0.0972P AD=0.18P
+ PS=0.9U PD=1.72U
M$3271 \$936 \$68 VSS VSS nfet_03v3 L=0.28U W=0.36U AS=0.1584P AD=0.1188P
+ PS=1.6U PD=1.02U
M$3272 \$937 \$902 \$936 VSS nfet_03v3 L=0.28U W=0.36U AS=0.1188P AD=0.1278P
+ PS=1.02U PD=1.07U
M$3273 \$1008 \$938 \$937 VSS nfet_03v3 L=0.28U W=0.36U AS=0.1278P AD=0.0567P
+ PS=1.07U PD=0.675U
M$3274 VSS \$903 \$1008 VSS nfet_03v3 L=0.28U W=0.36U AS=0.0567P AD=0.1584P
+ PS=0.675U PD=1.6U
M$3275 VSS \$937 \$938 VSS nfet_03v3 L=0.28U W=0.36U AS=0.1584P AD=0.0972P
+ PS=1.6U PD=0.9U
M$3276 \$939 \$937 VSS VSS nfet_03v3 L=0.28U W=0.36U AS=0.0972P AD=0.18P
+ PS=0.9U PD=1.72U
M$3277 \$940 \$71 VSS VSS nfet_03v3 L=0.28U W=0.36U AS=0.1584P AD=0.1188P
+ PS=1.6U PD=1.02U
M$3278 \$941 \$902 \$940 VSS nfet_03v3 L=0.28U W=0.36U AS=0.1188P AD=0.1278P
+ PS=1.02U PD=1.07U
M$3279 \$1004 \$942 \$941 VSS nfet_03v3 L=0.28U W=0.36U AS=0.1278P AD=0.0567P
+ PS=1.07U PD=0.675U
M$3280 VSS \$903 \$1004 VSS nfet_03v3 L=0.28U W=0.36U AS=0.0567P AD=0.1584P
+ PS=0.675U PD=1.6U
M$3281 VSS \$941 \$942 VSS nfet_03v3 L=0.28U W=0.36U AS=0.1584P AD=0.0972P
+ PS=1.6U PD=0.9U
M$3282 \$943 \$941 VSS VSS nfet_03v3 L=0.28U W=0.36U AS=0.0972P AD=0.18P
+ PS=0.9U PD=1.72U
M$3283 \$944 \$74 VSS VSS nfet_03v3 L=0.28U W=0.36U AS=0.1584P AD=0.1188P
+ PS=1.6U PD=1.02U
M$3284 \$945 \$902 \$944 VSS nfet_03v3 L=0.28U W=0.36U AS=0.1188P AD=0.1278P
+ PS=1.02U PD=1.07U
M$3285 \$997 \$946 \$945 VSS nfet_03v3 L=0.28U W=0.36U AS=0.1278P AD=0.0567P
+ PS=1.07U PD=0.675U
M$3286 VSS \$903 \$997 VSS nfet_03v3 L=0.28U W=0.36U AS=0.0567P AD=0.1584P
+ PS=0.675U PD=1.6U
M$3287 VSS \$945 \$946 VSS nfet_03v3 L=0.28U W=0.36U AS=0.1584P AD=0.0972P
+ PS=1.6U PD=0.9U
M$3288 \$947 \$945 VSS VSS nfet_03v3 L=0.28U W=0.36U AS=0.0972P AD=0.18P
+ PS=0.9U PD=1.72U
M$3289 \$948 \$77 VSS VSS nfet_03v3 L=0.28U W=0.36U AS=0.1584P AD=0.1188P
+ PS=1.6U PD=1.02U
M$3290 \$949 \$902 \$948 VSS nfet_03v3 L=0.28U W=0.36U AS=0.1188P AD=0.1278P
+ PS=1.02U PD=1.07U
M$3291 \$993 \$950 \$949 VSS nfet_03v3 L=0.28U W=0.36U AS=0.1278P AD=0.0567P
+ PS=1.07U PD=0.675U
M$3292 VSS \$903 \$993 VSS nfet_03v3 L=0.28U W=0.36U AS=0.0567P AD=0.1584P
+ PS=0.675U PD=1.6U
M$3293 VSS \$949 \$950 VSS nfet_03v3 L=0.28U W=0.36U AS=0.1584P AD=0.0972P
+ PS=1.6U PD=0.9U
M$3294 \$951 \$949 VSS VSS nfet_03v3 L=0.28U W=0.36U AS=0.0972P AD=0.18P
+ PS=0.9U PD=1.72U
M$3295 \$952 \$80 VSS VSS nfet_03v3 L=0.28U W=0.36U AS=0.1584P AD=0.1188P
+ PS=1.6U PD=1.02U
M$3296 \$953 \$902 \$952 VSS nfet_03v3 L=0.28U W=0.36U AS=0.1188P AD=0.1278P
+ PS=1.02U PD=1.07U
M$3297 \$988 \$954 \$953 VSS nfet_03v3 L=0.28U W=0.36U AS=0.1278P AD=0.0567P
+ PS=1.07U PD=0.675U
M$3298 VSS \$903 \$988 VSS nfet_03v3 L=0.28U W=0.36U AS=0.0567P AD=0.1584P
+ PS=0.675U PD=1.6U
M$3299 VSS \$953 \$954 VSS nfet_03v3 L=0.28U W=0.36U AS=0.1584P AD=0.0972P
+ PS=1.6U PD=0.9U
M$3300 \$955 \$953 VSS VSS nfet_03v3 L=0.28U W=0.36U AS=0.0972P AD=0.18P
+ PS=0.9U PD=1.72U
M$3301 \$956 \$83 VSS VSS nfet_03v3 L=0.28U W=0.36U AS=0.1584P AD=0.1188P
+ PS=1.6U PD=1.02U
M$3302 \$957 \$902 \$956 VSS nfet_03v3 L=0.28U W=0.36U AS=0.1188P AD=0.1278P
+ PS=1.02U PD=1.07U
M$3303 \$981 \$958 \$957 VSS nfet_03v3 L=0.28U W=0.36U AS=0.1278P AD=0.0567P
+ PS=1.07U PD=0.675U
M$3304 VSS \$903 \$981 VSS nfet_03v3 L=0.28U W=0.36U AS=0.0567P AD=0.1584P
+ PS=0.675U PD=1.6U
M$3305 VSS \$957 \$958 VSS nfet_03v3 L=0.28U W=0.36U AS=0.1584P AD=0.0972P
+ PS=1.6U PD=0.9U
M$3306 \$959 \$957 VSS VSS nfet_03v3 L=0.28U W=0.36U AS=0.0972P AD=0.18P
+ PS=0.9U PD=1.72U
M$3307 \$960 \$86 VSS VSS nfet_03v3 L=0.28U W=0.36U AS=0.1584P AD=0.1188P
+ PS=1.6U PD=1.02U
M$3308 \$961 \$902 \$960 VSS nfet_03v3 L=0.28U W=0.36U AS=0.1188P AD=0.1278P
+ PS=1.02U PD=1.07U
M$3309 \$977 \$962 \$961 VSS nfet_03v3 L=0.28U W=0.36U AS=0.1278P AD=0.0567P
+ PS=1.07U PD=0.675U
M$3310 VSS \$903 \$977 VSS nfet_03v3 L=0.28U W=0.36U AS=0.0567P AD=0.1584P
+ PS=0.675U PD=1.6U
M$3311 VSS \$961 \$962 VSS nfet_03v3 L=0.28U W=0.36U AS=0.1584P AD=0.0972P
+ PS=1.6U PD=0.9U
M$3312 \$963 \$961 VSS VSS nfet_03v3 L=0.28U W=0.36U AS=0.0972P AD=0.18P
+ PS=0.9U PD=1.72U
M$3313 \$964 \$89 VSS VSS nfet_03v3 L=0.28U W=0.36U AS=0.1584P AD=0.1188P
+ PS=1.6U PD=1.02U
M$3314 \$965 \$902 \$964 VSS nfet_03v3 L=0.28U W=0.36U AS=0.1188P AD=0.1278P
+ PS=1.02U PD=1.07U
M$3315 \$970 \$966 \$965 VSS nfet_03v3 L=0.28U W=0.36U AS=0.1278P AD=0.0567P
+ PS=1.07U PD=0.675U
M$3316 VSS \$903 \$970 VSS nfet_03v3 L=0.28U W=0.36U AS=0.0567P AD=0.1584P
+ PS=0.675U PD=1.6U
M$3317 VSS \$965 \$966 VSS nfet_03v3 L=0.28U W=0.36U AS=0.1584P AD=0.0972P
+ PS=1.6U PD=0.9U
M$3318 \$967 \$965 VSS VSS nfet_03v3 L=0.28U W=0.36U AS=0.0972P AD=0.18P
+ PS=0.9U PD=1.72U
M$3319 \$1024 RA13 VSS VSS nfet_03v3 L=0.28U W=0.36U AS=0.1656P AD=0.1944P
+ PS=1.64U PD=1.8U
M$3320 \$1227 RB12 VSS VSS nfet_03v3 L=0.28U W=0.36U AS=0.1656P AD=0.1944P
+ PS=1.64U PD=1.8U
M$3321 \$1226 RB12 \$360 VSS nfet_03v3 L=0.28U W=0.36U AS=0.1584P AD=0.1152P
+ PS=1.6U PD=1U
M$3322 \$361 RA12 \$1226 VSS nfet_03v3 L=0.28U W=0.36U AS=0.1152P AD=0.1584P
+ PS=1U PD=1.6U
M$3323 \$907 RA13 \$360 VSS nfet_03v3 L=0.28U W=0.36U AS=0.1584P AD=0.1152P
+ PS=1.6U PD=1U
M$3324 \$361 RB13 \$907 VSS nfet_03v3 L=0.28U W=0.36U AS=0.1152P AD=0.1584P
+ PS=1U PD=1.6U
M$3325 VSS RB13 \$1025 VSS nfet_03v3 L=0.28U W=0.36U AS=0.1854P AD=0.1584P
+ PS=1.75U PD=1.6U
M$3326 VSS RA12 \$1228 VSS nfet_03v3 L=0.28U W=0.36U AS=0.1854P AD=0.1584P
+ PS=1.75U PD=1.6U
M$3327 \$1026 RA13 VSS VSS nfet_03v3 L=0.28U W=0.36U AS=0.1656P AD=0.1944P
+ PS=1.64U PD=1.8U
M$3328 \$1233 RB12 VSS VSS nfet_03v3 L=0.28U W=0.36U AS=0.1656P AD=0.1944P
+ PS=1.64U PD=1.8U
M$3329 \$911 RA13 \$365 VSS nfet_03v3 L=0.28U W=0.36U AS=0.1584P AD=0.1152P
+ PS=1.6U PD=1U
M$3330 \$366 RB13 \$911 VSS nfet_03v3 L=0.28U W=0.36U AS=0.1152P AD=0.1584P
+ PS=1U PD=1.6U
M$3331 \$1232 RB12 \$365 VSS nfet_03v3 L=0.28U W=0.36U AS=0.1584P AD=0.1152P
+ PS=1.6U PD=1U
M$3332 \$366 RA12 \$1232 VSS nfet_03v3 L=0.28U W=0.36U AS=0.1152P AD=0.1584P
+ PS=1U PD=1.6U
M$3333 VSS RA12 \$1234 VSS nfet_03v3 L=0.28U W=0.36U AS=0.1854P AD=0.1584P
+ PS=1.75U PD=1.6U
M$3334 VSS RB13 \$1027 VSS nfet_03v3 L=0.28U W=0.36U AS=0.1854P AD=0.1584P
+ PS=1.75U PD=1.6U
M$3335 \$1028 RA13 VSS VSS nfet_03v3 L=0.28U W=0.36U AS=0.1656P AD=0.1944P
+ PS=1.64U PD=1.8U
M$3336 \$1239 RB12 VSS VSS nfet_03v3 L=0.28U W=0.36U AS=0.1656P AD=0.1944P
+ PS=1.64U PD=1.8U
M$3337 \$1238 RB12 \$370 VSS nfet_03v3 L=0.28U W=0.36U AS=0.1584P AD=0.1152P
+ PS=1.6U PD=1U
M$3338 \$371 RA12 \$1238 VSS nfet_03v3 L=0.28U W=0.36U AS=0.1152P AD=0.1584P
+ PS=1U PD=1.6U
M$3339 \$915 RA13 \$370 VSS nfet_03v3 L=0.28U W=0.36U AS=0.1584P AD=0.1152P
+ PS=1.6U PD=1U
M$3340 \$371 RB13 \$915 VSS nfet_03v3 L=0.28U W=0.36U AS=0.1152P AD=0.1584P
+ PS=1U PD=1.6U
M$3341 VSS RA12 \$1240 VSS nfet_03v3 L=0.28U W=0.36U AS=0.1854P AD=0.1584P
+ PS=1.75U PD=1.6U
M$3342 VSS RB13 \$1029 VSS nfet_03v3 L=0.28U W=0.36U AS=0.1854P AD=0.1584P
+ PS=1.75U PD=1.6U
M$3343 \$1030 RA13 VSS VSS nfet_03v3 L=0.28U W=0.36U AS=0.1656P AD=0.1944P
+ PS=1.64U PD=1.8U
M$3344 \$1245 RB12 VSS VSS nfet_03v3 L=0.28U W=0.36U AS=0.1656P AD=0.1944P
+ PS=1.64U PD=1.8U
M$3345 \$919 RA13 \$375 VSS nfet_03v3 L=0.28U W=0.36U AS=0.1584P AD=0.1152P
+ PS=1.6U PD=1U
M$3346 \$376 RB13 \$919 VSS nfet_03v3 L=0.28U W=0.36U AS=0.1152P AD=0.1584P
+ PS=1U PD=1.6U
M$3347 \$1244 RB12 \$375 VSS nfet_03v3 L=0.28U W=0.36U AS=0.1584P AD=0.1152P
+ PS=1.6U PD=1U
M$3348 \$376 RA12 \$1244 VSS nfet_03v3 L=0.28U W=0.36U AS=0.1152P AD=0.1584P
+ PS=1U PD=1.6U
M$3349 VSS RB13 \$1031 VSS nfet_03v3 L=0.28U W=0.36U AS=0.1854P AD=0.1584P
+ PS=1.75U PD=1.6U
M$3350 VSS RA12 \$1246 VSS nfet_03v3 L=0.28U W=0.36U AS=0.1854P AD=0.1584P
+ PS=1.75U PD=1.6U
M$3351 \$1251 RB12 VSS VSS nfet_03v3 L=0.28U W=0.36U AS=0.1656P AD=0.1944P
+ PS=1.64U PD=1.8U
M$3352 \$1032 RA13 VSS VSS nfet_03v3 L=0.28U W=0.36U AS=0.1656P AD=0.1944P
+ PS=1.64U PD=1.8U
M$3353 \$1250 RB12 \$380 VSS nfet_03v3 L=0.28U W=0.36U AS=0.1584P AD=0.1152P
+ PS=1.6U PD=1U
M$3354 \$381 RA12 \$1250 VSS nfet_03v3 L=0.28U W=0.36U AS=0.1152P AD=0.1584P
+ PS=1U PD=1.6U
M$3355 \$923 RA13 \$380 VSS nfet_03v3 L=0.28U W=0.36U AS=0.1584P AD=0.1152P
+ PS=1.6U PD=1U
M$3356 \$381 RB13 \$923 VSS nfet_03v3 L=0.28U W=0.36U AS=0.1152P AD=0.1584P
+ PS=1U PD=1.6U
M$3357 VSS RB13 \$1033 VSS nfet_03v3 L=0.28U W=0.36U AS=0.1854P AD=0.1584P
+ PS=1.75U PD=1.6U
M$3358 VSS RA12 \$1252 VSS nfet_03v3 L=0.28U W=0.36U AS=0.1854P AD=0.1584P
+ PS=1.75U PD=1.6U
M$3359 \$1257 RB12 VSS VSS nfet_03v3 L=0.28U W=0.36U AS=0.1656P AD=0.1944P
+ PS=1.64U PD=1.8U
M$3360 \$1034 RA13 VSS VSS nfet_03v3 L=0.28U W=0.36U AS=0.1656P AD=0.1944P
+ PS=1.64U PD=1.8U
M$3361 \$1256 RB12 \$385 VSS nfet_03v3 L=0.28U W=0.36U AS=0.1584P AD=0.1152P
+ PS=1.6U PD=1U
M$3362 \$386 RA12 \$1256 VSS nfet_03v3 L=0.28U W=0.36U AS=0.1152P AD=0.1584P
+ PS=1U PD=1.6U
M$3363 \$927 RA13 \$385 VSS nfet_03v3 L=0.28U W=0.36U AS=0.1584P AD=0.1152P
+ PS=1.6U PD=1U
M$3364 \$386 RB13 \$927 VSS nfet_03v3 L=0.28U W=0.36U AS=0.1152P AD=0.1584P
+ PS=1U PD=1.6U
M$3365 VSS RB13 \$1035 VSS nfet_03v3 L=0.28U W=0.36U AS=0.1854P AD=0.1584P
+ PS=1.75U PD=1.6U
M$3366 VSS RA12 \$1258 VSS nfet_03v3 L=0.28U W=0.36U AS=0.1854P AD=0.1584P
+ PS=1.75U PD=1.6U
M$3367 \$1263 RB12 VSS VSS nfet_03v3 L=0.28U W=0.36U AS=0.1656P AD=0.1944P
+ PS=1.64U PD=1.8U
M$3368 \$1036 RA13 VSS VSS nfet_03v3 L=0.28U W=0.36U AS=0.1656P AD=0.1944P
+ PS=1.64U PD=1.8U
M$3369 \$931 RA13 \$390 VSS nfet_03v3 L=0.28U W=0.36U AS=0.1584P AD=0.1152P
+ PS=1.6U PD=1U
M$3370 \$391 RB13 \$931 VSS nfet_03v3 L=0.28U W=0.36U AS=0.1152P AD=0.1584P
+ PS=1U PD=1.6U
M$3371 \$1262 RB12 \$390 VSS nfet_03v3 L=0.28U W=0.36U AS=0.1584P AD=0.1152P
+ PS=1.6U PD=1U
M$3372 \$391 RA12 \$1262 VSS nfet_03v3 L=0.28U W=0.36U AS=0.1152P AD=0.1584P
+ PS=1U PD=1.6U
M$3373 VSS RB13 \$1037 VSS nfet_03v3 L=0.28U W=0.36U AS=0.1854P AD=0.1584P
+ PS=1.75U PD=1.6U
M$3374 VSS RA12 \$1264 VSS nfet_03v3 L=0.28U W=0.36U AS=0.1854P AD=0.1584P
+ PS=1.75U PD=1.6U
M$3375 \$1269 RB12 VSS VSS nfet_03v3 L=0.28U W=0.36U AS=0.1656P AD=0.1944P
+ PS=1.64U PD=1.8U
M$3376 \$1038 RA13 VSS VSS nfet_03v3 L=0.28U W=0.36U AS=0.1656P AD=0.1944P
+ PS=1.64U PD=1.8U
M$3377 \$1268 RB12 \$395 VSS nfet_03v3 L=0.28U W=0.36U AS=0.1584P AD=0.1152P
+ PS=1.6U PD=1U
M$3378 \$396 RA12 \$1268 VSS nfet_03v3 L=0.28U W=0.36U AS=0.1152P AD=0.1584P
+ PS=1U PD=1.6U
M$3379 \$935 RA13 \$395 VSS nfet_03v3 L=0.28U W=0.36U AS=0.1584P AD=0.1152P
+ PS=1.6U PD=1U
M$3380 \$396 RB13 \$935 VSS nfet_03v3 L=0.28U W=0.36U AS=0.1152P AD=0.1584P
+ PS=1U PD=1.6U
M$3381 VSS RB13 \$1039 VSS nfet_03v3 L=0.28U W=0.36U AS=0.1854P AD=0.1584P
+ PS=1.75U PD=1.6U
M$3382 VSS RA12 \$1270 VSS nfet_03v3 L=0.28U W=0.36U AS=0.1854P AD=0.1584P
+ PS=1.75U PD=1.6U
M$3383 \$1040 RA13 VSS VSS nfet_03v3 L=0.28U W=0.36U AS=0.1656P AD=0.1944P
+ PS=1.64U PD=1.8U
M$3384 \$1275 RB12 VSS VSS nfet_03v3 L=0.28U W=0.36U AS=0.1656P AD=0.1944P
+ PS=1.64U PD=1.8U
M$3385 \$939 RA13 \$400 VSS nfet_03v3 L=0.28U W=0.36U AS=0.1584P AD=0.1152P
+ PS=1.6U PD=1U
M$3386 \$401 RB13 \$939 VSS nfet_03v3 L=0.28U W=0.36U AS=0.1152P AD=0.1584P
+ PS=1U PD=1.6U
M$3387 \$1274 RB12 \$400 VSS nfet_03v3 L=0.28U W=0.36U AS=0.1584P AD=0.1152P
+ PS=1.6U PD=1U
M$3388 \$401 RA12 \$1274 VSS nfet_03v3 L=0.28U W=0.36U AS=0.1152P AD=0.1584P
+ PS=1U PD=1.6U
M$3389 VSS RA12 \$1276 VSS nfet_03v3 L=0.28U W=0.36U AS=0.1854P AD=0.1584P
+ PS=1.75U PD=1.6U
M$3390 VSS RB13 \$1041 VSS nfet_03v3 L=0.28U W=0.36U AS=0.1854P AD=0.1584P
+ PS=1.75U PD=1.6U
M$3391 \$1281 RB12 VSS VSS nfet_03v3 L=0.28U W=0.36U AS=0.1656P AD=0.1944P
+ PS=1.64U PD=1.8U
M$3392 \$1042 RA13 VSS VSS nfet_03v3 L=0.28U W=0.36U AS=0.1656P AD=0.1944P
+ PS=1.64U PD=1.8U
M$3393 \$943 RA13 \$405 VSS nfet_03v3 L=0.28U W=0.36U AS=0.1584P AD=0.1152P
+ PS=1.6U PD=1U
M$3394 \$406 RB13 \$943 VSS nfet_03v3 L=0.28U W=0.36U AS=0.1152P AD=0.1584P
+ PS=1U PD=1.6U
M$3395 \$1280 RB12 \$405 VSS nfet_03v3 L=0.28U W=0.36U AS=0.1584P AD=0.1152P
+ PS=1.6U PD=1U
M$3396 \$406 RA12 \$1280 VSS nfet_03v3 L=0.28U W=0.36U AS=0.1152P AD=0.1584P
+ PS=1U PD=1.6U
M$3397 VSS RA12 \$1282 VSS nfet_03v3 L=0.28U W=0.36U AS=0.1854P AD=0.1584P
+ PS=1.75U PD=1.6U
M$3398 VSS RB13 \$1043 VSS nfet_03v3 L=0.28U W=0.36U AS=0.1854P AD=0.1584P
+ PS=1.75U PD=1.6U
M$3399 \$1287 RB12 VSS VSS nfet_03v3 L=0.28U W=0.36U AS=0.1656P AD=0.1944P
+ PS=1.64U PD=1.8U
M$3400 \$1044 RA13 VSS VSS nfet_03v3 L=0.28U W=0.36U AS=0.1656P AD=0.1944P
+ PS=1.64U PD=1.8U
M$3401 \$947 RA13 \$410 VSS nfet_03v3 L=0.28U W=0.36U AS=0.1584P AD=0.1152P
+ PS=1.6U PD=1U
M$3402 \$411 RB13 \$947 VSS nfet_03v3 L=0.28U W=0.36U AS=0.1152P AD=0.1584P
+ PS=1U PD=1.6U
M$3403 \$1286 RB12 \$410 VSS nfet_03v3 L=0.28U W=0.36U AS=0.1584P AD=0.1152P
+ PS=1.6U PD=1U
M$3404 \$411 RA12 \$1286 VSS nfet_03v3 L=0.28U W=0.36U AS=0.1152P AD=0.1584P
+ PS=1U PD=1.6U
M$3405 VSS RA12 \$1288 VSS nfet_03v3 L=0.28U W=0.36U AS=0.1854P AD=0.1584P
+ PS=1.75U PD=1.6U
M$3406 VSS RB13 \$1045 VSS nfet_03v3 L=0.28U W=0.36U AS=0.1854P AD=0.1584P
+ PS=1.75U PD=1.6U
M$3407 \$1046 RA13 VSS VSS nfet_03v3 L=0.28U W=0.36U AS=0.1656P AD=0.1944P
+ PS=1.64U PD=1.8U
M$3408 \$1293 RB12 VSS VSS nfet_03v3 L=0.28U W=0.36U AS=0.1656P AD=0.1944P
+ PS=1.64U PD=1.8U
M$3409 \$1292 RB12 \$415 VSS nfet_03v3 L=0.28U W=0.36U AS=0.1584P AD=0.1152P
+ PS=1.6U PD=1U
M$3410 \$416 RA12 \$1292 VSS nfet_03v3 L=0.28U W=0.36U AS=0.1152P AD=0.1584P
+ PS=1U PD=1.6U
M$3411 \$951 RA13 \$415 VSS nfet_03v3 L=0.28U W=0.36U AS=0.1584P AD=0.1152P
+ PS=1.6U PD=1U
M$3412 \$416 RB13 \$951 VSS nfet_03v3 L=0.28U W=0.36U AS=0.1152P AD=0.1584P
+ PS=1U PD=1.6U
M$3413 VSS RA12 \$1294 VSS nfet_03v3 L=0.28U W=0.36U AS=0.1854P AD=0.1584P
+ PS=1.75U PD=1.6U
M$3414 VSS RB13 \$1047 VSS nfet_03v3 L=0.28U W=0.36U AS=0.1854P AD=0.1584P
+ PS=1.75U PD=1.6U
M$3415 \$1299 RB12 VSS VSS nfet_03v3 L=0.28U W=0.36U AS=0.1656P AD=0.1944P
+ PS=1.64U PD=1.8U
M$3416 \$1048 RA13 VSS VSS nfet_03v3 L=0.28U W=0.36U AS=0.1656P AD=0.1944P
+ PS=1.64U PD=1.8U
M$3417 \$1298 RB12 \$420 VSS nfet_03v3 L=0.28U W=0.36U AS=0.1584P AD=0.1152P
+ PS=1.6U PD=1U
M$3418 \$421 RA12 \$1298 VSS nfet_03v3 L=0.28U W=0.36U AS=0.1152P AD=0.1584P
+ PS=1U PD=1.6U
M$3419 \$955 RA13 \$420 VSS nfet_03v3 L=0.28U W=0.36U AS=0.1584P AD=0.1152P
+ PS=1.6U PD=1U
M$3420 \$421 RB13 \$955 VSS nfet_03v3 L=0.28U W=0.36U AS=0.1152P AD=0.1584P
+ PS=1U PD=1.6U
M$3421 VSS RA12 \$1300 VSS nfet_03v3 L=0.28U W=0.36U AS=0.1854P AD=0.1584P
+ PS=1.75U PD=1.6U
M$3422 VSS RB13 \$1049 VSS nfet_03v3 L=0.28U W=0.36U AS=0.1854P AD=0.1584P
+ PS=1.75U PD=1.6U
M$3423 \$1050 RA13 VSS VSS nfet_03v3 L=0.28U W=0.36U AS=0.1656P AD=0.1944P
+ PS=1.64U PD=1.8U
M$3424 \$1305 RB12 VSS VSS nfet_03v3 L=0.28U W=0.36U AS=0.1656P AD=0.1944P
+ PS=1.64U PD=1.8U
M$3425 \$1304 RB12 \$425 VSS nfet_03v3 L=0.28U W=0.36U AS=0.1584P AD=0.1152P
+ PS=1.6U PD=1U
M$3426 \$426 RA12 \$1304 VSS nfet_03v3 L=0.28U W=0.36U AS=0.1152P AD=0.1584P
+ PS=1U PD=1.6U
M$3427 \$959 RA13 \$425 VSS nfet_03v3 L=0.28U W=0.36U AS=0.1584P AD=0.1152P
+ PS=1.6U PD=1U
M$3428 \$426 RB13 \$959 VSS nfet_03v3 L=0.28U W=0.36U AS=0.1152P AD=0.1584P
+ PS=1U PD=1.6U
M$3429 VSS RA12 \$1306 VSS nfet_03v3 L=0.28U W=0.36U AS=0.1854P AD=0.1584P
+ PS=1.75U PD=1.6U
M$3430 VSS RB13 \$1051 VSS nfet_03v3 L=0.28U W=0.36U AS=0.1854P AD=0.1584P
+ PS=1.75U PD=1.6U
M$3431 \$1311 RB12 VSS VSS nfet_03v3 L=0.28U W=0.36U AS=0.1656P AD=0.1944P
+ PS=1.64U PD=1.8U
M$3432 \$1052 RA13 VSS VSS nfet_03v3 L=0.28U W=0.36U AS=0.1656P AD=0.1944P
+ PS=1.64U PD=1.8U
M$3433 \$963 RA13 \$430 VSS nfet_03v3 L=0.28U W=0.36U AS=0.1584P AD=0.1152P
+ PS=1.6U PD=1U
M$3434 \$431 RB13 \$963 VSS nfet_03v3 L=0.28U W=0.36U AS=0.1152P AD=0.1584P
+ PS=1U PD=1.6U
M$3435 \$1310 RB12 \$430 VSS nfet_03v3 L=0.28U W=0.36U AS=0.1584P AD=0.1152P
+ PS=1.6U PD=1U
M$3436 \$431 RA12 \$1310 VSS nfet_03v3 L=0.28U W=0.36U AS=0.1152P AD=0.1584P
+ PS=1U PD=1.6U
M$3437 VSS RA12 \$1312 VSS nfet_03v3 L=0.28U W=0.36U AS=0.1854P AD=0.1584P
+ PS=1.75U PD=1.6U
M$3438 VSS RB13 \$1053 VSS nfet_03v3 L=0.28U W=0.36U AS=0.1854P AD=0.1584P
+ PS=1.75U PD=1.6U
M$3439 \$1054 RA13 VSS VSS nfet_03v3 L=0.28U W=0.36U AS=0.1656P AD=0.1944P
+ PS=1.64U PD=1.8U
M$3440 \$1317 RB12 VSS VSS nfet_03v3 L=0.28U W=0.36U AS=0.1656P AD=0.1944P
+ PS=1.64U PD=1.8U
M$3441 \$1316 RB12 \$435 VSS nfet_03v3 L=0.28U W=0.36U AS=0.1584P AD=0.1152P
+ PS=1.6U PD=1U
M$3442 \$436 RA12 \$1316 VSS nfet_03v3 L=0.28U W=0.36U AS=0.1152P AD=0.1584P
+ PS=1U PD=1.6U
M$3443 \$967 RA13 \$435 VSS nfet_03v3 L=0.28U W=0.36U AS=0.1584P AD=0.1152P
+ PS=1.6U PD=1U
M$3444 \$436 RB13 \$967 VSS nfet_03v3 L=0.28U W=0.36U AS=0.1152P AD=0.1584P
+ PS=1U PD=1.6U
M$3445 VSS RB13 \$1055 VSS nfet_03v3 L=0.28U W=0.36U AS=0.1854P AD=0.1584P
+ PS=1.75U PD=1.6U
M$3446 VSS RA12 \$1318 VSS nfet_03v3 L=0.28U W=0.36U AS=0.1854P AD=0.1584P
+ PS=1.75U PD=1.6U
M$3447 \$1422 WE12 VSS VSS nfet_03v3 L=0.28U W=0.72U AS=0.3168P AD=0.1872P
+ PS=2.32U PD=1.24U
M$3448 \$1217 CLK \$1422 VSS nfet_03v3 L=0.28U W=0.72U AS=0.1872P AD=0.3168P
+ PS=1.24U PD=2.32U
M$3449 \$1219 \$1217 VSS VSS nfet_03v3 L=0.28U W=1.27U AS=0.4487P AD=0.3302P
+ PS=3.34U PD=2.31U
M$3451 \$1220 \$1219 VSS VSS nfet_03v3 L=0.28U W=1.34U AS=0.3636P AD=0.4891P
+ PS=2.44U PD=3.47U
M$3453 \$1223 \$44 VSS VSS nfet_03v3 L=0.28U W=0.36U AS=0.1584P AD=0.1188P
+ PS=1.6U PD=1.02U
M$3454 \$1224 \$1219 \$1223 VSS nfet_03v3 L=0.28U W=0.36U AS=0.1188P AD=0.1278P
+ PS=1.02U PD=1.07U
M$3455 \$1427 \$1225 \$1224 VSS nfet_03v3 L=0.28U W=0.36U AS=0.1278P AD=0.0567P
+ PS=1.07U PD=0.675U
M$3456 VSS \$1220 \$1427 VSS nfet_03v3 L=0.28U W=0.36U AS=0.0567P AD=0.1584P
+ PS=0.675U PD=1.6U
M$3457 VSS \$1224 \$1225 VSS nfet_03v3 L=0.28U W=0.36U AS=0.1584P AD=0.0972P
+ PS=1.6U PD=0.9U
M$3458 \$1226 \$1224 VSS VSS nfet_03v3 L=0.28U W=0.36U AS=0.0972P AD=0.18P
+ PS=0.9U PD=1.72U
M$3459 \$1229 \$47 VSS VSS nfet_03v3 L=0.28U W=0.36U AS=0.1584P AD=0.1188P
+ PS=1.6U PD=1.02U
M$3460 \$1230 \$1219 \$1229 VSS nfet_03v3 L=0.28U W=0.36U AS=0.1188P AD=0.1278P
+ PS=1.02U PD=1.07U
M$3461 \$1436 \$1231 \$1230 VSS nfet_03v3 L=0.28U W=0.36U AS=0.1278P AD=0.0567P
+ PS=1.07U PD=0.675U
M$3462 VSS \$1220 \$1436 VSS nfet_03v3 L=0.28U W=0.36U AS=0.0567P AD=0.1584P
+ PS=0.675U PD=1.6U
M$3463 VSS \$1230 \$1231 VSS nfet_03v3 L=0.28U W=0.36U AS=0.1584P AD=0.0972P
+ PS=1.6U PD=0.9U
M$3464 \$1232 \$1230 VSS VSS nfet_03v3 L=0.28U W=0.36U AS=0.0972P AD=0.18P
+ PS=0.9U PD=1.72U
M$3465 \$1235 \$50 VSS VSS nfet_03v3 L=0.28U W=0.36U AS=0.1584P AD=0.1188P
+ PS=1.6U PD=1.02U
M$3466 \$1236 \$1219 \$1235 VSS nfet_03v3 L=0.28U W=0.36U AS=0.1188P AD=0.1278P
+ PS=1.02U PD=1.07U
M$3467 \$1443 \$1237 \$1236 VSS nfet_03v3 L=0.28U W=0.36U AS=0.1278P AD=0.0567P
+ PS=1.07U PD=0.675U
M$3468 VSS \$1220 \$1443 VSS nfet_03v3 L=0.28U W=0.36U AS=0.0567P AD=0.1584P
+ PS=0.675U PD=1.6U
M$3469 VSS \$1236 \$1237 VSS nfet_03v3 L=0.28U W=0.36U AS=0.1584P AD=0.0972P
+ PS=1.6U PD=0.9U
M$3470 \$1238 \$1236 VSS VSS nfet_03v3 L=0.28U W=0.36U AS=0.0972P AD=0.18P
+ PS=0.9U PD=1.72U
M$3471 \$1241 \$53 VSS VSS nfet_03v3 L=0.28U W=0.36U AS=0.1584P AD=0.1188P
+ PS=1.6U PD=1.02U
M$3472 \$1242 \$1219 \$1241 VSS nfet_03v3 L=0.28U W=0.36U AS=0.1188P AD=0.1278P
+ PS=1.02U PD=1.07U
M$3473 \$1450 \$1243 \$1242 VSS nfet_03v3 L=0.28U W=0.36U AS=0.1278P AD=0.0567P
+ PS=1.07U PD=0.675U
M$3474 VSS \$1220 \$1450 VSS nfet_03v3 L=0.28U W=0.36U AS=0.0567P AD=0.1584P
+ PS=0.675U PD=1.6U
M$3475 VSS \$1242 \$1243 VSS nfet_03v3 L=0.28U W=0.36U AS=0.1584P AD=0.0972P
+ PS=1.6U PD=0.9U
M$3476 \$1244 \$1242 VSS VSS nfet_03v3 L=0.28U W=0.36U AS=0.0972P AD=0.18P
+ PS=0.9U PD=1.72U
M$3477 \$1247 \$56 VSS VSS nfet_03v3 L=0.28U W=0.36U AS=0.1584P AD=0.1188P
+ PS=1.6U PD=1.02U
M$3478 \$1248 \$1219 \$1247 VSS nfet_03v3 L=0.28U W=0.36U AS=0.1188P AD=0.1278P
+ PS=1.02U PD=1.07U
M$3479 \$1460 \$1249 \$1248 VSS nfet_03v3 L=0.28U W=0.36U AS=0.1278P AD=0.0567P
+ PS=1.07U PD=0.675U
M$3480 VSS \$1220 \$1460 VSS nfet_03v3 L=0.28U W=0.36U AS=0.0567P AD=0.1584P
+ PS=0.675U PD=1.6U
M$3481 VSS \$1248 \$1249 VSS nfet_03v3 L=0.28U W=0.36U AS=0.1584P AD=0.0972P
+ PS=1.6U PD=0.9U
M$3482 \$1250 \$1248 VSS VSS nfet_03v3 L=0.28U W=0.36U AS=0.0972P AD=0.18P
+ PS=0.9U PD=1.72U
M$3483 \$1253 \$59 VSS VSS nfet_03v3 L=0.28U W=0.36U AS=0.1584P AD=0.1188P
+ PS=1.6U PD=1.02U
M$3484 \$1254 \$1219 \$1253 VSS nfet_03v3 L=0.28U W=0.36U AS=0.1188P AD=0.1278P
+ PS=1.02U PD=1.07U
M$3485 \$1467 \$1255 \$1254 VSS nfet_03v3 L=0.28U W=0.36U AS=0.1278P AD=0.0567P
+ PS=1.07U PD=0.675U
M$3486 VSS \$1220 \$1467 VSS nfet_03v3 L=0.28U W=0.36U AS=0.0567P AD=0.1584P
+ PS=0.675U PD=1.6U
M$3487 VSS \$1254 \$1255 VSS nfet_03v3 L=0.28U W=0.36U AS=0.1584P AD=0.0972P
+ PS=1.6U PD=0.9U
M$3488 \$1256 \$1254 VSS VSS nfet_03v3 L=0.28U W=0.36U AS=0.0972P AD=0.18P
+ PS=0.9U PD=1.72U
M$3489 \$1259 \$62 VSS VSS nfet_03v3 L=0.28U W=0.36U AS=0.1584P AD=0.1188P
+ PS=1.6U PD=1.02U
M$3490 \$1260 \$1219 \$1259 VSS nfet_03v3 L=0.28U W=0.36U AS=0.1188P AD=0.1278P
+ PS=1.02U PD=1.07U
M$3491 \$1475 \$1261 \$1260 VSS nfet_03v3 L=0.28U W=0.36U AS=0.1278P AD=0.0567P
+ PS=1.07U PD=0.675U
M$3492 VSS \$1220 \$1475 VSS nfet_03v3 L=0.28U W=0.36U AS=0.0567P AD=0.1584P
+ PS=0.675U PD=1.6U
M$3493 VSS \$1260 \$1261 VSS nfet_03v3 L=0.28U W=0.36U AS=0.1584P AD=0.0972P
+ PS=1.6U PD=0.9U
M$3494 \$1262 \$1260 VSS VSS nfet_03v3 L=0.28U W=0.36U AS=0.0972P AD=0.18P
+ PS=0.9U PD=1.72U
M$3495 \$1265 \$65 VSS VSS nfet_03v3 L=0.28U W=0.36U AS=0.1584P AD=0.1188P
+ PS=1.6U PD=1.02U
M$3496 \$1266 \$1219 \$1265 VSS nfet_03v3 L=0.28U W=0.36U AS=0.1188P AD=0.1278P
+ PS=1.02U PD=1.07U
M$3497 \$1484 \$1267 \$1266 VSS nfet_03v3 L=0.28U W=0.36U AS=0.1278P AD=0.0567P
+ PS=1.07U PD=0.675U
M$3498 VSS \$1220 \$1484 VSS nfet_03v3 L=0.28U W=0.36U AS=0.0567P AD=0.1584P
+ PS=0.675U PD=1.6U
M$3499 VSS \$1266 \$1267 VSS nfet_03v3 L=0.28U W=0.36U AS=0.1584P AD=0.0972P
+ PS=1.6U PD=0.9U
M$3500 \$1268 \$1266 VSS VSS nfet_03v3 L=0.28U W=0.36U AS=0.0972P AD=0.18P
+ PS=0.9U PD=1.72U
M$3501 \$1271 \$68 VSS VSS nfet_03v3 L=0.28U W=0.36U AS=0.1584P AD=0.1188P
+ PS=1.6U PD=1.02U
M$3502 \$1272 \$1219 \$1271 VSS nfet_03v3 L=0.28U W=0.36U AS=0.1188P AD=0.1278P
+ PS=1.02U PD=1.07U
M$3503 \$1490 \$1273 \$1272 VSS nfet_03v3 L=0.28U W=0.36U AS=0.1278P AD=0.0567P
+ PS=1.07U PD=0.675U
M$3504 VSS \$1220 \$1490 VSS nfet_03v3 L=0.28U W=0.36U AS=0.0567P AD=0.1584P
+ PS=0.675U PD=1.6U
M$3505 VSS \$1272 \$1273 VSS nfet_03v3 L=0.28U W=0.36U AS=0.1584P AD=0.0972P
+ PS=1.6U PD=0.9U
M$3506 \$1274 \$1272 VSS VSS nfet_03v3 L=0.28U W=0.36U AS=0.0972P AD=0.18P
+ PS=0.9U PD=1.72U
M$3507 \$1277 \$71 VSS VSS nfet_03v3 L=0.28U W=0.36U AS=0.1584P AD=0.1188P
+ PS=1.6U PD=1.02U
M$3508 \$1278 \$1219 \$1277 VSS nfet_03v3 L=0.28U W=0.36U AS=0.1188P AD=0.1278P
+ PS=1.02U PD=1.07U
M$3509 \$1498 \$1279 \$1278 VSS nfet_03v3 L=0.28U W=0.36U AS=0.1278P AD=0.0567P
+ PS=1.07U PD=0.675U
M$3510 VSS \$1220 \$1498 VSS nfet_03v3 L=0.28U W=0.36U AS=0.0567P AD=0.1584P
+ PS=0.675U PD=1.6U
M$3511 VSS \$1278 \$1279 VSS nfet_03v3 L=0.28U W=0.36U AS=0.1584P AD=0.0972P
+ PS=1.6U PD=0.9U
M$3512 \$1280 \$1278 VSS VSS nfet_03v3 L=0.28U W=0.36U AS=0.0972P AD=0.18P
+ PS=0.9U PD=1.72U
M$3513 \$1283 \$74 VSS VSS nfet_03v3 L=0.28U W=0.36U AS=0.1584P AD=0.1188P
+ PS=1.6U PD=1.02U
M$3514 \$1284 \$1219 \$1283 VSS nfet_03v3 L=0.28U W=0.36U AS=0.1188P AD=0.1278P
+ PS=1.02U PD=1.07U
M$3515 \$1506 \$1285 \$1284 VSS nfet_03v3 L=0.28U W=0.36U AS=0.1278P AD=0.0567P
+ PS=1.07U PD=0.675U
M$3516 VSS \$1220 \$1506 VSS nfet_03v3 L=0.28U W=0.36U AS=0.0567P AD=0.1584P
+ PS=0.675U PD=1.6U
M$3517 VSS \$1284 \$1285 VSS nfet_03v3 L=0.28U W=0.36U AS=0.1584P AD=0.0972P
+ PS=1.6U PD=0.9U
M$3518 \$1286 \$1284 VSS VSS nfet_03v3 L=0.28U W=0.36U AS=0.0972P AD=0.18P
+ PS=0.9U PD=1.72U
M$3519 \$1289 \$77 VSS VSS nfet_03v3 L=0.28U W=0.36U AS=0.1584P AD=0.1188P
+ PS=1.6U PD=1.02U
M$3520 \$1290 \$1219 \$1289 VSS nfet_03v3 L=0.28U W=0.36U AS=0.1188P AD=0.1278P
+ PS=1.02U PD=1.07U
M$3521 \$1514 \$1291 \$1290 VSS nfet_03v3 L=0.28U W=0.36U AS=0.1278P AD=0.0567P
+ PS=1.07U PD=0.675U
M$3522 VSS \$1220 \$1514 VSS nfet_03v3 L=0.28U W=0.36U AS=0.0567P AD=0.1584P
+ PS=0.675U PD=1.6U
M$3523 VSS \$1290 \$1291 VSS nfet_03v3 L=0.28U W=0.36U AS=0.1584P AD=0.0972P
+ PS=1.6U PD=0.9U
M$3524 \$1292 \$1290 VSS VSS nfet_03v3 L=0.28U W=0.36U AS=0.0972P AD=0.18P
+ PS=0.9U PD=1.72U
M$3525 \$1295 \$80 VSS VSS nfet_03v3 L=0.28U W=0.36U AS=0.1584P AD=0.1188P
+ PS=1.6U PD=1.02U
M$3526 \$1296 \$1219 \$1295 VSS nfet_03v3 L=0.28U W=0.36U AS=0.1188P AD=0.1278P
+ PS=1.02U PD=1.07U
M$3527 \$1509 \$1297 \$1296 VSS nfet_03v3 L=0.28U W=0.36U AS=0.1278P AD=0.0567P
+ PS=1.07U PD=0.675U
M$3528 VSS \$1220 \$1509 VSS nfet_03v3 L=0.28U W=0.36U AS=0.0567P AD=0.1584P
+ PS=0.675U PD=1.6U
M$3529 VSS \$1296 \$1297 VSS nfet_03v3 L=0.28U W=0.36U AS=0.1584P AD=0.0972P
+ PS=1.6U PD=0.9U
M$3530 \$1298 \$1296 VSS VSS nfet_03v3 L=0.28U W=0.36U AS=0.0972P AD=0.18P
+ PS=0.9U PD=1.72U
M$3531 \$1301 \$83 VSS VSS nfet_03v3 L=0.28U W=0.36U AS=0.1584P AD=0.1188P
+ PS=1.6U PD=1.02U
M$3532 \$1302 \$1219 \$1301 VSS nfet_03v3 L=0.28U W=0.36U AS=0.1188P AD=0.1278P
+ PS=1.02U PD=1.07U
M$3533 \$1483 \$1303 \$1302 VSS nfet_03v3 L=0.28U W=0.36U AS=0.1278P AD=0.0567P
+ PS=1.07U PD=0.675U
M$3534 VSS \$1220 \$1483 VSS nfet_03v3 L=0.28U W=0.36U AS=0.0567P AD=0.1584P
+ PS=0.675U PD=1.6U
M$3535 VSS \$1302 \$1303 VSS nfet_03v3 L=0.28U W=0.36U AS=0.1584P AD=0.0972P
+ PS=1.6U PD=0.9U
M$3536 \$1304 \$1302 VSS VSS nfet_03v3 L=0.28U W=0.36U AS=0.0972P AD=0.18P
+ PS=0.9U PD=1.72U
M$3537 \$1307 \$86 VSS VSS nfet_03v3 L=0.28U W=0.36U AS=0.1584P AD=0.1188P
+ PS=1.6U PD=1.02U
M$3538 \$1308 \$1219 \$1307 VSS nfet_03v3 L=0.28U W=0.36U AS=0.1188P AD=0.1278P
+ PS=1.02U PD=1.07U
M$3539 \$1459 \$1309 \$1308 VSS nfet_03v3 L=0.28U W=0.36U AS=0.1278P AD=0.0567P
+ PS=1.07U PD=0.675U
M$3540 VSS \$1220 \$1459 VSS nfet_03v3 L=0.28U W=0.36U AS=0.0567P AD=0.1584P
+ PS=0.675U PD=1.6U
M$3541 VSS \$1308 \$1309 VSS nfet_03v3 L=0.28U W=0.36U AS=0.1584P AD=0.0972P
+ PS=1.6U PD=0.9U
M$3542 \$1310 \$1308 VSS VSS nfet_03v3 L=0.28U W=0.36U AS=0.0972P AD=0.18P
+ PS=0.9U PD=1.72U
M$3543 \$1313 \$89 VSS VSS nfet_03v3 L=0.28U W=0.36U AS=0.1584P AD=0.1188P
+ PS=1.6U PD=1.02U
M$3544 \$1314 \$1219 \$1313 VSS nfet_03v3 L=0.28U W=0.36U AS=0.1188P AD=0.1278P
+ PS=1.02U PD=1.07U
M$3545 \$1435 \$1315 \$1314 VSS nfet_03v3 L=0.28U W=0.36U AS=0.1278P AD=0.0567P
+ PS=1.07U PD=0.675U
M$3546 VSS \$1220 \$1435 VSS nfet_03v3 L=0.28U W=0.36U AS=0.0567P AD=0.1584P
+ PS=0.675U PD=1.6U
M$3547 VSS \$1314 \$1315 VSS nfet_03v3 L=0.28U W=0.36U AS=0.1584P AD=0.0972P
+ PS=1.6U PD=0.9U
M$3548 \$1316 \$1314 VSS VSS nfet_03v3 L=0.28U W=0.36U AS=0.0972P AD=0.18P
+ PS=0.9U PD=1.72U
M$3549 \$1669 WE11 VSS VSS nfet_03v3 L=0.28U W=0.72U AS=0.3168P AD=0.1872P
+ PS=2.32U PD=1.24U
M$3550 \$1520 CLK \$1669 VSS nfet_03v3 L=0.28U W=0.72U AS=0.1872P AD=0.3168P
+ PS=1.24U PD=2.32U
M$3551 \$1521 \$1520 VSS VSS nfet_03v3 L=0.28U W=1.27U AS=0.4445P AD=0.3344P
+ PS=3.305U PD=2.345U
M$3553 \$1522 \$1521 VSS VSS nfet_03v3 L=0.28U W=1.34U AS=0.3636P AD=0.4891P
+ PS=2.44U PD=3.47U
M$3555 \$1523 \$44 VSS VSS nfet_03v3 L=0.28U W=0.36U AS=0.1584P AD=0.1188P
+ PS=1.6U PD=1.02U
M$3556 \$1524 \$1521 \$1523 VSS nfet_03v3 L=0.28U W=0.36U AS=0.1188P AD=0.1278P
+ PS=1.02U PD=1.07U
M$3557 \$1591 \$1525 \$1524 VSS nfet_03v3 L=0.28U W=0.36U AS=0.1278P AD=0.0567P
+ PS=1.07U PD=0.675U
M$3558 VSS \$1522 \$1591 VSS nfet_03v3 L=0.28U W=0.36U AS=0.0567P AD=0.1584P
+ PS=0.675U PD=1.6U
M$3559 VSS \$1524 \$1525 VSS nfet_03v3 L=0.28U W=0.36U AS=0.1584P AD=0.0972P
+ PS=1.6U PD=0.9U
M$3560 \$1526 \$1524 VSS VSS nfet_03v3 L=0.28U W=0.36U AS=0.0972P AD=0.18P
+ PS=0.9U PD=1.72U
M$3561 \$1527 \$47 VSS VSS nfet_03v3 L=0.28U W=0.36U AS=0.1584P AD=0.1188P
+ PS=1.6U PD=1.02U
M$3562 \$1528 \$1521 \$1527 VSS nfet_03v3 L=0.28U W=0.36U AS=0.1188P AD=0.1278P
+ PS=1.02U PD=1.07U
M$3563 \$1600 \$1529 \$1528 VSS nfet_03v3 L=0.28U W=0.36U AS=0.1278P AD=0.0567P
+ PS=1.07U PD=0.675U
M$3564 VSS \$1522 \$1600 VSS nfet_03v3 L=0.28U W=0.36U AS=0.0567P AD=0.1584P
+ PS=0.675U PD=1.6U
M$3565 VSS \$1528 \$1529 VSS nfet_03v3 L=0.28U W=0.36U AS=0.1584P AD=0.0972P
+ PS=1.6U PD=0.9U
M$3566 \$1530 \$1528 VSS VSS nfet_03v3 L=0.28U W=0.36U AS=0.0972P AD=0.18P
+ PS=0.9U PD=1.72U
M$3567 \$1531 \$50 VSS VSS nfet_03v3 L=0.28U W=0.36U AS=0.1584P AD=0.1188P
+ PS=1.6U PD=1.02U
M$3568 \$1532 \$1521 \$1531 VSS nfet_03v3 L=0.28U W=0.36U AS=0.1188P AD=0.1278P
+ PS=1.02U PD=1.07U
M$3569 \$1608 \$1533 \$1532 VSS nfet_03v3 L=0.28U W=0.36U AS=0.1278P AD=0.0567P
+ PS=1.07U PD=0.675U
M$3570 VSS \$1522 \$1608 VSS nfet_03v3 L=0.28U W=0.36U AS=0.0567P AD=0.1584P
+ PS=0.675U PD=1.6U
M$3571 VSS \$1532 \$1533 VSS nfet_03v3 L=0.28U W=0.36U AS=0.1584P AD=0.0972P
+ PS=1.6U PD=0.9U
M$3572 \$1534 \$1532 VSS VSS nfet_03v3 L=0.28U W=0.36U AS=0.0972P AD=0.18P
+ PS=0.9U PD=1.72U
M$3573 \$1535 \$53 VSS VSS nfet_03v3 L=0.28U W=0.36U AS=0.1584P AD=0.1188P
+ PS=1.6U PD=1.02U
M$3574 \$1536 \$1521 \$1535 VSS nfet_03v3 L=0.28U W=0.36U AS=0.1188P AD=0.1278P
+ PS=1.02U PD=1.07U
M$3575 \$1617 \$1537 \$1536 VSS nfet_03v3 L=0.28U W=0.36U AS=0.1278P AD=0.0567P
+ PS=1.07U PD=0.675U
M$3576 VSS \$1522 \$1617 VSS nfet_03v3 L=0.28U W=0.36U AS=0.0567P AD=0.1584P
+ PS=0.675U PD=1.6U
M$3577 VSS \$1536 \$1537 VSS nfet_03v3 L=0.28U W=0.36U AS=0.1584P AD=0.0972P
+ PS=1.6U PD=0.9U
M$3578 \$1538 \$1536 VSS VSS nfet_03v3 L=0.28U W=0.36U AS=0.0972P AD=0.18P
+ PS=0.9U PD=1.72U
M$3579 \$1539 \$56 VSS VSS nfet_03v3 L=0.28U W=0.36U AS=0.1584P AD=0.1188P
+ PS=1.6U PD=1.02U
M$3580 \$1540 \$1521 \$1539 VSS nfet_03v3 L=0.28U W=0.36U AS=0.1188P AD=0.1278P
+ PS=1.02U PD=1.07U
M$3581 \$1624 \$1541 \$1540 VSS nfet_03v3 L=0.28U W=0.36U AS=0.1278P AD=0.0567P
+ PS=1.07U PD=0.675U
M$3582 VSS \$1522 \$1624 VSS nfet_03v3 L=0.28U W=0.36U AS=0.0567P AD=0.1584P
+ PS=0.675U PD=1.6U
M$3583 VSS \$1540 \$1541 VSS nfet_03v3 L=0.28U W=0.36U AS=0.1584P AD=0.0972P
+ PS=1.6U PD=0.9U
M$3584 \$1542 \$1540 VSS VSS nfet_03v3 L=0.28U W=0.36U AS=0.0972P AD=0.18P
+ PS=0.9U PD=1.72U
M$3585 \$1543 \$59 VSS VSS nfet_03v3 L=0.28U W=0.36U AS=0.1584P AD=0.1188P
+ PS=1.6U PD=1.02U
M$3586 \$1544 \$1521 \$1543 VSS nfet_03v3 L=0.28U W=0.36U AS=0.1188P AD=0.1278P
+ PS=1.02U PD=1.07U
M$3587 \$1632 \$1545 \$1544 VSS nfet_03v3 L=0.28U W=0.36U AS=0.1278P AD=0.0567P
+ PS=1.07U PD=0.675U
M$3588 VSS \$1522 \$1632 VSS nfet_03v3 L=0.28U W=0.36U AS=0.0567P AD=0.1584P
+ PS=0.675U PD=1.6U
M$3589 VSS \$1544 \$1545 VSS nfet_03v3 L=0.28U W=0.36U AS=0.1584P AD=0.0972P
+ PS=1.6U PD=0.9U
M$3590 \$1546 \$1544 VSS VSS nfet_03v3 L=0.28U W=0.36U AS=0.0972P AD=0.18P
+ PS=0.9U PD=1.72U
M$3591 \$1547 \$62 VSS VSS nfet_03v3 L=0.28U W=0.36U AS=0.1584P AD=0.1188P
+ PS=1.6U PD=1.02U
M$3592 \$1548 \$1521 \$1547 VSS nfet_03v3 L=0.28U W=0.36U AS=0.1188P AD=0.1278P
+ PS=1.02U PD=1.07U
M$3593 \$1631 \$1549 \$1548 VSS nfet_03v3 L=0.28U W=0.36U AS=0.1278P AD=0.0567P
+ PS=1.07U PD=0.675U
M$3594 VSS \$1522 \$1631 VSS nfet_03v3 L=0.28U W=0.36U AS=0.0567P AD=0.1584P
+ PS=0.675U PD=1.6U
M$3595 VSS \$1548 \$1549 VSS nfet_03v3 L=0.28U W=0.36U AS=0.1584P AD=0.0972P
+ PS=1.6U PD=0.9U
M$3596 \$1550 \$1548 VSS VSS nfet_03v3 L=0.28U W=0.36U AS=0.0972P AD=0.18P
+ PS=0.9U PD=1.72U
M$3597 \$1551 \$65 VSS VSS nfet_03v3 L=0.28U W=0.36U AS=0.1584P AD=0.1188P
+ PS=1.6U PD=1.02U
M$3598 \$1552 \$1521 \$1551 VSS nfet_03v3 L=0.28U W=0.36U AS=0.1188P AD=0.1278P
+ PS=1.02U PD=1.07U
M$3599 \$1628 \$1553 \$1552 VSS nfet_03v3 L=0.28U W=0.36U AS=0.1278P AD=0.0567P
+ PS=1.07U PD=0.675U
M$3600 VSS \$1522 \$1628 VSS nfet_03v3 L=0.28U W=0.36U AS=0.0567P AD=0.1584P
+ PS=0.675U PD=1.6U
M$3601 VSS \$1552 \$1553 VSS nfet_03v3 L=0.28U W=0.36U AS=0.1584P AD=0.0972P
+ PS=1.6U PD=0.9U
M$3602 \$1554 \$1552 VSS VSS nfet_03v3 L=0.28U W=0.36U AS=0.0972P AD=0.18P
+ PS=0.9U PD=1.72U
M$3603 \$1555 \$68 VSS VSS nfet_03v3 L=0.28U W=0.36U AS=0.1584P AD=0.1188P
+ PS=1.6U PD=1.02U
M$3604 \$1556 \$1521 \$1555 VSS nfet_03v3 L=0.28U W=0.36U AS=0.1188P AD=0.1278P
+ PS=1.02U PD=1.07U
M$3605 \$1622 \$1557 \$1556 VSS nfet_03v3 L=0.28U W=0.36U AS=0.1278P AD=0.0567P
+ PS=1.07U PD=0.675U
M$3606 VSS \$1522 \$1622 VSS nfet_03v3 L=0.28U W=0.36U AS=0.0567P AD=0.1584P
+ PS=0.675U PD=1.6U
M$3607 VSS \$1556 \$1557 VSS nfet_03v3 L=0.28U W=0.36U AS=0.1584P AD=0.0972P
+ PS=1.6U PD=0.9U
M$3608 \$1558 \$1556 VSS VSS nfet_03v3 L=0.28U W=0.36U AS=0.0972P AD=0.18P
+ PS=0.9U PD=1.72U
M$3609 \$1559 \$71 VSS VSS nfet_03v3 L=0.28U W=0.36U AS=0.1584P AD=0.1188P
+ PS=1.6U PD=1.02U
M$3610 \$1560 \$1521 \$1559 VSS nfet_03v3 L=0.28U W=0.36U AS=0.1188P AD=0.1278P
+ PS=1.02U PD=1.07U
M$3611 \$1616 \$1561 \$1560 VSS nfet_03v3 L=0.28U W=0.36U AS=0.1278P AD=0.0567P
+ PS=1.07U PD=0.675U
M$3612 VSS \$1522 \$1616 VSS nfet_03v3 L=0.28U W=0.36U AS=0.0567P AD=0.1584P
+ PS=0.675U PD=1.6U
M$3613 VSS \$1560 \$1561 VSS nfet_03v3 L=0.28U W=0.36U AS=0.1584P AD=0.0972P
+ PS=1.6U PD=0.9U
M$3614 \$1562 \$1560 VSS VSS nfet_03v3 L=0.28U W=0.36U AS=0.0972P AD=0.18P
+ PS=0.9U PD=1.72U
M$3615 \$1563 \$74 VSS VSS nfet_03v3 L=0.28U W=0.36U AS=0.1584P AD=0.1188P
+ PS=1.6U PD=1.02U
M$3616 \$1564 \$1521 \$1563 VSS nfet_03v3 L=0.28U W=0.36U AS=0.1188P AD=0.1278P
+ PS=1.02U PD=1.07U
M$3617 \$1613 \$1565 \$1564 VSS nfet_03v3 L=0.28U W=0.36U AS=0.1278P AD=0.0567P
+ PS=1.07U PD=0.675U
M$3618 VSS \$1522 \$1613 VSS nfet_03v3 L=0.28U W=0.36U AS=0.0567P AD=0.1584P
+ PS=0.675U PD=1.6U
M$3619 VSS \$1564 \$1565 VSS nfet_03v3 L=0.28U W=0.36U AS=0.1584P AD=0.0972P
+ PS=1.6U PD=0.9U
M$3620 \$1566 \$1564 VSS VSS nfet_03v3 L=0.28U W=0.36U AS=0.0972P AD=0.18P
+ PS=0.9U PD=1.72U
M$3621 \$1567 \$77 VSS VSS nfet_03v3 L=0.28U W=0.36U AS=0.1584P AD=0.1188P
+ PS=1.6U PD=1.02U
M$3622 \$1568 \$1521 \$1567 VSS nfet_03v3 L=0.28U W=0.36U AS=0.1188P AD=0.1278P
+ PS=1.02U PD=1.07U
M$3623 \$1607 \$1569 \$1568 VSS nfet_03v3 L=0.28U W=0.36U AS=0.1278P AD=0.0567P
+ PS=1.07U PD=0.675U
M$3624 VSS \$1522 \$1607 VSS nfet_03v3 L=0.28U W=0.36U AS=0.0567P AD=0.1584P
+ PS=0.675U PD=1.6U
M$3625 VSS \$1568 \$1569 VSS nfet_03v3 L=0.28U W=0.36U AS=0.1584P AD=0.0972P
+ PS=1.6U PD=0.9U
M$3626 \$1570 \$1568 VSS VSS nfet_03v3 L=0.28U W=0.36U AS=0.0972P AD=0.18P
+ PS=0.9U PD=1.72U
M$3627 \$1571 \$80 VSS VSS nfet_03v3 L=0.28U W=0.36U AS=0.1584P AD=0.1188P
+ PS=1.6U PD=1.02U
M$3628 \$1572 \$1521 \$1571 VSS nfet_03v3 L=0.28U W=0.36U AS=0.1188P AD=0.1278P
+ PS=1.02U PD=1.07U
M$3629 \$1604 \$1573 \$1572 VSS nfet_03v3 L=0.28U W=0.36U AS=0.1278P AD=0.0567P
+ PS=1.07U PD=0.675U
M$3630 VSS \$1522 \$1604 VSS nfet_03v3 L=0.28U W=0.36U AS=0.0567P AD=0.1584P
+ PS=0.675U PD=1.6U
M$3631 VSS \$1572 \$1573 VSS nfet_03v3 L=0.28U W=0.36U AS=0.1584P AD=0.0972P
+ PS=1.6U PD=0.9U
M$3632 \$1574 \$1572 VSS VSS nfet_03v3 L=0.28U W=0.36U AS=0.0972P AD=0.18P
+ PS=0.9U PD=1.72U
M$3633 \$1575 \$83 VSS VSS nfet_03v3 L=0.28U W=0.36U AS=0.1584P AD=0.1188P
+ PS=1.6U PD=1.02U
M$3634 \$1576 \$1521 \$1575 VSS nfet_03v3 L=0.28U W=0.36U AS=0.1188P AD=0.1278P
+ PS=1.02U PD=1.07U
M$3635 \$1598 \$1577 \$1576 VSS nfet_03v3 L=0.28U W=0.36U AS=0.1278P AD=0.0567P
+ PS=1.07U PD=0.675U
M$3636 VSS \$1522 \$1598 VSS nfet_03v3 L=0.28U W=0.36U AS=0.0567P AD=0.1584P
+ PS=0.675U PD=1.6U
M$3637 VSS \$1576 \$1577 VSS nfet_03v3 L=0.28U W=0.36U AS=0.1584P AD=0.0972P
+ PS=1.6U PD=0.9U
M$3638 \$1578 \$1576 VSS VSS nfet_03v3 L=0.28U W=0.36U AS=0.0972P AD=0.18P
+ PS=0.9U PD=1.72U
M$3639 \$1579 \$86 VSS VSS nfet_03v3 L=0.28U W=0.36U AS=0.1584P AD=0.1188P
+ PS=1.6U PD=1.02U
M$3640 \$1580 \$1521 \$1579 VSS nfet_03v3 L=0.28U W=0.36U AS=0.1188P AD=0.1278P
+ PS=1.02U PD=1.07U
M$3641 \$1594 \$1581 \$1580 VSS nfet_03v3 L=0.28U W=0.36U AS=0.1278P AD=0.0567P
+ PS=1.07U PD=0.675U
M$3642 VSS \$1522 \$1594 VSS nfet_03v3 L=0.28U W=0.36U AS=0.0567P AD=0.1584P
+ PS=0.675U PD=1.6U
M$3643 VSS \$1580 \$1581 VSS nfet_03v3 L=0.28U W=0.36U AS=0.1584P AD=0.0972P
+ PS=1.6U PD=0.9U
M$3644 \$1582 \$1580 VSS VSS nfet_03v3 L=0.28U W=0.36U AS=0.0972P AD=0.18P
+ PS=0.9U PD=1.72U
M$3645 \$1583 \$89 VSS VSS nfet_03v3 L=0.28U W=0.36U AS=0.1584P AD=0.1188P
+ PS=1.6U PD=1.02U
M$3646 \$1584 \$1521 \$1583 VSS nfet_03v3 L=0.28U W=0.36U AS=0.1188P AD=0.1278P
+ PS=1.02U PD=1.07U
M$3647 \$1589 \$1585 \$1584 VSS nfet_03v3 L=0.28U W=0.36U AS=0.1278P AD=0.0567P
+ PS=1.07U PD=0.675U
M$3648 VSS \$1522 \$1589 VSS nfet_03v3 L=0.28U W=0.36U AS=0.0567P AD=0.1584P
+ PS=0.675U PD=1.6U
M$3649 VSS \$1584 \$1585 VSS nfet_03v3 L=0.28U W=0.36U AS=0.1584P AD=0.0972P
+ PS=1.6U PD=0.9U
M$3650 \$1586 \$1584 VSS VSS nfet_03v3 L=0.28U W=0.36U AS=0.0972P AD=0.18P
+ PS=0.9U PD=1.72U
M$3651 \$1840 RB10 VSS VSS nfet_03v3 L=0.28U W=0.36U AS=0.1656P AD=0.1944P
+ PS=1.64U PD=1.8U
M$3652 \$1637 RA11 VSS VSS nfet_03v3 L=0.28U W=0.36U AS=0.1656P AD=0.1944P
+ PS=1.64U PD=1.8U
M$3653 \$1526 RA11 \$360 VSS nfet_03v3 L=0.28U W=0.36U AS=0.1584P AD=0.1152P
+ PS=1.6U PD=1U
M$3654 \$361 RB11 \$1526 VSS nfet_03v3 L=0.28U W=0.36U AS=0.1152P AD=0.1584P
+ PS=1U PD=1.6U
M$3655 \$1839 RB10 \$360 VSS nfet_03v3 L=0.28U W=0.36U AS=0.1584P AD=0.1152P
+ PS=1.6U PD=1U
M$3656 \$361 RA10 \$1839 VSS nfet_03v3 L=0.28U W=0.36U AS=0.1152P AD=0.1584P
+ PS=1U PD=1.6U
M$3657 VSS RB11 \$1638 VSS nfet_03v3 L=0.28U W=0.36U AS=0.1854P AD=0.1584P
+ PS=1.75U PD=1.6U
M$3658 VSS RA10 \$1841 VSS nfet_03v3 L=0.28U W=0.36U AS=0.1854P AD=0.1584P
+ PS=1.75U PD=1.6U
M$3659 \$1639 RA11 VSS VSS nfet_03v3 L=0.28U W=0.36U AS=0.1656P AD=0.1944P
+ PS=1.64U PD=1.8U
M$3660 \$1846 RB10 VSS VSS nfet_03v3 L=0.28U W=0.36U AS=0.1656P AD=0.1944P
+ PS=1.64U PD=1.8U
M$3661 \$1845 RB10 \$365 VSS nfet_03v3 L=0.28U W=0.36U AS=0.1584P AD=0.1152P
+ PS=1.6U PD=1U
M$3662 \$366 RA10 \$1845 VSS nfet_03v3 L=0.28U W=0.36U AS=0.1152P AD=0.1584P
+ PS=1U PD=1.6U
M$3663 \$1530 RA11 \$365 VSS nfet_03v3 L=0.28U W=0.36U AS=0.1584P AD=0.1152P
+ PS=1.6U PD=1U
M$3664 \$366 RB11 \$1530 VSS nfet_03v3 L=0.28U W=0.36U AS=0.1152P AD=0.1584P
+ PS=1U PD=1.6U
M$3665 VSS RA10 \$1847 VSS nfet_03v3 L=0.28U W=0.36U AS=0.1854P AD=0.1584P
+ PS=1.75U PD=1.6U
M$3666 VSS RB11 \$1640 VSS nfet_03v3 L=0.28U W=0.36U AS=0.1854P AD=0.1584P
+ PS=1.75U PD=1.6U
M$3667 \$1852 RB10 VSS VSS nfet_03v3 L=0.28U W=0.36U AS=0.1656P AD=0.1944P
+ PS=1.64U PD=1.8U
M$3668 \$1641 RA11 VSS VSS nfet_03v3 L=0.28U W=0.36U AS=0.1656P AD=0.1944P
+ PS=1.64U PD=1.8U
M$3669 \$1534 RA11 \$370 VSS nfet_03v3 L=0.28U W=0.36U AS=0.1584P AD=0.1152P
+ PS=1.6U PD=1U
M$3670 \$371 RB11 \$1534 VSS nfet_03v3 L=0.28U W=0.36U AS=0.1152P AD=0.1584P
+ PS=1U PD=1.6U
M$3671 \$1851 RB10 \$370 VSS nfet_03v3 L=0.28U W=0.36U AS=0.1584P AD=0.1152P
+ PS=1.6U PD=1U
M$3672 \$371 RA10 \$1851 VSS nfet_03v3 L=0.28U W=0.36U AS=0.1152P AD=0.1584P
+ PS=1U PD=1.6U
M$3673 VSS RB11 \$1642 VSS nfet_03v3 L=0.28U W=0.36U AS=0.1854P AD=0.1584P
+ PS=1.75U PD=1.6U
M$3674 VSS RA10 \$1853 VSS nfet_03v3 L=0.28U W=0.36U AS=0.1854P AD=0.1584P
+ PS=1.75U PD=1.6U
M$3675 \$1858 RB10 VSS VSS nfet_03v3 L=0.28U W=0.36U AS=0.1656P AD=0.1944P
+ PS=1.64U PD=1.8U
M$3676 \$1643 RA11 VSS VSS nfet_03v3 L=0.28U W=0.36U AS=0.1656P AD=0.1944P
+ PS=1.64U PD=1.8U
M$3677 \$1857 RB10 \$375 VSS nfet_03v3 L=0.28U W=0.36U AS=0.1584P AD=0.1152P
+ PS=1.6U PD=1U
M$3678 \$376 RA10 \$1857 VSS nfet_03v3 L=0.28U W=0.36U AS=0.1152P AD=0.1584P
+ PS=1U PD=1.6U
M$3679 \$1538 RA11 \$375 VSS nfet_03v3 L=0.28U W=0.36U AS=0.1584P AD=0.1152P
+ PS=1.6U PD=1U
M$3680 \$376 RB11 \$1538 VSS nfet_03v3 L=0.28U W=0.36U AS=0.1152P AD=0.1584P
+ PS=1U PD=1.6U
M$3681 VSS RA10 \$1859 VSS nfet_03v3 L=0.28U W=0.36U AS=0.1854P AD=0.1584P
+ PS=1.75U PD=1.6U
M$3682 VSS RB11 \$1644 VSS nfet_03v3 L=0.28U W=0.36U AS=0.1854P AD=0.1584P
+ PS=1.75U PD=1.6U
M$3683 \$1864 RB10 VSS VSS nfet_03v3 L=0.28U W=0.36U AS=0.1656P AD=0.1944P
+ PS=1.64U PD=1.8U
M$3684 \$1645 RA11 VSS VSS nfet_03v3 L=0.28U W=0.36U AS=0.1656P AD=0.1944P
+ PS=1.64U PD=1.8U
M$3685 \$1863 RB10 \$380 VSS nfet_03v3 L=0.28U W=0.36U AS=0.1584P AD=0.1152P
+ PS=1.6U PD=1U
M$3686 \$381 RA10 \$1863 VSS nfet_03v3 L=0.28U W=0.36U AS=0.1152P AD=0.1584P
+ PS=1U PD=1.6U
M$3687 \$1542 RA11 \$380 VSS nfet_03v3 L=0.28U W=0.36U AS=0.1584P AD=0.1152P
+ PS=1.6U PD=1U
M$3688 \$381 RB11 \$1542 VSS nfet_03v3 L=0.28U W=0.36U AS=0.1152P AD=0.1584P
+ PS=1U PD=1.6U
M$3689 VSS RA10 \$1865 VSS nfet_03v3 L=0.28U W=0.36U AS=0.1854P AD=0.1584P
+ PS=1.75U PD=1.6U
M$3690 VSS RB11 \$1646 VSS nfet_03v3 L=0.28U W=0.36U AS=0.1854P AD=0.1584P
+ PS=1.75U PD=1.6U
M$3691 \$1647 RA11 VSS VSS nfet_03v3 L=0.28U W=0.36U AS=0.1656P AD=0.1944P
+ PS=1.64U PD=1.8U
M$3692 \$1870 RB10 VSS VSS nfet_03v3 L=0.28U W=0.36U AS=0.1656P AD=0.1944P
+ PS=1.64U PD=1.8U
M$3693 \$1546 RA11 \$385 VSS nfet_03v3 L=0.28U W=0.36U AS=0.1584P AD=0.1152P
+ PS=1.6U PD=1U
M$3694 \$386 RB11 \$1546 VSS nfet_03v3 L=0.28U W=0.36U AS=0.1152P AD=0.1584P
+ PS=1U PD=1.6U
M$3695 \$1869 RB10 \$385 VSS nfet_03v3 L=0.28U W=0.36U AS=0.1584P AD=0.1152P
+ PS=1.6U PD=1U
M$3696 \$386 RA10 \$1869 VSS nfet_03v3 L=0.28U W=0.36U AS=0.1152P AD=0.1584P
+ PS=1U PD=1.6U
M$3697 VSS RB11 \$1648 VSS nfet_03v3 L=0.28U W=0.36U AS=0.1854P AD=0.1584P
+ PS=1.75U PD=1.6U
M$3698 VSS RA10 \$1871 VSS nfet_03v3 L=0.28U W=0.36U AS=0.1854P AD=0.1584P
+ PS=1.75U PD=1.6U
M$3699 \$1876 RB10 VSS VSS nfet_03v3 L=0.28U W=0.36U AS=0.1656P AD=0.1944P
+ PS=1.64U PD=1.8U
M$3700 \$1649 RA11 VSS VSS nfet_03v3 L=0.28U W=0.36U AS=0.1656P AD=0.1944P
+ PS=1.64U PD=1.8U
M$3701 \$1875 RB10 \$390 VSS nfet_03v3 L=0.28U W=0.36U AS=0.1584P AD=0.1152P
+ PS=1.6U PD=1U
M$3702 \$391 RA10 \$1875 VSS nfet_03v3 L=0.28U W=0.36U AS=0.1152P AD=0.1584P
+ PS=1U PD=1.6U
M$3703 \$1550 RA11 \$390 VSS nfet_03v3 L=0.28U W=0.36U AS=0.1584P AD=0.1152P
+ PS=1.6U PD=1U
M$3704 \$391 RB11 \$1550 VSS nfet_03v3 L=0.28U W=0.36U AS=0.1152P AD=0.1584P
+ PS=1U PD=1.6U
M$3705 VSS RB11 \$1650 VSS nfet_03v3 L=0.28U W=0.36U AS=0.1854P AD=0.1584P
+ PS=1.75U PD=1.6U
M$3706 VSS RA10 \$1877 VSS nfet_03v3 L=0.28U W=0.36U AS=0.1854P AD=0.1584P
+ PS=1.75U PD=1.6U
M$3707 \$1651 RA11 VSS VSS nfet_03v3 L=0.28U W=0.36U AS=0.1656P AD=0.1944P
+ PS=1.64U PD=1.8U
M$3708 \$1882 RB10 VSS VSS nfet_03v3 L=0.28U W=0.36U AS=0.1656P AD=0.1944P
+ PS=1.64U PD=1.8U
M$3709 \$1554 RA11 \$395 VSS nfet_03v3 L=0.28U W=0.36U AS=0.1584P AD=0.1152P
+ PS=1.6U PD=1U
M$3710 \$396 RB11 \$1554 VSS nfet_03v3 L=0.28U W=0.36U AS=0.1152P AD=0.1584P
+ PS=1U PD=1.6U
M$3711 \$1881 RB10 \$395 VSS nfet_03v3 L=0.28U W=0.36U AS=0.1584P AD=0.1152P
+ PS=1.6U PD=1U
M$3712 \$396 RA10 \$1881 VSS nfet_03v3 L=0.28U W=0.36U AS=0.1152P AD=0.1584P
+ PS=1U PD=1.6U
M$3713 VSS RB11 \$1652 VSS nfet_03v3 L=0.28U W=0.36U AS=0.1854P AD=0.1584P
+ PS=1.75U PD=1.6U
M$3714 VSS RA10 \$1883 VSS nfet_03v3 L=0.28U W=0.36U AS=0.1854P AD=0.1584P
+ PS=1.75U PD=1.6U
M$3715 \$1653 RA11 VSS VSS nfet_03v3 L=0.28U W=0.36U AS=0.1656P AD=0.1944P
+ PS=1.64U PD=1.8U
M$3716 \$1888 RB10 VSS VSS nfet_03v3 L=0.28U W=0.36U AS=0.1656P AD=0.1944P
+ PS=1.64U PD=1.8U
M$3717 \$1558 RA11 \$400 VSS nfet_03v3 L=0.28U W=0.36U AS=0.1584P AD=0.1152P
+ PS=1.6U PD=1U
M$3718 \$401 RB11 \$1558 VSS nfet_03v3 L=0.28U W=0.36U AS=0.1152P AD=0.1584P
+ PS=1U PD=1.6U
M$3719 \$1887 RB10 \$400 VSS nfet_03v3 L=0.28U W=0.36U AS=0.1584P AD=0.1152P
+ PS=1.6U PD=1U
M$3720 \$401 RA10 \$1887 VSS nfet_03v3 L=0.28U W=0.36U AS=0.1152P AD=0.1584P
+ PS=1U PD=1.6U
M$3721 VSS RB11 \$1654 VSS nfet_03v3 L=0.28U W=0.36U AS=0.1854P AD=0.1584P
+ PS=1.75U PD=1.6U
M$3722 VSS RA10 \$1889 VSS nfet_03v3 L=0.28U W=0.36U AS=0.1854P AD=0.1584P
+ PS=1.75U PD=1.6U
M$3723 \$1655 RA11 VSS VSS nfet_03v3 L=0.28U W=0.36U AS=0.1656P AD=0.1944P
+ PS=1.64U PD=1.8U
M$3724 \$1894 RB10 VSS VSS nfet_03v3 L=0.28U W=0.36U AS=0.1656P AD=0.1944P
+ PS=1.64U PD=1.8U
M$3725 \$1562 RA11 \$405 VSS nfet_03v3 L=0.28U W=0.36U AS=0.1584P AD=0.1152P
+ PS=1.6U PD=1U
M$3726 \$406 RB11 \$1562 VSS nfet_03v3 L=0.28U W=0.36U AS=0.1152P AD=0.1584P
+ PS=1U PD=1.6U
M$3727 \$1893 RB10 \$405 VSS nfet_03v3 L=0.28U W=0.36U AS=0.1584P AD=0.1152P
+ PS=1.6U PD=1U
M$3728 \$406 RA10 \$1893 VSS nfet_03v3 L=0.28U W=0.36U AS=0.1152P AD=0.1584P
+ PS=1U PD=1.6U
M$3729 VSS RA10 \$1895 VSS nfet_03v3 L=0.28U W=0.36U AS=0.1854P AD=0.1584P
+ PS=1.75U PD=1.6U
M$3730 VSS RB11 \$1656 VSS nfet_03v3 L=0.28U W=0.36U AS=0.1854P AD=0.1584P
+ PS=1.75U PD=1.6U
M$3731 \$1900 RB10 VSS VSS nfet_03v3 L=0.28U W=0.36U AS=0.1656P AD=0.1944P
+ PS=1.64U PD=1.8U
M$3732 \$1657 RA11 VSS VSS nfet_03v3 L=0.28U W=0.36U AS=0.1656P AD=0.1944P
+ PS=1.64U PD=1.8U
M$3733 \$1566 RA11 \$410 VSS nfet_03v3 L=0.28U W=0.36U AS=0.1584P AD=0.1152P
+ PS=1.6U PD=1U
M$3734 \$411 RB11 \$1566 VSS nfet_03v3 L=0.28U W=0.36U AS=0.1152P AD=0.1584P
+ PS=1U PD=1.6U
M$3735 \$1899 RB10 \$410 VSS nfet_03v3 L=0.28U W=0.36U AS=0.1584P AD=0.1152P
+ PS=1.6U PD=1U
M$3736 \$411 RA10 \$1899 VSS nfet_03v3 L=0.28U W=0.36U AS=0.1152P AD=0.1584P
+ PS=1U PD=1.6U
M$3737 VSS RB11 \$1658 VSS nfet_03v3 L=0.28U W=0.36U AS=0.1854P AD=0.1584P
+ PS=1.75U PD=1.6U
M$3738 VSS RA10 \$1901 VSS nfet_03v3 L=0.28U W=0.36U AS=0.1854P AD=0.1584P
+ PS=1.75U PD=1.6U
M$3739 \$1906 RB10 VSS VSS nfet_03v3 L=0.28U W=0.36U AS=0.1656P AD=0.1944P
+ PS=1.64U PD=1.8U
M$3740 \$1659 RA11 VSS VSS nfet_03v3 L=0.28U W=0.36U AS=0.1656P AD=0.1944P
+ PS=1.64U PD=1.8U
M$3741 \$1570 RA11 \$415 VSS nfet_03v3 L=0.28U W=0.36U AS=0.1584P AD=0.1152P
+ PS=1.6U PD=1U
M$3742 \$416 RB11 \$1570 VSS nfet_03v3 L=0.28U W=0.36U AS=0.1152P AD=0.1584P
+ PS=1U PD=1.6U
M$3743 \$1905 RB10 \$415 VSS nfet_03v3 L=0.28U W=0.36U AS=0.1584P AD=0.1152P
+ PS=1.6U PD=1U
M$3744 \$416 RA10 \$1905 VSS nfet_03v3 L=0.28U W=0.36U AS=0.1152P AD=0.1584P
+ PS=1U PD=1.6U
M$3745 VSS RB11 \$1660 VSS nfet_03v3 L=0.28U W=0.36U AS=0.1854P AD=0.1584P
+ PS=1.75U PD=1.6U
M$3746 VSS RA10 \$1907 VSS nfet_03v3 L=0.28U W=0.36U AS=0.1854P AD=0.1584P
+ PS=1.75U PD=1.6U
M$3747 \$1661 RA11 VSS VSS nfet_03v3 L=0.28U W=0.36U AS=0.1656P AD=0.1944P
+ PS=1.64U PD=1.8U
M$3748 \$1912 RB10 VSS VSS nfet_03v3 L=0.28U W=0.36U AS=0.1656P AD=0.1944P
+ PS=1.64U PD=1.8U
M$3749 \$1911 RB10 \$420 VSS nfet_03v3 L=0.28U W=0.36U AS=0.1584P AD=0.1152P
+ PS=1.6U PD=1U
M$3750 \$421 RA10 \$1911 VSS nfet_03v3 L=0.28U W=0.36U AS=0.1152P AD=0.1584P
+ PS=1U PD=1.6U
M$3751 \$1574 RA11 \$420 VSS nfet_03v3 L=0.28U W=0.36U AS=0.1584P AD=0.1152P
+ PS=1.6U PD=1U
M$3752 \$421 RB11 \$1574 VSS nfet_03v3 L=0.28U W=0.36U AS=0.1152P AD=0.1584P
+ PS=1U PD=1.6U
M$3753 VSS RA10 \$1913 VSS nfet_03v3 L=0.28U W=0.36U AS=0.1854P AD=0.1584P
+ PS=1.75U PD=1.6U
M$3754 VSS RB11 \$1662 VSS nfet_03v3 L=0.28U W=0.36U AS=0.1854P AD=0.1584P
+ PS=1.75U PD=1.6U
M$3755 \$1918 RB10 VSS VSS nfet_03v3 L=0.28U W=0.36U AS=0.1656P AD=0.1944P
+ PS=1.64U PD=1.8U
M$3756 \$1663 RA11 VSS VSS nfet_03v3 L=0.28U W=0.36U AS=0.1656P AD=0.1944P
+ PS=1.64U PD=1.8U
M$3757 \$1917 RB10 \$425 VSS nfet_03v3 L=0.28U W=0.36U AS=0.1584P AD=0.1152P
+ PS=1.6U PD=1U
M$3758 \$426 RA10 \$1917 VSS nfet_03v3 L=0.28U W=0.36U AS=0.1152P AD=0.1584P
+ PS=1U PD=1.6U
M$3759 \$1578 RA11 \$425 VSS nfet_03v3 L=0.28U W=0.36U AS=0.1584P AD=0.1152P
+ PS=1.6U PD=1U
M$3760 \$426 RB11 \$1578 VSS nfet_03v3 L=0.28U W=0.36U AS=0.1152P AD=0.1584P
+ PS=1U PD=1.6U
M$3761 VSS RB11 \$1664 VSS nfet_03v3 L=0.28U W=0.36U AS=0.1854P AD=0.1584P
+ PS=1.75U PD=1.6U
M$3762 VSS RA10 \$1919 VSS nfet_03v3 L=0.28U W=0.36U AS=0.1854P AD=0.1584P
+ PS=1.75U PD=1.6U
M$3763 \$1924 RB10 VSS VSS nfet_03v3 L=0.28U W=0.36U AS=0.1656P AD=0.1944P
+ PS=1.64U PD=1.8U
M$3764 \$1665 RA11 VSS VSS nfet_03v3 L=0.28U W=0.36U AS=0.1656P AD=0.1944P
+ PS=1.64U PD=1.8U
M$3765 \$1582 RA11 \$430 VSS nfet_03v3 L=0.28U W=0.36U AS=0.1584P AD=0.1152P
+ PS=1.6U PD=1U
M$3766 \$431 RB11 \$1582 VSS nfet_03v3 L=0.28U W=0.36U AS=0.1152P AD=0.1584P
+ PS=1U PD=1.6U
M$3767 \$1923 RB10 \$430 VSS nfet_03v3 L=0.28U W=0.36U AS=0.1584P AD=0.1152P
+ PS=1.6U PD=1U
M$3768 \$431 RA10 \$1923 VSS nfet_03v3 L=0.28U W=0.36U AS=0.1152P AD=0.1584P
+ PS=1U PD=1.6U
M$3769 VSS RB11 \$1666 VSS nfet_03v3 L=0.28U W=0.36U AS=0.1854P AD=0.1584P
+ PS=1.75U PD=1.6U
M$3770 VSS RA10 \$1925 VSS nfet_03v3 L=0.28U W=0.36U AS=0.1854P AD=0.1584P
+ PS=1.75U PD=1.6U
M$3771 \$1930 RB10 VSS VSS nfet_03v3 L=0.28U W=0.36U AS=0.1656P AD=0.1944P
+ PS=1.64U PD=1.8U
M$3772 \$1667 RA11 VSS VSS nfet_03v3 L=0.28U W=0.36U AS=0.1656P AD=0.1944P
+ PS=1.64U PD=1.8U
M$3773 \$1586 RA11 \$435 VSS nfet_03v3 L=0.28U W=0.36U AS=0.1584P AD=0.1152P
+ PS=1.6U PD=1U
M$3774 \$436 RB11 \$1586 VSS nfet_03v3 L=0.28U W=0.36U AS=0.1152P AD=0.1584P
+ PS=1U PD=1.6U
M$3775 \$1929 RB10 \$435 VSS nfet_03v3 L=0.28U W=0.36U AS=0.1584P AD=0.1152P
+ PS=1.6U PD=1U
M$3776 \$436 RA10 \$1929 VSS nfet_03v3 L=0.28U W=0.36U AS=0.1152P AD=0.1584P
+ PS=1U PD=1.6U
M$3777 VSS RA10 \$1931 VSS nfet_03v3 L=0.28U W=0.36U AS=0.1854P AD=0.1584P
+ PS=1.75U PD=1.6U
M$3778 VSS RB11 \$1668 VSS nfet_03v3 L=0.28U W=0.36U AS=0.1854P AD=0.1584P
+ PS=1.75U PD=1.6U
M$3779 \$2035 WE10 VSS VSS nfet_03v3 L=0.28U W=0.72U AS=0.3168P AD=0.1872P
+ PS=2.32U PD=1.24U
M$3780 \$1830 CLK \$2035 VSS nfet_03v3 L=0.28U W=0.72U AS=0.1872P AD=0.3168P
+ PS=1.24U PD=2.32U
M$3781 \$1832 \$1830 VSS VSS nfet_03v3 L=0.28U W=1.27U AS=0.4487P AD=0.3302P
+ PS=3.34U PD=2.31U
M$3783 \$1833 \$1832 VSS VSS nfet_03v3 L=0.28U W=1.34U AS=0.3636P AD=0.4891P
+ PS=2.44U PD=3.47U
M$3785 \$1836 \$44 VSS VSS nfet_03v3 L=0.28U W=0.36U AS=0.1584P AD=0.1188P
+ PS=1.6U PD=1.02U
M$3786 \$1837 \$1832 \$1836 VSS nfet_03v3 L=0.28U W=0.36U AS=0.1188P AD=0.1278P
+ PS=1.02U PD=1.07U
M$3787 \$2040 \$1838 \$1837 VSS nfet_03v3 L=0.28U W=0.36U AS=0.1278P AD=0.0567P
+ PS=1.07U PD=0.675U
M$3788 VSS \$1833 \$2040 VSS nfet_03v3 L=0.28U W=0.36U AS=0.0567P AD=0.1584P
+ PS=0.675U PD=1.6U
M$3789 VSS \$1837 \$1838 VSS nfet_03v3 L=0.28U W=0.36U AS=0.1584P AD=0.0972P
+ PS=1.6U PD=0.9U
M$3790 \$1839 \$1837 VSS VSS nfet_03v3 L=0.28U W=0.36U AS=0.0972P AD=0.18P
+ PS=0.9U PD=1.72U
M$3791 \$1842 \$47 VSS VSS nfet_03v3 L=0.28U W=0.36U AS=0.1584P AD=0.1188P
+ PS=1.6U PD=1.02U
M$3792 \$1843 \$1832 \$1842 VSS nfet_03v3 L=0.28U W=0.36U AS=0.1188P AD=0.1278P
+ PS=1.02U PD=1.07U
M$3793 \$2049 \$1844 \$1843 VSS nfet_03v3 L=0.28U W=0.36U AS=0.1278P AD=0.0567P
+ PS=1.07U PD=0.675U
M$3794 VSS \$1833 \$2049 VSS nfet_03v3 L=0.28U W=0.36U AS=0.0567P AD=0.1584P
+ PS=0.675U PD=1.6U
M$3795 VSS \$1843 \$1844 VSS nfet_03v3 L=0.28U W=0.36U AS=0.1584P AD=0.0972P
+ PS=1.6U PD=0.9U
M$3796 \$1845 \$1843 VSS VSS nfet_03v3 L=0.28U W=0.36U AS=0.0972P AD=0.18P
+ PS=0.9U PD=1.72U
M$3797 \$1848 \$50 VSS VSS nfet_03v3 L=0.28U W=0.36U AS=0.1584P AD=0.1188P
+ PS=1.6U PD=1.02U
M$3798 \$1849 \$1832 \$1848 VSS nfet_03v3 L=0.28U W=0.36U AS=0.1188P AD=0.1278P
+ PS=1.02U PD=1.07U
M$3799 \$2056 \$1850 \$1849 VSS nfet_03v3 L=0.28U W=0.36U AS=0.1278P AD=0.0567P
+ PS=1.07U PD=0.675U
M$3800 VSS \$1833 \$2056 VSS nfet_03v3 L=0.28U W=0.36U AS=0.0567P AD=0.1584P
+ PS=0.675U PD=1.6U
M$3801 VSS \$1849 \$1850 VSS nfet_03v3 L=0.28U W=0.36U AS=0.1584P AD=0.0972P
+ PS=1.6U PD=0.9U
M$3802 \$1851 \$1849 VSS VSS nfet_03v3 L=0.28U W=0.36U AS=0.0972P AD=0.18P
+ PS=0.9U PD=1.72U
M$3803 \$1854 \$53 VSS VSS nfet_03v3 L=0.28U W=0.36U AS=0.1584P AD=0.1188P
+ PS=1.6U PD=1.02U
M$3804 \$1855 \$1832 \$1854 VSS nfet_03v3 L=0.28U W=0.36U AS=0.1188P AD=0.1278P
+ PS=1.02U PD=1.07U
M$3805 \$2063 \$1856 \$1855 VSS nfet_03v3 L=0.28U W=0.36U AS=0.1278P AD=0.0567P
+ PS=1.07U PD=0.675U
M$3806 VSS \$1833 \$2063 VSS nfet_03v3 L=0.28U W=0.36U AS=0.0567P AD=0.1584P
+ PS=0.675U PD=1.6U
M$3807 VSS \$1855 \$1856 VSS nfet_03v3 L=0.28U W=0.36U AS=0.1584P AD=0.0972P
+ PS=1.6U PD=0.9U
M$3808 \$1857 \$1855 VSS VSS nfet_03v3 L=0.28U W=0.36U AS=0.0972P AD=0.18P
+ PS=0.9U PD=1.72U
M$3809 \$1860 \$56 VSS VSS nfet_03v3 L=0.28U W=0.36U AS=0.1584P AD=0.1188P
+ PS=1.6U PD=1.02U
M$3810 \$1861 \$1832 \$1860 VSS nfet_03v3 L=0.28U W=0.36U AS=0.1188P AD=0.1278P
+ PS=1.02U PD=1.07U
M$3811 \$2073 \$1862 \$1861 VSS nfet_03v3 L=0.28U W=0.36U AS=0.1278P AD=0.0567P
+ PS=1.07U PD=0.675U
M$3812 VSS \$1833 \$2073 VSS nfet_03v3 L=0.28U W=0.36U AS=0.0567P AD=0.1584P
+ PS=0.675U PD=1.6U
M$3813 VSS \$1861 \$1862 VSS nfet_03v3 L=0.28U W=0.36U AS=0.1584P AD=0.0972P
+ PS=1.6U PD=0.9U
M$3814 \$1863 \$1861 VSS VSS nfet_03v3 L=0.28U W=0.36U AS=0.0972P AD=0.18P
+ PS=0.9U PD=1.72U
M$3815 \$1866 \$59 VSS VSS nfet_03v3 L=0.28U W=0.36U AS=0.1584P AD=0.1188P
+ PS=1.6U PD=1.02U
M$3816 \$1867 \$1832 \$1866 VSS nfet_03v3 L=0.28U W=0.36U AS=0.1188P AD=0.1278P
+ PS=1.02U PD=1.07U
M$3817 \$2080 \$1868 \$1867 VSS nfet_03v3 L=0.28U W=0.36U AS=0.1278P AD=0.0567P
+ PS=1.07U PD=0.675U
M$3818 VSS \$1833 \$2080 VSS nfet_03v3 L=0.28U W=0.36U AS=0.0567P AD=0.1584P
+ PS=0.675U PD=1.6U
M$3819 VSS \$1867 \$1868 VSS nfet_03v3 L=0.28U W=0.36U AS=0.1584P AD=0.0972P
+ PS=1.6U PD=0.9U
M$3820 \$1869 \$1867 VSS VSS nfet_03v3 L=0.28U W=0.36U AS=0.0972P AD=0.18P
+ PS=0.9U PD=1.72U
M$3821 \$1872 \$62 VSS VSS nfet_03v3 L=0.28U W=0.36U AS=0.1584P AD=0.1188P
+ PS=1.6U PD=1.02U
M$3822 \$1873 \$1832 \$1872 VSS nfet_03v3 L=0.28U W=0.36U AS=0.1188P AD=0.1278P
+ PS=1.02U PD=1.07U
M$3823 \$2087 \$1874 \$1873 VSS nfet_03v3 L=0.28U W=0.36U AS=0.1278P AD=0.0567P
+ PS=1.07U PD=0.675U
M$3824 VSS \$1833 \$2087 VSS nfet_03v3 L=0.28U W=0.36U AS=0.0567P AD=0.1584P
+ PS=0.675U PD=1.6U
M$3825 VSS \$1873 \$1874 VSS nfet_03v3 L=0.28U W=0.36U AS=0.1584P AD=0.0972P
+ PS=1.6U PD=0.9U
M$3826 \$1875 \$1873 VSS VSS nfet_03v3 L=0.28U W=0.36U AS=0.0972P AD=0.18P
+ PS=0.9U PD=1.72U
M$3827 \$1878 \$65 VSS VSS nfet_03v3 L=0.28U W=0.36U AS=0.1584P AD=0.1188P
+ PS=1.6U PD=1.02U
M$3828 \$1879 \$1832 \$1878 VSS nfet_03v3 L=0.28U W=0.36U AS=0.1188P AD=0.1278P
+ PS=1.02U PD=1.07U
M$3829 \$2097 \$1880 \$1879 VSS nfet_03v3 L=0.28U W=0.36U AS=0.1278P AD=0.0567P
+ PS=1.07U PD=0.675U
M$3830 VSS \$1833 \$2097 VSS nfet_03v3 L=0.28U W=0.36U AS=0.0567P AD=0.1584P
+ PS=0.675U PD=1.6U
M$3831 VSS \$1879 \$1880 VSS nfet_03v3 L=0.28U W=0.36U AS=0.1584P AD=0.0972P
+ PS=1.6U PD=0.9U
M$3832 \$1881 \$1879 VSS VSS nfet_03v3 L=0.28U W=0.36U AS=0.0972P AD=0.18P
+ PS=0.9U PD=1.72U
M$3833 \$1884 \$68 VSS VSS nfet_03v3 L=0.28U W=0.36U AS=0.1584P AD=0.1188P
+ PS=1.6U PD=1.02U
M$3834 \$1885 \$1832 \$1884 VSS nfet_03v3 L=0.28U W=0.36U AS=0.1188P AD=0.1278P
+ PS=1.02U PD=1.07U
M$3835 \$2103 \$1886 \$1885 VSS nfet_03v3 L=0.28U W=0.36U AS=0.1278P AD=0.0567P
+ PS=1.07U PD=0.675U
M$3836 VSS \$1833 \$2103 VSS nfet_03v3 L=0.28U W=0.36U AS=0.0567P AD=0.1584P
+ PS=0.675U PD=1.6U
M$3837 VSS \$1885 \$1886 VSS nfet_03v3 L=0.28U W=0.36U AS=0.1584P AD=0.0972P
+ PS=1.6U PD=0.9U
M$3838 \$1887 \$1885 VSS VSS nfet_03v3 L=0.28U W=0.36U AS=0.0972P AD=0.18P
+ PS=0.9U PD=1.72U
M$3839 \$1890 \$71 VSS VSS nfet_03v3 L=0.28U W=0.36U AS=0.1584P AD=0.1188P
+ PS=1.6U PD=1.02U
M$3840 \$1891 \$1832 \$1890 VSS nfet_03v3 L=0.28U W=0.36U AS=0.1188P AD=0.1278P
+ PS=1.02U PD=1.07U
M$3841 \$2111 \$1892 \$1891 VSS nfet_03v3 L=0.28U W=0.36U AS=0.1278P AD=0.0567P
+ PS=1.07U PD=0.675U
M$3842 VSS \$1833 \$2111 VSS nfet_03v3 L=0.28U W=0.36U AS=0.0567P AD=0.1584P
+ PS=0.675U PD=1.6U
M$3843 VSS \$1891 \$1892 VSS nfet_03v3 L=0.28U W=0.36U AS=0.1584P AD=0.0972P
+ PS=1.6U PD=0.9U
M$3844 \$1893 \$1891 VSS VSS nfet_03v3 L=0.28U W=0.36U AS=0.0972P AD=0.18P
+ PS=0.9U PD=1.72U
M$3845 \$1896 \$74 VSS VSS nfet_03v3 L=0.28U W=0.36U AS=0.1584P AD=0.1188P
+ PS=1.6U PD=1.02U
M$3846 \$1897 \$1832 \$1896 VSS nfet_03v3 L=0.28U W=0.36U AS=0.1188P AD=0.1278P
+ PS=1.02U PD=1.07U
M$3847 \$2119 \$1898 \$1897 VSS nfet_03v3 L=0.28U W=0.36U AS=0.1278P AD=0.0567P
+ PS=1.07U PD=0.675U
M$3848 VSS \$1833 \$2119 VSS nfet_03v3 L=0.28U W=0.36U AS=0.0567P AD=0.1584P
+ PS=0.675U PD=1.6U
M$3849 VSS \$1897 \$1898 VSS nfet_03v3 L=0.28U W=0.36U AS=0.1584P AD=0.0972P
+ PS=1.6U PD=0.9U
M$3850 \$1899 \$1897 VSS VSS nfet_03v3 L=0.28U W=0.36U AS=0.0972P AD=0.18P
+ PS=0.9U PD=1.72U
M$3851 \$1902 \$77 VSS VSS nfet_03v3 L=0.28U W=0.36U AS=0.1584P AD=0.1188P
+ PS=1.6U PD=1.02U
M$3852 \$1903 \$1832 \$1902 VSS nfet_03v3 L=0.28U W=0.36U AS=0.1188P AD=0.1278P
+ PS=1.02U PD=1.07U
M$3853 \$2127 \$1904 \$1903 VSS nfet_03v3 L=0.28U W=0.36U AS=0.1278P AD=0.0567P
+ PS=1.07U PD=0.675U
M$3854 VSS \$1833 \$2127 VSS nfet_03v3 L=0.28U W=0.36U AS=0.0567P AD=0.1584P
+ PS=0.675U PD=1.6U
M$3855 VSS \$1903 \$1904 VSS nfet_03v3 L=0.28U W=0.36U AS=0.1584P AD=0.0972P
+ PS=1.6U PD=0.9U
M$3856 \$1905 \$1903 VSS VSS nfet_03v3 L=0.28U W=0.36U AS=0.0972P AD=0.18P
+ PS=0.9U PD=1.72U
M$3857 \$1908 \$80 VSS VSS nfet_03v3 L=0.28U W=0.36U AS=0.1584P AD=0.1188P
+ PS=1.6U PD=1.02U
M$3858 \$1909 \$1832 \$1908 VSS nfet_03v3 L=0.28U W=0.36U AS=0.1188P AD=0.1278P
+ PS=1.02U PD=1.07U
M$3859 \$2122 \$1910 \$1909 VSS nfet_03v3 L=0.28U W=0.36U AS=0.1278P AD=0.0567P
+ PS=1.07U PD=0.675U
M$3860 VSS \$1833 \$2122 VSS nfet_03v3 L=0.28U W=0.36U AS=0.0567P AD=0.1584P
+ PS=0.675U PD=1.6U
M$3861 VSS \$1909 \$1910 VSS nfet_03v3 L=0.28U W=0.36U AS=0.1584P AD=0.0972P
+ PS=1.6U PD=0.9U
M$3862 \$1911 \$1909 VSS VSS nfet_03v3 L=0.28U W=0.36U AS=0.0972P AD=0.18P
+ PS=0.9U PD=1.72U
M$3863 \$1914 \$83 VSS VSS nfet_03v3 L=0.28U W=0.36U AS=0.1584P AD=0.1188P
+ PS=1.6U PD=1.02U
M$3864 \$1915 \$1832 \$1914 VSS nfet_03v3 L=0.28U W=0.36U AS=0.1188P AD=0.1278P
+ PS=1.02U PD=1.07U
M$3865 \$2096 \$1916 \$1915 VSS nfet_03v3 L=0.28U W=0.36U AS=0.1278P AD=0.0567P
+ PS=1.07U PD=0.675U
M$3866 VSS \$1833 \$2096 VSS nfet_03v3 L=0.28U W=0.36U AS=0.0567P AD=0.1584P
+ PS=0.675U PD=1.6U
M$3867 VSS \$1915 \$1916 VSS nfet_03v3 L=0.28U W=0.36U AS=0.1584P AD=0.0972P
+ PS=1.6U PD=0.9U
M$3868 \$1917 \$1915 VSS VSS nfet_03v3 L=0.28U W=0.36U AS=0.0972P AD=0.18P
+ PS=0.9U PD=1.72U
M$3869 \$1920 \$86 VSS VSS nfet_03v3 L=0.28U W=0.36U AS=0.1584P AD=0.1188P
+ PS=1.6U PD=1.02U
M$3870 \$1921 \$1832 \$1920 VSS nfet_03v3 L=0.28U W=0.36U AS=0.1188P AD=0.1278P
+ PS=1.02U PD=1.07U
M$3871 \$2072 \$1922 \$1921 VSS nfet_03v3 L=0.28U W=0.36U AS=0.1278P AD=0.0567P
+ PS=1.07U PD=0.675U
M$3872 VSS \$1833 \$2072 VSS nfet_03v3 L=0.28U W=0.36U AS=0.0567P AD=0.1584P
+ PS=0.675U PD=1.6U
M$3873 VSS \$1921 \$1922 VSS nfet_03v3 L=0.28U W=0.36U AS=0.1584P AD=0.0972P
+ PS=1.6U PD=0.9U
M$3874 \$1923 \$1921 VSS VSS nfet_03v3 L=0.28U W=0.36U AS=0.0972P AD=0.18P
+ PS=0.9U PD=1.72U
M$3875 \$1926 \$89 VSS VSS nfet_03v3 L=0.28U W=0.36U AS=0.1584P AD=0.1188P
+ PS=1.6U PD=1.02U
M$3876 \$1927 \$1832 \$1926 VSS nfet_03v3 L=0.28U W=0.36U AS=0.1188P AD=0.1278P
+ PS=1.02U PD=1.07U
M$3877 \$2048 \$1928 \$1927 VSS nfet_03v3 L=0.28U W=0.36U AS=0.1278P AD=0.0567P
+ PS=1.07U PD=0.675U
M$3878 VSS \$1833 \$2048 VSS nfet_03v3 L=0.28U W=0.36U AS=0.0567P AD=0.1584P
+ PS=0.675U PD=1.6U
M$3879 VSS \$1927 \$1928 VSS nfet_03v3 L=0.28U W=0.36U AS=0.1584P AD=0.0972P
+ PS=1.6U PD=0.9U
M$3880 \$1929 \$1927 VSS VSS nfet_03v3 L=0.28U W=0.36U AS=0.0972P AD=0.18P
+ PS=0.9U PD=1.72U
M$3881 \$2282 WE9 VSS VSS nfet_03v3 L=0.28U W=0.72U AS=0.3168P AD=0.1872P
+ PS=2.32U PD=1.24U
M$3882 \$2133 CLK \$2282 VSS nfet_03v3 L=0.28U W=0.72U AS=0.1872P AD=0.3168P
+ PS=1.24U PD=2.32U
M$3883 \$2134 \$2133 VSS VSS nfet_03v3 L=0.28U W=1.27U AS=0.4445P AD=0.3344P
+ PS=3.305U PD=2.345U
M$3885 \$2135 \$2134 VSS VSS nfet_03v3 L=0.28U W=1.34U AS=0.3636P AD=0.4891P
+ PS=2.44U PD=3.47U
M$3887 \$2136 \$44 VSS VSS nfet_03v3 L=0.28U W=0.36U AS=0.1584P AD=0.1188P
+ PS=1.6U PD=1.02U
M$3888 \$2137 \$2134 \$2136 VSS nfet_03v3 L=0.28U W=0.36U AS=0.1188P AD=0.1278P
+ PS=1.02U PD=1.07U
M$3889 \$2204 \$2138 \$2137 VSS nfet_03v3 L=0.28U W=0.36U AS=0.1278P AD=0.0567P
+ PS=1.07U PD=0.675U
M$3890 VSS \$2135 \$2204 VSS nfet_03v3 L=0.28U W=0.36U AS=0.0567P AD=0.1584P
+ PS=0.675U PD=1.6U
M$3891 VSS \$2137 \$2138 VSS nfet_03v3 L=0.28U W=0.36U AS=0.1584P AD=0.0972P
+ PS=1.6U PD=0.9U
M$3892 \$2139 \$2137 VSS VSS nfet_03v3 L=0.28U W=0.36U AS=0.0972P AD=0.18P
+ PS=0.9U PD=1.72U
M$3893 \$2140 \$47 VSS VSS nfet_03v3 L=0.28U W=0.36U AS=0.1584P AD=0.1188P
+ PS=1.6U PD=1.02U
M$3894 \$2141 \$2134 \$2140 VSS nfet_03v3 L=0.28U W=0.36U AS=0.1188P AD=0.1278P
+ PS=1.02U PD=1.07U
M$3895 \$2213 \$2142 \$2141 VSS nfet_03v3 L=0.28U W=0.36U AS=0.1278P AD=0.0567P
+ PS=1.07U PD=0.675U
M$3896 VSS \$2135 \$2213 VSS nfet_03v3 L=0.28U W=0.36U AS=0.0567P AD=0.1584P
+ PS=0.675U PD=1.6U
M$3897 VSS \$2141 \$2142 VSS nfet_03v3 L=0.28U W=0.36U AS=0.1584P AD=0.0972P
+ PS=1.6U PD=0.9U
M$3898 \$2143 \$2141 VSS VSS nfet_03v3 L=0.28U W=0.36U AS=0.0972P AD=0.18P
+ PS=0.9U PD=1.72U
M$3899 \$2144 \$50 VSS VSS nfet_03v3 L=0.28U W=0.36U AS=0.1584P AD=0.1188P
+ PS=1.6U PD=1.02U
M$3900 \$2145 \$2134 \$2144 VSS nfet_03v3 L=0.28U W=0.36U AS=0.1188P AD=0.1278P
+ PS=1.02U PD=1.07U
M$3901 \$2221 \$2146 \$2145 VSS nfet_03v3 L=0.28U W=0.36U AS=0.1278P AD=0.0567P
+ PS=1.07U PD=0.675U
M$3902 VSS \$2135 \$2221 VSS nfet_03v3 L=0.28U W=0.36U AS=0.0567P AD=0.1584P
+ PS=0.675U PD=1.6U
M$3903 VSS \$2145 \$2146 VSS nfet_03v3 L=0.28U W=0.36U AS=0.1584P AD=0.0972P
+ PS=1.6U PD=0.9U
M$3904 \$2147 \$2145 VSS VSS nfet_03v3 L=0.28U W=0.36U AS=0.0972P AD=0.18P
+ PS=0.9U PD=1.72U
M$3905 \$2148 \$53 VSS VSS nfet_03v3 L=0.28U W=0.36U AS=0.1584P AD=0.1188P
+ PS=1.6U PD=1.02U
M$3906 \$2149 \$2134 \$2148 VSS nfet_03v3 L=0.28U W=0.36U AS=0.1188P AD=0.1278P
+ PS=1.02U PD=1.07U
M$3907 \$2230 \$2150 \$2149 VSS nfet_03v3 L=0.28U W=0.36U AS=0.1278P AD=0.0567P
+ PS=1.07U PD=0.675U
M$3908 VSS \$2135 \$2230 VSS nfet_03v3 L=0.28U W=0.36U AS=0.0567P AD=0.1584P
+ PS=0.675U PD=1.6U
M$3909 VSS \$2149 \$2150 VSS nfet_03v3 L=0.28U W=0.36U AS=0.1584P AD=0.0972P
+ PS=1.6U PD=0.9U
M$3910 \$2151 \$2149 VSS VSS nfet_03v3 L=0.28U W=0.36U AS=0.0972P AD=0.18P
+ PS=0.9U PD=1.72U
M$3911 \$2152 \$56 VSS VSS nfet_03v3 L=0.28U W=0.36U AS=0.1584P AD=0.1188P
+ PS=1.6U PD=1.02U
M$3912 \$2153 \$2134 \$2152 VSS nfet_03v3 L=0.28U W=0.36U AS=0.1188P AD=0.1278P
+ PS=1.02U PD=1.07U
M$3913 \$2237 \$2154 \$2153 VSS nfet_03v3 L=0.28U W=0.36U AS=0.1278P AD=0.0567P
+ PS=1.07U PD=0.675U
M$3914 VSS \$2135 \$2237 VSS nfet_03v3 L=0.28U W=0.36U AS=0.0567P AD=0.1584P
+ PS=0.675U PD=1.6U
M$3915 VSS \$2153 \$2154 VSS nfet_03v3 L=0.28U W=0.36U AS=0.1584P AD=0.0972P
+ PS=1.6U PD=0.9U
M$3916 \$2155 \$2153 VSS VSS nfet_03v3 L=0.28U W=0.36U AS=0.0972P AD=0.18P
+ PS=0.9U PD=1.72U
M$3917 \$2156 \$59 VSS VSS nfet_03v3 L=0.28U W=0.36U AS=0.1584P AD=0.1188P
+ PS=1.6U PD=1.02U
M$3918 \$2157 \$2134 \$2156 VSS nfet_03v3 L=0.28U W=0.36U AS=0.1188P AD=0.1278P
+ PS=1.02U PD=1.07U
M$3919 \$2245 \$2158 \$2157 VSS nfet_03v3 L=0.28U W=0.36U AS=0.1278P AD=0.0567P
+ PS=1.07U PD=0.675U
M$3920 VSS \$2135 \$2245 VSS nfet_03v3 L=0.28U W=0.36U AS=0.0567P AD=0.1584P
+ PS=0.675U PD=1.6U
M$3921 VSS \$2157 \$2158 VSS nfet_03v3 L=0.28U W=0.36U AS=0.1584P AD=0.0972P
+ PS=1.6U PD=0.9U
M$3922 \$2159 \$2157 VSS VSS nfet_03v3 L=0.28U W=0.36U AS=0.0972P AD=0.18P
+ PS=0.9U PD=1.72U
M$3923 \$2160 \$62 VSS VSS nfet_03v3 L=0.28U W=0.36U AS=0.1584P AD=0.1188P
+ PS=1.6U PD=1.02U
M$3924 \$2161 \$2134 \$2160 VSS nfet_03v3 L=0.28U W=0.36U AS=0.1188P AD=0.1278P
+ PS=1.02U PD=1.07U
M$3925 \$2244 \$2162 \$2161 VSS nfet_03v3 L=0.28U W=0.36U AS=0.1278P AD=0.0567P
+ PS=1.07U PD=0.675U
M$3926 VSS \$2135 \$2244 VSS nfet_03v3 L=0.28U W=0.36U AS=0.0567P AD=0.1584P
+ PS=0.675U PD=1.6U
M$3927 VSS \$2161 \$2162 VSS nfet_03v3 L=0.28U W=0.36U AS=0.1584P AD=0.0972P
+ PS=1.6U PD=0.9U
M$3928 \$2163 \$2161 VSS VSS nfet_03v3 L=0.28U W=0.36U AS=0.0972P AD=0.18P
+ PS=0.9U PD=1.72U
M$3929 \$2164 \$65 VSS VSS nfet_03v3 L=0.28U W=0.36U AS=0.1584P AD=0.1188P
+ PS=1.6U PD=1.02U
M$3930 \$2165 \$2134 \$2164 VSS nfet_03v3 L=0.28U W=0.36U AS=0.1188P AD=0.1278P
+ PS=1.02U PD=1.07U
M$3931 \$2241 \$2166 \$2165 VSS nfet_03v3 L=0.28U W=0.36U AS=0.1278P AD=0.0567P
+ PS=1.07U PD=0.675U
M$3932 VSS \$2135 \$2241 VSS nfet_03v3 L=0.28U W=0.36U AS=0.0567P AD=0.1584P
+ PS=0.675U PD=1.6U
M$3933 VSS \$2165 \$2166 VSS nfet_03v3 L=0.28U W=0.36U AS=0.1584P AD=0.0972P
+ PS=1.6U PD=0.9U
M$3934 \$2167 \$2165 VSS VSS nfet_03v3 L=0.28U W=0.36U AS=0.0972P AD=0.18P
+ PS=0.9U PD=1.72U
M$3935 \$2168 \$68 VSS VSS nfet_03v3 L=0.28U W=0.36U AS=0.1584P AD=0.1188P
+ PS=1.6U PD=1.02U
M$3936 \$2169 \$2134 \$2168 VSS nfet_03v3 L=0.28U W=0.36U AS=0.1188P AD=0.1278P
+ PS=1.02U PD=1.07U
M$3937 \$2235 \$2170 \$2169 VSS nfet_03v3 L=0.28U W=0.36U AS=0.1278P AD=0.0567P
+ PS=1.07U PD=0.675U
M$3938 VSS \$2135 \$2235 VSS nfet_03v3 L=0.28U W=0.36U AS=0.0567P AD=0.1584P
+ PS=0.675U PD=1.6U
M$3939 VSS \$2169 \$2170 VSS nfet_03v3 L=0.28U W=0.36U AS=0.1584P AD=0.0972P
+ PS=1.6U PD=0.9U
M$3940 \$2171 \$2169 VSS VSS nfet_03v3 L=0.28U W=0.36U AS=0.0972P AD=0.18P
+ PS=0.9U PD=1.72U
M$3941 \$2172 \$71 VSS VSS nfet_03v3 L=0.28U W=0.36U AS=0.1584P AD=0.1188P
+ PS=1.6U PD=1.02U
M$3942 \$2173 \$2134 \$2172 VSS nfet_03v3 L=0.28U W=0.36U AS=0.1188P AD=0.1278P
+ PS=1.02U PD=1.07U
M$3943 \$2229 \$2174 \$2173 VSS nfet_03v3 L=0.28U W=0.36U AS=0.1278P AD=0.0567P
+ PS=1.07U PD=0.675U
M$3944 VSS \$2135 \$2229 VSS nfet_03v3 L=0.28U W=0.36U AS=0.0567P AD=0.1584P
+ PS=0.675U PD=1.6U
M$3945 VSS \$2173 \$2174 VSS nfet_03v3 L=0.28U W=0.36U AS=0.1584P AD=0.0972P
+ PS=1.6U PD=0.9U
M$3946 \$2175 \$2173 VSS VSS nfet_03v3 L=0.28U W=0.36U AS=0.0972P AD=0.18P
+ PS=0.9U PD=1.72U
M$3947 \$2176 \$74 VSS VSS nfet_03v3 L=0.28U W=0.36U AS=0.1584P AD=0.1188P
+ PS=1.6U PD=1.02U
M$3948 \$2177 \$2134 \$2176 VSS nfet_03v3 L=0.28U W=0.36U AS=0.1188P AD=0.1278P
+ PS=1.02U PD=1.07U
M$3949 \$2226 \$2178 \$2177 VSS nfet_03v3 L=0.28U W=0.36U AS=0.1278P AD=0.0567P
+ PS=1.07U PD=0.675U
M$3950 VSS \$2135 \$2226 VSS nfet_03v3 L=0.28U W=0.36U AS=0.0567P AD=0.1584P
+ PS=0.675U PD=1.6U
M$3951 VSS \$2177 \$2178 VSS nfet_03v3 L=0.28U W=0.36U AS=0.1584P AD=0.0972P
+ PS=1.6U PD=0.9U
M$3952 \$2179 \$2177 VSS VSS nfet_03v3 L=0.28U W=0.36U AS=0.0972P AD=0.18P
+ PS=0.9U PD=1.72U
M$3953 \$2180 \$77 VSS VSS nfet_03v3 L=0.28U W=0.36U AS=0.1584P AD=0.1188P
+ PS=1.6U PD=1.02U
M$3954 \$2181 \$2134 \$2180 VSS nfet_03v3 L=0.28U W=0.36U AS=0.1188P AD=0.1278P
+ PS=1.02U PD=1.07U
M$3955 \$2220 \$2182 \$2181 VSS nfet_03v3 L=0.28U W=0.36U AS=0.1278P AD=0.0567P
+ PS=1.07U PD=0.675U
M$3956 VSS \$2135 \$2220 VSS nfet_03v3 L=0.28U W=0.36U AS=0.0567P AD=0.1584P
+ PS=0.675U PD=1.6U
M$3957 VSS \$2181 \$2182 VSS nfet_03v3 L=0.28U W=0.36U AS=0.1584P AD=0.0972P
+ PS=1.6U PD=0.9U
M$3958 \$2183 \$2181 VSS VSS nfet_03v3 L=0.28U W=0.36U AS=0.0972P AD=0.18P
+ PS=0.9U PD=1.72U
M$3959 \$2184 \$80 VSS VSS nfet_03v3 L=0.28U W=0.36U AS=0.1584P AD=0.1188P
+ PS=1.6U PD=1.02U
M$3960 \$2185 \$2134 \$2184 VSS nfet_03v3 L=0.28U W=0.36U AS=0.1188P AD=0.1278P
+ PS=1.02U PD=1.07U
M$3961 \$2217 \$2186 \$2185 VSS nfet_03v3 L=0.28U W=0.36U AS=0.1278P AD=0.0567P
+ PS=1.07U PD=0.675U
M$3962 VSS \$2135 \$2217 VSS nfet_03v3 L=0.28U W=0.36U AS=0.0567P AD=0.1584P
+ PS=0.675U PD=1.6U
M$3963 VSS \$2185 \$2186 VSS nfet_03v3 L=0.28U W=0.36U AS=0.1584P AD=0.0972P
+ PS=1.6U PD=0.9U
M$3964 \$2187 \$2185 VSS VSS nfet_03v3 L=0.28U W=0.36U AS=0.0972P AD=0.18P
+ PS=0.9U PD=1.72U
M$3965 \$2188 \$83 VSS VSS nfet_03v3 L=0.28U W=0.36U AS=0.1584P AD=0.1188P
+ PS=1.6U PD=1.02U
M$3966 \$2189 \$2134 \$2188 VSS nfet_03v3 L=0.28U W=0.36U AS=0.1188P AD=0.1278P
+ PS=1.02U PD=1.07U
M$3967 \$2211 \$2190 \$2189 VSS nfet_03v3 L=0.28U W=0.36U AS=0.1278P AD=0.0567P
+ PS=1.07U PD=0.675U
M$3968 VSS \$2135 \$2211 VSS nfet_03v3 L=0.28U W=0.36U AS=0.0567P AD=0.1584P
+ PS=0.675U PD=1.6U
M$3969 VSS \$2189 \$2190 VSS nfet_03v3 L=0.28U W=0.36U AS=0.1584P AD=0.0972P
+ PS=1.6U PD=0.9U
M$3970 \$2191 \$2189 VSS VSS nfet_03v3 L=0.28U W=0.36U AS=0.0972P AD=0.18P
+ PS=0.9U PD=1.72U
M$3971 \$2192 \$86 VSS VSS nfet_03v3 L=0.28U W=0.36U AS=0.1584P AD=0.1188P
+ PS=1.6U PD=1.02U
M$3972 \$2193 \$2134 \$2192 VSS nfet_03v3 L=0.28U W=0.36U AS=0.1188P AD=0.1278P
+ PS=1.02U PD=1.07U
M$3973 \$2207 \$2194 \$2193 VSS nfet_03v3 L=0.28U W=0.36U AS=0.1278P AD=0.0567P
+ PS=1.07U PD=0.675U
M$3974 VSS \$2135 \$2207 VSS nfet_03v3 L=0.28U W=0.36U AS=0.0567P AD=0.1584P
+ PS=0.675U PD=1.6U
M$3975 VSS \$2193 \$2194 VSS nfet_03v3 L=0.28U W=0.36U AS=0.1584P AD=0.0972P
+ PS=1.6U PD=0.9U
M$3976 \$2195 \$2193 VSS VSS nfet_03v3 L=0.28U W=0.36U AS=0.0972P AD=0.18P
+ PS=0.9U PD=1.72U
M$3977 \$2196 \$89 VSS VSS nfet_03v3 L=0.28U W=0.36U AS=0.1584P AD=0.1188P
+ PS=1.6U PD=1.02U
M$3978 \$2197 \$2134 \$2196 VSS nfet_03v3 L=0.28U W=0.36U AS=0.1188P AD=0.1278P
+ PS=1.02U PD=1.07U
M$3979 \$2202 \$2198 \$2197 VSS nfet_03v3 L=0.28U W=0.36U AS=0.1278P AD=0.0567P
+ PS=1.07U PD=0.675U
M$3980 VSS \$2135 \$2202 VSS nfet_03v3 L=0.28U W=0.36U AS=0.0567P AD=0.1584P
+ PS=0.675U PD=1.6U
M$3981 VSS \$2197 \$2198 VSS nfet_03v3 L=0.28U W=0.36U AS=0.1584P AD=0.0972P
+ PS=1.6U PD=0.9U
M$3982 \$2199 \$2197 VSS VSS nfet_03v3 L=0.28U W=0.36U AS=0.0972P AD=0.18P
+ PS=0.9U PD=1.72U
M$3983 \$2452 RA8 VSS VSS nfet_03v3 L=0.28U W=0.36U AS=0.1656P AD=0.1944P
+ PS=1.64U PD=1.8U
M$3984 \$2250 RA9 VSS VSS nfet_03v3 L=0.28U W=0.36U AS=0.1656P AD=0.1944P
+ PS=1.64U PD=1.8U
M$3985 \$2451 RA8 \$360 VSS nfet_03v3 L=0.28U W=0.36U AS=0.1584P AD=0.1152P
+ PS=1.6U PD=1U
M$3986 \$361 \$2454 \$2451 VSS nfet_03v3 L=0.28U W=0.36U AS=0.1152P AD=0.1584P
+ PS=1U PD=1.6U
M$3987 \$2139 RA9 \$360 VSS nfet_03v3 L=0.28U W=0.36U AS=0.1584P AD=0.1152P
+ PS=1.6U PD=1U
M$3988 \$361 RB9 \$2139 VSS nfet_03v3 L=0.28U W=0.36U AS=0.1152P AD=0.1584P
+ PS=1U PD=1.6U
M$3989 VSS RB9 \$2251 VSS nfet_03v3 L=0.28U W=0.36U AS=0.1854P AD=0.1584P
+ PS=1.75U PD=1.6U
M$3990 VSS \$2454 \$2453 VSS nfet_03v3 L=0.28U W=0.36U AS=0.1854P AD=0.1584P
+ PS=1.75U PD=1.6U
M$3991 \$2252 RA9 VSS VSS nfet_03v3 L=0.28U W=0.36U AS=0.1656P AD=0.1944P
+ PS=1.64U PD=1.8U
M$3992 \$2459 RA8 VSS VSS nfet_03v3 L=0.28U W=0.36U AS=0.1656P AD=0.1944P
+ PS=1.64U PD=1.8U
M$3993 \$2143 RA9 \$365 VSS nfet_03v3 L=0.28U W=0.36U AS=0.1584P AD=0.1152P
+ PS=1.6U PD=1U
M$3994 \$366 RB9 \$2143 VSS nfet_03v3 L=0.28U W=0.36U AS=0.1152P AD=0.1584P
+ PS=1U PD=1.6U
M$3995 \$2458 RA8 \$365 VSS nfet_03v3 L=0.28U W=0.36U AS=0.1584P AD=0.1152P
+ PS=1.6U PD=1U
M$3996 \$366 \$2454 \$2458 VSS nfet_03v3 L=0.28U W=0.36U AS=0.1152P AD=0.1584P
+ PS=1U PD=1.6U
M$3997 VSS \$2454 \$2460 VSS nfet_03v3 L=0.28U W=0.36U AS=0.1854P AD=0.1584P
+ PS=1.75U PD=1.6U
M$3998 VSS RB9 \$2253 VSS nfet_03v3 L=0.28U W=0.36U AS=0.1854P AD=0.1584P
+ PS=1.75U PD=1.6U
M$3999 \$2465 RA8 VSS VSS nfet_03v3 L=0.28U W=0.36U AS=0.1656P AD=0.1944P
+ PS=1.64U PD=1.8U
M$4000 \$2254 RA9 VSS VSS nfet_03v3 L=0.28U W=0.36U AS=0.1656P AD=0.1944P
+ PS=1.64U PD=1.8U
M$4001 \$2464 RA8 \$370 VSS nfet_03v3 L=0.28U W=0.36U AS=0.1584P AD=0.1152P
+ PS=1.6U PD=1U
M$4002 \$371 \$2454 \$2464 VSS nfet_03v3 L=0.28U W=0.36U AS=0.1152P AD=0.1584P
+ PS=1U PD=1.6U
M$4003 \$2147 RA9 \$370 VSS nfet_03v3 L=0.28U W=0.36U AS=0.1584P AD=0.1152P
+ PS=1.6U PD=1U
M$4004 \$371 RB9 \$2147 VSS nfet_03v3 L=0.28U W=0.36U AS=0.1152P AD=0.1584P
+ PS=1U PD=1.6U
M$4005 VSS RB9 \$2255 VSS nfet_03v3 L=0.28U W=0.36U AS=0.1854P AD=0.1584P
+ PS=1.75U PD=1.6U
M$4006 VSS \$2454 \$2466 VSS nfet_03v3 L=0.28U W=0.36U AS=0.1854P AD=0.1584P
+ PS=1.75U PD=1.6U
M$4007 \$2471 RA8 VSS VSS nfet_03v3 L=0.28U W=0.36U AS=0.1656P AD=0.1944P
+ PS=1.64U PD=1.8U
M$4008 \$2256 RA9 VSS VSS nfet_03v3 L=0.28U W=0.36U AS=0.1656P AD=0.1944P
+ PS=1.64U PD=1.8U
M$4009 \$2470 RA8 \$375 VSS nfet_03v3 L=0.28U W=0.36U AS=0.1584P AD=0.1152P
+ PS=1.6U PD=1U
M$4010 \$376 \$2454 \$2470 VSS nfet_03v3 L=0.28U W=0.36U AS=0.1152P AD=0.1584P
+ PS=1U PD=1.6U
M$4011 \$2151 RA9 \$375 VSS nfet_03v3 L=0.28U W=0.36U AS=0.1584P AD=0.1152P
+ PS=1.6U PD=1U
M$4012 \$376 RB9 \$2151 VSS nfet_03v3 L=0.28U W=0.36U AS=0.1152P AD=0.1584P
+ PS=1U PD=1.6U
M$4013 VSS RB9 \$2257 VSS nfet_03v3 L=0.28U W=0.36U AS=0.1854P AD=0.1584P
+ PS=1.75U PD=1.6U
M$4014 VSS \$2454 \$2472 VSS nfet_03v3 L=0.28U W=0.36U AS=0.1854P AD=0.1584P
+ PS=1.75U PD=1.6U
M$4015 \$2477 RA8 VSS VSS nfet_03v3 L=0.28U W=0.36U AS=0.1656P AD=0.1944P
+ PS=1.64U PD=1.8U
M$4016 \$2258 RA9 VSS VSS nfet_03v3 L=0.28U W=0.36U AS=0.1656P AD=0.1944P
+ PS=1.64U PD=1.8U
M$4017 \$2476 RA8 \$380 VSS nfet_03v3 L=0.28U W=0.36U AS=0.1584P AD=0.1152P
+ PS=1.6U PD=1U
M$4018 \$381 \$2454 \$2476 VSS nfet_03v3 L=0.28U W=0.36U AS=0.1152P AD=0.1584P
+ PS=1U PD=1.6U
M$4019 \$2155 RA9 \$380 VSS nfet_03v3 L=0.28U W=0.36U AS=0.1584P AD=0.1152P
+ PS=1.6U PD=1U
M$4020 \$381 RB9 \$2155 VSS nfet_03v3 L=0.28U W=0.36U AS=0.1152P AD=0.1584P
+ PS=1U PD=1.6U
M$4021 VSS \$2454 \$2478 VSS nfet_03v3 L=0.28U W=0.36U AS=0.1854P AD=0.1584P
+ PS=1.75U PD=1.6U
M$4022 VSS RB9 \$2259 VSS nfet_03v3 L=0.28U W=0.36U AS=0.1854P AD=0.1584P
+ PS=1.75U PD=1.6U
M$4023 \$2260 RA9 VSS VSS nfet_03v3 L=0.28U W=0.36U AS=0.1656P AD=0.1944P
+ PS=1.64U PD=1.8U
M$4024 \$2483 RA8 VSS VSS nfet_03v3 L=0.28U W=0.36U AS=0.1656P AD=0.1944P
+ PS=1.64U PD=1.8U
M$4025 \$2159 RA9 \$385 VSS nfet_03v3 L=0.28U W=0.36U AS=0.1584P AD=0.1152P
+ PS=1.6U PD=1U
M$4026 \$386 RB9 \$2159 VSS nfet_03v3 L=0.28U W=0.36U AS=0.1152P AD=0.1584P
+ PS=1U PD=1.6U
M$4027 \$2482 RA8 \$385 VSS nfet_03v3 L=0.28U W=0.36U AS=0.1584P AD=0.1152P
+ PS=1.6U PD=1U
M$4028 \$386 \$2454 \$2482 VSS nfet_03v3 L=0.28U W=0.36U AS=0.1152P AD=0.1584P
+ PS=1U PD=1.6U
M$4029 VSS RB9 \$2261 VSS nfet_03v3 L=0.28U W=0.36U AS=0.1854P AD=0.1584P
+ PS=1.75U PD=1.6U
M$4030 VSS \$2454 \$2484 VSS nfet_03v3 L=0.28U W=0.36U AS=0.1854P AD=0.1584P
+ PS=1.75U PD=1.6U
M$4031 \$2262 RA9 VSS VSS nfet_03v3 L=0.28U W=0.36U AS=0.1656P AD=0.1944P
+ PS=1.64U PD=1.8U
M$4032 \$2489 RA8 VSS VSS nfet_03v3 L=0.28U W=0.36U AS=0.1656P AD=0.1944P
+ PS=1.64U PD=1.8U
M$4033 \$2163 RA9 \$390 VSS nfet_03v3 L=0.28U W=0.36U AS=0.1584P AD=0.1152P
+ PS=1.6U PD=1U
M$4034 \$391 RB9 \$2163 VSS nfet_03v3 L=0.28U W=0.36U AS=0.1152P AD=0.1584P
+ PS=1U PD=1.6U
M$4035 \$2488 RA8 \$390 VSS nfet_03v3 L=0.28U W=0.36U AS=0.1584P AD=0.1152P
+ PS=1.6U PD=1U
M$4036 \$391 \$2454 \$2488 VSS nfet_03v3 L=0.28U W=0.36U AS=0.1152P AD=0.1584P
+ PS=1U PD=1.6U
M$4037 VSS RB9 \$2263 VSS nfet_03v3 L=0.28U W=0.36U AS=0.1854P AD=0.1584P
+ PS=1.75U PD=1.6U
M$4038 VSS \$2454 \$2490 VSS nfet_03v3 L=0.28U W=0.36U AS=0.1854P AD=0.1584P
+ PS=1.75U PD=1.6U
M$4039 \$2264 RA9 VSS VSS nfet_03v3 L=0.28U W=0.36U AS=0.1656P AD=0.1944P
+ PS=1.64U PD=1.8U
M$4040 \$2495 RA8 VSS VSS nfet_03v3 L=0.28U W=0.36U AS=0.1656P AD=0.1944P
+ PS=1.64U PD=1.8U
M$4041 \$2167 RA9 \$395 VSS nfet_03v3 L=0.28U W=0.36U AS=0.1584P AD=0.1152P
+ PS=1.6U PD=1U
M$4042 \$396 RB9 \$2167 VSS nfet_03v3 L=0.28U W=0.36U AS=0.1152P AD=0.1584P
+ PS=1U PD=1.6U
M$4043 \$2494 RA8 \$395 VSS nfet_03v3 L=0.28U W=0.36U AS=0.1584P AD=0.1152P
+ PS=1.6U PD=1U
M$4044 \$396 \$2454 \$2494 VSS nfet_03v3 L=0.28U W=0.36U AS=0.1152P AD=0.1584P
+ PS=1U PD=1.6U
M$4045 VSS \$2454 \$2496 VSS nfet_03v3 L=0.28U W=0.36U AS=0.1854P AD=0.1584P
+ PS=1.75U PD=1.6U
M$4046 VSS RB9 \$2265 VSS nfet_03v3 L=0.28U W=0.36U AS=0.1854P AD=0.1584P
+ PS=1.75U PD=1.6U
M$4047 \$2501 RA8 VSS VSS nfet_03v3 L=0.28U W=0.36U AS=0.1656P AD=0.1944P
+ PS=1.64U PD=1.8U
M$4048 \$2266 RA9 VSS VSS nfet_03v3 L=0.28U W=0.36U AS=0.1656P AD=0.1944P
+ PS=1.64U PD=1.8U
M$4049 \$2500 RA8 \$400 VSS nfet_03v3 L=0.28U W=0.36U AS=0.1584P AD=0.1152P
+ PS=1.6U PD=1U
M$4050 \$401 \$2454 \$2500 VSS nfet_03v3 L=0.28U W=0.36U AS=0.1152P AD=0.1584P
+ PS=1U PD=1.6U
M$4051 \$2171 RA9 \$400 VSS nfet_03v3 L=0.28U W=0.36U AS=0.1584P AD=0.1152P
+ PS=1.6U PD=1U
M$4052 \$401 RB9 \$2171 VSS nfet_03v3 L=0.28U W=0.36U AS=0.1152P AD=0.1584P
+ PS=1U PD=1.6U
M$4053 VSS \$2454 \$2502 VSS nfet_03v3 L=0.28U W=0.36U AS=0.1854P AD=0.1584P
+ PS=1.75U PD=1.6U
M$4054 VSS RB9 \$2267 VSS nfet_03v3 L=0.28U W=0.36U AS=0.1854P AD=0.1584P
+ PS=1.75U PD=1.6U
M$4055 \$2268 RA9 VSS VSS nfet_03v3 L=0.28U W=0.36U AS=0.1656P AD=0.1944P
+ PS=1.64U PD=1.8U
M$4056 \$2507 RA8 VSS VSS nfet_03v3 L=0.28U W=0.36U AS=0.1656P AD=0.1944P
+ PS=1.64U PD=1.8U
M$4057 \$2506 RA8 \$405 VSS nfet_03v3 L=0.28U W=0.36U AS=0.1584P AD=0.1152P
+ PS=1.6U PD=1U
M$4058 \$406 \$2454 \$2506 VSS nfet_03v3 L=0.28U W=0.36U AS=0.1152P AD=0.1584P
+ PS=1U PD=1.6U
M$4059 \$2175 RA9 \$405 VSS nfet_03v3 L=0.28U W=0.36U AS=0.1584P AD=0.1152P
+ PS=1.6U PD=1U
M$4060 \$406 RB9 \$2175 VSS nfet_03v3 L=0.28U W=0.36U AS=0.1152P AD=0.1584P
+ PS=1U PD=1.6U
M$4061 VSS RB9 \$2269 VSS nfet_03v3 L=0.28U W=0.36U AS=0.1854P AD=0.1584P
+ PS=1.75U PD=1.6U
M$4062 VSS \$2454 \$2508 VSS nfet_03v3 L=0.28U W=0.36U AS=0.1854P AD=0.1584P
+ PS=1.75U PD=1.6U
M$4063 \$2513 RA8 VSS VSS nfet_03v3 L=0.28U W=0.36U AS=0.1656P AD=0.1944P
+ PS=1.64U PD=1.8U
M$4064 \$2270 RA9 VSS VSS nfet_03v3 L=0.28U W=0.36U AS=0.1656P AD=0.1944P
+ PS=1.64U PD=1.8U
M$4065 \$2179 RA9 \$410 VSS nfet_03v3 L=0.28U W=0.36U AS=0.1584P AD=0.1152P
+ PS=1.6U PD=1U
M$4066 \$411 RB9 \$2179 VSS nfet_03v3 L=0.28U W=0.36U AS=0.1152P AD=0.1584P
+ PS=1U PD=1.6U
M$4067 \$2512 RA8 \$410 VSS nfet_03v3 L=0.28U W=0.36U AS=0.1584P AD=0.1152P
+ PS=1.6U PD=1U
M$4068 \$411 \$2454 \$2512 VSS nfet_03v3 L=0.28U W=0.36U AS=0.1152P AD=0.1584P
+ PS=1U PD=1.6U
M$4069 VSS RB9 \$2271 VSS nfet_03v3 L=0.28U W=0.36U AS=0.1854P AD=0.1584P
+ PS=1.75U PD=1.6U
M$4070 VSS \$2454 \$2514 VSS nfet_03v3 L=0.28U W=0.36U AS=0.1854P AD=0.1584P
+ PS=1.75U PD=1.6U
M$4071 \$2272 RA9 VSS VSS nfet_03v3 L=0.28U W=0.36U AS=0.1656P AD=0.1944P
+ PS=1.64U PD=1.8U
M$4072 \$2519 RA8 VSS VSS nfet_03v3 L=0.28U W=0.36U AS=0.1656P AD=0.1944P
+ PS=1.64U PD=1.8U
M$4073 \$2183 RA9 \$415 VSS nfet_03v3 L=0.28U W=0.36U AS=0.1584P AD=0.1152P
+ PS=1.6U PD=1U
M$4074 \$416 RB9 \$2183 VSS nfet_03v3 L=0.28U W=0.36U AS=0.1152P AD=0.1584P
+ PS=1U PD=1.6U
M$4075 \$2518 RA8 \$415 VSS nfet_03v3 L=0.28U W=0.36U AS=0.1584P AD=0.1152P
+ PS=1.6U PD=1U
M$4076 \$416 \$2454 \$2518 VSS nfet_03v3 L=0.28U W=0.36U AS=0.1152P AD=0.1584P
+ PS=1U PD=1.6U
M$4077 VSS \$2454 \$2520 VSS nfet_03v3 L=0.28U W=0.36U AS=0.1854P AD=0.1584P
+ PS=1.75U PD=1.6U
M$4078 VSS RB9 \$2273 VSS nfet_03v3 L=0.28U W=0.36U AS=0.1854P AD=0.1584P
+ PS=1.75U PD=1.6U
M$4079 \$2525 RA8 VSS VSS nfet_03v3 L=0.28U W=0.36U AS=0.1656P AD=0.1944P
+ PS=1.64U PD=1.8U
M$4080 \$2274 RA9 VSS VSS nfet_03v3 L=0.28U W=0.36U AS=0.1656P AD=0.1944P
+ PS=1.64U PD=1.8U
M$4081 \$2187 RA9 \$420 VSS nfet_03v3 L=0.28U W=0.36U AS=0.1584P AD=0.1152P
+ PS=1.6U PD=1U
M$4082 \$421 RB9 \$2187 VSS nfet_03v3 L=0.28U W=0.36U AS=0.1152P AD=0.1584P
+ PS=1U PD=1.6U
M$4083 \$2524 RA8 \$420 VSS nfet_03v3 L=0.28U W=0.36U AS=0.1584P AD=0.1152P
+ PS=1.6U PD=1U
M$4084 \$421 \$2454 \$2524 VSS nfet_03v3 L=0.28U W=0.36U AS=0.1152P AD=0.1584P
+ PS=1U PD=1.6U
M$4085 VSS \$2454 \$2526 VSS nfet_03v3 L=0.28U W=0.36U AS=0.1854P AD=0.1584P
+ PS=1.75U PD=1.6U
M$4086 VSS RB9 \$2275 VSS nfet_03v3 L=0.28U W=0.36U AS=0.1854P AD=0.1584P
+ PS=1.75U PD=1.6U
M$4087 \$2531 RA8 VSS VSS nfet_03v3 L=0.28U W=0.36U AS=0.1656P AD=0.1944P
+ PS=1.64U PD=1.8U
M$4088 \$2276 RA9 VSS VSS nfet_03v3 L=0.28U W=0.36U AS=0.1656P AD=0.1944P
+ PS=1.64U PD=1.8U
M$4089 \$2530 RA8 \$425 VSS nfet_03v3 L=0.28U W=0.36U AS=0.1584P AD=0.1152P
+ PS=1.6U PD=1U
M$4090 \$426 \$2454 \$2530 VSS nfet_03v3 L=0.28U W=0.36U AS=0.1152P AD=0.1584P
+ PS=1U PD=1.6U
M$4091 \$2191 RA9 \$425 VSS nfet_03v3 L=0.28U W=0.36U AS=0.1584P AD=0.1152P
+ PS=1.6U PD=1U
M$4092 \$426 RB9 \$2191 VSS nfet_03v3 L=0.28U W=0.36U AS=0.1152P AD=0.1584P
+ PS=1U PD=1.6U
M$4093 VSS RB9 \$2277 VSS nfet_03v3 L=0.28U W=0.36U AS=0.1854P AD=0.1584P
+ PS=1.75U PD=1.6U
M$4094 VSS \$2454 \$2532 VSS nfet_03v3 L=0.28U W=0.36U AS=0.1854P AD=0.1584P
+ PS=1.75U PD=1.6U
M$4095 \$2278 RA9 VSS VSS nfet_03v3 L=0.28U W=0.36U AS=0.1656P AD=0.1944P
+ PS=1.64U PD=1.8U
M$4096 \$2537 RA8 VSS VSS nfet_03v3 L=0.28U W=0.36U AS=0.1656P AD=0.1944P
+ PS=1.64U PD=1.8U
M$4097 \$2195 RA9 \$430 VSS nfet_03v3 L=0.28U W=0.36U AS=0.1584P AD=0.1152P
+ PS=1.6U PD=1U
M$4098 \$431 RB9 \$2195 VSS nfet_03v3 L=0.28U W=0.36U AS=0.1152P AD=0.1584P
+ PS=1U PD=1.6U
M$4099 \$2536 RA8 \$430 VSS nfet_03v3 L=0.28U W=0.36U AS=0.1584P AD=0.1152P
+ PS=1.6U PD=1U
M$4100 \$431 \$2454 \$2536 VSS nfet_03v3 L=0.28U W=0.36U AS=0.1152P AD=0.1584P
+ PS=1U PD=1.6U
M$4101 VSS RB9 \$2279 VSS nfet_03v3 L=0.28U W=0.36U AS=0.1854P AD=0.1584P
+ PS=1.75U PD=1.6U
M$4102 VSS \$2454 \$2538 VSS nfet_03v3 L=0.28U W=0.36U AS=0.1854P AD=0.1584P
+ PS=1.75U PD=1.6U
M$4103 \$2543 RA8 VSS VSS nfet_03v3 L=0.28U W=0.36U AS=0.1656P AD=0.1944P
+ PS=1.64U PD=1.8U
M$4104 \$2280 RA9 VSS VSS nfet_03v3 L=0.28U W=0.36U AS=0.1656P AD=0.1944P
+ PS=1.64U PD=1.8U
M$4105 \$2199 RA9 \$435 VSS nfet_03v3 L=0.28U W=0.36U AS=0.1584P AD=0.1152P
+ PS=1.6U PD=1U
M$4106 \$436 RB9 \$2199 VSS nfet_03v3 L=0.28U W=0.36U AS=0.1152P AD=0.1584P
+ PS=1U PD=1.6U
M$4107 \$2542 RA8 \$435 VSS nfet_03v3 L=0.28U W=0.36U AS=0.1584P AD=0.1152P
+ PS=1.6U PD=1U
M$4108 \$436 \$2454 \$2542 VSS nfet_03v3 L=0.28U W=0.36U AS=0.1152P AD=0.1584P
+ PS=1U PD=1.6U
M$4109 VSS RB9 \$2281 VSS nfet_03v3 L=0.28U W=0.36U AS=0.1854P AD=0.1584P
+ PS=1.75U PD=1.6U
M$4110 VSS \$2454 \$2544 VSS nfet_03v3 L=0.28U W=0.36U AS=0.1854P AD=0.1584P
+ PS=1.75U PD=1.6U
M$4111 \$2648 WE8 VSS VSS nfet_03v3 L=0.28U W=0.72U AS=0.3168P AD=0.1872P
+ PS=2.32U PD=1.24U
M$4112 \$2443 CLK \$2648 VSS nfet_03v3 L=0.28U W=0.72U AS=0.1872P AD=0.3168P
+ PS=1.24U PD=2.32U
M$4113 \$2445 \$2443 VSS VSS nfet_03v3 L=0.28U W=1.27U AS=0.4487P AD=0.3302P
+ PS=3.34U PD=2.31U
M$4115 RB8 \$2445 VSS VSS nfet_03v3 L=0.28U W=1.34U AS=0.3636P AD=0.4891P
+ PS=2.44U PD=3.47U
M$4117 \$2448 \$44 VSS VSS nfet_03v3 L=0.28U W=0.36U AS=0.1584P AD=0.1188P
+ PS=1.6U PD=1.02U
M$4118 \$2449 \$2445 \$2448 VSS nfet_03v3 L=0.28U W=0.36U AS=0.1188P AD=0.1278P
+ PS=1.02U PD=1.07U
M$4119 \$2653 \$2450 \$2449 VSS nfet_03v3 L=0.28U W=0.36U AS=0.1278P AD=0.0567P
+ PS=1.07U PD=0.675U
M$4120 VSS RB8 \$2653 VSS nfet_03v3 L=0.28U W=0.36U AS=0.0567P AD=0.1584P
+ PS=0.675U PD=1.6U
M$4121 VSS \$2449 \$2450 VSS nfet_03v3 L=0.28U W=0.36U AS=0.1584P AD=0.0972P
+ PS=1.6U PD=0.9U
M$4122 \$2451 \$2449 VSS VSS nfet_03v3 L=0.28U W=0.36U AS=0.0972P AD=0.18P
+ PS=0.9U PD=1.72U
M$4123 \$2455 \$47 VSS VSS nfet_03v3 L=0.28U W=0.36U AS=0.1584P AD=0.1188P
+ PS=1.6U PD=1.02U
M$4124 \$2456 \$2445 \$2455 VSS nfet_03v3 L=0.28U W=0.36U AS=0.1188P AD=0.1278P
+ PS=1.02U PD=1.07U
M$4125 \$2662 \$2457 \$2456 VSS nfet_03v3 L=0.28U W=0.36U AS=0.1278P AD=0.0567P
+ PS=1.07U PD=0.675U
M$4126 VSS RB8 \$2662 VSS nfet_03v3 L=0.28U W=0.36U AS=0.0567P AD=0.1584P
+ PS=0.675U PD=1.6U
M$4127 VSS \$2456 \$2457 VSS nfet_03v3 L=0.28U W=0.36U AS=0.1584P AD=0.0972P
+ PS=1.6U PD=0.9U
M$4128 \$2458 \$2456 VSS VSS nfet_03v3 L=0.28U W=0.36U AS=0.0972P AD=0.18P
+ PS=0.9U PD=1.72U
M$4129 \$2461 \$50 VSS VSS nfet_03v3 L=0.28U W=0.36U AS=0.1584P AD=0.1188P
+ PS=1.6U PD=1.02U
M$4130 \$2462 \$2445 \$2461 VSS nfet_03v3 L=0.28U W=0.36U AS=0.1188P AD=0.1278P
+ PS=1.02U PD=1.07U
M$4131 \$2669 \$2463 \$2462 VSS nfet_03v3 L=0.28U W=0.36U AS=0.1278P AD=0.0567P
+ PS=1.07U PD=0.675U
M$4132 VSS RB8 \$2669 VSS nfet_03v3 L=0.28U W=0.36U AS=0.0567P AD=0.1584P
+ PS=0.675U PD=1.6U
M$4133 VSS \$2462 \$2463 VSS nfet_03v3 L=0.28U W=0.36U AS=0.1584P AD=0.0972P
+ PS=1.6U PD=0.9U
M$4134 \$2464 \$2462 VSS VSS nfet_03v3 L=0.28U W=0.36U AS=0.0972P AD=0.18P
+ PS=0.9U PD=1.72U
M$4135 \$2467 \$53 VSS VSS nfet_03v3 L=0.28U W=0.36U AS=0.1584P AD=0.1188P
+ PS=1.6U PD=1.02U
M$4136 \$2468 \$2445 \$2467 VSS nfet_03v3 L=0.28U W=0.36U AS=0.1188P AD=0.1278P
+ PS=1.02U PD=1.07U
M$4137 \$2677 \$2469 \$2468 VSS nfet_03v3 L=0.28U W=0.36U AS=0.1278P AD=0.0567P
+ PS=1.07U PD=0.675U
M$4138 VSS RB8 \$2677 VSS nfet_03v3 L=0.28U W=0.36U AS=0.0567P AD=0.1584P
+ PS=0.675U PD=1.6U
M$4139 VSS \$2468 \$2469 VSS nfet_03v3 L=0.28U W=0.36U AS=0.1584P AD=0.0972P
+ PS=1.6U PD=0.9U
M$4140 \$2470 \$2468 VSS VSS nfet_03v3 L=0.28U W=0.36U AS=0.0972P AD=0.18P
+ PS=0.9U PD=1.72U
M$4141 \$2473 \$56 VSS VSS nfet_03v3 L=0.28U W=0.36U AS=0.1584P AD=0.1188P
+ PS=1.6U PD=1.02U
M$4142 \$2474 \$2445 \$2473 VSS nfet_03v3 L=0.28U W=0.36U AS=0.1188P AD=0.1278P
+ PS=1.02U PD=1.07U
M$4143 \$2686 \$2475 \$2474 VSS nfet_03v3 L=0.28U W=0.36U AS=0.1278P AD=0.0567P
+ PS=1.07U PD=0.675U
M$4144 VSS RB8 \$2686 VSS nfet_03v3 L=0.28U W=0.36U AS=0.0567P AD=0.1584P
+ PS=0.675U PD=1.6U
M$4145 VSS \$2474 \$2475 VSS nfet_03v3 L=0.28U W=0.36U AS=0.1584P AD=0.0972P
+ PS=1.6U PD=0.9U
M$4146 \$2476 \$2474 VSS VSS nfet_03v3 L=0.28U W=0.36U AS=0.0972P AD=0.18P
+ PS=0.9U PD=1.72U
M$4147 \$2479 \$59 VSS VSS nfet_03v3 L=0.28U W=0.36U AS=0.1584P AD=0.1188P
+ PS=1.6U PD=1.02U
M$4148 \$2480 \$2445 \$2479 VSS nfet_03v3 L=0.28U W=0.36U AS=0.1188P AD=0.1278P
+ PS=1.02U PD=1.07U
M$4149 \$2693 \$2481 \$2480 VSS nfet_03v3 L=0.28U W=0.36U AS=0.1278P AD=0.0567P
+ PS=1.07U PD=0.675U
M$4150 VSS RB8 \$2693 VSS nfet_03v3 L=0.28U W=0.36U AS=0.0567P AD=0.1584P
+ PS=0.675U PD=1.6U
M$4151 VSS \$2480 \$2481 VSS nfet_03v3 L=0.28U W=0.36U AS=0.1584P AD=0.0972P
+ PS=1.6U PD=0.9U
M$4152 \$2482 \$2480 VSS VSS nfet_03v3 L=0.28U W=0.36U AS=0.0972P AD=0.18P
+ PS=0.9U PD=1.72U
M$4153 \$2485 \$62 VSS VSS nfet_03v3 L=0.28U W=0.36U AS=0.1584P AD=0.1188P
+ PS=1.6U PD=1.02U
M$4154 \$2486 \$2445 \$2485 VSS nfet_03v3 L=0.28U W=0.36U AS=0.1188P AD=0.1278P
+ PS=1.02U PD=1.07U
M$4155 \$2701 \$2487 \$2486 VSS nfet_03v3 L=0.28U W=0.36U AS=0.1278P AD=0.0567P
+ PS=1.07U PD=0.675U
M$4156 VSS RB8 \$2701 VSS nfet_03v3 L=0.28U W=0.36U AS=0.0567P AD=0.1584P
+ PS=0.675U PD=1.6U
M$4157 VSS \$2486 \$2487 VSS nfet_03v3 L=0.28U W=0.36U AS=0.1584P AD=0.0972P
+ PS=1.6U PD=0.9U
M$4158 \$2488 \$2486 VSS VSS nfet_03v3 L=0.28U W=0.36U AS=0.0972P AD=0.18P
+ PS=0.9U PD=1.72U
M$4159 \$2491 \$65 VSS VSS nfet_03v3 L=0.28U W=0.36U AS=0.1584P AD=0.1188P
+ PS=1.6U PD=1.02U
M$4160 \$2492 \$2445 \$2491 VSS nfet_03v3 L=0.28U W=0.36U AS=0.1188P AD=0.1278P
+ PS=1.02U PD=1.07U
M$4161 \$2710 \$2493 \$2492 VSS nfet_03v3 L=0.28U W=0.36U AS=0.1278P AD=0.0567P
+ PS=1.07U PD=0.675U
M$4162 VSS RB8 \$2710 VSS nfet_03v3 L=0.28U W=0.36U AS=0.0567P AD=0.1584P
+ PS=0.675U PD=1.6U
M$4163 VSS \$2492 \$2493 VSS nfet_03v3 L=0.28U W=0.36U AS=0.1584P AD=0.0972P
+ PS=1.6U PD=0.9U
M$4164 \$2494 \$2492 VSS VSS nfet_03v3 L=0.28U W=0.36U AS=0.0972P AD=0.18P
+ PS=0.9U PD=1.72U
M$4165 \$2497 \$68 VSS VSS nfet_03v3 L=0.28U W=0.36U AS=0.1584P AD=0.1188P
+ PS=1.6U PD=1.02U
M$4166 \$2498 \$2445 \$2497 VSS nfet_03v3 L=0.28U W=0.36U AS=0.1188P AD=0.1278P
+ PS=1.02U PD=1.07U
M$4167 \$2717 \$2499 \$2498 VSS nfet_03v3 L=0.28U W=0.36U AS=0.1278P AD=0.0567P
+ PS=1.07U PD=0.675U
M$4168 VSS RB8 \$2717 VSS nfet_03v3 L=0.28U W=0.36U AS=0.0567P AD=0.1584P
+ PS=0.675U PD=1.6U
M$4169 VSS \$2498 \$2499 VSS nfet_03v3 L=0.28U W=0.36U AS=0.1584P AD=0.0972P
+ PS=1.6U PD=0.9U
M$4170 \$2500 \$2498 VSS VSS nfet_03v3 L=0.28U W=0.36U AS=0.0972P AD=0.18P
+ PS=0.9U PD=1.72U
M$4171 \$2503 \$71 VSS VSS nfet_03v3 L=0.28U W=0.36U AS=0.1584P AD=0.1188P
+ PS=1.6U PD=1.02U
M$4172 \$2504 \$2445 \$2503 VSS nfet_03v3 L=0.28U W=0.36U AS=0.1188P AD=0.1278P
+ PS=1.02U PD=1.07U
M$4173 \$2725 \$2505 \$2504 VSS nfet_03v3 L=0.28U W=0.36U AS=0.1278P AD=0.0567P
+ PS=1.07U PD=0.675U
M$4174 VSS RB8 \$2725 VSS nfet_03v3 L=0.28U W=0.36U AS=0.0567P AD=0.1584P
+ PS=0.675U PD=1.6U
M$4175 VSS \$2504 \$2505 VSS nfet_03v3 L=0.28U W=0.36U AS=0.1584P AD=0.0972P
+ PS=1.6U PD=0.9U
M$4176 \$2506 \$2504 VSS VSS nfet_03v3 L=0.28U W=0.36U AS=0.0972P AD=0.18P
+ PS=0.9U PD=1.72U
M$4177 \$2509 \$74 VSS VSS nfet_03v3 L=0.28U W=0.36U AS=0.1584P AD=0.1188P
+ PS=1.6U PD=1.02U
M$4178 \$2510 \$2445 \$2509 VSS nfet_03v3 L=0.28U W=0.36U AS=0.1188P AD=0.1278P
+ PS=1.02U PD=1.07U
M$4179 \$2734 \$2511 \$2510 VSS nfet_03v3 L=0.28U W=0.36U AS=0.1278P AD=0.0567P
+ PS=1.07U PD=0.675U
M$4180 VSS RB8 \$2734 VSS nfet_03v3 L=0.28U W=0.36U AS=0.0567P AD=0.1584P
+ PS=0.675U PD=1.6U
M$4181 VSS \$2510 \$2511 VSS nfet_03v3 L=0.28U W=0.36U AS=0.1584P AD=0.0972P
+ PS=1.6U PD=0.9U
M$4182 \$2512 \$2510 VSS VSS nfet_03v3 L=0.28U W=0.36U AS=0.0972P AD=0.18P
+ PS=0.9U PD=1.72U
M$4183 \$2515 \$77 VSS VSS nfet_03v3 L=0.28U W=0.36U AS=0.1584P AD=0.1188P
+ PS=1.6U PD=1.02U
M$4184 \$2516 \$2445 \$2515 VSS nfet_03v3 L=0.28U W=0.36U AS=0.1188P AD=0.1278P
+ PS=1.02U PD=1.07U
M$4185 \$2740 \$2517 \$2516 VSS nfet_03v3 L=0.28U W=0.36U AS=0.1278P AD=0.0567P
+ PS=1.07U PD=0.675U
M$4186 VSS RB8 \$2740 VSS nfet_03v3 L=0.28U W=0.36U AS=0.0567P AD=0.1584P
+ PS=0.675U PD=1.6U
M$4187 VSS \$2516 \$2517 VSS nfet_03v3 L=0.28U W=0.36U AS=0.1584P AD=0.0972P
+ PS=1.6U PD=0.9U
M$4188 \$2518 \$2516 VSS VSS nfet_03v3 L=0.28U W=0.36U AS=0.0972P AD=0.18P
+ PS=0.9U PD=1.72U
M$4189 \$2521 \$80 VSS VSS nfet_03v3 L=0.28U W=0.36U AS=0.1584P AD=0.1188P
+ PS=1.6U PD=1.02U
M$4190 \$2522 \$2445 \$2521 VSS nfet_03v3 L=0.28U W=0.36U AS=0.1188P AD=0.1278P
+ PS=1.02U PD=1.07U
M$4191 \$2733 \$2523 \$2522 VSS nfet_03v3 L=0.28U W=0.36U AS=0.1278P AD=0.0567P
+ PS=1.07U PD=0.675U
M$4192 VSS RB8 \$2733 VSS nfet_03v3 L=0.28U W=0.36U AS=0.0567P AD=0.1584P
+ PS=0.675U PD=1.6U
M$4193 VSS \$2522 \$2523 VSS nfet_03v3 L=0.28U W=0.36U AS=0.1584P AD=0.0972P
+ PS=1.6U PD=0.9U
M$4194 \$2524 \$2522 VSS VSS nfet_03v3 L=0.28U W=0.36U AS=0.0972P AD=0.18P
+ PS=0.9U PD=1.72U
M$4195 \$2527 \$83 VSS VSS nfet_03v3 L=0.28U W=0.36U AS=0.1584P AD=0.1188P
+ PS=1.6U PD=1.02U
M$4196 \$2528 \$2445 \$2527 VSS nfet_03v3 L=0.28U W=0.36U AS=0.1188P AD=0.1278P
+ PS=1.02U PD=1.07U
M$4197 \$2709 \$2529 \$2528 VSS nfet_03v3 L=0.28U W=0.36U AS=0.1278P AD=0.0567P
+ PS=1.07U PD=0.675U
M$4198 VSS RB8 \$2709 VSS nfet_03v3 L=0.28U W=0.36U AS=0.0567P AD=0.1584P
+ PS=0.675U PD=1.6U
M$4199 VSS \$2528 \$2529 VSS nfet_03v3 L=0.28U W=0.36U AS=0.1584P AD=0.0972P
+ PS=1.6U PD=0.9U
M$4200 \$2530 \$2528 VSS VSS nfet_03v3 L=0.28U W=0.36U AS=0.0972P AD=0.18P
+ PS=0.9U PD=1.72U
M$4201 \$2533 \$86 VSS VSS nfet_03v3 L=0.28U W=0.36U AS=0.1584P AD=0.1188P
+ PS=1.6U PD=1.02U
M$4202 \$2534 \$2445 \$2533 VSS nfet_03v3 L=0.28U W=0.36U AS=0.1188P AD=0.1278P
+ PS=1.02U PD=1.07U
M$4203 \$2685 \$2535 \$2534 VSS nfet_03v3 L=0.28U W=0.36U AS=0.1278P AD=0.0567P
+ PS=1.07U PD=0.675U
M$4204 VSS RB8 \$2685 VSS nfet_03v3 L=0.28U W=0.36U AS=0.0567P AD=0.1584P
+ PS=0.675U PD=1.6U
M$4205 VSS \$2534 \$2535 VSS nfet_03v3 L=0.28U W=0.36U AS=0.1584P AD=0.0972P
+ PS=1.6U PD=0.9U
M$4206 \$2536 \$2534 VSS VSS nfet_03v3 L=0.28U W=0.36U AS=0.0972P AD=0.18P
+ PS=0.9U PD=1.72U
M$4207 \$2539 \$89 VSS VSS nfet_03v3 L=0.28U W=0.36U AS=0.1584P AD=0.1188P
+ PS=1.6U PD=1.02U
M$4208 \$2540 \$2445 \$2539 VSS nfet_03v3 L=0.28U W=0.36U AS=0.1188P AD=0.1278P
+ PS=1.02U PD=1.07U
M$4209 \$2661 \$2541 \$2540 VSS nfet_03v3 L=0.28U W=0.36U AS=0.1278P AD=0.0567P
+ PS=1.07U PD=0.675U
M$4210 VSS RB8 \$2661 VSS nfet_03v3 L=0.28U W=0.36U AS=0.0567P AD=0.1584P
+ PS=0.675U PD=1.6U
M$4211 VSS \$2540 \$2541 VSS nfet_03v3 L=0.28U W=0.36U AS=0.1584P AD=0.0972P
+ PS=1.6U PD=0.9U
M$4212 \$2542 \$2540 VSS VSS nfet_03v3 L=0.28U W=0.36U AS=0.0972P AD=0.18P
+ PS=0.9U PD=1.72U
M$4213 \$2901 WE7 VSS VSS nfet_03v3 L=0.28U W=0.72U AS=0.3168P AD=0.1872P
+ PS=2.32U PD=1.24U
M$4214 \$2746 CLK \$2901 VSS nfet_03v3 L=0.28U W=0.72U AS=0.1872P AD=0.3168P
+ PS=1.24U PD=2.32U
M$4215 \$2747 \$2746 VSS VSS nfet_03v3 L=0.28U W=1.27U AS=0.4445P AD=0.3344P
+ PS=3.305U PD=2.345U
M$4217 \$2748 \$2747 VSS VSS nfet_03v3 L=0.28U W=1.34U AS=0.3636P AD=0.4891P
+ PS=2.44U PD=3.47U
M$4219 \$2749 \$44 VSS VSS nfet_03v3 L=0.28U W=0.36U AS=0.1584P AD=0.1188P
+ PS=1.6U PD=1.02U
M$4220 \$2750 \$2747 \$2749 VSS nfet_03v3 L=0.28U W=0.36U AS=0.1188P AD=0.1278P
+ PS=1.02U PD=1.07U
M$4221 \$2818 \$2751 \$2750 VSS nfet_03v3 L=0.28U W=0.36U AS=0.1278P AD=0.0567P
+ PS=1.07U PD=0.675U
M$4222 VSS \$2748 \$2818 VSS nfet_03v3 L=0.28U W=0.36U AS=0.0567P AD=0.1584P
+ PS=0.675U PD=1.6U
M$4223 VSS \$2750 \$2751 VSS nfet_03v3 L=0.28U W=0.36U AS=0.1584P AD=0.0972P
+ PS=1.6U PD=0.9U
M$4224 \$2752 \$2750 VSS VSS nfet_03v3 L=0.28U W=0.36U AS=0.0972P AD=0.18P
+ PS=0.9U PD=1.72U
M$4225 \$2753 \$47 VSS VSS nfet_03v3 L=0.28U W=0.36U AS=0.1584P AD=0.1188P
+ PS=1.6U PD=1.02U
M$4226 \$2754 \$2747 \$2753 VSS nfet_03v3 L=0.28U W=0.36U AS=0.1188P AD=0.1278P
+ PS=1.02U PD=1.07U
M$4227 \$2827 \$2755 \$2754 VSS nfet_03v3 L=0.28U W=0.36U AS=0.1278P AD=0.0567P
+ PS=1.07U PD=0.675U
M$4228 VSS \$2748 \$2827 VSS nfet_03v3 L=0.28U W=0.36U AS=0.0567P AD=0.1584P
+ PS=0.675U PD=1.6U
M$4229 VSS \$2754 \$2755 VSS nfet_03v3 L=0.28U W=0.36U AS=0.1584P AD=0.0972P
+ PS=1.6U PD=0.9U
M$4230 \$2756 \$2754 VSS VSS nfet_03v3 L=0.28U W=0.36U AS=0.0972P AD=0.18P
+ PS=0.9U PD=1.72U
M$4231 \$2757 \$50 VSS VSS nfet_03v3 L=0.28U W=0.36U AS=0.1584P AD=0.1188P
+ PS=1.6U PD=1.02U
M$4232 \$2758 \$2747 \$2757 VSS nfet_03v3 L=0.28U W=0.36U AS=0.1188P AD=0.1278P
+ PS=1.02U PD=1.07U
M$4233 \$2836 \$2759 \$2758 VSS nfet_03v3 L=0.28U W=0.36U AS=0.1278P AD=0.0567P
+ PS=1.07U PD=0.675U
M$4234 VSS \$2748 \$2836 VSS nfet_03v3 L=0.28U W=0.36U AS=0.0567P AD=0.1584P
+ PS=0.675U PD=1.6U
M$4235 VSS \$2758 \$2759 VSS nfet_03v3 L=0.28U W=0.36U AS=0.1584P AD=0.0972P
+ PS=1.6U PD=0.9U
M$4236 \$2760 \$2758 VSS VSS nfet_03v3 L=0.28U W=0.36U AS=0.0972P AD=0.18P
+ PS=0.9U PD=1.72U
M$4237 \$2761 \$53 VSS VSS nfet_03v3 L=0.28U W=0.36U AS=0.1584P AD=0.1188P
+ PS=1.6U PD=1.02U
M$4238 \$2762 \$2747 \$2761 VSS nfet_03v3 L=0.28U W=0.36U AS=0.1188P AD=0.1278P
+ PS=1.02U PD=1.07U
M$4239 \$2845 \$2763 \$2762 VSS nfet_03v3 L=0.28U W=0.36U AS=0.1278P AD=0.0567P
+ PS=1.07U PD=0.675U
M$4240 VSS \$2748 \$2845 VSS nfet_03v3 L=0.28U W=0.36U AS=0.0567P AD=0.1584P
+ PS=0.675U PD=1.6U
M$4241 VSS \$2762 \$2763 VSS nfet_03v3 L=0.28U W=0.36U AS=0.1584P AD=0.0972P
+ PS=1.6U PD=0.9U
M$4242 \$2764 \$2762 VSS VSS nfet_03v3 L=0.28U W=0.36U AS=0.0972P AD=0.18P
+ PS=0.9U PD=1.72U
M$4243 \$2765 \$56 VSS VSS nfet_03v3 L=0.28U W=0.36U AS=0.1584P AD=0.1188P
+ PS=1.6U PD=1.02U
M$4244 \$2766 \$2747 \$2765 VSS nfet_03v3 L=0.28U W=0.36U AS=0.1188P AD=0.1278P
+ PS=1.02U PD=1.07U
M$4245 \$2854 \$2767 \$2766 VSS nfet_03v3 L=0.28U W=0.36U AS=0.1278P AD=0.0567P
+ PS=1.07U PD=0.675U
M$4246 VSS \$2748 \$2854 VSS nfet_03v3 L=0.28U W=0.36U AS=0.0567P AD=0.1584P
+ PS=0.675U PD=1.6U
M$4247 VSS \$2766 \$2767 VSS nfet_03v3 L=0.28U W=0.36U AS=0.1584P AD=0.0972P
+ PS=1.6U PD=0.9U
M$4248 \$2768 \$2766 VSS VSS nfet_03v3 L=0.28U W=0.36U AS=0.0972P AD=0.18P
+ PS=0.9U PD=1.72U
M$4249 \$2769 \$59 VSS VSS nfet_03v3 L=0.28U W=0.36U AS=0.1584P AD=0.1188P
+ PS=1.6U PD=1.02U
M$4250 \$2770 \$2747 \$2769 VSS nfet_03v3 L=0.28U W=0.36U AS=0.1188P AD=0.1278P
+ PS=1.02U PD=1.07U
M$4251 \$2862 \$2771 \$2770 VSS nfet_03v3 L=0.28U W=0.36U AS=0.1278P AD=0.0567P
+ PS=1.07U PD=0.675U
M$4252 VSS \$2748 \$2862 VSS nfet_03v3 L=0.28U W=0.36U AS=0.0567P AD=0.1584P
+ PS=0.675U PD=1.6U
M$4253 VSS \$2770 \$2771 VSS nfet_03v3 L=0.28U W=0.36U AS=0.1584P AD=0.0972P
+ PS=1.6U PD=0.9U
M$4254 \$2772 \$2770 VSS VSS nfet_03v3 L=0.28U W=0.36U AS=0.0972P AD=0.18P
+ PS=0.9U PD=1.72U
M$4255 \$2773 \$62 VSS VSS nfet_03v3 L=0.28U W=0.36U AS=0.1584P AD=0.1188P
+ PS=1.6U PD=1.02U
M$4256 \$2774 \$2747 \$2773 VSS nfet_03v3 L=0.28U W=0.36U AS=0.1188P AD=0.1278P
+ PS=1.02U PD=1.07U
M$4257 \$2865 \$2775 \$2774 VSS nfet_03v3 L=0.28U W=0.36U AS=0.1278P AD=0.0567P
+ PS=1.07U PD=0.675U
M$4258 VSS \$2748 \$2865 VSS nfet_03v3 L=0.28U W=0.36U AS=0.0567P AD=0.1584P
+ PS=0.675U PD=1.6U
M$4259 VSS \$2774 \$2775 VSS nfet_03v3 L=0.28U W=0.36U AS=0.1584P AD=0.0972P
+ PS=1.6U PD=0.9U
M$4260 \$2776 \$2774 VSS VSS nfet_03v3 L=0.28U W=0.36U AS=0.0972P AD=0.18P
+ PS=0.9U PD=1.72U
M$4261 \$2777 \$65 VSS VSS nfet_03v3 L=0.28U W=0.36U AS=0.1584P AD=0.1188P
+ PS=1.6U PD=1.02U
M$4262 \$2778 \$2747 \$2777 VSS nfet_03v3 L=0.28U W=0.36U AS=0.1188P AD=0.1278P
+ PS=1.02U PD=1.07U
M$4263 \$2859 \$2779 \$2778 VSS nfet_03v3 L=0.28U W=0.36U AS=0.1278P AD=0.0567P
+ PS=1.07U PD=0.675U
M$4264 VSS \$2748 \$2859 VSS nfet_03v3 L=0.28U W=0.36U AS=0.0567P AD=0.1584P
+ PS=0.675U PD=1.6U
M$4265 VSS \$2778 \$2779 VSS nfet_03v3 L=0.28U W=0.36U AS=0.1584P AD=0.0972P
+ PS=1.6U PD=0.9U
M$4266 \$2780 \$2778 VSS VSS nfet_03v3 L=0.28U W=0.36U AS=0.0972P AD=0.18P
+ PS=0.9U PD=1.72U
M$4267 \$2781 \$68 VSS VSS nfet_03v3 L=0.28U W=0.36U AS=0.1584P AD=0.1188P
+ PS=1.6U PD=1.02U
M$4268 \$2782 \$2747 \$2781 VSS nfet_03v3 L=0.28U W=0.36U AS=0.1188P AD=0.1278P
+ PS=1.02U PD=1.07U
M$4269 \$2853 \$2783 \$2782 VSS nfet_03v3 L=0.28U W=0.36U AS=0.1278P AD=0.0567P
+ PS=1.07U PD=0.675U
M$4270 VSS \$2748 \$2853 VSS nfet_03v3 L=0.28U W=0.36U AS=0.0567P AD=0.1584P
+ PS=0.675U PD=1.6U
M$4271 VSS \$2782 \$2783 VSS nfet_03v3 L=0.28U W=0.36U AS=0.1584P AD=0.0972P
+ PS=1.6U PD=0.9U
M$4272 \$2784 \$2782 VSS VSS nfet_03v3 L=0.28U W=0.36U AS=0.0972P AD=0.18P
+ PS=0.9U PD=1.72U
M$4273 \$2785 \$71 VSS VSS nfet_03v3 L=0.28U W=0.36U AS=0.1584P AD=0.1188P
+ PS=1.6U PD=1.02U
M$4274 \$2786 \$2747 \$2785 VSS nfet_03v3 L=0.28U W=0.36U AS=0.1188P AD=0.1278P
+ PS=1.02U PD=1.07U
M$4275 \$2849 \$2787 \$2786 VSS nfet_03v3 L=0.28U W=0.36U AS=0.1278P AD=0.0567P
+ PS=1.07U PD=0.675U
M$4276 VSS \$2748 \$2849 VSS nfet_03v3 L=0.28U W=0.36U AS=0.0567P AD=0.1584P
+ PS=0.675U PD=1.6U
M$4277 VSS \$2786 \$2787 VSS nfet_03v3 L=0.28U W=0.36U AS=0.1584P AD=0.0972P
+ PS=1.6U PD=0.9U
M$4278 \$2788 \$2786 VSS VSS nfet_03v3 L=0.28U W=0.36U AS=0.0972P AD=0.18P
+ PS=0.9U PD=1.72U
M$4279 \$2789 \$74 VSS VSS nfet_03v3 L=0.28U W=0.36U AS=0.1584P AD=0.1188P
+ PS=1.6U PD=1.02U
M$4280 \$2790 \$2747 \$2789 VSS nfet_03v3 L=0.28U W=0.36U AS=0.1188P AD=0.1278P
+ PS=1.02U PD=1.07U
M$4281 \$2842 \$2791 \$2790 VSS nfet_03v3 L=0.28U W=0.36U AS=0.1278P AD=0.0567P
+ PS=1.07U PD=0.675U
M$4282 VSS \$2748 \$2842 VSS nfet_03v3 L=0.28U W=0.36U AS=0.0567P AD=0.1584P
+ PS=0.675U PD=1.6U
M$4283 VSS \$2790 \$2791 VSS nfet_03v3 L=0.28U W=0.36U AS=0.1584P AD=0.0972P
+ PS=1.6U PD=0.9U
M$4284 \$2792 \$2790 VSS VSS nfet_03v3 L=0.28U W=0.36U AS=0.0972P AD=0.18P
+ PS=0.9U PD=1.72U
M$4285 \$2793 \$77 VSS VSS nfet_03v3 L=0.28U W=0.36U AS=0.1584P AD=0.1188P
+ PS=1.6U PD=1.02U
M$4286 \$2794 \$2747 \$2793 VSS nfet_03v3 L=0.28U W=0.36U AS=0.1188P AD=0.1278P
+ PS=1.02U PD=1.07U
M$4287 \$2838 \$2795 \$2794 VSS nfet_03v3 L=0.28U W=0.36U AS=0.1278P AD=0.0567P
+ PS=1.07U PD=0.675U
M$4288 VSS \$2748 \$2838 VSS nfet_03v3 L=0.28U W=0.36U AS=0.0567P AD=0.1584P
+ PS=0.675U PD=1.6U
M$4289 VSS \$2794 \$2795 VSS nfet_03v3 L=0.28U W=0.36U AS=0.1584P AD=0.0972P
+ PS=1.6U PD=0.9U
M$4290 \$2796 \$2794 VSS VSS nfet_03v3 L=0.28U W=0.36U AS=0.0972P AD=0.18P
+ PS=0.9U PD=1.72U
M$4291 \$2797 \$80 VSS VSS nfet_03v3 L=0.28U W=0.36U AS=0.1584P AD=0.1188P
+ PS=1.6U PD=1.02U
M$4292 \$2798 \$2747 \$2797 VSS nfet_03v3 L=0.28U W=0.36U AS=0.1188P AD=0.1278P
+ PS=1.02U PD=1.07U
M$4293 \$2833 \$2799 \$2798 VSS nfet_03v3 L=0.28U W=0.36U AS=0.1278P AD=0.0567P
+ PS=1.07U PD=0.675U
M$4294 VSS \$2748 \$2833 VSS nfet_03v3 L=0.28U W=0.36U AS=0.0567P AD=0.1584P
+ PS=0.675U PD=1.6U
M$4295 VSS \$2798 \$2799 VSS nfet_03v3 L=0.28U W=0.36U AS=0.1584P AD=0.0972P
+ PS=1.6U PD=0.9U
M$4296 \$2800 \$2798 VSS VSS nfet_03v3 L=0.28U W=0.36U AS=0.0972P AD=0.18P
+ PS=0.9U PD=1.72U
M$4297 \$2801 \$83 VSS VSS nfet_03v3 L=0.28U W=0.36U AS=0.1584P AD=0.1188P
+ PS=1.6U PD=1.02U
M$4298 \$2802 \$2747 \$2801 VSS nfet_03v3 L=0.28U W=0.36U AS=0.1188P AD=0.1278P
+ PS=1.02U PD=1.07U
M$4299 \$2826 \$2803 \$2802 VSS nfet_03v3 L=0.28U W=0.36U AS=0.1278P AD=0.0567P
+ PS=1.07U PD=0.675U
M$4300 VSS \$2748 \$2826 VSS nfet_03v3 L=0.28U W=0.36U AS=0.0567P AD=0.1584P
+ PS=0.675U PD=1.6U
M$4301 VSS \$2802 \$2803 VSS nfet_03v3 L=0.28U W=0.36U AS=0.1584P AD=0.0972P
+ PS=1.6U PD=0.9U
M$4302 \$2804 \$2802 VSS VSS nfet_03v3 L=0.28U W=0.36U AS=0.0972P AD=0.18P
+ PS=0.9U PD=1.72U
M$4303 \$2805 \$86 VSS VSS nfet_03v3 L=0.28U W=0.36U AS=0.1584P AD=0.1188P
+ PS=1.6U PD=1.02U
M$4304 \$2806 \$2747 \$2805 VSS nfet_03v3 L=0.28U W=0.36U AS=0.1188P AD=0.1278P
+ PS=1.02U PD=1.07U
M$4305 \$2822 \$2807 \$2806 VSS nfet_03v3 L=0.28U W=0.36U AS=0.1278P AD=0.0567P
+ PS=1.07U PD=0.675U
M$4306 VSS \$2748 \$2822 VSS nfet_03v3 L=0.28U W=0.36U AS=0.0567P AD=0.1584P
+ PS=0.675U PD=1.6U
M$4307 VSS \$2806 \$2807 VSS nfet_03v3 L=0.28U W=0.36U AS=0.1584P AD=0.0972P
+ PS=1.6U PD=0.9U
M$4308 \$2808 \$2806 VSS VSS nfet_03v3 L=0.28U W=0.36U AS=0.0972P AD=0.18P
+ PS=0.9U PD=1.72U
M$4309 \$2809 \$89 VSS VSS nfet_03v3 L=0.28U W=0.36U AS=0.1584P AD=0.1188P
+ PS=1.6U PD=1.02U
M$4310 \$2810 \$2747 \$2809 VSS nfet_03v3 L=0.28U W=0.36U AS=0.1188P AD=0.1278P
+ PS=1.02U PD=1.07U
M$4311 \$2815 \$2811 \$2810 VSS nfet_03v3 L=0.28U W=0.36U AS=0.1278P AD=0.0567P
+ PS=1.07U PD=0.675U
M$4312 VSS \$2748 \$2815 VSS nfet_03v3 L=0.28U W=0.36U AS=0.0567P AD=0.1584P
+ PS=0.675U PD=1.6U
M$4313 VSS \$2810 \$2811 VSS nfet_03v3 L=0.28U W=0.36U AS=0.1584P AD=0.0972P
+ PS=1.6U PD=0.9U
M$4314 \$2812 \$2810 VSS VSS nfet_03v3 L=0.28U W=0.36U AS=0.0972P AD=0.18P
+ PS=0.9U PD=1.72U
M$4315 \$2869 RA7 VSS VSS nfet_03v3 L=0.28U W=0.36U AS=0.1656P AD=0.1944P
+ PS=1.64U PD=1.8U
M$4316 \$3072 RB6 VSS VSS nfet_03v3 L=0.28U W=0.36U AS=0.1656P AD=0.1944P
+ PS=1.64U PD=1.8U
M$4317 \$2752 RA7 \$360 VSS nfet_03v3 L=0.28U W=0.36U AS=0.1584P AD=0.1152P
+ PS=1.6U PD=1U
M$4318 \$361 RB7 \$2752 VSS nfet_03v3 L=0.28U W=0.36U AS=0.1152P AD=0.1584P
+ PS=1U PD=1.6U
M$4319 \$3071 RB6 \$360 VSS nfet_03v3 L=0.28U W=0.36U AS=0.1584P AD=0.1152P
+ PS=1.6U PD=1U
M$4320 \$361 RA6 \$3071 VSS nfet_03v3 L=0.28U W=0.36U AS=0.1152P AD=0.1584P
+ PS=1U PD=1.6U
M$4321 VSS RA6 \$3073 VSS nfet_03v3 L=0.28U W=0.36U AS=0.1854P AD=0.1584P
+ PS=1.75U PD=1.6U
M$4322 VSS RB7 \$2870 VSS nfet_03v3 L=0.28U W=0.36U AS=0.1854P AD=0.1584P
+ PS=1.75U PD=1.6U
M$4323 \$2871 RA7 VSS VSS nfet_03v3 L=0.28U W=0.36U AS=0.1656P AD=0.1944P
+ PS=1.64U PD=1.8U
M$4324 \$3078 RB6 VSS VSS nfet_03v3 L=0.28U W=0.36U AS=0.1656P AD=0.1944P
+ PS=1.64U PD=1.8U
M$4325 \$3077 RB6 \$365 VSS nfet_03v3 L=0.28U W=0.36U AS=0.1584P AD=0.1152P
+ PS=1.6U PD=1U
M$4326 \$366 RA6 \$3077 VSS nfet_03v3 L=0.28U W=0.36U AS=0.1152P AD=0.1584P
+ PS=1U PD=1.6U
M$4327 \$2756 RA7 \$365 VSS nfet_03v3 L=0.28U W=0.36U AS=0.1584P AD=0.1152P
+ PS=1.6U PD=1U
M$4328 \$366 RB7 \$2756 VSS nfet_03v3 L=0.28U W=0.36U AS=0.1152P AD=0.1584P
+ PS=1U PD=1.6U
M$4329 VSS RB7 \$2872 VSS nfet_03v3 L=0.28U W=0.36U AS=0.1854P AD=0.1584P
+ PS=1.75U PD=1.6U
M$4330 VSS RA6 \$3079 VSS nfet_03v3 L=0.28U W=0.36U AS=0.1854P AD=0.1584P
+ PS=1.75U PD=1.6U
M$4331 \$3084 RB6 VSS VSS nfet_03v3 L=0.28U W=0.36U AS=0.1656P AD=0.1944P
+ PS=1.64U PD=1.8U
M$4332 \$2873 RA7 VSS VSS nfet_03v3 L=0.28U W=0.36U AS=0.1656P AD=0.1944P
+ PS=1.64U PD=1.8U
M$4333 \$2760 RA7 \$370 VSS nfet_03v3 L=0.28U W=0.36U AS=0.1584P AD=0.1152P
+ PS=1.6U PD=1U
M$4334 \$371 RB7 \$2760 VSS nfet_03v3 L=0.28U W=0.36U AS=0.1152P AD=0.1584P
+ PS=1U PD=1.6U
M$4335 \$3083 RB6 \$370 VSS nfet_03v3 L=0.28U W=0.36U AS=0.1584P AD=0.1152P
+ PS=1.6U PD=1U
M$4336 \$371 RA6 \$3083 VSS nfet_03v3 L=0.28U W=0.36U AS=0.1152P AD=0.1584P
+ PS=1U PD=1.6U
M$4337 VSS RB7 \$2874 VSS nfet_03v3 L=0.28U W=0.36U AS=0.1854P AD=0.1584P
+ PS=1.75U PD=1.6U
M$4338 VSS RA6 \$3085 VSS nfet_03v3 L=0.28U W=0.36U AS=0.1854P AD=0.1584P
+ PS=1.75U PD=1.6U
M$4339 \$3090 RB6 VSS VSS nfet_03v3 L=0.28U W=0.36U AS=0.1656P AD=0.1944P
+ PS=1.64U PD=1.8U
M$4340 \$2875 RA7 VSS VSS nfet_03v3 L=0.28U W=0.36U AS=0.1656P AD=0.1944P
+ PS=1.64U PD=1.8U
M$4341 \$3089 RB6 \$375 VSS nfet_03v3 L=0.28U W=0.36U AS=0.1584P AD=0.1152P
+ PS=1.6U PD=1U
M$4342 \$376 RA6 \$3089 VSS nfet_03v3 L=0.28U W=0.36U AS=0.1152P AD=0.1584P
+ PS=1U PD=1.6U
M$4343 \$2764 RA7 \$375 VSS nfet_03v3 L=0.28U W=0.36U AS=0.1584P AD=0.1152P
+ PS=1.6U PD=1U
M$4344 \$376 RB7 \$2764 VSS nfet_03v3 L=0.28U W=0.36U AS=0.1152P AD=0.1584P
+ PS=1U PD=1.6U
M$4345 VSS RA6 \$3091 VSS nfet_03v3 L=0.28U W=0.36U AS=0.1854P AD=0.1584P
+ PS=1.75U PD=1.6U
M$4346 VSS RB7 \$2876 VSS nfet_03v3 L=0.28U W=0.36U AS=0.1854P AD=0.1584P
+ PS=1.75U PD=1.6U
M$4347 \$3096 RB6 VSS VSS nfet_03v3 L=0.28U W=0.36U AS=0.1656P AD=0.1944P
+ PS=1.64U PD=1.8U
M$4348 \$2877 RA7 VSS VSS nfet_03v3 L=0.28U W=0.36U AS=0.1656P AD=0.1944P
+ PS=1.64U PD=1.8U
M$4349 \$2768 RA7 \$380 VSS nfet_03v3 L=0.28U W=0.36U AS=0.1584P AD=0.1152P
+ PS=1.6U PD=1U
M$4350 \$381 RB7 \$2768 VSS nfet_03v3 L=0.28U W=0.36U AS=0.1152P AD=0.1584P
+ PS=1U PD=1.6U
M$4351 \$3095 RB6 \$380 VSS nfet_03v3 L=0.28U W=0.36U AS=0.1584P AD=0.1152P
+ PS=1.6U PD=1U
M$4352 \$381 RA6 \$3095 VSS nfet_03v3 L=0.28U W=0.36U AS=0.1152P AD=0.1584P
+ PS=1U PD=1.6U
M$4353 VSS RA6 \$3097 VSS nfet_03v3 L=0.28U W=0.36U AS=0.1854P AD=0.1584P
+ PS=1.75U PD=1.6U
M$4354 VSS RB7 \$2878 VSS nfet_03v3 L=0.28U W=0.36U AS=0.1854P AD=0.1584P
+ PS=1.75U PD=1.6U
M$4355 \$2879 RA7 VSS VSS nfet_03v3 L=0.28U W=0.36U AS=0.1656P AD=0.1944P
+ PS=1.64U PD=1.8U
M$4356 \$3102 RB6 VSS VSS nfet_03v3 L=0.28U W=0.36U AS=0.1656P AD=0.1944P
+ PS=1.64U PD=1.8U
M$4357 \$3101 RB6 \$385 VSS nfet_03v3 L=0.28U W=0.36U AS=0.1584P AD=0.1152P
+ PS=1.6U PD=1U
M$4358 \$386 RA6 \$3101 VSS nfet_03v3 L=0.28U W=0.36U AS=0.1152P AD=0.1584P
+ PS=1U PD=1.6U
M$4359 \$2772 RA7 \$385 VSS nfet_03v3 L=0.28U W=0.36U AS=0.1584P AD=0.1152P
+ PS=1.6U PD=1U
M$4360 \$386 RB7 \$2772 VSS nfet_03v3 L=0.28U W=0.36U AS=0.1152P AD=0.1584P
+ PS=1U PD=1.6U
M$4361 VSS RB7 \$2880 VSS nfet_03v3 L=0.28U W=0.36U AS=0.1854P AD=0.1584P
+ PS=1.75U PD=1.6U
M$4362 VSS RA6 \$3103 VSS nfet_03v3 L=0.28U W=0.36U AS=0.1854P AD=0.1584P
+ PS=1.75U PD=1.6U
M$4363 \$2881 RA7 VSS VSS nfet_03v3 L=0.28U W=0.36U AS=0.1656P AD=0.1944P
+ PS=1.64U PD=1.8U
M$4364 \$3108 RB6 VSS VSS nfet_03v3 L=0.28U W=0.36U AS=0.1656P AD=0.1944P
+ PS=1.64U PD=1.8U
M$4365 \$2776 RA7 \$390 VSS nfet_03v3 L=0.28U W=0.36U AS=0.1584P AD=0.1152P
+ PS=1.6U PD=1U
M$4366 \$391 RB7 \$2776 VSS nfet_03v3 L=0.28U W=0.36U AS=0.1152P AD=0.1584P
+ PS=1U PD=1.6U
M$4367 \$3107 RB6 \$390 VSS nfet_03v3 L=0.28U W=0.36U AS=0.1584P AD=0.1152P
+ PS=1.6U PD=1U
M$4368 \$391 RA6 \$3107 VSS nfet_03v3 L=0.28U W=0.36U AS=0.1152P AD=0.1584P
+ PS=1U PD=1.6U
M$4369 VSS RA6 \$3109 VSS nfet_03v3 L=0.28U W=0.36U AS=0.1854P AD=0.1584P
+ PS=1.75U PD=1.6U
M$4370 VSS RB7 \$2882 VSS nfet_03v3 L=0.28U W=0.36U AS=0.1854P AD=0.1584P
+ PS=1.75U PD=1.6U
M$4371 \$3114 RB6 VSS VSS nfet_03v3 L=0.28U W=0.36U AS=0.1656P AD=0.1944P
+ PS=1.64U PD=1.8U
M$4372 \$2883 RA7 VSS VSS nfet_03v3 L=0.28U W=0.36U AS=0.1656P AD=0.1944P
+ PS=1.64U PD=1.8U
M$4373 \$3113 RB6 \$395 VSS nfet_03v3 L=0.28U W=0.36U AS=0.1584P AD=0.1152P
+ PS=1.6U PD=1U
M$4374 \$396 RA6 \$3113 VSS nfet_03v3 L=0.28U W=0.36U AS=0.1152P AD=0.1584P
+ PS=1U PD=1.6U
M$4375 \$2780 RA7 \$395 VSS nfet_03v3 L=0.28U W=0.36U AS=0.1584P AD=0.1152P
+ PS=1.6U PD=1U
M$4376 \$396 RB7 \$2780 VSS nfet_03v3 L=0.28U W=0.36U AS=0.1152P AD=0.1584P
+ PS=1U PD=1.6U
M$4377 VSS RB7 \$2884 VSS nfet_03v3 L=0.28U W=0.36U AS=0.1854P AD=0.1584P
+ PS=1.75U PD=1.6U
M$4378 VSS RA6 \$3115 VSS nfet_03v3 L=0.28U W=0.36U AS=0.1854P AD=0.1584P
+ PS=1.75U PD=1.6U
M$4379 \$2885 RA7 VSS VSS nfet_03v3 L=0.28U W=0.36U AS=0.1656P AD=0.1944P
+ PS=1.64U PD=1.8U
M$4380 \$3120 RB6 VSS VSS nfet_03v3 L=0.28U W=0.36U AS=0.1656P AD=0.1944P
+ PS=1.64U PD=1.8U
M$4381 \$3119 RB6 \$400 VSS nfet_03v3 L=0.28U W=0.36U AS=0.1584P AD=0.1152P
+ PS=1.6U PD=1U
M$4382 \$401 RA6 \$3119 VSS nfet_03v3 L=0.28U W=0.36U AS=0.1152P AD=0.1584P
+ PS=1U PD=1.6U
M$4383 \$2784 RA7 \$400 VSS nfet_03v3 L=0.28U W=0.36U AS=0.1584P AD=0.1152P
+ PS=1.6U PD=1U
M$4384 \$401 RB7 \$2784 VSS nfet_03v3 L=0.28U W=0.36U AS=0.1152P AD=0.1584P
+ PS=1U PD=1.6U
M$4385 VSS RA6 \$3121 VSS nfet_03v3 L=0.28U W=0.36U AS=0.1854P AD=0.1584P
+ PS=1.75U PD=1.6U
M$4386 VSS RB7 \$2886 VSS nfet_03v3 L=0.28U W=0.36U AS=0.1854P AD=0.1584P
+ PS=1.75U PD=1.6U
M$4387 \$2887 RA7 VSS VSS nfet_03v3 L=0.28U W=0.36U AS=0.1656P AD=0.1944P
+ PS=1.64U PD=1.8U
M$4388 \$3126 RB6 VSS VSS nfet_03v3 L=0.28U W=0.36U AS=0.1656P AD=0.1944P
+ PS=1.64U PD=1.8U
M$4389 \$3125 RB6 \$405 VSS nfet_03v3 L=0.28U W=0.36U AS=0.1584P AD=0.1152P
+ PS=1.6U PD=1U
M$4390 \$406 RA6 \$3125 VSS nfet_03v3 L=0.28U W=0.36U AS=0.1152P AD=0.1584P
+ PS=1U PD=1.6U
M$4391 \$2788 RA7 \$405 VSS nfet_03v3 L=0.28U W=0.36U AS=0.1584P AD=0.1152P
+ PS=1.6U PD=1U
M$4392 \$406 RB7 \$2788 VSS nfet_03v3 L=0.28U W=0.36U AS=0.1152P AD=0.1584P
+ PS=1U PD=1.6U
M$4393 VSS RB7 \$2888 VSS nfet_03v3 L=0.28U W=0.36U AS=0.1854P AD=0.1584P
+ PS=1.75U PD=1.6U
M$4394 VSS RA6 \$3127 VSS nfet_03v3 L=0.28U W=0.36U AS=0.1854P AD=0.1584P
+ PS=1.75U PD=1.6U
M$4395 \$2889 RA7 VSS VSS nfet_03v3 L=0.28U W=0.36U AS=0.1656P AD=0.1944P
+ PS=1.64U PD=1.8U
M$4396 \$3132 RB6 VSS VSS nfet_03v3 L=0.28U W=0.36U AS=0.1656P AD=0.1944P
+ PS=1.64U PD=1.8U
M$4397 \$3131 RB6 \$410 VSS nfet_03v3 L=0.28U W=0.36U AS=0.1584P AD=0.1152P
+ PS=1.6U PD=1U
M$4398 \$411 RA6 \$3131 VSS nfet_03v3 L=0.28U W=0.36U AS=0.1152P AD=0.1584P
+ PS=1U PD=1.6U
M$4399 \$2792 RA7 \$410 VSS nfet_03v3 L=0.28U W=0.36U AS=0.1584P AD=0.1152P
+ PS=1.6U PD=1U
M$4400 \$411 RB7 \$2792 VSS nfet_03v3 L=0.28U W=0.36U AS=0.1152P AD=0.1584P
+ PS=1U PD=1.6U
M$4401 VSS RB7 \$2890 VSS nfet_03v3 L=0.28U W=0.36U AS=0.1854P AD=0.1584P
+ PS=1.75U PD=1.6U
M$4402 VSS RA6 \$3133 VSS nfet_03v3 L=0.28U W=0.36U AS=0.1854P AD=0.1584P
+ PS=1.75U PD=1.6U
M$4403 \$2891 RA7 VSS VSS nfet_03v3 L=0.28U W=0.36U AS=0.1656P AD=0.1944P
+ PS=1.64U PD=1.8U
M$4404 \$3138 RB6 VSS VSS nfet_03v3 L=0.28U W=0.36U AS=0.1656P AD=0.1944P
+ PS=1.64U PD=1.8U
M$4405 \$3137 RB6 \$415 VSS nfet_03v3 L=0.28U W=0.36U AS=0.1584P AD=0.1152P
+ PS=1.6U PD=1U
M$4406 \$416 RA6 \$3137 VSS nfet_03v3 L=0.28U W=0.36U AS=0.1152P AD=0.1584P
+ PS=1U PD=1.6U
M$4407 \$2796 RA7 \$415 VSS nfet_03v3 L=0.28U W=0.36U AS=0.1584P AD=0.1152P
+ PS=1.6U PD=1U
M$4408 \$416 RB7 \$2796 VSS nfet_03v3 L=0.28U W=0.36U AS=0.1152P AD=0.1584P
+ PS=1U PD=1.6U
M$4409 VSS RB7 \$2892 VSS nfet_03v3 L=0.28U W=0.36U AS=0.1854P AD=0.1584P
+ PS=1.75U PD=1.6U
M$4410 VSS RA6 \$3139 VSS nfet_03v3 L=0.28U W=0.36U AS=0.1854P AD=0.1584P
+ PS=1.75U PD=1.6U
M$4411 \$3144 RB6 VSS VSS nfet_03v3 L=0.28U W=0.36U AS=0.1656P AD=0.1944P
+ PS=1.64U PD=1.8U
M$4412 \$2893 RA7 VSS VSS nfet_03v3 L=0.28U W=0.36U AS=0.1656P AD=0.1944P
+ PS=1.64U PD=1.8U
M$4413 \$3143 RB6 \$420 VSS nfet_03v3 L=0.28U W=0.36U AS=0.1584P AD=0.1152P
+ PS=1.6U PD=1U
M$4414 \$421 RA6 \$3143 VSS nfet_03v3 L=0.28U W=0.36U AS=0.1152P AD=0.1584P
+ PS=1U PD=1.6U
M$4415 \$2800 RA7 \$420 VSS nfet_03v3 L=0.28U W=0.36U AS=0.1584P AD=0.1152P
+ PS=1.6U PD=1U
M$4416 \$421 RB7 \$2800 VSS nfet_03v3 L=0.28U W=0.36U AS=0.1152P AD=0.1584P
+ PS=1U PD=1.6U
M$4417 VSS RB7 \$2894 VSS nfet_03v3 L=0.28U W=0.36U AS=0.1854P AD=0.1584P
+ PS=1.75U PD=1.6U
M$4418 VSS RA6 \$3145 VSS nfet_03v3 L=0.28U W=0.36U AS=0.1854P AD=0.1584P
+ PS=1.75U PD=1.6U
M$4419 \$3150 RB6 VSS VSS nfet_03v3 L=0.28U W=0.36U AS=0.1656P AD=0.1944P
+ PS=1.64U PD=1.8U
M$4420 \$2895 RA7 VSS VSS nfet_03v3 L=0.28U W=0.36U AS=0.1656P AD=0.1944P
+ PS=1.64U PD=1.8U
M$4421 \$3149 RB6 \$425 VSS nfet_03v3 L=0.28U W=0.36U AS=0.1584P AD=0.1152P
+ PS=1.6U PD=1U
M$4422 \$426 RA6 \$3149 VSS nfet_03v3 L=0.28U W=0.36U AS=0.1152P AD=0.1584P
+ PS=1U PD=1.6U
M$4423 \$2804 RA7 \$425 VSS nfet_03v3 L=0.28U W=0.36U AS=0.1584P AD=0.1152P
+ PS=1.6U PD=1U
M$4424 \$426 RB7 \$2804 VSS nfet_03v3 L=0.28U W=0.36U AS=0.1152P AD=0.1584P
+ PS=1U PD=1.6U
M$4425 VSS RB7 \$2896 VSS nfet_03v3 L=0.28U W=0.36U AS=0.1854P AD=0.1584P
+ PS=1.75U PD=1.6U
M$4426 VSS RA6 \$3151 VSS nfet_03v3 L=0.28U W=0.36U AS=0.1854P AD=0.1584P
+ PS=1.75U PD=1.6U
M$4427 \$3156 RB6 VSS VSS nfet_03v3 L=0.28U W=0.36U AS=0.1656P AD=0.1944P
+ PS=1.64U PD=1.8U
M$4428 \$2897 RA7 VSS VSS nfet_03v3 L=0.28U W=0.36U AS=0.1656P AD=0.1944P
+ PS=1.64U PD=1.8U
M$4429 \$3155 RB6 \$430 VSS nfet_03v3 L=0.28U W=0.36U AS=0.1584P AD=0.1152P
+ PS=1.6U PD=1U
M$4430 \$431 RA6 \$3155 VSS nfet_03v3 L=0.28U W=0.36U AS=0.1152P AD=0.1584P
+ PS=1U PD=1.6U
M$4431 \$2808 RA7 \$430 VSS nfet_03v3 L=0.28U W=0.36U AS=0.1584P AD=0.1152P
+ PS=1.6U PD=1U
M$4432 \$431 RB7 \$2808 VSS nfet_03v3 L=0.28U W=0.36U AS=0.1152P AD=0.1584P
+ PS=1U PD=1.6U
M$4433 VSS RA6 \$3157 VSS nfet_03v3 L=0.28U W=0.36U AS=0.1854P AD=0.1584P
+ PS=1.75U PD=1.6U
M$4434 VSS RB7 \$2898 VSS nfet_03v3 L=0.28U W=0.36U AS=0.1854P AD=0.1584P
+ PS=1.75U PD=1.6U
M$4435 \$3162 RB6 VSS VSS nfet_03v3 L=0.28U W=0.36U AS=0.1656P AD=0.1944P
+ PS=1.64U PD=1.8U
M$4436 \$2899 RA7 VSS VSS nfet_03v3 L=0.28U W=0.36U AS=0.1656P AD=0.1944P
+ PS=1.64U PD=1.8U
M$4437 \$2812 RA7 \$435 VSS nfet_03v3 L=0.28U W=0.36U AS=0.1584P AD=0.1152P
+ PS=1.6U PD=1U
M$4438 \$436 RB7 \$2812 VSS nfet_03v3 L=0.28U W=0.36U AS=0.1152P AD=0.1584P
+ PS=1U PD=1.6U
M$4439 \$3161 RB6 \$435 VSS nfet_03v3 L=0.28U W=0.36U AS=0.1584P AD=0.1152P
+ PS=1.6U PD=1U
M$4440 \$436 RA6 \$3161 VSS nfet_03v3 L=0.28U W=0.36U AS=0.1152P AD=0.1584P
+ PS=1U PD=1.6U
M$4441 VSS RA6 \$3163 VSS nfet_03v3 L=0.28U W=0.36U AS=0.1854P AD=0.1584P
+ PS=1.75U PD=1.6U
M$4442 VSS RB7 \$2900 VSS nfet_03v3 L=0.28U W=0.36U AS=0.1854P AD=0.1584P
+ PS=1.75U PD=1.6U
M$4443 \$3267 WE6 VSS VSS nfet_03v3 L=0.28U W=0.72U AS=0.3168P AD=0.1872P
+ PS=2.32U PD=1.24U
M$4444 \$3062 CLK \$3267 VSS nfet_03v3 L=0.28U W=0.72U AS=0.1872P AD=0.3168P
+ PS=1.24U PD=2.32U
M$4445 \$3064 \$3062 VSS VSS nfet_03v3 L=0.28U W=1.27U AS=0.4487P AD=0.3302P
+ PS=3.34U PD=2.31U
M$4447 \$3065 \$3064 VSS VSS nfet_03v3 L=0.28U W=1.34U AS=0.3636P AD=0.4891P
+ PS=2.44U PD=3.47U
M$4449 \$3068 \$44 VSS VSS nfet_03v3 L=0.28U W=0.36U AS=0.1584P AD=0.1188P
+ PS=1.6U PD=1.02U
M$4450 \$3069 \$3064 \$3068 VSS nfet_03v3 L=0.28U W=0.36U AS=0.1188P AD=0.1278P
+ PS=1.02U PD=1.07U
M$4451 \$3272 \$3070 \$3069 VSS nfet_03v3 L=0.28U W=0.36U AS=0.1278P AD=0.0567P
+ PS=1.07U PD=0.675U
M$4452 VSS \$3065 \$3272 VSS nfet_03v3 L=0.28U W=0.36U AS=0.0567P AD=0.1584P
+ PS=0.675U PD=1.6U
M$4453 VSS \$3069 \$3070 VSS nfet_03v3 L=0.28U W=0.36U AS=0.1584P AD=0.0972P
+ PS=1.6U PD=0.9U
M$4454 \$3071 \$3069 VSS VSS nfet_03v3 L=0.28U W=0.36U AS=0.0972P AD=0.18P
+ PS=0.9U PD=1.72U
M$4455 \$3074 \$47 VSS VSS nfet_03v3 L=0.28U W=0.36U AS=0.1584P AD=0.1188P
+ PS=1.6U PD=1.02U
M$4456 \$3075 \$3064 \$3074 VSS nfet_03v3 L=0.28U W=0.36U AS=0.1188P AD=0.1278P
+ PS=1.02U PD=1.07U
M$4457 \$3281 \$3076 \$3075 VSS nfet_03v3 L=0.28U W=0.36U AS=0.1278P AD=0.0567P
+ PS=1.07U PD=0.675U
M$4458 VSS \$3065 \$3281 VSS nfet_03v3 L=0.28U W=0.36U AS=0.0567P AD=0.1584P
+ PS=0.675U PD=1.6U
M$4459 VSS \$3075 \$3076 VSS nfet_03v3 L=0.28U W=0.36U AS=0.1584P AD=0.0972P
+ PS=1.6U PD=0.9U
M$4460 \$3077 \$3075 VSS VSS nfet_03v3 L=0.28U W=0.36U AS=0.0972P AD=0.18P
+ PS=0.9U PD=1.72U
M$4461 \$3080 \$50 VSS VSS nfet_03v3 L=0.28U W=0.36U AS=0.1584P AD=0.1188P
+ PS=1.6U PD=1.02U
M$4462 \$3081 \$3064 \$3080 VSS nfet_03v3 L=0.28U W=0.36U AS=0.1188P AD=0.1278P
+ PS=1.02U PD=1.07U
M$4463 \$3287 \$3082 \$3081 VSS nfet_03v3 L=0.28U W=0.36U AS=0.1278P AD=0.0567P
+ PS=1.07U PD=0.675U
M$4464 VSS \$3065 \$3287 VSS nfet_03v3 L=0.28U W=0.36U AS=0.0567P AD=0.1584P
+ PS=0.675U PD=1.6U
M$4465 VSS \$3081 \$3082 VSS nfet_03v3 L=0.28U W=0.36U AS=0.1584P AD=0.0972P
+ PS=1.6U PD=0.9U
M$4466 \$3083 \$3081 VSS VSS nfet_03v3 L=0.28U W=0.36U AS=0.0972P AD=0.18P
+ PS=0.9U PD=1.72U
M$4467 \$3086 \$53 VSS VSS nfet_03v3 L=0.28U W=0.36U AS=0.1584P AD=0.1188P
+ PS=1.6U PD=1.02U
M$4468 \$3087 \$3064 \$3086 VSS nfet_03v3 L=0.28U W=0.36U AS=0.1188P AD=0.1278P
+ PS=1.02U PD=1.07U
M$4469 \$3296 \$3088 \$3087 VSS nfet_03v3 L=0.28U W=0.36U AS=0.1278P AD=0.0567P
+ PS=1.07U PD=0.675U
M$4470 VSS \$3065 \$3296 VSS nfet_03v3 L=0.28U W=0.36U AS=0.0567P AD=0.1584P
+ PS=0.675U PD=1.6U
M$4471 VSS \$3087 \$3088 VSS nfet_03v3 L=0.28U W=0.36U AS=0.1584P AD=0.0972P
+ PS=1.6U PD=0.9U
M$4472 \$3089 \$3087 VSS VSS nfet_03v3 L=0.28U W=0.36U AS=0.0972P AD=0.18P
+ PS=0.9U PD=1.72U
M$4473 \$3092 \$56 VSS VSS nfet_03v3 L=0.28U W=0.36U AS=0.1584P AD=0.1188P
+ PS=1.6U PD=1.02U
M$4474 \$3093 \$3064 \$3092 VSS nfet_03v3 L=0.28U W=0.36U AS=0.1188P AD=0.1278P
+ PS=1.02U PD=1.07U
M$4475 \$3305 \$3094 \$3093 VSS nfet_03v3 L=0.28U W=0.36U AS=0.1278P AD=0.0567P
+ PS=1.07U PD=0.675U
M$4476 VSS \$3065 \$3305 VSS nfet_03v3 L=0.28U W=0.36U AS=0.0567P AD=0.1584P
+ PS=0.675U PD=1.6U
M$4477 VSS \$3093 \$3094 VSS nfet_03v3 L=0.28U W=0.36U AS=0.1584P AD=0.0972P
+ PS=1.6U PD=0.9U
M$4478 \$3095 \$3093 VSS VSS nfet_03v3 L=0.28U W=0.36U AS=0.0972P AD=0.18P
+ PS=0.9U PD=1.72U
M$4479 \$3098 \$59 VSS VSS nfet_03v3 L=0.28U W=0.36U AS=0.1584P AD=0.1188P
+ PS=1.6U PD=1.02U
M$4480 \$3099 \$3064 \$3098 VSS nfet_03v3 L=0.28U W=0.36U AS=0.1188P AD=0.1278P
+ PS=1.02U PD=1.07U
M$4481 \$3312 \$3100 \$3099 VSS nfet_03v3 L=0.28U W=0.36U AS=0.1278P AD=0.0567P
+ PS=1.07U PD=0.675U
M$4482 VSS \$3065 \$3312 VSS nfet_03v3 L=0.28U W=0.36U AS=0.0567P AD=0.1584P
+ PS=0.675U PD=1.6U
M$4483 VSS \$3099 \$3100 VSS nfet_03v3 L=0.28U W=0.36U AS=0.1584P AD=0.0972P
+ PS=1.6U PD=0.9U
M$4484 \$3101 \$3099 VSS VSS nfet_03v3 L=0.28U W=0.36U AS=0.0972P AD=0.18P
+ PS=0.9U PD=1.72U
M$4485 \$3104 \$62 VSS VSS nfet_03v3 L=0.28U W=0.36U AS=0.1584P AD=0.1188P
+ PS=1.6U PD=1.02U
M$4486 \$3105 \$3064 \$3104 VSS nfet_03v3 L=0.28U W=0.36U AS=0.1188P AD=0.1278P
+ PS=1.02U PD=1.07U
M$4487 \$3320 \$3106 \$3105 VSS nfet_03v3 L=0.28U W=0.36U AS=0.1278P AD=0.0567P
+ PS=1.07U PD=0.675U
M$4488 VSS \$3065 \$3320 VSS nfet_03v3 L=0.28U W=0.36U AS=0.0567P AD=0.1584P
+ PS=0.675U PD=1.6U
M$4489 VSS \$3105 \$3106 VSS nfet_03v3 L=0.28U W=0.36U AS=0.1584P AD=0.0972P
+ PS=1.6U PD=0.9U
M$4490 \$3107 \$3105 VSS VSS nfet_03v3 L=0.28U W=0.36U AS=0.0972P AD=0.18P
+ PS=0.9U PD=1.72U
M$4491 \$3110 \$65 VSS VSS nfet_03v3 L=0.28U W=0.36U AS=0.1584P AD=0.1188P
+ PS=1.6U PD=1.02U
M$4492 \$3111 \$3064 \$3110 VSS nfet_03v3 L=0.28U W=0.36U AS=0.1188P AD=0.1278P
+ PS=1.02U PD=1.07U
M$4493 \$3329 \$3112 \$3111 VSS nfet_03v3 L=0.28U W=0.36U AS=0.1278P AD=0.0567P
+ PS=1.07U PD=0.675U
M$4494 VSS \$3065 \$3329 VSS nfet_03v3 L=0.28U W=0.36U AS=0.0567P AD=0.1584P
+ PS=0.675U PD=1.6U
M$4495 VSS \$3111 \$3112 VSS nfet_03v3 L=0.28U W=0.36U AS=0.1584P AD=0.0972P
+ PS=1.6U PD=0.9U
M$4496 \$3113 \$3111 VSS VSS nfet_03v3 L=0.28U W=0.36U AS=0.0972P AD=0.18P
+ PS=0.9U PD=1.72U
M$4497 \$3116 \$68 VSS VSS nfet_03v3 L=0.28U W=0.36U AS=0.1584P AD=0.1188P
+ PS=1.6U PD=1.02U
M$4498 \$3117 \$3064 \$3116 VSS nfet_03v3 L=0.28U W=0.36U AS=0.1188P AD=0.1278P
+ PS=1.02U PD=1.07U
M$4499 \$3335 \$3118 \$3117 VSS nfet_03v3 L=0.28U W=0.36U AS=0.1278P AD=0.0567P
+ PS=1.07U PD=0.675U
M$4500 VSS \$3065 \$3335 VSS nfet_03v3 L=0.28U W=0.36U AS=0.0567P AD=0.1584P
+ PS=0.675U PD=1.6U
M$4501 VSS \$3117 \$3118 VSS nfet_03v3 L=0.28U W=0.36U AS=0.1584P AD=0.0972P
+ PS=1.6U PD=0.9U
M$4502 \$3119 \$3117 VSS VSS nfet_03v3 L=0.28U W=0.36U AS=0.0972P AD=0.18P
+ PS=0.9U PD=1.72U
M$4503 \$3122 \$71 VSS VSS nfet_03v3 L=0.28U W=0.36U AS=0.1584P AD=0.1188P
+ PS=1.6U PD=1.02U
M$4504 \$3123 \$3064 \$3122 VSS nfet_03v3 L=0.28U W=0.36U AS=0.1188P AD=0.1278P
+ PS=1.02U PD=1.07U
M$4505 \$3343 \$3124 \$3123 VSS nfet_03v3 L=0.28U W=0.36U AS=0.1278P AD=0.0567P
+ PS=1.07U PD=0.675U
M$4506 VSS \$3065 \$3343 VSS nfet_03v3 L=0.28U W=0.36U AS=0.0567P AD=0.1584P
+ PS=0.675U PD=1.6U
M$4507 VSS \$3123 \$3124 VSS nfet_03v3 L=0.28U W=0.36U AS=0.1584P AD=0.0972P
+ PS=1.6U PD=0.9U
M$4508 \$3125 \$3123 VSS VSS nfet_03v3 L=0.28U W=0.36U AS=0.0972P AD=0.18P
+ PS=0.9U PD=1.72U
M$4509 \$3128 \$74 VSS VSS nfet_03v3 L=0.28U W=0.36U AS=0.1584P AD=0.1188P
+ PS=1.6U PD=1.02U
M$4510 \$3129 \$3064 \$3128 VSS nfet_03v3 L=0.28U W=0.36U AS=0.1188P AD=0.1278P
+ PS=1.02U PD=1.07U
M$4511 \$3351 \$3130 \$3129 VSS nfet_03v3 L=0.28U W=0.36U AS=0.1278P AD=0.0567P
+ PS=1.07U PD=0.675U
M$4512 VSS \$3065 \$3351 VSS nfet_03v3 L=0.28U W=0.36U AS=0.0567P AD=0.1584P
+ PS=0.675U PD=1.6U
M$4513 VSS \$3129 \$3130 VSS nfet_03v3 L=0.28U W=0.36U AS=0.1584P AD=0.0972P
+ PS=1.6U PD=0.9U
M$4514 \$3131 \$3129 VSS VSS nfet_03v3 L=0.28U W=0.36U AS=0.0972P AD=0.18P
+ PS=0.9U PD=1.72U
M$4515 \$3134 \$77 VSS VSS nfet_03v3 L=0.28U W=0.36U AS=0.1584P AD=0.1188P
+ PS=1.6U PD=1.02U
M$4516 \$3135 \$3064 \$3134 VSS nfet_03v3 L=0.28U W=0.36U AS=0.1188P AD=0.1278P
+ PS=1.02U PD=1.07U
M$4517 \$3359 \$3136 \$3135 VSS nfet_03v3 L=0.28U W=0.36U AS=0.1278P AD=0.0567P
+ PS=1.07U PD=0.675U
M$4518 VSS \$3065 \$3359 VSS nfet_03v3 L=0.28U W=0.36U AS=0.0567P AD=0.1584P
+ PS=0.675U PD=1.6U
M$4519 VSS \$3135 \$3136 VSS nfet_03v3 L=0.28U W=0.36U AS=0.1584P AD=0.0972P
+ PS=1.6U PD=0.9U
M$4520 \$3137 \$3135 VSS VSS nfet_03v3 L=0.28U W=0.36U AS=0.0972P AD=0.18P
+ PS=0.9U PD=1.72U
M$4521 \$3140 \$80 VSS VSS nfet_03v3 L=0.28U W=0.36U AS=0.1584P AD=0.1188P
+ PS=1.6U PD=1.02U
M$4522 \$3141 \$3064 \$3140 VSS nfet_03v3 L=0.28U W=0.36U AS=0.1188P AD=0.1278P
+ PS=1.02U PD=1.07U
M$4523 \$3354 \$3142 \$3141 VSS nfet_03v3 L=0.28U W=0.36U AS=0.1278P AD=0.0567P
+ PS=1.07U PD=0.675U
M$4524 VSS \$3065 \$3354 VSS nfet_03v3 L=0.28U W=0.36U AS=0.0567P AD=0.1584P
+ PS=0.675U PD=1.6U
M$4525 VSS \$3141 \$3142 VSS nfet_03v3 L=0.28U W=0.36U AS=0.1584P AD=0.0972P
+ PS=1.6U PD=0.9U
M$4526 \$3143 \$3141 VSS VSS nfet_03v3 L=0.28U W=0.36U AS=0.0972P AD=0.18P
+ PS=0.9U PD=1.72U
M$4527 \$3146 \$83 VSS VSS nfet_03v3 L=0.28U W=0.36U AS=0.1584P AD=0.1188P
+ PS=1.6U PD=1.02U
M$4528 \$3147 \$3064 \$3146 VSS nfet_03v3 L=0.28U W=0.36U AS=0.1188P AD=0.1278P
+ PS=1.02U PD=1.07U
M$4529 \$3328 \$3148 \$3147 VSS nfet_03v3 L=0.28U W=0.36U AS=0.1278P AD=0.0567P
+ PS=1.07U PD=0.675U
M$4530 VSS \$3065 \$3328 VSS nfet_03v3 L=0.28U W=0.36U AS=0.0567P AD=0.1584P
+ PS=0.675U PD=1.6U
M$4531 VSS \$3147 \$3148 VSS nfet_03v3 L=0.28U W=0.36U AS=0.1584P AD=0.0972P
+ PS=1.6U PD=0.9U
M$4532 \$3149 \$3147 VSS VSS nfet_03v3 L=0.28U W=0.36U AS=0.0972P AD=0.18P
+ PS=0.9U PD=1.72U
M$4533 \$3152 \$86 VSS VSS nfet_03v3 L=0.28U W=0.36U AS=0.1584P AD=0.1188P
+ PS=1.6U PD=1.02U
M$4534 \$3153 \$3064 \$3152 VSS nfet_03v3 L=0.28U W=0.36U AS=0.1188P AD=0.1278P
+ PS=1.02U PD=1.07U
M$4535 \$3304 \$3154 \$3153 VSS nfet_03v3 L=0.28U W=0.36U AS=0.1278P AD=0.0567P
+ PS=1.07U PD=0.675U
M$4536 VSS \$3065 \$3304 VSS nfet_03v3 L=0.28U W=0.36U AS=0.0567P AD=0.1584P
+ PS=0.675U PD=1.6U
M$4537 VSS \$3153 \$3154 VSS nfet_03v3 L=0.28U W=0.36U AS=0.1584P AD=0.0972P
+ PS=1.6U PD=0.9U
M$4538 \$3155 \$3153 VSS VSS nfet_03v3 L=0.28U W=0.36U AS=0.0972P AD=0.18P
+ PS=0.9U PD=1.72U
M$4539 \$3158 \$89 VSS VSS nfet_03v3 L=0.28U W=0.36U AS=0.1584P AD=0.1188P
+ PS=1.6U PD=1.02U
M$4540 \$3159 \$3064 \$3158 VSS nfet_03v3 L=0.28U W=0.36U AS=0.1188P AD=0.1278P
+ PS=1.02U PD=1.07U
M$4541 \$3280 \$3160 \$3159 VSS nfet_03v3 L=0.28U W=0.36U AS=0.1278P AD=0.0567P
+ PS=1.07U PD=0.675U
M$4542 VSS \$3065 \$3280 VSS nfet_03v3 L=0.28U W=0.36U AS=0.0567P AD=0.1584P
+ PS=0.675U PD=1.6U
M$4543 VSS \$3159 \$3160 VSS nfet_03v3 L=0.28U W=0.36U AS=0.1584P AD=0.0972P
+ PS=1.6U PD=0.9U
M$4544 \$3161 \$3159 VSS VSS nfet_03v3 L=0.28U W=0.36U AS=0.0972P AD=0.18P
+ PS=0.9U PD=1.72U
M$4545 \$3514 WE5 VSS VSS nfet_03v3 L=0.28U W=0.72U AS=0.3168P AD=0.1872P
+ PS=2.32U PD=1.24U
M$4546 \$3365 CLK \$3514 VSS nfet_03v3 L=0.28U W=0.72U AS=0.1872P AD=0.3168P
+ PS=1.24U PD=2.32U
M$4547 \$3366 \$3365 VSS VSS nfet_03v3 L=0.28U W=1.27U AS=0.4445P AD=0.3344P
+ PS=3.305U PD=2.345U
M$4549 \$3367 \$3366 VSS VSS nfet_03v3 L=0.28U W=1.34U AS=0.3636P AD=0.4891P
+ PS=2.44U PD=3.47U
M$4551 \$3368 \$44 VSS VSS nfet_03v3 L=0.28U W=0.36U AS=0.1584P AD=0.1188P
+ PS=1.6U PD=1.02U
M$4552 \$3369 \$3366 \$3368 VSS nfet_03v3 L=0.28U W=0.36U AS=0.1188P AD=0.1278P
+ PS=1.02U PD=1.07U
M$4553 \$3436 \$3370 \$3369 VSS nfet_03v3 L=0.28U W=0.36U AS=0.1278P AD=0.0567P
+ PS=1.07U PD=0.675U
M$4554 VSS \$3367 \$3436 VSS nfet_03v3 L=0.28U W=0.36U AS=0.0567P AD=0.1584P
+ PS=0.675U PD=1.6U
M$4555 VSS \$3369 \$3370 VSS nfet_03v3 L=0.28U W=0.36U AS=0.1584P AD=0.0972P
+ PS=1.6U PD=0.9U
M$4556 \$3371 \$3369 VSS VSS nfet_03v3 L=0.28U W=0.36U AS=0.0972P AD=0.18P
+ PS=0.9U PD=1.72U
M$4557 \$3372 \$47 VSS VSS nfet_03v3 L=0.28U W=0.36U AS=0.1584P AD=0.1188P
+ PS=1.6U PD=1.02U
M$4558 \$3373 \$3366 \$3372 VSS nfet_03v3 L=0.28U W=0.36U AS=0.1188P AD=0.1278P
+ PS=1.02U PD=1.07U
M$4559 \$3445 \$3374 \$3373 VSS nfet_03v3 L=0.28U W=0.36U AS=0.1278P AD=0.0567P
+ PS=1.07U PD=0.675U
M$4560 VSS \$3367 \$3445 VSS nfet_03v3 L=0.28U W=0.36U AS=0.0567P AD=0.1584P
+ PS=0.675U PD=1.6U
M$4561 VSS \$3373 \$3374 VSS nfet_03v3 L=0.28U W=0.36U AS=0.1584P AD=0.0972P
+ PS=1.6U PD=0.9U
M$4562 \$3375 \$3373 VSS VSS nfet_03v3 L=0.28U W=0.36U AS=0.0972P AD=0.18P
+ PS=0.9U PD=1.72U
M$4563 \$3376 \$50 VSS VSS nfet_03v3 L=0.28U W=0.36U AS=0.1584P AD=0.1188P
+ PS=1.6U PD=1.02U
M$4564 \$3377 \$3366 \$3376 VSS nfet_03v3 L=0.28U W=0.36U AS=0.1188P AD=0.1278P
+ PS=1.02U PD=1.07U
M$4565 \$3453 \$3378 \$3377 VSS nfet_03v3 L=0.28U W=0.36U AS=0.1278P AD=0.0567P
+ PS=1.07U PD=0.675U
M$4566 VSS \$3367 \$3453 VSS nfet_03v3 L=0.28U W=0.36U AS=0.0567P AD=0.1584P
+ PS=0.675U PD=1.6U
M$4567 VSS \$3377 \$3378 VSS nfet_03v3 L=0.28U W=0.36U AS=0.1584P AD=0.0972P
+ PS=1.6U PD=0.9U
M$4568 \$3379 \$3377 VSS VSS nfet_03v3 L=0.28U W=0.36U AS=0.0972P AD=0.18P
+ PS=0.9U PD=1.72U
M$4569 \$3380 \$53 VSS VSS nfet_03v3 L=0.28U W=0.36U AS=0.1584P AD=0.1188P
+ PS=1.6U PD=1.02U
M$4570 \$3381 \$3366 \$3380 VSS nfet_03v3 L=0.28U W=0.36U AS=0.1188P AD=0.1278P
+ PS=1.02U PD=1.07U
M$4571 \$3462 \$3382 \$3381 VSS nfet_03v3 L=0.28U W=0.36U AS=0.1278P AD=0.0567P
+ PS=1.07U PD=0.675U
M$4572 VSS \$3367 \$3462 VSS nfet_03v3 L=0.28U W=0.36U AS=0.0567P AD=0.1584P
+ PS=0.675U PD=1.6U
M$4573 VSS \$3381 \$3382 VSS nfet_03v3 L=0.28U W=0.36U AS=0.1584P AD=0.0972P
+ PS=1.6U PD=0.9U
M$4574 \$3383 \$3381 VSS VSS nfet_03v3 L=0.28U W=0.36U AS=0.0972P AD=0.18P
+ PS=0.9U PD=1.72U
M$4575 \$3384 \$56 VSS VSS nfet_03v3 L=0.28U W=0.36U AS=0.1584P AD=0.1188P
+ PS=1.6U PD=1.02U
M$4576 \$3385 \$3366 \$3384 VSS nfet_03v3 L=0.28U W=0.36U AS=0.1188P AD=0.1278P
+ PS=1.02U PD=1.07U
M$4577 \$3469 \$3386 \$3385 VSS nfet_03v3 L=0.28U W=0.36U AS=0.1278P AD=0.0567P
+ PS=1.07U PD=0.675U
M$4578 VSS \$3367 \$3469 VSS nfet_03v3 L=0.28U W=0.36U AS=0.0567P AD=0.1584P
+ PS=0.675U PD=1.6U
M$4579 VSS \$3385 \$3386 VSS nfet_03v3 L=0.28U W=0.36U AS=0.1584P AD=0.0972P
+ PS=1.6U PD=0.9U
M$4580 \$3387 \$3385 VSS VSS nfet_03v3 L=0.28U W=0.36U AS=0.0972P AD=0.18P
+ PS=0.9U PD=1.72U
M$4581 \$3388 \$59 VSS VSS nfet_03v3 L=0.28U W=0.36U AS=0.1584P AD=0.1188P
+ PS=1.6U PD=1.02U
M$4582 \$3389 \$3366 \$3388 VSS nfet_03v3 L=0.28U W=0.36U AS=0.1188P AD=0.1278P
+ PS=1.02U PD=1.07U
M$4583 \$3477 \$3390 \$3389 VSS nfet_03v3 L=0.28U W=0.36U AS=0.1278P AD=0.0567P
+ PS=1.07U PD=0.675U
M$4584 VSS \$3367 \$3477 VSS nfet_03v3 L=0.28U W=0.36U AS=0.0567P AD=0.1584P
+ PS=0.675U PD=1.6U
M$4585 VSS \$3389 \$3390 VSS nfet_03v3 L=0.28U W=0.36U AS=0.1584P AD=0.0972P
+ PS=1.6U PD=0.9U
M$4586 \$3391 \$3389 VSS VSS nfet_03v3 L=0.28U W=0.36U AS=0.0972P AD=0.18P
+ PS=0.9U PD=1.72U
M$4587 \$3392 \$62 VSS VSS nfet_03v3 L=0.28U W=0.36U AS=0.1584P AD=0.1188P
+ PS=1.6U PD=1.02U
M$4588 \$3393 \$3366 \$3392 VSS nfet_03v3 L=0.28U W=0.36U AS=0.1188P AD=0.1278P
+ PS=1.02U PD=1.07U
M$4589 \$3476 \$3394 \$3393 VSS nfet_03v3 L=0.28U W=0.36U AS=0.1278P AD=0.0567P
+ PS=1.07U PD=0.675U
M$4590 VSS \$3367 \$3476 VSS nfet_03v3 L=0.28U W=0.36U AS=0.0567P AD=0.1584P
+ PS=0.675U PD=1.6U
M$4591 VSS \$3393 \$3394 VSS nfet_03v3 L=0.28U W=0.36U AS=0.1584P AD=0.0972P
+ PS=1.6U PD=0.9U
M$4592 \$3395 \$3393 VSS VSS nfet_03v3 L=0.28U W=0.36U AS=0.0972P AD=0.18P
+ PS=0.9U PD=1.72U
M$4593 \$3396 \$65 VSS VSS nfet_03v3 L=0.28U W=0.36U AS=0.1584P AD=0.1188P
+ PS=1.6U PD=1.02U
M$4594 \$3397 \$3366 \$3396 VSS nfet_03v3 L=0.28U W=0.36U AS=0.1188P AD=0.1278P
+ PS=1.02U PD=1.07U
M$4595 \$3473 \$3398 \$3397 VSS nfet_03v3 L=0.28U W=0.36U AS=0.1278P AD=0.0567P
+ PS=1.07U PD=0.675U
M$4596 VSS \$3367 \$3473 VSS nfet_03v3 L=0.28U W=0.36U AS=0.0567P AD=0.1584P
+ PS=0.675U PD=1.6U
M$4597 VSS \$3397 \$3398 VSS nfet_03v3 L=0.28U W=0.36U AS=0.1584P AD=0.0972P
+ PS=1.6U PD=0.9U
M$4598 \$3399 \$3397 VSS VSS nfet_03v3 L=0.28U W=0.36U AS=0.0972P AD=0.18P
+ PS=0.9U PD=1.72U
M$4599 \$3400 \$68 VSS VSS nfet_03v3 L=0.28U W=0.36U AS=0.1584P AD=0.1188P
+ PS=1.6U PD=1.02U
M$4600 \$3401 \$3366 \$3400 VSS nfet_03v3 L=0.28U W=0.36U AS=0.1188P AD=0.1278P
+ PS=1.02U PD=1.07U
M$4601 \$3467 \$3402 \$3401 VSS nfet_03v3 L=0.28U W=0.36U AS=0.1278P AD=0.0567P
+ PS=1.07U PD=0.675U
M$4602 VSS \$3367 \$3467 VSS nfet_03v3 L=0.28U W=0.36U AS=0.0567P AD=0.1584P
+ PS=0.675U PD=1.6U
M$4603 VSS \$3401 \$3402 VSS nfet_03v3 L=0.28U W=0.36U AS=0.1584P AD=0.0972P
+ PS=1.6U PD=0.9U
M$4604 \$3403 \$3401 VSS VSS nfet_03v3 L=0.28U W=0.36U AS=0.0972P AD=0.18P
+ PS=0.9U PD=1.72U
M$4605 \$3404 \$71 VSS VSS nfet_03v3 L=0.28U W=0.36U AS=0.1584P AD=0.1188P
+ PS=1.6U PD=1.02U
M$4606 \$3405 \$3366 \$3404 VSS nfet_03v3 L=0.28U W=0.36U AS=0.1188P AD=0.1278P
+ PS=1.02U PD=1.07U
M$4607 \$3461 \$3406 \$3405 VSS nfet_03v3 L=0.28U W=0.36U AS=0.1278P AD=0.0567P
+ PS=1.07U PD=0.675U
M$4608 VSS \$3367 \$3461 VSS nfet_03v3 L=0.28U W=0.36U AS=0.0567P AD=0.1584P
+ PS=0.675U PD=1.6U
M$4609 VSS \$3405 \$3406 VSS nfet_03v3 L=0.28U W=0.36U AS=0.1584P AD=0.0972P
+ PS=1.6U PD=0.9U
M$4610 \$3407 \$3405 VSS VSS nfet_03v3 L=0.28U W=0.36U AS=0.0972P AD=0.18P
+ PS=0.9U PD=1.72U
M$4611 \$3408 \$74 VSS VSS nfet_03v3 L=0.28U W=0.36U AS=0.1584P AD=0.1188P
+ PS=1.6U PD=1.02U
M$4612 \$3409 \$3366 \$3408 VSS nfet_03v3 L=0.28U W=0.36U AS=0.1188P AD=0.1278P
+ PS=1.02U PD=1.07U
M$4613 \$3458 \$3410 \$3409 VSS nfet_03v3 L=0.28U W=0.36U AS=0.1278P AD=0.0567P
+ PS=1.07U PD=0.675U
M$4614 VSS \$3367 \$3458 VSS nfet_03v3 L=0.28U W=0.36U AS=0.0567P AD=0.1584P
+ PS=0.675U PD=1.6U
M$4615 VSS \$3409 \$3410 VSS nfet_03v3 L=0.28U W=0.36U AS=0.1584P AD=0.0972P
+ PS=1.6U PD=0.9U
M$4616 \$3411 \$3409 VSS VSS nfet_03v3 L=0.28U W=0.36U AS=0.0972P AD=0.18P
+ PS=0.9U PD=1.72U
M$4617 \$3412 \$77 VSS VSS nfet_03v3 L=0.28U W=0.36U AS=0.1584P AD=0.1188P
+ PS=1.6U PD=1.02U
M$4618 \$3413 \$3366 \$3412 VSS nfet_03v3 L=0.28U W=0.36U AS=0.1188P AD=0.1278P
+ PS=1.02U PD=1.07U
M$4619 \$3452 \$3414 \$3413 VSS nfet_03v3 L=0.28U W=0.36U AS=0.1278P AD=0.0567P
+ PS=1.07U PD=0.675U
M$4620 VSS \$3367 \$3452 VSS nfet_03v3 L=0.28U W=0.36U AS=0.0567P AD=0.1584P
+ PS=0.675U PD=1.6U
M$4621 VSS \$3413 \$3414 VSS nfet_03v3 L=0.28U W=0.36U AS=0.1584P AD=0.0972P
+ PS=1.6U PD=0.9U
M$4622 \$3415 \$3413 VSS VSS nfet_03v3 L=0.28U W=0.36U AS=0.0972P AD=0.18P
+ PS=0.9U PD=1.72U
M$4623 \$3416 \$80 VSS VSS nfet_03v3 L=0.28U W=0.36U AS=0.1584P AD=0.1188P
+ PS=1.6U PD=1.02U
M$4624 \$3417 \$3366 \$3416 VSS nfet_03v3 L=0.28U W=0.36U AS=0.1188P AD=0.1278P
+ PS=1.02U PD=1.07U
M$4625 \$3449 \$3418 \$3417 VSS nfet_03v3 L=0.28U W=0.36U AS=0.1278P AD=0.0567P
+ PS=1.07U PD=0.675U
M$4626 VSS \$3367 \$3449 VSS nfet_03v3 L=0.28U W=0.36U AS=0.0567P AD=0.1584P
+ PS=0.675U PD=1.6U
M$4627 VSS \$3417 \$3418 VSS nfet_03v3 L=0.28U W=0.36U AS=0.1584P AD=0.0972P
+ PS=1.6U PD=0.9U
M$4628 \$3419 \$3417 VSS VSS nfet_03v3 L=0.28U W=0.36U AS=0.0972P AD=0.18P
+ PS=0.9U PD=1.72U
M$4629 \$3420 \$83 VSS VSS nfet_03v3 L=0.28U W=0.36U AS=0.1584P AD=0.1188P
+ PS=1.6U PD=1.02U
M$4630 \$3421 \$3366 \$3420 VSS nfet_03v3 L=0.28U W=0.36U AS=0.1188P AD=0.1278P
+ PS=1.02U PD=1.07U
M$4631 \$3443 \$3422 \$3421 VSS nfet_03v3 L=0.28U W=0.36U AS=0.1278P AD=0.0567P
+ PS=1.07U PD=0.675U
M$4632 VSS \$3367 \$3443 VSS nfet_03v3 L=0.28U W=0.36U AS=0.0567P AD=0.1584P
+ PS=0.675U PD=1.6U
M$4633 VSS \$3421 \$3422 VSS nfet_03v3 L=0.28U W=0.36U AS=0.1584P AD=0.0972P
+ PS=1.6U PD=0.9U
M$4634 \$3423 \$3421 VSS VSS nfet_03v3 L=0.28U W=0.36U AS=0.0972P AD=0.18P
+ PS=0.9U PD=1.72U
M$4635 \$3424 \$86 VSS VSS nfet_03v3 L=0.28U W=0.36U AS=0.1584P AD=0.1188P
+ PS=1.6U PD=1.02U
M$4636 \$3425 \$3366 \$3424 VSS nfet_03v3 L=0.28U W=0.36U AS=0.1188P AD=0.1278P
+ PS=1.02U PD=1.07U
M$4637 \$3439 \$3426 \$3425 VSS nfet_03v3 L=0.28U W=0.36U AS=0.1278P AD=0.0567P
+ PS=1.07U PD=0.675U
M$4638 VSS \$3367 \$3439 VSS nfet_03v3 L=0.28U W=0.36U AS=0.0567P AD=0.1584P
+ PS=0.675U PD=1.6U
M$4639 VSS \$3425 \$3426 VSS nfet_03v3 L=0.28U W=0.36U AS=0.1584P AD=0.0972P
+ PS=1.6U PD=0.9U
M$4640 \$3427 \$3425 VSS VSS nfet_03v3 L=0.28U W=0.36U AS=0.0972P AD=0.18P
+ PS=0.9U PD=1.72U
M$4641 \$3428 \$89 VSS VSS nfet_03v3 L=0.28U W=0.36U AS=0.1584P AD=0.1188P
+ PS=1.6U PD=1.02U
M$4642 \$3429 \$3366 \$3428 VSS nfet_03v3 L=0.28U W=0.36U AS=0.1188P AD=0.1278P
+ PS=1.02U PD=1.07U
M$4643 \$3434 \$3430 \$3429 VSS nfet_03v3 L=0.28U W=0.36U AS=0.1278P AD=0.0567P
+ PS=1.07U PD=0.675U
M$4644 VSS \$3367 \$3434 VSS nfet_03v3 L=0.28U W=0.36U AS=0.0567P AD=0.1584P
+ PS=0.675U PD=1.6U
M$4645 VSS \$3429 \$3430 VSS nfet_03v3 L=0.28U W=0.36U AS=0.1584P AD=0.0972P
+ PS=1.6U PD=0.9U
M$4646 \$3431 \$3429 VSS VSS nfet_03v3 L=0.28U W=0.36U AS=0.0972P AD=0.18P
+ PS=0.9U PD=1.72U
M$4647 \$3482 RA5 VSS VSS nfet_03v3 L=0.28U W=0.36U AS=0.1656P AD=0.1944P
+ PS=1.64U PD=1.8U
M$4648 \$3685 RB4 VSS VSS nfet_03v3 L=0.28U W=0.36U AS=0.1656P AD=0.1944P
+ PS=1.64U PD=1.8U
M$4649 \$3684 RB4 \$360 VSS nfet_03v3 L=0.28U W=0.36U AS=0.1584P AD=0.1152P
+ PS=1.6U PD=1U
M$4650 \$361 RA4 \$3684 VSS nfet_03v3 L=0.28U W=0.36U AS=0.1152P AD=0.1584P
+ PS=1U PD=1.6U
M$4651 \$3371 RA5 \$360 VSS nfet_03v3 L=0.28U W=0.36U AS=0.1584P AD=0.1152P
+ PS=1.6U PD=1U
M$4652 \$361 RB5 \$3371 VSS nfet_03v3 L=0.28U W=0.36U AS=0.1152P AD=0.1584P
+ PS=1U PD=1.6U
M$4653 VSS RA4 \$3686 VSS nfet_03v3 L=0.28U W=0.36U AS=0.1854P AD=0.1584P
+ PS=1.75U PD=1.6U
M$4654 VSS RB5 \$3483 VSS nfet_03v3 L=0.28U W=0.36U AS=0.1854P AD=0.1584P
+ PS=1.75U PD=1.6U
M$4655 \$3484 RA5 VSS VSS nfet_03v3 L=0.28U W=0.36U AS=0.1656P AD=0.1944P
+ PS=1.64U PD=1.8U
M$4656 \$3691 RB4 VSS VSS nfet_03v3 L=0.28U W=0.36U AS=0.1656P AD=0.1944P
+ PS=1.64U PD=1.8U
M$4657 \$3375 RA5 \$365 VSS nfet_03v3 L=0.28U W=0.36U AS=0.1584P AD=0.1152P
+ PS=1.6U PD=1U
M$4658 \$366 RB5 \$3375 VSS nfet_03v3 L=0.28U W=0.36U AS=0.1152P AD=0.1584P
+ PS=1U PD=1.6U
M$4659 \$3690 RB4 \$365 VSS nfet_03v3 L=0.28U W=0.36U AS=0.1584P AD=0.1152P
+ PS=1.6U PD=1U
M$4660 \$366 RA4 \$3690 VSS nfet_03v3 L=0.28U W=0.36U AS=0.1152P AD=0.1584P
+ PS=1U PD=1.6U
M$4661 VSS RA4 \$3692 VSS nfet_03v3 L=0.28U W=0.36U AS=0.1854P AD=0.1584P
+ PS=1.75U PD=1.6U
M$4662 VSS RB5 \$3485 VSS nfet_03v3 L=0.28U W=0.36U AS=0.1854P AD=0.1584P
+ PS=1.75U PD=1.6U
M$4663 \$3486 RA5 VSS VSS nfet_03v3 L=0.28U W=0.36U AS=0.1656P AD=0.1944P
+ PS=1.64U PD=1.8U
M$4664 \$3697 RB4 VSS VSS nfet_03v3 L=0.28U W=0.36U AS=0.1656P AD=0.1944P
+ PS=1.64U PD=1.8U
M$4665 \$3379 RA5 \$370 VSS nfet_03v3 L=0.28U W=0.36U AS=0.1584P AD=0.1152P
+ PS=1.6U PD=1U
M$4666 \$371 RB5 \$3379 VSS nfet_03v3 L=0.28U W=0.36U AS=0.1152P AD=0.1584P
+ PS=1U PD=1.6U
M$4667 \$3696 RB4 \$370 VSS nfet_03v3 L=0.28U W=0.36U AS=0.1584P AD=0.1152P
+ PS=1.6U PD=1U
M$4668 \$371 RA4 \$3696 VSS nfet_03v3 L=0.28U W=0.36U AS=0.1152P AD=0.1584P
+ PS=1U PD=1.6U
M$4669 VSS RA4 \$3698 VSS nfet_03v3 L=0.28U W=0.36U AS=0.1854P AD=0.1584P
+ PS=1.75U PD=1.6U
M$4670 VSS RB5 \$3487 VSS nfet_03v3 L=0.28U W=0.36U AS=0.1854P AD=0.1584P
+ PS=1.75U PD=1.6U
M$4671 \$3488 RA5 VSS VSS nfet_03v3 L=0.28U W=0.36U AS=0.1656P AD=0.1944P
+ PS=1.64U PD=1.8U
M$4672 \$3703 RB4 VSS VSS nfet_03v3 L=0.28U W=0.36U AS=0.1656P AD=0.1944P
+ PS=1.64U PD=1.8U
M$4673 \$3383 RA5 \$375 VSS nfet_03v3 L=0.28U W=0.36U AS=0.1584P AD=0.1152P
+ PS=1.6U PD=1U
M$4674 \$376 RB5 \$3383 VSS nfet_03v3 L=0.28U W=0.36U AS=0.1152P AD=0.1584P
+ PS=1U PD=1.6U
M$4675 \$3702 RB4 \$375 VSS nfet_03v3 L=0.28U W=0.36U AS=0.1584P AD=0.1152P
+ PS=1.6U PD=1U
M$4676 \$376 RA4 \$3702 VSS nfet_03v3 L=0.28U W=0.36U AS=0.1152P AD=0.1584P
+ PS=1U PD=1.6U
M$4677 VSS RA4 \$3704 VSS nfet_03v3 L=0.28U W=0.36U AS=0.1854P AD=0.1584P
+ PS=1.75U PD=1.6U
M$4678 VSS RB5 \$3489 VSS nfet_03v3 L=0.28U W=0.36U AS=0.1854P AD=0.1584P
+ PS=1.75U PD=1.6U
M$4679 \$3490 RA5 VSS VSS nfet_03v3 L=0.28U W=0.36U AS=0.1656P AD=0.1944P
+ PS=1.64U PD=1.8U
M$4680 \$3709 RB4 VSS VSS nfet_03v3 L=0.28U W=0.36U AS=0.1656P AD=0.1944P
+ PS=1.64U PD=1.8U
M$4681 \$3387 RA5 \$380 VSS nfet_03v3 L=0.28U W=0.36U AS=0.1584P AD=0.1152P
+ PS=1.6U PD=1U
M$4682 \$381 RB5 \$3387 VSS nfet_03v3 L=0.28U W=0.36U AS=0.1152P AD=0.1584P
+ PS=1U PD=1.6U
M$4683 \$3708 RB4 \$380 VSS nfet_03v3 L=0.28U W=0.36U AS=0.1584P AD=0.1152P
+ PS=1.6U PD=1U
M$4684 \$381 RA4 \$3708 VSS nfet_03v3 L=0.28U W=0.36U AS=0.1152P AD=0.1584P
+ PS=1U PD=1.6U
M$4685 VSS RA4 \$3710 VSS nfet_03v3 L=0.28U W=0.36U AS=0.1854P AD=0.1584P
+ PS=1.75U PD=1.6U
M$4686 VSS RB5 \$3491 VSS nfet_03v3 L=0.28U W=0.36U AS=0.1854P AD=0.1584P
+ PS=1.75U PD=1.6U
M$4687 \$3715 RB4 VSS VSS nfet_03v3 L=0.28U W=0.36U AS=0.1656P AD=0.1944P
+ PS=1.64U PD=1.8U
M$4688 \$3492 RA5 VSS VSS nfet_03v3 L=0.28U W=0.36U AS=0.1656P AD=0.1944P
+ PS=1.64U PD=1.8U
M$4689 \$3391 RA5 \$385 VSS nfet_03v3 L=0.28U W=0.36U AS=0.1584P AD=0.1152P
+ PS=1.6U PD=1U
M$4690 \$386 RB5 \$3391 VSS nfet_03v3 L=0.28U W=0.36U AS=0.1152P AD=0.1584P
+ PS=1U PD=1.6U
M$4691 \$3714 RB4 \$385 VSS nfet_03v3 L=0.28U W=0.36U AS=0.1584P AD=0.1152P
+ PS=1.6U PD=1U
M$4692 \$386 RA4 \$3714 VSS nfet_03v3 L=0.28U W=0.36U AS=0.1152P AD=0.1584P
+ PS=1U PD=1.6U
M$4693 VSS RA4 \$3716 VSS nfet_03v3 L=0.28U W=0.36U AS=0.1854P AD=0.1584P
+ PS=1.75U PD=1.6U
M$4694 VSS RB5 \$3493 VSS nfet_03v3 L=0.28U W=0.36U AS=0.1854P AD=0.1584P
+ PS=1.75U PD=1.6U
M$4695 \$3494 RA5 VSS VSS nfet_03v3 L=0.28U W=0.36U AS=0.1656P AD=0.1944P
+ PS=1.64U PD=1.8U
M$4696 \$3721 RB4 VSS VSS nfet_03v3 L=0.28U W=0.36U AS=0.1656P AD=0.1944P
+ PS=1.64U PD=1.8U
M$4697 \$3720 RB4 \$390 VSS nfet_03v3 L=0.28U W=0.36U AS=0.1584P AD=0.1152P
+ PS=1.6U PD=1U
M$4698 \$391 RA4 \$3720 VSS nfet_03v3 L=0.28U W=0.36U AS=0.1152P AD=0.1584P
+ PS=1U PD=1.6U
M$4699 \$3395 RA5 \$390 VSS nfet_03v3 L=0.28U W=0.36U AS=0.1584P AD=0.1152P
+ PS=1.6U PD=1U
M$4700 \$391 RB5 \$3395 VSS nfet_03v3 L=0.28U W=0.36U AS=0.1152P AD=0.1584P
+ PS=1U PD=1.6U
M$4701 VSS RA4 \$3722 VSS nfet_03v3 L=0.28U W=0.36U AS=0.1854P AD=0.1584P
+ PS=1.75U PD=1.6U
M$4702 VSS RB5 \$3495 VSS nfet_03v3 L=0.28U W=0.36U AS=0.1854P AD=0.1584P
+ PS=1.75U PD=1.6U
M$4703 \$3727 RB4 VSS VSS nfet_03v3 L=0.28U W=0.36U AS=0.1656P AD=0.1944P
+ PS=1.64U PD=1.8U
M$4704 \$3496 RA5 VSS VSS nfet_03v3 L=0.28U W=0.36U AS=0.1656P AD=0.1944P
+ PS=1.64U PD=1.8U
M$4705 \$3726 RB4 \$395 VSS nfet_03v3 L=0.28U W=0.36U AS=0.1584P AD=0.1152P
+ PS=1.6U PD=1U
M$4706 \$396 RA4 \$3726 VSS nfet_03v3 L=0.28U W=0.36U AS=0.1152P AD=0.1584P
+ PS=1U PD=1.6U
M$4707 \$3399 RA5 \$395 VSS nfet_03v3 L=0.28U W=0.36U AS=0.1584P AD=0.1152P
+ PS=1.6U PD=1U
M$4708 \$396 RB5 \$3399 VSS nfet_03v3 L=0.28U W=0.36U AS=0.1152P AD=0.1584P
+ PS=1U PD=1.6U
M$4709 VSS RA4 \$3728 VSS nfet_03v3 L=0.28U W=0.36U AS=0.1854P AD=0.1584P
+ PS=1.75U PD=1.6U
M$4710 VSS RB5 \$3497 VSS nfet_03v3 L=0.28U W=0.36U AS=0.1854P AD=0.1584P
+ PS=1.75U PD=1.6U
M$4711 \$3498 RA5 VSS VSS nfet_03v3 L=0.28U W=0.36U AS=0.1656P AD=0.1944P
+ PS=1.64U PD=1.8U
M$4712 \$3733 RB4 VSS VSS nfet_03v3 L=0.28U W=0.36U AS=0.1656P AD=0.1944P
+ PS=1.64U PD=1.8U
M$4713 \$3732 RB4 \$400 VSS nfet_03v3 L=0.28U W=0.36U AS=0.1584P AD=0.1152P
+ PS=1.6U PD=1U
M$4714 \$401 RA4 \$3732 VSS nfet_03v3 L=0.28U W=0.36U AS=0.1152P AD=0.1584P
+ PS=1U PD=1.6U
M$4715 \$3403 RA5 \$400 VSS nfet_03v3 L=0.28U W=0.36U AS=0.1584P AD=0.1152P
+ PS=1.6U PD=1U
M$4716 \$401 RB5 \$3403 VSS nfet_03v3 L=0.28U W=0.36U AS=0.1152P AD=0.1584P
+ PS=1U PD=1.6U
M$4717 VSS RB5 \$3499 VSS nfet_03v3 L=0.28U W=0.36U AS=0.1854P AD=0.1584P
+ PS=1.75U PD=1.6U
M$4718 VSS RA4 \$3734 VSS nfet_03v3 L=0.28U W=0.36U AS=0.1854P AD=0.1584P
+ PS=1.75U PD=1.6U
M$4719 \$3500 RA5 VSS VSS nfet_03v3 L=0.28U W=0.36U AS=0.1656P AD=0.1944P
+ PS=1.64U PD=1.8U
M$4720 \$3739 RB4 VSS VSS nfet_03v3 L=0.28U W=0.36U AS=0.1656P AD=0.1944P
+ PS=1.64U PD=1.8U
M$4721 \$3738 RB4 \$405 VSS nfet_03v3 L=0.28U W=0.36U AS=0.1584P AD=0.1152P
+ PS=1.6U PD=1U
M$4722 \$406 RA4 \$3738 VSS nfet_03v3 L=0.28U W=0.36U AS=0.1152P AD=0.1584P
+ PS=1U PD=1.6U
M$4723 \$3407 RA5 \$405 VSS nfet_03v3 L=0.28U W=0.36U AS=0.1584P AD=0.1152P
+ PS=1.6U PD=1U
M$4724 \$406 RB5 \$3407 VSS nfet_03v3 L=0.28U W=0.36U AS=0.1152P AD=0.1584P
+ PS=1U PD=1.6U
M$4725 VSS RA4 \$3740 VSS nfet_03v3 L=0.28U W=0.36U AS=0.1854P AD=0.1584P
+ PS=1.75U PD=1.6U
M$4726 VSS RB5 \$3501 VSS nfet_03v3 L=0.28U W=0.36U AS=0.1854P AD=0.1584P
+ PS=1.75U PD=1.6U
M$4727 \$3502 RA5 VSS VSS nfet_03v3 L=0.28U W=0.36U AS=0.1656P AD=0.1944P
+ PS=1.64U PD=1.8U
M$4728 \$3745 RB4 VSS VSS nfet_03v3 L=0.28U W=0.36U AS=0.1656P AD=0.1944P
+ PS=1.64U PD=1.8U
M$4729 \$3411 RA5 \$410 VSS nfet_03v3 L=0.28U W=0.36U AS=0.1584P AD=0.1152P
+ PS=1.6U PD=1U
M$4730 \$411 RB5 \$3411 VSS nfet_03v3 L=0.28U W=0.36U AS=0.1152P AD=0.1584P
+ PS=1U PD=1.6U
M$4731 \$3744 RB4 \$410 VSS nfet_03v3 L=0.28U W=0.36U AS=0.1584P AD=0.1152P
+ PS=1.6U PD=1U
M$4732 \$411 RA4 \$3744 VSS nfet_03v3 L=0.28U W=0.36U AS=0.1152P AD=0.1584P
+ PS=1U PD=1.6U
M$4733 VSS RA4 \$3746 VSS nfet_03v3 L=0.28U W=0.36U AS=0.1854P AD=0.1584P
+ PS=1.75U PD=1.6U
M$4734 VSS RB5 \$3503 VSS nfet_03v3 L=0.28U W=0.36U AS=0.1854P AD=0.1584P
+ PS=1.75U PD=1.6U
M$4735 \$3504 RA5 VSS VSS nfet_03v3 L=0.28U W=0.36U AS=0.1656P AD=0.1944P
+ PS=1.64U PD=1.8U
M$4736 \$3751 RB4 VSS VSS nfet_03v3 L=0.28U W=0.36U AS=0.1656P AD=0.1944P
+ PS=1.64U PD=1.8U
M$4737 \$3750 RB4 \$415 VSS nfet_03v3 L=0.28U W=0.36U AS=0.1584P AD=0.1152P
+ PS=1.6U PD=1U
M$4738 \$416 RA4 \$3750 VSS nfet_03v3 L=0.28U W=0.36U AS=0.1152P AD=0.1584P
+ PS=1U PD=1.6U
M$4739 \$3415 RA5 \$415 VSS nfet_03v3 L=0.28U W=0.36U AS=0.1584P AD=0.1152P
+ PS=1.6U PD=1U
M$4740 \$416 RB5 \$3415 VSS nfet_03v3 L=0.28U W=0.36U AS=0.1152P AD=0.1584P
+ PS=1U PD=1.6U
M$4741 VSS RB5 \$3505 VSS nfet_03v3 L=0.28U W=0.36U AS=0.1854P AD=0.1584P
+ PS=1.75U PD=1.6U
M$4742 VSS RA4 \$3752 VSS nfet_03v3 L=0.28U W=0.36U AS=0.1854P AD=0.1584P
+ PS=1.75U PD=1.6U
M$4743 \$3757 RB4 VSS VSS nfet_03v3 L=0.28U W=0.36U AS=0.1656P AD=0.1944P
+ PS=1.64U PD=1.8U
M$4744 \$3506 RA5 VSS VSS nfet_03v3 L=0.28U W=0.36U AS=0.1656P AD=0.1944P
+ PS=1.64U PD=1.8U
M$4745 \$3756 RB4 \$420 VSS nfet_03v3 L=0.28U W=0.36U AS=0.1584P AD=0.1152P
+ PS=1.6U PD=1U
M$4746 \$421 RA4 \$3756 VSS nfet_03v3 L=0.28U W=0.36U AS=0.1152P AD=0.1584P
+ PS=1U PD=1.6U
M$4747 \$3419 RA5 \$420 VSS nfet_03v3 L=0.28U W=0.36U AS=0.1584P AD=0.1152P
+ PS=1.6U PD=1U
M$4748 \$421 RB5 \$3419 VSS nfet_03v3 L=0.28U W=0.36U AS=0.1152P AD=0.1584P
+ PS=1U PD=1.6U
M$4749 VSS RB5 \$3507 VSS nfet_03v3 L=0.28U W=0.36U AS=0.1854P AD=0.1584P
+ PS=1.75U PD=1.6U
M$4750 VSS RA4 \$3758 VSS nfet_03v3 L=0.28U W=0.36U AS=0.1854P AD=0.1584P
+ PS=1.75U PD=1.6U
M$4751 \$3508 RA5 VSS VSS nfet_03v3 L=0.28U W=0.36U AS=0.1656P AD=0.1944P
+ PS=1.64U PD=1.8U
M$4752 \$3763 RB4 VSS VSS nfet_03v3 L=0.28U W=0.36U AS=0.1656P AD=0.1944P
+ PS=1.64U PD=1.8U
M$4753 \$3762 RB4 \$425 VSS nfet_03v3 L=0.28U W=0.36U AS=0.1584P AD=0.1152P
+ PS=1.6U PD=1U
M$4754 \$426 RA4 \$3762 VSS nfet_03v3 L=0.28U W=0.36U AS=0.1152P AD=0.1584P
+ PS=1U PD=1.6U
M$4755 \$3423 RA5 \$425 VSS nfet_03v3 L=0.28U W=0.36U AS=0.1584P AD=0.1152P
+ PS=1.6U PD=1U
M$4756 \$426 RB5 \$3423 VSS nfet_03v3 L=0.28U W=0.36U AS=0.1152P AD=0.1584P
+ PS=1U PD=1.6U
M$4757 VSS RA4 \$3764 VSS nfet_03v3 L=0.28U W=0.36U AS=0.1854P AD=0.1584P
+ PS=1.75U PD=1.6U
M$4758 VSS RB5 \$3509 VSS nfet_03v3 L=0.28U W=0.36U AS=0.1854P AD=0.1584P
+ PS=1.75U PD=1.6U
M$4759 \$3510 RA5 VSS VSS nfet_03v3 L=0.28U W=0.36U AS=0.1656P AD=0.1944P
+ PS=1.64U PD=1.8U
M$4760 \$3769 RB4 VSS VSS nfet_03v3 L=0.28U W=0.36U AS=0.1656P AD=0.1944P
+ PS=1.64U PD=1.8U
M$4761 \$3427 RA5 \$430 VSS nfet_03v3 L=0.28U W=0.36U AS=0.1584P AD=0.1152P
+ PS=1.6U PD=1U
M$4762 \$431 RB5 \$3427 VSS nfet_03v3 L=0.28U W=0.36U AS=0.1152P AD=0.1584P
+ PS=1U PD=1.6U
M$4763 \$3768 RB4 \$430 VSS nfet_03v3 L=0.28U W=0.36U AS=0.1584P AD=0.1152P
+ PS=1.6U PD=1U
M$4764 \$431 RA4 \$3768 VSS nfet_03v3 L=0.28U W=0.36U AS=0.1152P AD=0.1584P
+ PS=1U PD=1.6U
M$4765 VSS RA4 \$3770 VSS nfet_03v3 L=0.28U W=0.36U AS=0.1854P AD=0.1584P
+ PS=1.75U PD=1.6U
M$4766 VSS RB5 \$3511 VSS nfet_03v3 L=0.28U W=0.36U AS=0.1854P AD=0.1584P
+ PS=1.75U PD=1.6U
M$4767 \$3775 RB4 VSS VSS nfet_03v3 L=0.28U W=0.36U AS=0.1656P AD=0.1944P
+ PS=1.64U PD=1.8U
M$4768 \$3512 RA5 VSS VSS nfet_03v3 L=0.28U W=0.36U AS=0.1656P AD=0.1944P
+ PS=1.64U PD=1.8U
M$4769 \$3774 RB4 \$435 VSS nfet_03v3 L=0.28U W=0.36U AS=0.1584P AD=0.1152P
+ PS=1.6U PD=1U
M$4770 \$436 RA4 \$3774 VSS nfet_03v3 L=0.28U W=0.36U AS=0.1152P AD=0.1584P
+ PS=1U PD=1.6U
M$4771 \$3431 RA5 \$435 VSS nfet_03v3 L=0.28U W=0.36U AS=0.1584P AD=0.1152P
+ PS=1.6U PD=1U
M$4772 \$436 RB5 \$3431 VSS nfet_03v3 L=0.28U W=0.36U AS=0.1152P AD=0.1584P
+ PS=1U PD=1.6U
M$4773 VSS RA4 \$3776 VSS nfet_03v3 L=0.28U W=0.36U AS=0.1854P AD=0.1584P
+ PS=1.75U PD=1.6U
M$4774 VSS RB5 \$3513 VSS nfet_03v3 L=0.28U W=0.36U AS=0.1854P AD=0.1584P
+ PS=1.75U PD=1.6U
M$4775 \$3880 WE4 VSS VSS nfet_03v3 L=0.28U W=0.72U AS=0.3168P AD=0.1872P
+ PS=2.32U PD=1.24U
M$4776 \$3675 CLK \$3880 VSS nfet_03v3 L=0.28U W=0.72U AS=0.1872P AD=0.3168P
+ PS=1.24U PD=2.32U
M$4777 \$3677 \$3675 VSS VSS nfet_03v3 L=0.28U W=1.27U AS=0.4487P AD=0.3302P
+ PS=3.34U PD=2.31U
M$4779 \$3678 \$3677 VSS VSS nfet_03v3 L=0.28U W=1.34U AS=0.3636P AD=0.4891P
+ PS=2.44U PD=3.47U
M$4781 \$3681 \$44 VSS VSS nfet_03v3 L=0.28U W=0.36U AS=0.1584P AD=0.1188P
+ PS=1.6U PD=1.02U
M$4782 \$3682 \$3677 \$3681 VSS nfet_03v3 L=0.28U W=0.36U AS=0.1188P AD=0.1278P
+ PS=1.02U PD=1.07U
M$4783 \$3885 \$3683 \$3682 VSS nfet_03v3 L=0.28U W=0.36U AS=0.1278P AD=0.0567P
+ PS=1.07U PD=0.675U
M$4784 VSS \$3678 \$3885 VSS nfet_03v3 L=0.28U W=0.36U AS=0.0567P AD=0.1584P
+ PS=0.675U PD=1.6U
M$4785 VSS \$3682 \$3683 VSS nfet_03v3 L=0.28U W=0.36U AS=0.1584P AD=0.0972P
+ PS=1.6U PD=0.9U
M$4786 \$3684 \$3682 VSS VSS nfet_03v3 L=0.28U W=0.36U AS=0.0972P AD=0.18P
+ PS=0.9U PD=1.72U
M$4787 \$3687 \$47 VSS VSS nfet_03v3 L=0.28U W=0.36U AS=0.1584P AD=0.1188P
+ PS=1.6U PD=1.02U
M$4788 \$3688 \$3677 \$3687 VSS nfet_03v3 L=0.28U W=0.36U AS=0.1188P AD=0.1278P
+ PS=1.02U PD=1.07U
M$4789 \$3894 \$3689 \$3688 VSS nfet_03v3 L=0.28U W=0.36U AS=0.1278P AD=0.0567P
+ PS=1.07U PD=0.675U
M$4790 VSS \$3678 \$3894 VSS nfet_03v3 L=0.28U W=0.36U AS=0.0567P AD=0.1584P
+ PS=0.675U PD=1.6U
M$4791 VSS \$3688 \$3689 VSS nfet_03v3 L=0.28U W=0.36U AS=0.1584P AD=0.0972P
+ PS=1.6U PD=0.9U
M$4792 \$3690 \$3688 VSS VSS nfet_03v3 L=0.28U W=0.36U AS=0.0972P AD=0.18P
+ PS=0.9U PD=1.72U
M$4793 \$3693 \$50 VSS VSS nfet_03v3 L=0.28U W=0.36U AS=0.1584P AD=0.1188P
+ PS=1.6U PD=1.02U
M$4794 \$3694 \$3677 \$3693 VSS nfet_03v3 L=0.28U W=0.36U AS=0.1188P AD=0.1278P
+ PS=1.02U PD=1.07U
M$4795 \$3901 \$3695 \$3694 VSS nfet_03v3 L=0.28U W=0.36U AS=0.1278P AD=0.0567P
+ PS=1.07U PD=0.675U
M$4796 VSS \$3678 \$3901 VSS nfet_03v3 L=0.28U W=0.36U AS=0.0567P AD=0.1584P
+ PS=0.675U PD=1.6U
M$4797 VSS \$3694 \$3695 VSS nfet_03v3 L=0.28U W=0.36U AS=0.1584P AD=0.0972P
+ PS=1.6U PD=0.9U
M$4798 \$3696 \$3694 VSS VSS nfet_03v3 L=0.28U W=0.36U AS=0.0972P AD=0.18P
+ PS=0.9U PD=1.72U
M$4799 \$3699 \$53 VSS VSS nfet_03v3 L=0.28U W=0.36U AS=0.1584P AD=0.1188P
+ PS=1.6U PD=1.02U
M$4800 \$3700 \$3677 \$3699 VSS nfet_03v3 L=0.28U W=0.36U AS=0.1188P AD=0.1278P
+ PS=1.02U PD=1.07U
M$4801 \$3909 \$3701 \$3700 VSS nfet_03v3 L=0.28U W=0.36U AS=0.1278P AD=0.0567P
+ PS=1.07U PD=0.675U
M$4802 VSS \$3678 \$3909 VSS nfet_03v3 L=0.28U W=0.36U AS=0.0567P AD=0.1584P
+ PS=0.675U PD=1.6U
M$4803 VSS \$3700 \$3701 VSS nfet_03v3 L=0.28U W=0.36U AS=0.1584P AD=0.0972P
+ PS=1.6U PD=0.9U
M$4804 \$3702 \$3700 VSS VSS nfet_03v3 L=0.28U W=0.36U AS=0.0972P AD=0.18P
+ PS=0.9U PD=1.72U
M$4805 \$3705 \$56 VSS VSS nfet_03v3 L=0.28U W=0.36U AS=0.1584P AD=0.1188P
+ PS=1.6U PD=1.02U
M$4806 \$3706 \$3677 \$3705 VSS nfet_03v3 L=0.28U W=0.36U AS=0.1188P AD=0.1278P
+ PS=1.02U PD=1.07U
M$4807 \$3918 \$3707 \$3706 VSS nfet_03v3 L=0.28U W=0.36U AS=0.1278P AD=0.0567P
+ PS=1.07U PD=0.675U
M$4808 VSS \$3678 \$3918 VSS nfet_03v3 L=0.28U W=0.36U AS=0.0567P AD=0.1584P
+ PS=0.675U PD=1.6U
M$4809 VSS \$3706 \$3707 VSS nfet_03v3 L=0.28U W=0.36U AS=0.1584P AD=0.0972P
+ PS=1.6U PD=0.9U
M$4810 \$3708 \$3706 VSS VSS nfet_03v3 L=0.28U W=0.36U AS=0.0972P AD=0.18P
+ PS=0.9U PD=1.72U
M$4811 \$3711 \$59 VSS VSS nfet_03v3 L=0.28U W=0.36U AS=0.1584P AD=0.1188P
+ PS=1.6U PD=1.02U
M$4812 \$3712 \$3677 \$3711 VSS nfet_03v3 L=0.28U W=0.36U AS=0.1188P AD=0.1278P
+ PS=1.02U PD=1.07U
M$4813 \$3924 \$3713 \$3712 VSS nfet_03v3 L=0.28U W=0.36U AS=0.1278P AD=0.0567P
+ PS=1.07U PD=0.675U
M$4814 VSS \$3678 \$3924 VSS nfet_03v3 L=0.28U W=0.36U AS=0.0567P AD=0.1584P
+ PS=0.675U PD=1.6U
M$4815 VSS \$3712 \$3713 VSS nfet_03v3 L=0.28U W=0.36U AS=0.1584P AD=0.0972P
+ PS=1.6U PD=0.9U
M$4816 \$3714 \$3712 VSS VSS nfet_03v3 L=0.28U W=0.36U AS=0.0972P AD=0.18P
+ PS=0.9U PD=1.72U
M$4817 \$3717 \$62 VSS VSS nfet_03v3 L=0.28U W=0.36U AS=0.1584P AD=0.1188P
+ PS=1.6U PD=1.02U
M$4818 \$3718 \$3677 \$3717 VSS nfet_03v3 L=0.28U W=0.36U AS=0.1188P AD=0.1278P
+ PS=1.02U PD=1.07U
M$4819 \$3933 \$3719 \$3718 VSS nfet_03v3 L=0.28U W=0.36U AS=0.1278P AD=0.0567P
+ PS=1.07U PD=0.675U
M$4820 VSS \$3678 \$3933 VSS nfet_03v3 L=0.28U W=0.36U AS=0.0567P AD=0.1584P
+ PS=0.675U PD=1.6U
M$4821 VSS \$3718 \$3719 VSS nfet_03v3 L=0.28U W=0.36U AS=0.1584P AD=0.0972P
+ PS=1.6U PD=0.9U
M$4822 \$3720 \$3718 VSS VSS nfet_03v3 L=0.28U W=0.36U AS=0.0972P AD=0.18P
+ PS=0.9U PD=1.72U
M$4823 \$3723 \$65 VSS VSS nfet_03v3 L=0.28U W=0.36U AS=0.1584P AD=0.1188P
+ PS=1.6U PD=1.02U
M$4824 \$3724 \$3677 \$3723 VSS nfet_03v3 L=0.28U W=0.36U AS=0.1188P AD=0.1278P
+ PS=1.02U PD=1.07U
M$4825 \$3942 \$3725 \$3724 VSS nfet_03v3 L=0.28U W=0.36U AS=0.1278P AD=0.0567P
+ PS=1.07U PD=0.675U
M$4826 VSS \$3678 \$3942 VSS nfet_03v3 L=0.28U W=0.36U AS=0.0567P AD=0.1584P
+ PS=0.675U PD=1.6U
M$4827 VSS \$3724 \$3725 VSS nfet_03v3 L=0.28U W=0.36U AS=0.1584P AD=0.0972P
+ PS=1.6U PD=0.9U
M$4828 \$3726 \$3724 VSS VSS nfet_03v3 L=0.28U W=0.36U AS=0.0972P AD=0.18P
+ PS=0.9U PD=1.72U
M$4829 \$3729 \$68 VSS VSS nfet_03v3 L=0.28U W=0.36U AS=0.1584P AD=0.1188P
+ PS=1.6U PD=1.02U
M$4830 \$3730 \$3677 \$3729 VSS nfet_03v3 L=0.28U W=0.36U AS=0.1188P AD=0.1278P
+ PS=1.02U PD=1.07U
M$4831 \$3948 \$3731 \$3730 VSS nfet_03v3 L=0.28U W=0.36U AS=0.1278P AD=0.0567P
+ PS=1.07U PD=0.675U
M$4832 VSS \$3678 \$3948 VSS nfet_03v3 L=0.28U W=0.36U AS=0.0567P AD=0.1584P
+ PS=0.675U PD=1.6U
M$4833 VSS \$3730 \$3731 VSS nfet_03v3 L=0.28U W=0.36U AS=0.1584P AD=0.0972P
+ PS=1.6U PD=0.9U
M$4834 \$3732 \$3730 VSS VSS nfet_03v3 L=0.28U W=0.36U AS=0.0972P AD=0.18P
+ PS=0.9U PD=1.72U
M$4835 \$3735 \$71 VSS VSS nfet_03v3 L=0.28U W=0.36U AS=0.1584P AD=0.1188P
+ PS=1.6U PD=1.02U
M$4836 \$3736 \$3677 \$3735 VSS nfet_03v3 L=0.28U W=0.36U AS=0.1188P AD=0.1278P
+ PS=1.02U PD=1.07U
M$4837 \$3956 \$3737 \$3736 VSS nfet_03v3 L=0.28U W=0.36U AS=0.1278P AD=0.0567P
+ PS=1.07U PD=0.675U
M$4838 VSS \$3678 \$3956 VSS nfet_03v3 L=0.28U W=0.36U AS=0.0567P AD=0.1584P
+ PS=0.675U PD=1.6U
M$4839 VSS \$3736 \$3737 VSS nfet_03v3 L=0.28U W=0.36U AS=0.1584P AD=0.0972P
+ PS=1.6U PD=0.9U
M$4840 \$3738 \$3736 VSS VSS nfet_03v3 L=0.28U W=0.36U AS=0.0972P AD=0.18P
+ PS=0.9U PD=1.72U
M$4841 \$3741 \$74 VSS VSS nfet_03v3 L=0.28U W=0.36U AS=0.1584P AD=0.1188P
+ PS=1.6U PD=1.02U
M$4842 \$3742 \$3677 \$3741 VSS nfet_03v3 L=0.28U W=0.36U AS=0.1188P AD=0.1278P
+ PS=1.02U PD=1.07U
M$4843 \$3964 \$3743 \$3742 VSS nfet_03v3 L=0.28U W=0.36U AS=0.1278P AD=0.0567P
+ PS=1.07U PD=0.675U
M$4844 VSS \$3678 \$3964 VSS nfet_03v3 L=0.28U W=0.36U AS=0.0567P AD=0.1584P
+ PS=0.675U PD=1.6U
M$4845 VSS \$3742 \$3743 VSS nfet_03v3 L=0.28U W=0.36U AS=0.1584P AD=0.0972P
+ PS=1.6U PD=0.9U
M$4846 \$3744 \$3742 VSS VSS nfet_03v3 L=0.28U W=0.36U AS=0.0972P AD=0.18P
+ PS=0.9U PD=1.72U
M$4847 \$3747 \$77 VSS VSS nfet_03v3 L=0.28U W=0.36U AS=0.1584P AD=0.1188P
+ PS=1.6U PD=1.02U
M$4848 \$3748 \$3677 \$3747 VSS nfet_03v3 L=0.28U W=0.36U AS=0.1188P AD=0.1278P
+ PS=1.02U PD=1.07U
M$4849 \$3972 \$3749 \$3748 VSS nfet_03v3 L=0.28U W=0.36U AS=0.1278P AD=0.0567P
+ PS=1.07U PD=0.675U
M$4850 VSS \$3678 \$3972 VSS nfet_03v3 L=0.28U W=0.36U AS=0.0567P AD=0.1584P
+ PS=0.675U PD=1.6U
M$4851 VSS \$3748 \$3749 VSS nfet_03v3 L=0.28U W=0.36U AS=0.1584P AD=0.0972P
+ PS=1.6U PD=0.9U
M$4852 \$3750 \$3748 VSS VSS nfet_03v3 L=0.28U W=0.36U AS=0.0972P AD=0.18P
+ PS=0.9U PD=1.72U
M$4853 \$3753 \$80 VSS VSS nfet_03v3 L=0.28U W=0.36U AS=0.1584P AD=0.1188P
+ PS=1.6U PD=1.02U
M$4854 \$3754 \$3677 \$3753 VSS nfet_03v3 L=0.28U W=0.36U AS=0.1188P AD=0.1278P
+ PS=1.02U PD=1.07U
M$4855 \$3967 \$3755 \$3754 VSS nfet_03v3 L=0.28U W=0.36U AS=0.1278P AD=0.0567P
+ PS=1.07U PD=0.675U
M$4856 VSS \$3678 \$3967 VSS nfet_03v3 L=0.28U W=0.36U AS=0.0567P AD=0.1584P
+ PS=0.675U PD=1.6U
M$4857 VSS \$3754 \$3755 VSS nfet_03v3 L=0.28U W=0.36U AS=0.1584P AD=0.0972P
+ PS=1.6U PD=0.9U
M$4858 \$3756 \$3754 VSS VSS nfet_03v3 L=0.28U W=0.36U AS=0.0972P AD=0.18P
+ PS=0.9U PD=1.72U
M$4859 \$3759 \$83 VSS VSS nfet_03v3 L=0.28U W=0.36U AS=0.1584P AD=0.1188P
+ PS=1.6U PD=1.02U
M$4860 \$3760 \$3677 \$3759 VSS nfet_03v3 L=0.28U W=0.36U AS=0.1188P AD=0.1278P
+ PS=1.02U PD=1.07U
M$4861 \$3941 \$3761 \$3760 VSS nfet_03v3 L=0.28U W=0.36U AS=0.1278P AD=0.0567P
+ PS=1.07U PD=0.675U
M$4862 VSS \$3678 \$3941 VSS nfet_03v3 L=0.28U W=0.36U AS=0.0567P AD=0.1584P
+ PS=0.675U PD=1.6U
M$4863 VSS \$3760 \$3761 VSS nfet_03v3 L=0.28U W=0.36U AS=0.1584P AD=0.0972P
+ PS=1.6U PD=0.9U
M$4864 \$3762 \$3760 VSS VSS nfet_03v3 L=0.28U W=0.36U AS=0.0972P AD=0.18P
+ PS=0.9U PD=1.72U
M$4865 \$3765 \$86 VSS VSS nfet_03v3 L=0.28U W=0.36U AS=0.1584P AD=0.1188P
+ PS=1.6U PD=1.02U
M$4866 \$3766 \$3677 \$3765 VSS nfet_03v3 L=0.28U W=0.36U AS=0.1188P AD=0.1278P
+ PS=1.02U PD=1.07U
M$4867 \$3917 \$3767 \$3766 VSS nfet_03v3 L=0.28U W=0.36U AS=0.1278P AD=0.0567P
+ PS=1.07U PD=0.675U
M$4868 VSS \$3678 \$3917 VSS nfet_03v3 L=0.28U W=0.36U AS=0.0567P AD=0.1584P
+ PS=0.675U PD=1.6U
M$4869 VSS \$3766 \$3767 VSS nfet_03v3 L=0.28U W=0.36U AS=0.1584P AD=0.0972P
+ PS=1.6U PD=0.9U
M$4870 \$3768 \$3766 VSS VSS nfet_03v3 L=0.28U W=0.36U AS=0.0972P AD=0.18P
+ PS=0.9U PD=1.72U
M$4871 \$3771 \$89 VSS VSS nfet_03v3 L=0.28U W=0.36U AS=0.1584P AD=0.1188P
+ PS=1.6U PD=1.02U
M$4872 \$3772 \$3677 \$3771 VSS nfet_03v3 L=0.28U W=0.36U AS=0.1188P AD=0.1278P
+ PS=1.02U PD=1.07U
M$4873 \$3893 \$3773 \$3772 VSS nfet_03v3 L=0.28U W=0.36U AS=0.1278P AD=0.0567P
+ PS=1.07U PD=0.675U
M$4874 VSS \$3678 \$3893 VSS nfet_03v3 L=0.28U W=0.36U AS=0.0567P AD=0.1584P
+ PS=0.675U PD=1.6U
M$4875 VSS \$3772 \$3773 VSS nfet_03v3 L=0.28U W=0.36U AS=0.1584P AD=0.0972P
+ PS=1.6U PD=0.9U
M$4876 \$3774 \$3772 VSS VSS nfet_03v3 L=0.28U W=0.36U AS=0.0972P AD=0.18P
+ PS=0.9U PD=1.72U
M$4877 \$4127 WE3 VSS VSS nfet_03v3 L=0.28U W=0.72U AS=0.3168P AD=0.1872P
+ PS=2.32U PD=1.24U
M$4878 \$3978 CLK \$4127 VSS nfet_03v3 L=0.28U W=0.72U AS=0.1872P AD=0.3168P
+ PS=1.24U PD=2.32U
M$4879 \$3979 \$3978 VSS VSS nfet_03v3 L=0.28U W=1.27U AS=0.4445P AD=0.3344P
+ PS=3.305U PD=2.345U
M$4881 \$3980 \$3979 VSS VSS nfet_03v3 L=0.28U W=1.34U AS=0.3636P AD=0.4891P
+ PS=2.44U PD=3.47U
M$4883 \$3981 \$44 VSS VSS nfet_03v3 L=0.28U W=0.36U AS=0.1584P AD=0.1188P
+ PS=1.6U PD=1.02U
M$4884 \$3982 \$3979 \$3981 VSS nfet_03v3 L=0.28U W=0.36U AS=0.1188P AD=0.1278P
+ PS=1.02U PD=1.07U
M$4885 \$4049 \$3983 \$3982 VSS nfet_03v3 L=0.28U W=0.36U AS=0.1278P AD=0.0567P
+ PS=1.07U PD=0.675U
M$4886 VSS \$3980 \$4049 VSS nfet_03v3 L=0.28U W=0.36U AS=0.0567P AD=0.1584P
+ PS=0.675U PD=1.6U
M$4887 VSS \$3982 \$3983 VSS nfet_03v3 L=0.28U W=0.36U AS=0.1584P AD=0.0972P
+ PS=1.6U PD=0.9U
M$4888 \$3984 \$3982 VSS VSS nfet_03v3 L=0.28U W=0.36U AS=0.0972P AD=0.18P
+ PS=0.9U PD=1.72U
M$4889 \$3985 \$47 VSS VSS nfet_03v3 L=0.28U W=0.36U AS=0.1584P AD=0.1188P
+ PS=1.6U PD=1.02U
M$4890 \$3986 \$3979 \$3985 VSS nfet_03v3 L=0.28U W=0.36U AS=0.1188P AD=0.1278P
+ PS=1.02U PD=1.07U
M$4891 \$4058 \$3987 \$3986 VSS nfet_03v3 L=0.28U W=0.36U AS=0.1278P AD=0.0567P
+ PS=1.07U PD=0.675U
M$4892 VSS \$3980 \$4058 VSS nfet_03v3 L=0.28U W=0.36U AS=0.0567P AD=0.1584P
+ PS=0.675U PD=1.6U
M$4893 VSS \$3986 \$3987 VSS nfet_03v3 L=0.28U W=0.36U AS=0.1584P AD=0.0972P
+ PS=1.6U PD=0.9U
M$4894 \$3988 \$3986 VSS VSS nfet_03v3 L=0.28U W=0.36U AS=0.0972P AD=0.18P
+ PS=0.9U PD=1.72U
M$4895 \$3989 \$50 VSS VSS nfet_03v3 L=0.28U W=0.36U AS=0.1584P AD=0.1188P
+ PS=1.6U PD=1.02U
M$4896 \$3990 \$3979 \$3989 VSS nfet_03v3 L=0.28U W=0.36U AS=0.1188P AD=0.1278P
+ PS=1.02U PD=1.07U
M$4897 \$4066 \$3991 \$3990 VSS nfet_03v3 L=0.28U W=0.36U AS=0.1278P AD=0.0567P
+ PS=1.07U PD=0.675U
M$4898 VSS \$3980 \$4066 VSS nfet_03v3 L=0.28U W=0.36U AS=0.0567P AD=0.1584P
+ PS=0.675U PD=1.6U
M$4899 VSS \$3990 \$3991 VSS nfet_03v3 L=0.28U W=0.36U AS=0.1584P AD=0.0972P
+ PS=1.6U PD=0.9U
M$4900 \$3992 \$3990 VSS VSS nfet_03v3 L=0.28U W=0.36U AS=0.0972P AD=0.18P
+ PS=0.9U PD=1.72U
M$4901 \$3993 \$53 VSS VSS nfet_03v3 L=0.28U W=0.36U AS=0.1584P AD=0.1188P
+ PS=1.6U PD=1.02U
M$4902 \$3994 \$3979 \$3993 VSS nfet_03v3 L=0.28U W=0.36U AS=0.1188P AD=0.1278P
+ PS=1.02U PD=1.07U
M$4903 \$4075 \$3995 \$3994 VSS nfet_03v3 L=0.28U W=0.36U AS=0.1278P AD=0.0567P
+ PS=1.07U PD=0.675U
M$4904 VSS \$3980 \$4075 VSS nfet_03v3 L=0.28U W=0.36U AS=0.0567P AD=0.1584P
+ PS=0.675U PD=1.6U
M$4905 VSS \$3994 \$3995 VSS nfet_03v3 L=0.28U W=0.36U AS=0.1584P AD=0.0972P
+ PS=1.6U PD=0.9U
M$4906 \$3996 \$3994 VSS VSS nfet_03v3 L=0.28U W=0.36U AS=0.0972P AD=0.18P
+ PS=0.9U PD=1.72U
M$4907 \$3997 \$56 VSS VSS nfet_03v3 L=0.28U W=0.36U AS=0.1584P AD=0.1188P
+ PS=1.6U PD=1.02U
M$4908 \$3998 \$3979 \$3997 VSS nfet_03v3 L=0.28U W=0.36U AS=0.1188P AD=0.1278P
+ PS=1.02U PD=1.07U
M$4909 \$4082 \$3999 \$3998 VSS nfet_03v3 L=0.28U W=0.36U AS=0.1278P AD=0.0567P
+ PS=1.07U PD=0.675U
M$4910 VSS \$3980 \$4082 VSS nfet_03v3 L=0.28U W=0.36U AS=0.0567P AD=0.1584P
+ PS=0.675U PD=1.6U
M$4911 VSS \$3998 \$3999 VSS nfet_03v3 L=0.28U W=0.36U AS=0.1584P AD=0.0972P
+ PS=1.6U PD=0.9U
M$4912 \$4000 \$3998 VSS VSS nfet_03v3 L=0.28U W=0.36U AS=0.0972P AD=0.18P
+ PS=0.9U PD=1.72U
M$4913 \$4001 \$59 VSS VSS nfet_03v3 L=0.28U W=0.36U AS=0.1584P AD=0.1188P
+ PS=1.6U PD=1.02U
M$4914 \$4002 \$3979 \$4001 VSS nfet_03v3 L=0.28U W=0.36U AS=0.1188P AD=0.1278P
+ PS=1.02U PD=1.07U
M$4915 \$4090 \$4003 \$4002 VSS nfet_03v3 L=0.28U W=0.36U AS=0.1278P AD=0.0567P
+ PS=1.07U PD=0.675U
M$4916 VSS \$3980 \$4090 VSS nfet_03v3 L=0.28U W=0.36U AS=0.0567P AD=0.1584P
+ PS=0.675U PD=1.6U
M$4917 VSS \$4002 \$4003 VSS nfet_03v3 L=0.28U W=0.36U AS=0.1584P AD=0.0972P
+ PS=1.6U PD=0.9U
M$4918 \$4004 \$4002 VSS VSS nfet_03v3 L=0.28U W=0.36U AS=0.0972P AD=0.18P
+ PS=0.9U PD=1.72U
M$4919 \$4005 \$62 VSS VSS nfet_03v3 L=0.28U W=0.36U AS=0.1584P AD=0.1188P
+ PS=1.6U PD=1.02U
M$4920 \$4006 \$3979 \$4005 VSS nfet_03v3 L=0.28U W=0.36U AS=0.1188P AD=0.1278P
+ PS=1.02U PD=1.07U
M$4921 \$4089 \$4007 \$4006 VSS nfet_03v3 L=0.28U W=0.36U AS=0.1278P AD=0.0567P
+ PS=1.07U PD=0.675U
M$4922 VSS \$3980 \$4089 VSS nfet_03v3 L=0.28U W=0.36U AS=0.0567P AD=0.1584P
+ PS=0.675U PD=1.6U
M$4923 VSS \$4006 \$4007 VSS nfet_03v3 L=0.28U W=0.36U AS=0.1584P AD=0.0972P
+ PS=1.6U PD=0.9U
M$4924 \$4008 \$4006 VSS VSS nfet_03v3 L=0.28U W=0.36U AS=0.0972P AD=0.18P
+ PS=0.9U PD=1.72U
M$4925 \$4009 \$65 VSS VSS nfet_03v3 L=0.28U W=0.36U AS=0.1584P AD=0.1188P
+ PS=1.6U PD=1.02U
M$4926 \$4010 \$3979 \$4009 VSS nfet_03v3 L=0.28U W=0.36U AS=0.1188P AD=0.1278P
+ PS=1.02U PD=1.07U
M$4927 \$4086 \$4011 \$4010 VSS nfet_03v3 L=0.28U W=0.36U AS=0.1278P AD=0.0567P
+ PS=1.07U PD=0.675U
M$4928 VSS \$3980 \$4086 VSS nfet_03v3 L=0.28U W=0.36U AS=0.0567P AD=0.1584P
+ PS=0.675U PD=1.6U
M$4929 VSS \$4010 \$4011 VSS nfet_03v3 L=0.28U W=0.36U AS=0.1584P AD=0.0972P
+ PS=1.6U PD=0.9U
M$4930 \$4012 \$4010 VSS VSS nfet_03v3 L=0.28U W=0.36U AS=0.0972P AD=0.18P
+ PS=0.9U PD=1.72U
M$4931 \$4013 \$68 VSS VSS nfet_03v3 L=0.28U W=0.36U AS=0.1584P AD=0.1188P
+ PS=1.6U PD=1.02U
M$4932 \$4014 \$3979 \$4013 VSS nfet_03v3 L=0.28U W=0.36U AS=0.1188P AD=0.1278P
+ PS=1.02U PD=1.07U
M$4933 \$4080 \$4015 \$4014 VSS nfet_03v3 L=0.28U W=0.36U AS=0.1278P AD=0.0567P
+ PS=1.07U PD=0.675U
M$4934 VSS \$3980 \$4080 VSS nfet_03v3 L=0.28U W=0.36U AS=0.0567P AD=0.1584P
+ PS=0.675U PD=1.6U
M$4935 VSS \$4014 \$4015 VSS nfet_03v3 L=0.28U W=0.36U AS=0.1584P AD=0.0972P
+ PS=1.6U PD=0.9U
M$4936 \$4016 \$4014 VSS VSS nfet_03v3 L=0.28U W=0.36U AS=0.0972P AD=0.18P
+ PS=0.9U PD=1.72U
M$4937 \$4017 \$71 VSS VSS nfet_03v3 L=0.28U W=0.36U AS=0.1584P AD=0.1188P
+ PS=1.6U PD=1.02U
M$4938 \$4018 \$3979 \$4017 VSS nfet_03v3 L=0.28U W=0.36U AS=0.1188P AD=0.1278P
+ PS=1.02U PD=1.07U
M$4939 \$4074 \$4019 \$4018 VSS nfet_03v3 L=0.28U W=0.36U AS=0.1278P AD=0.0567P
+ PS=1.07U PD=0.675U
M$4940 VSS \$3980 \$4074 VSS nfet_03v3 L=0.28U W=0.36U AS=0.0567P AD=0.1584P
+ PS=0.675U PD=1.6U
M$4941 VSS \$4018 \$4019 VSS nfet_03v3 L=0.28U W=0.36U AS=0.1584P AD=0.0972P
+ PS=1.6U PD=0.9U
M$4942 \$4020 \$4018 VSS VSS nfet_03v3 L=0.28U W=0.36U AS=0.0972P AD=0.18P
+ PS=0.9U PD=1.72U
M$4943 \$4021 \$74 VSS VSS nfet_03v3 L=0.28U W=0.36U AS=0.1584P AD=0.1188P
+ PS=1.6U PD=1.02U
M$4944 \$4022 \$3979 \$4021 VSS nfet_03v3 L=0.28U W=0.36U AS=0.1188P AD=0.1278P
+ PS=1.02U PD=1.07U
M$4945 \$4071 \$4023 \$4022 VSS nfet_03v3 L=0.28U W=0.36U AS=0.1278P AD=0.0567P
+ PS=1.07U PD=0.675U
M$4946 VSS \$3980 \$4071 VSS nfet_03v3 L=0.28U W=0.36U AS=0.0567P AD=0.1584P
+ PS=0.675U PD=1.6U
M$4947 VSS \$4022 \$4023 VSS nfet_03v3 L=0.28U W=0.36U AS=0.1584P AD=0.0972P
+ PS=1.6U PD=0.9U
M$4948 \$4024 \$4022 VSS VSS nfet_03v3 L=0.28U W=0.36U AS=0.0972P AD=0.18P
+ PS=0.9U PD=1.72U
M$4949 \$4025 \$77 VSS VSS nfet_03v3 L=0.28U W=0.36U AS=0.1584P AD=0.1188P
+ PS=1.6U PD=1.02U
M$4950 \$4026 \$3979 \$4025 VSS nfet_03v3 L=0.28U W=0.36U AS=0.1188P AD=0.1278P
+ PS=1.02U PD=1.07U
M$4951 \$4065 \$4027 \$4026 VSS nfet_03v3 L=0.28U W=0.36U AS=0.1278P AD=0.0567P
+ PS=1.07U PD=0.675U
M$4952 VSS \$3980 \$4065 VSS nfet_03v3 L=0.28U W=0.36U AS=0.0567P AD=0.1584P
+ PS=0.675U PD=1.6U
M$4953 VSS \$4026 \$4027 VSS nfet_03v3 L=0.28U W=0.36U AS=0.1584P AD=0.0972P
+ PS=1.6U PD=0.9U
M$4954 \$4028 \$4026 VSS VSS nfet_03v3 L=0.28U W=0.36U AS=0.0972P AD=0.18P
+ PS=0.9U PD=1.72U
M$4955 \$4029 \$80 VSS VSS nfet_03v3 L=0.28U W=0.36U AS=0.1584P AD=0.1188P
+ PS=1.6U PD=1.02U
M$4956 \$4030 \$3979 \$4029 VSS nfet_03v3 L=0.28U W=0.36U AS=0.1188P AD=0.1278P
+ PS=1.02U PD=1.07U
M$4957 \$4062 \$4031 \$4030 VSS nfet_03v3 L=0.28U W=0.36U AS=0.1278P AD=0.0567P
+ PS=1.07U PD=0.675U
M$4958 VSS \$3980 \$4062 VSS nfet_03v3 L=0.28U W=0.36U AS=0.0567P AD=0.1584P
+ PS=0.675U PD=1.6U
M$4959 VSS \$4030 \$4031 VSS nfet_03v3 L=0.28U W=0.36U AS=0.1584P AD=0.0972P
+ PS=1.6U PD=0.9U
M$4960 \$4032 \$4030 VSS VSS nfet_03v3 L=0.28U W=0.36U AS=0.0972P AD=0.18P
+ PS=0.9U PD=1.72U
M$4961 \$4033 \$83 VSS VSS nfet_03v3 L=0.28U W=0.36U AS=0.1584P AD=0.1188P
+ PS=1.6U PD=1.02U
M$4962 \$4034 \$3979 \$4033 VSS nfet_03v3 L=0.28U W=0.36U AS=0.1188P AD=0.1278P
+ PS=1.02U PD=1.07U
M$4963 \$4056 \$4035 \$4034 VSS nfet_03v3 L=0.28U W=0.36U AS=0.1278P AD=0.0567P
+ PS=1.07U PD=0.675U
M$4964 VSS \$3980 \$4056 VSS nfet_03v3 L=0.28U W=0.36U AS=0.0567P AD=0.1584P
+ PS=0.675U PD=1.6U
M$4965 VSS \$4034 \$4035 VSS nfet_03v3 L=0.28U W=0.36U AS=0.1584P AD=0.0972P
+ PS=1.6U PD=0.9U
M$4966 \$4036 \$4034 VSS VSS nfet_03v3 L=0.28U W=0.36U AS=0.0972P AD=0.18P
+ PS=0.9U PD=1.72U
M$4967 \$4037 \$86 VSS VSS nfet_03v3 L=0.28U W=0.36U AS=0.1584P AD=0.1188P
+ PS=1.6U PD=1.02U
M$4968 \$4038 \$3979 \$4037 VSS nfet_03v3 L=0.28U W=0.36U AS=0.1188P AD=0.1278P
+ PS=1.02U PD=1.07U
M$4969 \$4052 \$4039 \$4038 VSS nfet_03v3 L=0.28U W=0.36U AS=0.1278P AD=0.0567P
+ PS=1.07U PD=0.675U
M$4970 VSS \$3980 \$4052 VSS nfet_03v3 L=0.28U W=0.36U AS=0.0567P AD=0.1584P
+ PS=0.675U PD=1.6U
M$4971 VSS \$4038 \$4039 VSS nfet_03v3 L=0.28U W=0.36U AS=0.1584P AD=0.0972P
+ PS=1.6U PD=0.9U
M$4972 \$4040 \$4038 VSS VSS nfet_03v3 L=0.28U W=0.36U AS=0.0972P AD=0.18P
+ PS=0.9U PD=1.72U
M$4973 \$4041 \$89 VSS VSS nfet_03v3 L=0.28U W=0.36U AS=0.1584P AD=0.1188P
+ PS=1.6U PD=1.02U
M$4974 \$4042 \$3979 \$4041 VSS nfet_03v3 L=0.28U W=0.36U AS=0.1188P AD=0.1278P
+ PS=1.02U PD=1.07U
M$4975 \$4047 \$4043 \$4042 VSS nfet_03v3 L=0.28U W=0.36U AS=0.1278P AD=0.0567P
+ PS=1.07U PD=0.675U
M$4976 VSS \$3980 \$4047 VSS nfet_03v3 L=0.28U W=0.36U AS=0.0567P AD=0.1584P
+ PS=0.675U PD=1.6U
M$4977 VSS \$4042 \$4043 VSS nfet_03v3 L=0.28U W=0.36U AS=0.1584P AD=0.0972P
+ PS=1.6U PD=0.9U
M$4978 \$4044 \$4042 VSS VSS nfet_03v3 L=0.28U W=0.36U AS=0.0972P AD=0.18P
+ PS=0.9U PD=1.72U
M$4979 \$4298 RB2 VSS VSS nfet_03v3 L=0.28U W=0.36U AS=0.1656P AD=0.1944P
+ PS=1.64U PD=1.8U
M$4980 \$4095 RA3 VSS VSS nfet_03v3 L=0.28U W=0.36U AS=0.1656P AD=0.1944P
+ PS=1.64U PD=1.8U
M$4981 \$3984 RA3 \$360 VSS nfet_03v3 L=0.28U W=0.36U AS=0.1584P AD=0.1152P
+ PS=1.6U PD=1U
M$4982 \$361 RB3 \$3984 VSS nfet_03v3 L=0.28U W=0.36U AS=0.1152P AD=0.1584P
+ PS=1U PD=1.6U
M$4983 \$4297 RB2 \$360 VSS nfet_03v3 L=0.28U W=0.36U AS=0.1584P AD=0.1152P
+ PS=1.6U PD=1U
M$4984 \$361 RA2 \$4297 VSS nfet_03v3 L=0.28U W=0.36U AS=0.1152P AD=0.1584P
+ PS=1U PD=1.6U
M$4985 VSS RB3 \$4096 VSS nfet_03v3 L=0.28U W=0.36U AS=0.1854P AD=0.1584P
+ PS=1.75U PD=1.6U
M$4986 VSS RA2 \$4299 VSS nfet_03v3 L=0.28U W=0.36U AS=0.1854P AD=0.1584P
+ PS=1.75U PD=1.6U
M$4987 \$4097 RA3 VSS VSS nfet_03v3 L=0.28U W=0.36U AS=0.1656P AD=0.1944P
+ PS=1.64U PD=1.8U
M$4988 \$4304 RB2 VSS VSS nfet_03v3 L=0.28U W=0.36U AS=0.1656P AD=0.1944P
+ PS=1.64U PD=1.8U
M$4989 \$3988 RA3 \$365 VSS nfet_03v3 L=0.28U W=0.36U AS=0.1584P AD=0.1152P
+ PS=1.6U PD=1U
M$4990 \$366 RB3 \$3988 VSS nfet_03v3 L=0.28U W=0.36U AS=0.1152P AD=0.1584P
+ PS=1U PD=1.6U
M$4991 \$4303 RB2 \$365 VSS nfet_03v3 L=0.28U W=0.36U AS=0.1584P AD=0.1152P
+ PS=1.6U PD=1U
M$4992 \$366 RA2 \$4303 VSS nfet_03v3 L=0.28U W=0.36U AS=0.1152P AD=0.1584P
+ PS=1U PD=1.6U
M$4993 VSS RA2 \$4305 VSS nfet_03v3 L=0.28U W=0.36U AS=0.1854P AD=0.1584P
+ PS=1.75U PD=1.6U
M$4994 VSS RB3 \$4098 VSS nfet_03v3 L=0.28U W=0.36U AS=0.1854P AD=0.1584P
+ PS=1.75U PD=1.6U
M$4995 \$4099 RA3 VSS VSS nfet_03v3 L=0.28U W=0.36U AS=0.1656P AD=0.1944P
+ PS=1.64U PD=1.8U
M$4996 \$4310 RB2 VSS VSS nfet_03v3 L=0.28U W=0.36U AS=0.1656P AD=0.1944P
+ PS=1.64U PD=1.8U
M$4997 \$4309 RB2 \$370 VSS nfet_03v3 L=0.28U W=0.36U AS=0.1584P AD=0.1152P
+ PS=1.6U PD=1U
M$4998 \$371 RA2 \$4309 VSS nfet_03v3 L=0.28U W=0.36U AS=0.1152P AD=0.1584P
+ PS=1U PD=1.6U
M$4999 \$3992 RA3 \$370 VSS nfet_03v3 L=0.28U W=0.36U AS=0.1584P AD=0.1152P
+ PS=1.6U PD=1U
M$5000 \$371 RB3 \$3992 VSS nfet_03v3 L=0.28U W=0.36U AS=0.1152P AD=0.1584P
+ PS=1U PD=1.6U
M$5001 VSS RB3 \$4100 VSS nfet_03v3 L=0.28U W=0.36U AS=0.1854P AD=0.1584P
+ PS=1.75U PD=1.6U
M$5002 VSS RA2 \$4311 VSS nfet_03v3 L=0.28U W=0.36U AS=0.1854P AD=0.1584P
+ PS=1.75U PD=1.6U
M$5003 \$4101 RA3 VSS VSS nfet_03v3 L=0.28U W=0.36U AS=0.1656P AD=0.1944P
+ PS=1.64U PD=1.8U
M$5004 \$4316 RB2 VSS VSS nfet_03v3 L=0.28U W=0.36U AS=0.1656P AD=0.1944P
+ PS=1.64U PD=1.8U
M$5005 \$4315 RB2 \$375 VSS nfet_03v3 L=0.28U W=0.36U AS=0.1584P AD=0.1152P
+ PS=1.6U PD=1U
M$5006 \$376 RA2 \$4315 VSS nfet_03v3 L=0.28U W=0.36U AS=0.1152P AD=0.1584P
+ PS=1U PD=1.6U
M$5007 \$3996 RA3 \$375 VSS nfet_03v3 L=0.28U W=0.36U AS=0.1584P AD=0.1152P
+ PS=1.6U PD=1U
M$5008 \$376 RB3 \$3996 VSS nfet_03v3 L=0.28U W=0.36U AS=0.1152P AD=0.1584P
+ PS=1U PD=1.6U
M$5009 VSS RA2 \$4317 VSS nfet_03v3 L=0.28U W=0.36U AS=0.1854P AD=0.1584P
+ PS=1.75U PD=1.6U
M$5010 VSS RB3 \$4102 VSS nfet_03v3 L=0.28U W=0.36U AS=0.1854P AD=0.1584P
+ PS=1.75U PD=1.6U
M$5011 \$4322 RB2 VSS VSS nfet_03v3 L=0.28U W=0.36U AS=0.1656P AD=0.1944P
+ PS=1.64U PD=1.8U
M$5012 \$4103 RA3 VSS VSS nfet_03v3 L=0.28U W=0.36U AS=0.1656P AD=0.1944P
+ PS=1.64U PD=1.8U
M$5013 \$4321 RB2 \$380 VSS nfet_03v3 L=0.28U W=0.36U AS=0.1584P AD=0.1152P
+ PS=1.6U PD=1U
M$5014 \$381 RA2 \$4321 VSS nfet_03v3 L=0.28U W=0.36U AS=0.1152P AD=0.1584P
+ PS=1U PD=1.6U
M$5015 \$4000 RA3 \$380 VSS nfet_03v3 L=0.28U W=0.36U AS=0.1584P AD=0.1152P
+ PS=1.6U PD=1U
M$5016 \$381 RB3 \$4000 VSS nfet_03v3 L=0.28U W=0.36U AS=0.1152P AD=0.1584P
+ PS=1U PD=1.6U
M$5017 VSS RB3 \$4104 VSS nfet_03v3 L=0.28U W=0.36U AS=0.1854P AD=0.1584P
+ PS=1.75U PD=1.6U
M$5018 VSS RA2 \$4323 VSS nfet_03v3 L=0.28U W=0.36U AS=0.1854P AD=0.1584P
+ PS=1.75U PD=1.6U
M$5019 \$4105 RA3 VSS VSS nfet_03v3 L=0.28U W=0.36U AS=0.1656P AD=0.1944P
+ PS=1.64U PD=1.8U
M$5020 \$4328 RB2 VSS VSS nfet_03v3 L=0.28U W=0.36U AS=0.1656P AD=0.1944P
+ PS=1.64U PD=1.8U
M$5021 \$4327 RB2 \$385 VSS nfet_03v3 L=0.28U W=0.36U AS=0.1584P AD=0.1152P
+ PS=1.6U PD=1U
M$5022 \$386 RA2 \$4327 VSS nfet_03v3 L=0.28U W=0.36U AS=0.1152P AD=0.1584P
+ PS=1U PD=1.6U
M$5023 \$4004 RA3 \$385 VSS nfet_03v3 L=0.28U W=0.36U AS=0.1584P AD=0.1152P
+ PS=1.6U PD=1U
M$5024 \$386 RB3 \$4004 VSS nfet_03v3 L=0.28U W=0.36U AS=0.1152P AD=0.1584P
+ PS=1U PD=1.6U
M$5025 VSS RA2 \$4329 VSS nfet_03v3 L=0.28U W=0.36U AS=0.1854P AD=0.1584P
+ PS=1.75U PD=1.6U
M$5026 VSS RB3 \$4106 VSS nfet_03v3 L=0.28U W=0.36U AS=0.1854P AD=0.1584P
+ PS=1.75U PD=1.6U
M$5027 \$4334 RB2 VSS VSS nfet_03v3 L=0.28U W=0.36U AS=0.1656P AD=0.1944P
+ PS=1.64U PD=1.8U
M$5028 \$4107 RA3 VSS VSS nfet_03v3 L=0.28U W=0.36U AS=0.1656P AD=0.1944P
+ PS=1.64U PD=1.8U
M$5029 \$4333 RB2 \$390 VSS nfet_03v3 L=0.28U W=0.36U AS=0.1584P AD=0.1152P
+ PS=1.6U PD=1U
M$5030 \$391 RA2 \$4333 VSS nfet_03v3 L=0.28U W=0.36U AS=0.1152P AD=0.1584P
+ PS=1U PD=1.6U
M$5031 \$4008 RA3 \$390 VSS nfet_03v3 L=0.28U W=0.36U AS=0.1584P AD=0.1152P
+ PS=1.6U PD=1U
M$5032 \$391 RB3 \$4008 VSS nfet_03v3 L=0.28U W=0.36U AS=0.1152P AD=0.1584P
+ PS=1U PD=1.6U
M$5033 VSS RA2 \$4335 VSS nfet_03v3 L=0.28U W=0.36U AS=0.1854P AD=0.1584P
+ PS=1.75U PD=1.6U
M$5034 VSS RB3 \$4108 VSS nfet_03v3 L=0.28U W=0.36U AS=0.1854P AD=0.1584P
+ PS=1.75U PD=1.6U
M$5035 \$4109 RA3 VSS VSS nfet_03v3 L=0.28U W=0.36U AS=0.1656P AD=0.1944P
+ PS=1.64U PD=1.8U
M$5036 \$4340 RB2 VSS VSS nfet_03v3 L=0.28U W=0.36U AS=0.1656P AD=0.1944P
+ PS=1.64U PD=1.8U
M$5037 \$4339 RB2 \$395 VSS nfet_03v3 L=0.28U W=0.36U AS=0.1584P AD=0.1152P
+ PS=1.6U PD=1U
M$5038 \$396 RA2 \$4339 VSS nfet_03v3 L=0.28U W=0.36U AS=0.1152P AD=0.1584P
+ PS=1U PD=1.6U
M$5039 \$4012 RA3 \$395 VSS nfet_03v3 L=0.28U W=0.36U AS=0.1584P AD=0.1152P
+ PS=1.6U PD=1U
M$5040 \$396 RB3 \$4012 VSS nfet_03v3 L=0.28U W=0.36U AS=0.1152P AD=0.1584P
+ PS=1U PD=1.6U
M$5041 VSS RA2 \$4341 VSS nfet_03v3 L=0.28U W=0.36U AS=0.1854P AD=0.1584P
+ PS=1.75U PD=1.6U
M$5042 VSS RB3 \$4110 VSS nfet_03v3 L=0.28U W=0.36U AS=0.1854P AD=0.1584P
+ PS=1.75U PD=1.6U
M$5043 \$4346 RB2 VSS VSS nfet_03v3 L=0.28U W=0.36U AS=0.1656P AD=0.1944P
+ PS=1.64U PD=1.8U
M$5044 \$4111 RA3 VSS VSS nfet_03v3 L=0.28U W=0.36U AS=0.1656P AD=0.1944P
+ PS=1.64U PD=1.8U
M$5045 \$4016 RA3 \$400 VSS nfet_03v3 L=0.28U W=0.36U AS=0.1584P AD=0.1152P
+ PS=1.6U PD=1U
M$5046 \$401 RB3 \$4016 VSS nfet_03v3 L=0.28U W=0.36U AS=0.1152P AD=0.1584P
+ PS=1U PD=1.6U
M$5047 \$4345 RB2 \$400 VSS nfet_03v3 L=0.28U W=0.36U AS=0.1584P AD=0.1152P
+ PS=1.6U PD=1U
M$5048 \$401 RA2 \$4345 VSS nfet_03v3 L=0.28U W=0.36U AS=0.1152P AD=0.1584P
+ PS=1U PD=1.6U
M$5049 VSS RA2 \$4347 VSS nfet_03v3 L=0.28U W=0.36U AS=0.1854P AD=0.1584P
+ PS=1.75U PD=1.6U
M$5050 VSS RB3 \$4112 VSS nfet_03v3 L=0.28U W=0.36U AS=0.1854P AD=0.1584P
+ PS=1.75U PD=1.6U
M$5051 \$4352 RB2 VSS VSS nfet_03v3 L=0.28U W=0.36U AS=0.1656P AD=0.1944P
+ PS=1.64U PD=1.8U
M$5052 \$4113 RA3 VSS VSS nfet_03v3 L=0.28U W=0.36U AS=0.1656P AD=0.1944P
+ PS=1.64U PD=1.8U
M$5053 \$4020 RA3 \$405 VSS nfet_03v3 L=0.28U W=0.36U AS=0.1584P AD=0.1152P
+ PS=1.6U PD=1U
M$5054 \$406 RB3 \$4020 VSS nfet_03v3 L=0.28U W=0.36U AS=0.1152P AD=0.1584P
+ PS=1U PD=1.6U
M$5055 \$4351 RB2 \$405 VSS nfet_03v3 L=0.28U W=0.36U AS=0.1584P AD=0.1152P
+ PS=1.6U PD=1U
M$5056 \$406 RA2 \$4351 VSS nfet_03v3 L=0.28U W=0.36U AS=0.1152P AD=0.1584P
+ PS=1U PD=1.6U
M$5057 VSS RB3 \$4114 VSS nfet_03v3 L=0.28U W=0.36U AS=0.1854P AD=0.1584P
+ PS=1.75U PD=1.6U
M$5058 VSS RA2 \$4353 VSS nfet_03v3 L=0.28U W=0.36U AS=0.1854P AD=0.1584P
+ PS=1.75U PD=1.6U
M$5059 \$4115 RA3 VSS VSS nfet_03v3 L=0.28U W=0.36U AS=0.1656P AD=0.1944P
+ PS=1.64U PD=1.8U
M$5060 \$4358 RB2 VSS VSS nfet_03v3 L=0.28U W=0.36U AS=0.1656P AD=0.1944P
+ PS=1.64U PD=1.8U
M$5061 \$4357 RB2 \$410 VSS nfet_03v3 L=0.28U W=0.36U AS=0.1584P AD=0.1152P
+ PS=1.6U PD=1U
M$5062 \$411 RA2 \$4357 VSS nfet_03v3 L=0.28U W=0.36U AS=0.1152P AD=0.1584P
+ PS=1U PD=1.6U
M$5063 \$4024 RA3 \$410 VSS nfet_03v3 L=0.28U W=0.36U AS=0.1584P AD=0.1152P
+ PS=1.6U PD=1U
M$5064 \$411 RB3 \$4024 VSS nfet_03v3 L=0.28U W=0.36U AS=0.1152P AD=0.1584P
+ PS=1U PD=1.6U
M$5065 VSS RB3 \$4116 VSS nfet_03v3 L=0.28U W=0.36U AS=0.1854P AD=0.1584P
+ PS=1.75U PD=1.6U
M$5066 VSS RA2 \$4359 VSS nfet_03v3 L=0.28U W=0.36U AS=0.1854P AD=0.1584P
+ PS=1.75U PD=1.6U
M$5067 \$4364 RB2 VSS VSS nfet_03v3 L=0.28U W=0.36U AS=0.1656P AD=0.1944P
+ PS=1.64U PD=1.8U
M$5068 \$4117 RA3 VSS VSS nfet_03v3 L=0.28U W=0.36U AS=0.1656P AD=0.1944P
+ PS=1.64U PD=1.8U
M$5069 \$4028 RA3 \$415 VSS nfet_03v3 L=0.28U W=0.36U AS=0.1584P AD=0.1152P
+ PS=1.6U PD=1U
M$5070 \$416 RB3 \$4028 VSS nfet_03v3 L=0.28U W=0.36U AS=0.1152P AD=0.1584P
+ PS=1U PD=1.6U
M$5071 \$4363 RB2 \$415 VSS nfet_03v3 L=0.28U W=0.36U AS=0.1584P AD=0.1152P
+ PS=1.6U PD=1U
M$5072 \$416 RA2 \$4363 VSS nfet_03v3 L=0.28U W=0.36U AS=0.1152P AD=0.1584P
+ PS=1U PD=1.6U
M$5073 VSS RA2 \$4365 VSS nfet_03v3 L=0.28U W=0.36U AS=0.1854P AD=0.1584P
+ PS=1.75U PD=1.6U
M$5074 VSS RB3 \$4118 VSS nfet_03v3 L=0.28U W=0.36U AS=0.1854P AD=0.1584P
+ PS=1.75U PD=1.6U
M$5075 \$4119 RA3 VSS VSS nfet_03v3 L=0.28U W=0.36U AS=0.1656P AD=0.1944P
+ PS=1.64U PD=1.8U
M$5076 \$4370 RB2 VSS VSS nfet_03v3 L=0.28U W=0.36U AS=0.1656P AD=0.1944P
+ PS=1.64U PD=1.8U
M$5077 \$4369 RB2 \$420 VSS nfet_03v3 L=0.28U W=0.36U AS=0.1584P AD=0.1152P
+ PS=1.6U PD=1U
M$5078 \$421 RA2 \$4369 VSS nfet_03v3 L=0.28U W=0.36U AS=0.1152P AD=0.1584P
+ PS=1U PD=1.6U
M$5079 \$4032 RA3 \$420 VSS nfet_03v3 L=0.28U W=0.36U AS=0.1584P AD=0.1152P
+ PS=1.6U PD=1U
M$5080 \$421 RB3 \$4032 VSS nfet_03v3 L=0.28U W=0.36U AS=0.1152P AD=0.1584P
+ PS=1U PD=1.6U
M$5081 VSS RA2 \$4371 VSS nfet_03v3 L=0.28U W=0.36U AS=0.1854P AD=0.1584P
+ PS=1.75U PD=1.6U
M$5082 VSS RB3 \$4120 VSS nfet_03v3 L=0.28U W=0.36U AS=0.1854P AD=0.1584P
+ PS=1.75U PD=1.6U
M$5083 \$4121 RA3 VSS VSS nfet_03v3 L=0.28U W=0.36U AS=0.1656P AD=0.1944P
+ PS=1.64U PD=1.8U
M$5084 \$4376 RB2 VSS VSS nfet_03v3 L=0.28U W=0.36U AS=0.1656P AD=0.1944P
+ PS=1.64U PD=1.8U
M$5085 \$4036 RA3 \$425 VSS nfet_03v3 L=0.28U W=0.36U AS=0.1584P AD=0.1152P
+ PS=1.6U PD=1U
M$5086 \$426 RB3 \$4036 VSS nfet_03v3 L=0.28U W=0.36U AS=0.1152P AD=0.1584P
+ PS=1U PD=1.6U
M$5087 \$4375 RB2 \$425 VSS nfet_03v3 L=0.28U W=0.36U AS=0.1584P AD=0.1152P
+ PS=1.6U PD=1U
M$5088 \$426 RA2 \$4375 VSS nfet_03v3 L=0.28U W=0.36U AS=0.1152P AD=0.1584P
+ PS=1U PD=1.6U
M$5089 VSS RB3 \$4122 VSS nfet_03v3 L=0.28U W=0.36U AS=0.1854P AD=0.1584P
+ PS=1.75U PD=1.6U
M$5090 VSS RA2 \$4377 VSS nfet_03v3 L=0.28U W=0.36U AS=0.1854P AD=0.1584P
+ PS=1.75U PD=1.6U
M$5091 \$4382 RB2 VSS VSS nfet_03v3 L=0.28U W=0.36U AS=0.1656P AD=0.1944P
+ PS=1.64U PD=1.8U
M$5092 \$4123 RA3 VSS VSS nfet_03v3 L=0.28U W=0.36U AS=0.1656P AD=0.1944P
+ PS=1.64U PD=1.8U
M$5093 \$4381 RB2 \$430 VSS nfet_03v3 L=0.28U W=0.36U AS=0.1584P AD=0.1152P
+ PS=1.6U PD=1U
M$5094 \$431 RA2 \$4381 VSS nfet_03v3 L=0.28U W=0.36U AS=0.1152P AD=0.1584P
+ PS=1U PD=1.6U
M$5095 \$4040 RA3 \$430 VSS nfet_03v3 L=0.28U W=0.36U AS=0.1584P AD=0.1152P
+ PS=1.6U PD=1U
M$5096 \$431 RB3 \$4040 VSS nfet_03v3 L=0.28U W=0.36U AS=0.1152P AD=0.1584P
+ PS=1U PD=1.6U
M$5097 VSS RA2 \$4383 VSS nfet_03v3 L=0.28U W=0.36U AS=0.1854P AD=0.1584P
+ PS=1.75U PD=1.6U
M$5098 VSS RB3 \$4124 VSS nfet_03v3 L=0.28U W=0.36U AS=0.1854P AD=0.1584P
+ PS=1.75U PD=1.6U
M$5099 \$4125 RA3 VSS VSS nfet_03v3 L=0.28U W=0.36U AS=0.1656P AD=0.1944P
+ PS=1.64U PD=1.8U
M$5100 \$4388 RB2 VSS VSS nfet_03v3 L=0.28U W=0.36U AS=0.1656P AD=0.1944P
+ PS=1.64U PD=1.8U
M$5101 \$4044 RA3 \$435 VSS nfet_03v3 L=0.28U W=0.36U AS=0.1584P AD=0.1152P
+ PS=1.6U PD=1U
M$5102 \$436 RB3 \$4044 VSS nfet_03v3 L=0.28U W=0.36U AS=0.1152P AD=0.1584P
+ PS=1U PD=1.6U
M$5103 \$4387 RB2 \$435 VSS nfet_03v3 L=0.28U W=0.36U AS=0.1584P AD=0.1152P
+ PS=1.6U PD=1U
M$5104 \$436 RA2 \$4387 VSS nfet_03v3 L=0.28U W=0.36U AS=0.1152P AD=0.1584P
+ PS=1U PD=1.6U
M$5105 VSS RA2 \$4389 VSS nfet_03v3 L=0.28U W=0.36U AS=0.1854P AD=0.1584P
+ PS=1.75U PD=1.6U
M$5106 VSS RB3 \$4126 VSS nfet_03v3 L=0.28U W=0.36U AS=0.1854P AD=0.1584P
+ PS=1.75U PD=1.6U
M$5107 \$4493 WE2 VSS VSS nfet_03v3 L=0.28U W=0.72U AS=0.3168P AD=0.1872P
+ PS=2.32U PD=1.24U
M$5108 \$4288 CLK \$4493 VSS nfet_03v3 L=0.28U W=0.72U AS=0.1872P AD=0.3168P
+ PS=1.24U PD=2.32U
M$5109 \$4290 \$4288 VSS VSS nfet_03v3 L=0.28U W=1.27U AS=0.4487P AD=0.3302P
+ PS=3.34U PD=2.31U
M$5111 \$4291 \$4290 VSS VSS nfet_03v3 L=0.28U W=1.34U AS=0.3636P AD=0.4891P
+ PS=2.44U PD=3.47U
M$5113 \$4294 \$44 VSS VSS nfet_03v3 L=0.28U W=0.36U AS=0.1584P AD=0.1188P
+ PS=1.6U PD=1.02U
M$5114 \$4295 \$4290 \$4294 VSS nfet_03v3 L=0.28U W=0.36U AS=0.1188P AD=0.1278P
+ PS=1.02U PD=1.07U
M$5115 \$4498 \$4296 \$4295 VSS nfet_03v3 L=0.28U W=0.36U AS=0.1278P AD=0.0567P
+ PS=1.07U PD=0.675U
M$5116 VSS \$4291 \$4498 VSS nfet_03v3 L=0.28U W=0.36U AS=0.0567P AD=0.1584P
+ PS=0.675U PD=1.6U
M$5117 VSS \$4295 \$4296 VSS nfet_03v3 L=0.28U W=0.36U AS=0.1584P AD=0.0972P
+ PS=1.6U PD=0.9U
M$5118 \$4297 \$4295 VSS VSS nfet_03v3 L=0.28U W=0.36U AS=0.0972P AD=0.18P
+ PS=0.9U PD=1.72U
M$5119 \$4300 \$47 VSS VSS nfet_03v3 L=0.28U W=0.36U AS=0.1584P AD=0.1188P
+ PS=1.6U PD=1.02U
M$5120 \$4301 \$4290 \$4300 VSS nfet_03v3 L=0.28U W=0.36U AS=0.1188P AD=0.1278P
+ PS=1.02U PD=1.07U
M$5121 \$4507 \$4302 \$4301 VSS nfet_03v3 L=0.28U W=0.36U AS=0.1278P AD=0.0567P
+ PS=1.07U PD=0.675U
M$5122 VSS \$4291 \$4507 VSS nfet_03v3 L=0.28U W=0.36U AS=0.0567P AD=0.1584P
+ PS=0.675U PD=1.6U
M$5123 VSS \$4301 \$4302 VSS nfet_03v3 L=0.28U W=0.36U AS=0.1584P AD=0.0972P
+ PS=1.6U PD=0.9U
M$5124 \$4303 \$4301 VSS VSS nfet_03v3 L=0.28U W=0.36U AS=0.0972P AD=0.18P
+ PS=0.9U PD=1.72U
M$5125 \$4306 \$50 VSS VSS nfet_03v3 L=0.28U W=0.36U AS=0.1584P AD=0.1188P
+ PS=1.6U PD=1.02U
M$5126 \$4307 \$4290 \$4306 VSS nfet_03v3 L=0.28U W=0.36U AS=0.1188P AD=0.1278P
+ PS=1.02U PD=1.07U
M$5127 \$4514 \$4308 \$4307 VSS nfet_03v3 L=0.28U W=0.36U AS=0.1278P AD=0.0567P
+ PS=1.07U PD=0.675U
M$5128 VSS \$4291 \$4514 VSS nfet_03v3 L=0.28U W=0.36U AS=0.0567P AD=0.1584P
+ PS=0.675U PD=1.6U
M$5129 VSS \$4307 \$4308 VSS nfet_03v3 L=0.28U W=0.36U AS=0.1584P AD=0.0972P
+ PS=1.6U PD=0.9U
M$5130 \$4309 \$4307 VSS VSS nfet_03v3 L=0.28U W=0.36U AS=0.0972P AD=0.18P
+ PS=0.9U PD=1.72U
M$5131 \$4312 \$53 VSS VSS nfet_03v3 L=0.28U W=0.36U AS=0.1584P AD=0.1188P
+ PS=1.6U PD=1.02U
M$5132 \$4313 \$4290 \$4312 VSS nfet_03v3 L=0.28U W=0.36U AS=0.1188P AD=0.1278P
+ PS=1.02U PD=1.07U
M$5133 \$4522 \$4314 \$4313 VSS nfet_03v3 L=0.28U W=0.36U AS=0.1278P AD=0.0567P
+ PS=1.07U PD=0.675U
M$5134 VSS \$4291 \$4522 VSS nfet_03v3 L=0.28U W=0.36U AS=0.0567P AD=0.1584P
+ PS=0.675U PD=1.6U
M$5135 VSS \$4313 \$4314 VSS nfet_03v3 L=0.28U W=0.36U AS=0.1584P AD=0.0972P
+ PS=1.6U PD=0.9U
M$5136 \$4315 \$4313 VSS VSS nfet_03v3 L=0.28U W=0.36U AS=0.0972P AD=0.18P
+ PS=0.9U PD=1.72U
M$5137 \$4318 \$56 VSS VSS nfet_03v3 L=0.28U W=0.36U AS=0.1584P AD=0.1188P
+ PS=1.6U PD=1.02U
M$5138 \$4319 \$4290 \$4318 VSS nfet_03v3 L=0.28U W=0.36U AS=0.1188P AD=0.1278P
+ PS=1.02U PD=1.07U
M$5139 \$4531 \$4320 \$4319 VSS nfet_03v3 L=0.28U W=0.36U AS=0.1278P AD=0.0567P
+ PS=1.07U PD=0.675U
M$5140 VSS \$4291 \$4531 VSS nfet_03v3 L=0.28U W=0.36U AS=0.0567P AD=0.1584P
+ PS=0.675U PD=1.6U
M$5141 VSS \$4319 \$4320 VSS nfet_03v3 L=0.28U W=0.36U AS=0.1584P AD=0.0972P
+ PS=1.6U PD=0.9U
M$5142 \$4321 \$4319 VSS VSS nfet_03v3 L=0.28U W=0.36U AS=0.0972P AD=0.18P
+ PS=0.9U PD=1.72U
M$5143 \$4324 \$59 VSS VSS nfet_03v3 L=0.28U W=0.36U AS=0.1584P AD=0.1188P
+ PS=1.6U PD=1.02U
M$5144 \$4325 \$4290 \$4324 VSS nfet_03v3 L=0.28U W=0.36U AS=0.1188P AD=0.1278P
+ PS=1.02U PD=1.07U
M$5145 \$4538 \$4326 \$4325 VSS nfet_03v3 L=0.28U W=0.36U AS=0.1278P AD=0.0567P
+ PS=1.07U PD=0.675U
M$5146 VSS \$4291 \$4538 VSS nfet_03v3 L=0.28U W=0.36U AS=0.0567P AD=0.1584P
+ PS=0.675U PD=1.6U
M$5147 VSS \$4325 \$4326 VSS nfet_03v3 L=0.28U W=0.36U AS=0.1584P AD=0.0972P
+ PS=1.6U PD=0.9U
M$5148 \$4327 \$4325 VSS VSS nfet_03v3 L=0.28U W=0.36U AS=0.0972P AD=0.18P
+ PS=0.9U PD=1.72U
M$5149 \$4330 \$62 VSS VSS nfet_03v3 L=0.28U W=0.36U AS=0.1584P AD=0.1188P
+ PS=1.6U PD=1.02U
M$5150 \$4331 \$4290 \$4330 VSS nfet_03v3 L=0.28U W=0.36U AS=0.1188P AD=0.1278P
+ PS=1.02U PD=1.07U
M$5151 \$4546 \$4332 \$4331 VSS nfet_03v3 L=0.28U W=0.36U AS=0.1278P AD=0.0567P
+ PS=1.07U PD=0.675U
M$5152 VSS \$4291 \$4546 VSS nfet_03v3 L=0.28U W=0.36U AS=0.0567P AD=0.1584P
+ PS=0.675U PD=1.6U
M$5153 VSS \$4331 \$4332 VSS nfet_03v3 L=0.28U W=0.36U AS=0.1584P AD=0.0972P
+ PS=1.6U PD=0.9U
M$5154 \$4333 \$4331 VSS VSS nfet_03v3 L=0.28U W=0.36U AS=0.0972P AD=0.18P
+ PS=0.9U PD=1.72U
M$5155 \$4336 \$65 VSS VSS nfet_03v3 L=0.28U W=0.36U AS=0.1584P AD=0.1188P
+ PS=1.6U PD=1.02U
M$5156 \$4337 \$4290 \$4336 VSS nfet_03v3 L=0.28U W=0.36U AS=0.1188P AD=0.1278P
+ PS=1.02U PD=1.07U
M$5157 \$4555 \$4338 \$4337 VSS nfet_03v3 L=0.28U W=0.36U AS=0.1278P AD=0.0567P
+ PS=1.07U PD=0.675U
M$5158 VSS \$4291 \$4555 VSS nfet_03v3 L=0.28U W=0.36U AS=0.0567P AD=0.1584P
+ PS=0.675U PD=1.6U
M$5159 VSS \$4337 \$4338 VSS nfet_03v3 L=0.28U W=0.36U AS=0.1584P AD=0.0972P
+ PS=1.6U PD=0.9U
M$5160 \$4339 \$4337 VSS VSS nfet_03v3 L=0.28U W=0.36U AS=0.0972P AD=0.18P
+ PS=0.9U PD=1.72U
M$5161 \$4342 \$68 VSS VSS nfet_03v3 L=0.28U W=0.36U AS=0.1584P AD=0.1188P
+ PS=1.6U PD=1.02U
M$5162 \$4343 \$4290 \$4342 VSS nfet_03v3 L=0.28U W=0.36U AS=0.1188P AD=0.1278P
+ PS=1.02U PD=1.07U
M$5163 \$4562 \$4344 \$4343 VSS nfet_03v3 L=0.28U W=0.36U AS=0.1278P AD=0.0567P
+ PS=1.07U PD=0.675U
M$5164 VSS \$4291 \$4562 VSS nfet_03v3 L=0.28U W=0.36U AS=0.0567P AD=0.1584P
+ PS=0.675U PD=1.6U
M$5165 VSS \$4343 \$4344 VSS nfet_03v3 L=0.28U W=0.36U AS=0.1584P AD=0.0972P
+ PS=1.6U PD=0.9U
M$5166 \$4345 \$4343 VSS VSS nfet_03v3 L=0.28U W=0.36U AS=0.0972P AD=0.18P
+ PS=0.9U PD=1.72U
M$5167 \$4348 \$71 VSS VSS nfet_03v3 L=0.28U W=0.36U AS=0.1584P AD=0.1188P
+ PS=1.6U PD=1.02U
M$5168 \$4349 \$4290 \$4348 VSS nfet_03v3 L=0.28U W=0.36U AS=0.1188P AD=0.1278P
+ PS=1.02U PD=1.07U
M$5169 \$4570 \$4350 \$4349 VSS nfet_03v3 L=0.28U W=0.36U AS=0.1278P AD=0.0567P
+ PS=1.07U PD=0.675U
M$5170 VSS \$4291 \$4570 VSS nfet_03v3 L=0.28U W=0.36U AS=0.0567P AD=0.1584P
+ PS=0.675U PD=1.6U
M$5171 VSS \$4349 \$4350 VSS nfet_03v3 L=0.28U W=0.36U AS=0.1584P AD=0.0972P
+ PS=1.6U PD=0.9U
M$5172 \$4351 \$4349 VSS VSS nfet_03v3 L=0.28U W=0.36U AS=0.0972P AD=0.18P
+ PS=0.9U PD=1.72U
M$5173 \$4354 \$74 VSS VSS nfet_03v3 L=0.28U W=0.36U AS=0.1584P AD=0.1188P
+ PS=1.6U PD=1.02U
M$5174 \$4355 \$4290 \$4354 VSS nfet_03v3 L=0.28U W=0.36U AS=0.1188P AD=0.1278P
+ PS=1.02U PD=1.07U
M$5175 \$4579 \$4356 \$4355 VSS nfet_03v3 L=0.28U W=0.36U AS=0.1278P AD=0.0567P
+ PS=1.07U PD=0.675U
M$5176 VSS \$4291 \$4579 VSS nfet_03v3 L=0.28U W=0.36U AS=0.0567P AD=0.1584P
+ PS=0.675U PD=1.6U
M$5177 VSS \$4355 \$4356 VSS nfet_03v3 L=0.28U W=0.36U AS=0.1584P AD=0.0972P
+ PS=1.6U PD=0.9U
M$5178 \$4357 \$4355 VSS VSS nfet_03v3 L=0.28U W=0.36U AS=0.0972P AD=0.18P
+ PS=0.9U PD=1.72U
M$5179 \$4360 \$77 VSS VSS nfet_03v3 L=0.28U W=0.36U AS=0.1584P AD=0.1188P
+ PS=1.6U PD=1.02U
M$5180 \$4361 \$4290 \$4360 VSS nfet_03v3 L=0.28U W=0.36U AS=0.1188P AD=0.1278P
+ PS=1.02U PD=1.07U
M$5181 \$4586 \$4362 \$4361 VSS nfet_03v3 L=0.28U W=0.36U AS=0.1278P AD=0.0567P
+ PS=1.07U PD=0.675U
M$5182 VSS \$4291 \$4586 VSS nfet_03v3 L=0.28U W=0.36U AS=0.0567P AD=0.1584P
+ PS=0.675U PD=1.6U
M$5183 VSS \$4361 \$4362 VSS nfet_03v3 L=0.28U W=0.36U AS=0.1584P AD=0.0972P
+ PS=1.6U PD=0.9U
M$5184 \$4363 \$4361 VSS VSS nfet_03v3 L=0.28U W=0.36U AS=0.0972P AD=0.18P
+ PS=0.9U PD=1.72U
M$5185 \$4366 \$80 VSS VSS nfet_03v3 L=0.28U W=0.36U AS=0.1584P AD=0.1188P
+ PS=1.6U PD=1.02U
M$5186 \$4367 \$4290 \$4366 VSS nfet_03v3 L=0.28U W=0.36U AS=0.1188P AD=0.1278P
+ PS=1.02U PD=1.07U
M$5187 \$4578 \$4368 \$4367 VSS nfet_03v3 L=0.28U W=0.36U AS=0.1278P AD=0.0567P
+ PS=1.07U PD=0.675U
M$5188 VSS \$4291 \$4578 VSS nfet_03v3 L=0.28U W=0.36U AS=0.0567P AD=0.1584P
+ PS=0.675U PD=1.6U
M$5189 VSS \$4367 \$4368 VSS nfet_03v3 L=0.28U W=0.36U AS=0.1584P AD=0.0972P
+ PS=1.6U PD=0.9U
M$5190 \$4369 \$4367 VSS VSS nfet_03v3 L=0.28U W=0.36U AS=0.0972P AD=0.18P
+ PS=0.9U PD=1.72U
M$5191 \$4372 \$83 VSS VSS nfet_03v3 L=0.28U W=0.36U AS=0.1584P AD=0.1188P
+ PS=1.6U PD=1.02U
M$5192 \$4373 \$4290 \$4372 VSS nfet_03v3 L=0.28U W=0.36U AS=0.1188P AD=0.1278P
+ PS=1.02U PD=1.07U
M$5193 \$4554 \$4374 \$4373 VSS nfet_03v3 L=0.28U W=0.36U AS=0.1278P AD=0.0567P
+ PS=1.07U PD=0.675U
M$5194 VSS \$4291 \$4554 VSS nfet_03v3 L=0.28U W=0.36U AS=0.0567P AD=0.1584P
+ PS=0.675U PD=1.6U
M$5195 VSS \$4373 \$4374 VSS nfet_03v3 L=0.28U W=0.36U AS=0.1584P AD=0.0972P
+ PS=1.6U PD=0.9U
M$5196 \$4375 \$4373 VSS VSS nfet_03v3 L=0.28U W=0.36U AS=0.0972P AD=0.18P
+ PS=0.9U PD=1.72U
M$5197 \$4378 \$86 VSS VSS nfet_03v3 L=0.28U W=0.36U AS=0.1584P AD=0.1188P
+ PS=1.6U PD=1.02U
M$5198 \$4379 \$4290 \$4378 VSS nfet_03v3 L=0.28U W=0.36U AS=0.1188P AD=0.1278P
+ PS=1.02U PD=1.07U
M$5199 \$4530 \$4380 \$4379 VSS nfet_03v3 L=0.28U W=0.36U AS=0.1278P AD=0.0567P
+ PS=1.07U PD=0.675U
M$5200 VSS \$4291 \$4530 VSS nfet_03v3 L=0.28U W=0.36U AS=0.0567P AD=0.1584P
+ PS=0.675U PD=1.6U
M$5201 VSS \$4379 \$4380 VSS nfet_03v3 L=0.28U W=0.36U AS=0.1584P AD=0.0972P
+ PS=1.6U PD=0.9U
M$5202 \$4381 \$4379 VSS VSS nfet_03v3 L=0.28U W=0.36U AS=0.0972P AD=0.18P
+ PS=0.9U PD=1.72U
M$5203 \$4384 \$89 VSS VSS nfet_03v3 L=0.28U W=0.36U AS=0.1584P AD=0.1188P
+ PS=1.6U PD=1.02U
M$5204 \$4385 \$4290 \$4384 VSS nfet_03v3 L=0.28U W=0.36U AS=0.1188P AD=0.1278P
+ PS=1.02U PD=1.07U
M$5205 \$4506 \$4386 \$4385 VSS nfet_03v3 L=0.28U W=0.36U AS=0.1278P AD=0.0567P
+ PS=1.07U PD=0.675U
M$5206 VSS \$4291 \$4506 VSS nfet_03v3 L=0.28U W=0.36U AS=0.0567P AD=0.1584P
+ PS=0.675U PD=1.6U
M$5207 VSS \$4385 \$4386 VSS nfet_03v3 L=0.28U W=0.36U AS=0.1584P AD=0.0972P
+ PS=1.6U PD=0.9U
M$5208 \$4387 \$4385 VSS VSS nfet_03v3 L=0.28U W=0.36U AS=0.0972P AD=0.18P
+ PS=0.9U PD=1.72U
M$5209 \$4746 WE1 VSS VSS nfet_03v3 L=0.28U W=0.72U AS=0.3168P AD=0.1872P
+ PS=2.32U PD=1.24U
M$5210 \$4591 CLK \$4746 VSS nfet_03v3 L=0.28U W=0.72U AS=0.1872P AD=0.3168P
+ PS=1.24U PD=2.32U
M$5211 \$4592 \$4591 VSS VSS nfet_03v3 L=0.28U W=1.27U AS=0.4445P AD=0.3344P
+ PS=3.305U PD=2.345U
M$5213 \$4593 \$4592 VSS VSS nfet_03v3 L=0.28U W=1.34U AS=0.3636P AD=0.4891P
+ PS=2.44U PD=3.47U
M$5215 \$4594 \$44 VSS VSS nfet_03v3 L=0.28U W=0.36U AS=0.1584P AD=0.1188P
+ PS=1.6U PD=1.02U
M$5216 \$4595 \$4592 \$4594 VSS nfet_03v3 L=0.28U W=0.36U AS=0.1188P AD=0.1278P
+ PS=1.02U PD=1.07U
M$5217 \$4663 \$4596 \$4595 VSS nfet_03v3 L=0.28U W=0.36U AS=0.1278P AD=0.0567P
+ PS=1.07U PD=0.675U
M$5218 VSS \$4593 \$4663 VSS nfet_03v3 L=0.28U W=0.36U AS=0.0567P AD=0.1584P
+ PS=0.675U PD=1.6U
M$5219 VSS \$4595 \$4596 VSS nfet_03v3 L=0.28U W=0.36U AS=0.1584P AD=0.0972P
+ PS=1.6U PD=0.9U
M$5220 \$4597 \$4595 VSS VSS nfet_03v3 L=0.28U W=0.36U AS=0.0972P AD=0.18P
+ PS=0.9U PD=1.72U
M$5221 \$4598 \$47 VSS VSS nfet_03v3 L=0.28U W=0.36U AS=0.1584P AD=0.1188P
+ PS=1.6U PD=1.02U
M$5222 \$4599 \$4592 \$4598 VSS nfet_03v3 L=0.28U W=0.36U AS=0.1188P AD=0.1278P
+ PS=1.02U PD=1.07U
M$5223 \$4673 \$4600 \$4599 VSS nfet_03v3 L=0.28U W=0.36U AS=0.1278P AD=0.0567P
+ PS=1.07U PD=0.675U
M$5224 VSS \$4593 \$4673 VSS nfet_03v3 L=0.28U W=0.36U AS=0.0567P AD=0.1584P
+ PS=0.675U PD=1.6U
M$5225 VSS \$4599 \$4600 VSS nfet_03v3 L=0.28U W=0.36U AS=0.1584P AD=0.0972P
+ PS=1.6U PD=0.9U
M$5226 \$4601 \$4599 VSS VSS nfet_03v3 L=0.28U W=0.36U AS=0.0972P AD=0.18P
+ PS=0.9U PD=1.72U
M$5227 \$4602 \$50 VSS VSS nfet_03v3 L=0.28U W=0.36U AS=0.1584P AD=0.1188P
+ PS=1.6U PD=1.02U
M$5228 \$4603 \$4592 \$4602 VSS nfet_03v3 L=0.28U W=0.36U AS=0.1188P AD=0.1278P
+ PS=1.02U PD=1.07U
M$5229 \$4681 \$4604 \$4603 VSS nfet_03v3 L=0.28U W=0.36U AS=0.1278P AD=0.0567P
+ PS=1.07U PD=0.675U
M$5230 VSS \$4593 \$4681 VSS nfet_03v3 L=0.28U W=0.36U AS=0.0567P AD=0.1584P
+ PS=0.675U PD=1.6U
M$5231 VSS \$4603 \$4604 VSS nfet_03v3 L=0.28U W=0.36U AS=0.1584P AD=0.0972P
+ PS=1.6U PD=0.9U
M$5232 \$4605 \$4603 VSS VSS nfet_03v3 L=0.28U W=0.36U AS=0.0972P AD=0.18P
+ PS=0.9U PD=1.72U
M$5233 \$4606 \$53 VSS VSS nfet_03v3 L=0.28U W=0.36U AS=0.1584P AD=0.1188P
+ PS=1.6U PD=1.02U
M$5234 \$4607 \$4592 \$4606 VSS nfet_03v3 L=0.28U W=0.36U AS=0.1188P AD=0.1278P
+ PS=1.02U PD=1.07U
M$5235 \$4690 \$4608 \$4607 VSS nfet_03v3 L=0.28U W=0.36U AS=0.1278P AD=0.0567P
+ PS=1.07U PD=0.675U
M$5236 VSS \$4593 \$4690 VSS nfet_03v3 L=0.28U W=0.36U AS=0.0567P AD=0.1584P
+ PS=0.675U PD=1.6U
M$5237 VSS \$4607 \$4608 VSS nfet_03v3 L=0.28U W=0.36U AS=0.1584P AD=0.0972P
+ PS=1.6U PD=0.9U
M$5238 \$4609 \$4607 VSS VSS nfet_03v3 L=0.28U W=0.36U AS=0.0972P AD=0.18P
+ PS=0.9U PD=1.72U
M$5239 \$4610 \$56 VSS VSS nfet_03v3 L=0.28U W=0.36U AS=0.1584P AD=0.1188P
+ PS=1.6U PD=1.02U
M$5240 \$4611 \$4592 \$4610 VSS nfet_03v3 L=0.28U W=0.36U AS=0.1188P AD=0.1278P
+ PS=1.02U PD=1.07U
M$5241 \$4699 \$4612 \$4611 VSS nfet_03v3 L=0.28U W=0.36U AS=0.1278P AD=0.0567P
+ PS=1.07U PD=0.675U
M$5242 VSS \$4593 \$4699 VSS nfet_03v3 L=0.28U W=0.36U AS=0.0567P AD=0.1584P
+ PS=0.675U PD=1.6U
M$5243 VSS \$4611 \$4612 VSS nfet_03v3 L=0.28U W=0.36U AS=0.1584P AD=0.0972P
+ PS=1.6U PD=0.9U
M$5244 \$4613 \$4611 VSS VSS nfet_03v3 L=0.28U W=0.36U AS=0.0972P AD=0.18P
+ PS=0.9U PD=1.72U
M$5245 \$4614 \$59 VSS VSS nfet_03v3 L=0.28U W=0.36U AS=0.1584P AD=0.1188P
+ PS=1.6U PD=1.02U
M$5246 \$4615 \$4592 \$4614 VSS nfet_03v3 L=0.28U W=0.36U AS=0.1188P AD=0.1278P
+ PS=1.02U PD=1.07U
M$5247 \$4707 \$4616 \$4615 VSS nfet_03v3 L=0.28U W=0.36U AS=0.1278P AD=0.0567P
+ PS=1.07U PD=0.675U
M$5248 VSS \$4593 \$4707 VSS nfet_03v3 L=0.28U W=0.36U AS=0.0567P AD=0.1584P
+ PS=0.675U PD=1.6U
M$5249 VSS \$4615 \$4616 VSS nfet_03v3 L=0.28U W=0.36U AS=0.1584P AD=0.0972P
+ PS=1.6U PD=0.9U
M$5250 \$4617 \$4615 VSS VSS nfet_03v3 L=0.28U W=0.36U AS=0.0972P AD=0.18P
+ PS=0.9U PD=1.72U
M$5251 \$4618 \$62 VSS VSS nfet_03v3 L=0.28U W=0.36U AS=0.1584P AD=0.1188P
+ PS=1.6U PD=1.02U
M$5252 \$4619 \$4592 \$4618 VSS nfet_03v3 L=0.28U W=0.36U AS=0.1188P AD=0.1278P
+ PS=1.02U PD=1.07U
M$5253 \$4710 \$4620 \$4619 VSS nfet_03v3 L=0.28U W=0.36U AS=0.1278P AD=0.0567P
+ PS=1.07U PD=0.675U
M$5254 VSS \$4593 \$4710 VSS nfet_03v3 L=0.28U W=0.36U AS=0.0567P AD=0.1584P
+ PS=0.675U PD=1.6U
M$5255 VSS \$4619 \$4620 VSS nfet_03v3 L=0.28U W=0.36U AS=0.1584P AD=0.0972P
+ PS=1.6U PD=0.9U
M$5256 \$4621 \$4619 VSS VSS nfet_03v3 L=0.28U W=0.36U AS=0.0972P AD=0.18P
+ PS=0.9U PD=1.72U
M$5257 \$4622 \$65 VSS VSS nfet_03v3 L=0.28U W=0.36U AS=0.1584P AD=0.1188P
+ PS=1.6U PD=1.02U
M$5258 \$4623 \$4592 \$4622 VSS nfet_03v3 L=0.28U W=0.36U AS=0.1188P AD=0.1278P
+ PS=1.02U PD=1.07U
M$5259 \$4704 \$4624 \$4623 VSS nfet_03v3 L=0.28U W=0.36U AS=0.1278P AD=0.0567P
+ PS=1.07U PD=0.675U
M$5260 VSS \$4593 \$4704 VSS nfet_03v3 L=0.28U W=0.36U AS=0.0567P AD=0.1584P
+ PS=0.675U PD=1.6U
M$5261 VSS \$4623 \$4624 VSS nfet_03v3 L=0.28U W=0.36U AS=0.1584P AD=0.0972P
+ PS=1.6U PD=0.9U
M$5262 \$4625 \$4623 VSS VSS nfet_03v3 L=0.28U W=0.36U AS=0.0972P AD=0.18P
+ PS=0.9U PD=1.72U
M$5263 \$4626 \$68 VSS VSS nfet_03v3 L=0.28U W=0.36U AS=0.1584P AD=0.1188P
+ PS=1.6U PD=1.02U
M$5264 \$4627 \$4592 \$4626 VSS nfet_03v3 L=0.28U W=0.36U AS=0.1188P AD=0.1278P
+ PS=1.02U PD=1.07U
M$5265 \$4698 \$4628 \$4627 VSS nfet_03v3 L=0.28U W=0.36U AS=0.1278P AD=0.0567P
+ PS=1.07U PD=0.675U
M$5266 VSS \$4593 \$4698 VSS nfet_03v3 L=0.28U W=0.36U AS=0.0567P AD=0.1584P
+ PS=0.675U PD=1.6U
M$5267 VSS \$4627 \$4628 VSS nfet_03v3 L=0.28U W=0.36U AS=0.1584P AD=0.0972P
+ PS=1.6U PD=0.9U
M$5268 \$4629 \$4627 VSS VSS nfet_03v3 L=0.28U W=0.36U AS=0.0972P AD=0.18P
+ PS=0.9U PD=1.72U
M$5269 \$4630 \$71 VSS VSS nfet_03v3 L=0.28U W=0.36U AS=0.1584P AD=0.1188P
+ PS=1.6U PD=1.02U
M$5270 \$4631 \$4592 \$4630 VSS nfet_03v3 L=0.28U W=0.36U AS=0.1188P AD=0.1278P
+ PS=1.02U PD=1.07U
M$5271 \$4694 \$4632 \$4631 VSS nfet_03v3 L=0.28U W=0.36U AS=0.1278P AD=0.0567P
+ PS=1.07U PD=0.675U
M$5272 VSS \$4593 \$4694 VSS nfet_03v3 L=0.28U W=0.36U AS=0.0567P AD=0.1584P
+ PS=0.675U PD=1.6U
M$5273 VSS \$4631 \$4632 VSS nfet_03v3 L=0.28U W=0.36U AS=0.1584P AD=0.0972P
+ PS=1.6U PD=0.9U
M$5274 \$4633 \$4631 VSS VSS nfet_03v3 L=0.28U W=0.36U AS=0.0972P AD=0.18P
+ PS=0.9U PD=1.72U
M$5275 \$4634 \$74 VSS VSS nfet_03v3 L=0.28U W=0.36U AS=0.1584P AD=0.1188P
+ PS=1.6U PD=1.02U
M$5276 \$4635 \$4592 \$4634 VSS nfet_03v3 L=0.28U W=0.36U AS=0.1188P AD=0.1278P
+ PS=1.02U PD=1.07U
M$5277 \$4687 \$4636 \$4635 VSS nfet_03v3 L=0.28U W=0.36U AS=0.1278P AD=0.0567P
+ PS=1.07U PD=0.675U
M$5278 VSS \$4593 \$4687 VSS nfet_03v3 L=0.28U W=0.36U AS=0.0567P AD=0.1584P
+ PS=0.675U PD=1.6U
M$5279 VSS \$4635 \$4636 VSS nfet_03v3 L=0.28U W=0.36U AS=0.1584P AD=0.0972P
+ PS=1.6U PD=0.9U
M$5280 \$4637 \$4635 VSS VSS nfet_03v3 L=0.28U W=0.36U AS=0.0972P AD=0.18P
+ PS=0.9U PD=1.72U
M$5281 \$4638 \$77 VSS VSS nfet_03v3 L=0.28U W=0.36U AS=0.1584P AD=0.1188P
+ PS=1.6U PD=1.02U
M$5282 \$4639 \$4592 \$4638 VSS nfet_03v3 L=0.28U W=0.36U AS=0.1188P AD=0.1278P
+ PS=1.02U PD=1.07U
M$5283 \$4683 \$4640 \$4639 VSS nfet_03v3 L=0.28U W=0.36U AS=0.1278P AD=0.0567P
+ PS=1.07U PD=0.675U
M$5284 VSS \$4593 \$4683 VSS nfet_03v3 L=0.28U W=0.36U AS=0.0567P AD=0.1584P
+ PS=0.675U PD=1.6U
M$5285 VSS \$4639 \$4640 VSS nfet_03v3 L=0.28U W=0.36U AS=0.1584P AD=0.0972P
+ PS=1.6U PD=0.9U
M$5286 \$4641 \$4639 VSS VSS nfet_03v3 L=0.28U W=0.36U AS=0.0972P AD=0.18P
+ PS=0.9U PD=1.72U
M$5287 \$4642 \$80 VSS VSS nfet_03v3 L=0.28U W=0.36U AS=0.1584P AD=0.1188P
+ PS=1.6U PD=1.02U
M$5288 \$4643 \$4592 \$4642 VSS nfet_03v3 L=0.28U W=0.36U AS=0.1188P AD=0.1278P
+ PS=1.02U PD=1.07U
M$5289 \$4678 \$4644 \$4643 VSS nfet_03v3 L=0.28U W=0.36U AS=0.1278P AD=0.0567P
+ PS=1.07U PD=0.675U
M$5290 VSS \$4593 \$4678 VSS nfet_03v3 L=0.28U W=0.36U AS=0.0567P AD=0.1584P
+ PS=0.675U PD=1.6U
M$5291 VSS \$4643 \$4644 VSS nfet_03v3 L=0.28U W=0.36U AS=0.1584P AD=0.0972P
+ PS=1.6U PD=0.9U
M$5292 \$4645 \$4643 VSS VSS nfet_03v3 L=0.28U W=0.36U AS=0.0972P AD=0.18P
+ PS=0.9U PD=1.72U
M$5293 \$4646 \$83 VSS VSS nfet_03v3 L=0.28U W=0.36U AS=0.1584P AD=0.1188P
+ PS=1.6U PD=1.02U
M$5294 \$4647 \$4592 \$4646 VSS nfet_03v3 L=0.28U W=0.36U AS=0.1188P AD=0.1278P
+ PS=1.02U PD=1.07U
M$5295 \$4671 \$4648 \$4647 VSS nfet_03v3 L=0.28U W=0.36U AS=0.1278P AD=0.0567P
+ PS=1.07U PD=0.675U
M$5296 VSS \$4593 \$4671 VSS nfet_03v3 L=0.28U W=0.36U AS=0.0567P AD=0.1584P
+ PS=0.675U PD=1.6U
M$5297 VSS \$4647 \$4648 VSS nfet_03v3 L=0.28U W=0.36U AS=0.1584P AD=0.0972P
+ PS=1.6U PD=0.9U
M$5298 \$4649 \$4647 VSS VSS nfet_03v3 L=0.28U W=0.36U AS=0.0972P AD=0.18P
+ PS=0.9U PD=1.72U
M$5299 \$4650 \$86 VSS VSS nfet_03v3 L=0.28U W=0.36U AS=0.1584P AD=0.1188P
+ PS=1.6U PD=1.02U
M$5300 \$4651 \$4592 \$4650 VSS nfet_03v3 L=0.28U W=0.36U AS=0.1188P AD=0.1278P
+ PS=1.02U PD=1.07U
M$5301 \$4667 \$4652 \$4651 VSS nfet_03v3 L=0.28U W=0.36U AS=0.1278P AD=0.0567P
+ PS=1.07U PD=0.675U
M$5302 VSS \$4593 \$4667 VSS nfet_03v3 L=0.28U W=0.36U AS=0.0567P AD=0.1584P
+ PS=0.675U PD=1.6U
M$5303 VSS \$4651 \$4652 VSS nfet_03v3 L=0.28U W=0.36U AS=0.1584P AD=0.0972P
+ PS=1.6U PD=0.9U
M$5304 \$4653 \$4651 VSS VSS nfet_03v3 L=0.28U W=0.36U AS=0.0972P AD=0.18P
+ PS=0.9U PD=1.72U
M$5305 \$4654 \$89 VSS VSS nfet_03v3 L=0.28U W=0.36U AS=0.1584P AD=0.1188P
+ PS=1.6U PD=1.02U
M$5306 \$4655 \$4592 \$4654 VSS nfet_03v3 L=0.28U W=0.36U AS=0.1188P AD=0.1278P
+ PS=1.02U PD=1.07U
M$5307 \$4660 \$4656 \$4655 VSS nfet_03v3 L=0.28U W=0.36U AS=0.1278P AD=0.0567P
+ PS=1.07U PD=0.675U
M$5308 VSS \$4593 \$4660 VSS nfet_03v3 L=0.28U W=0.36U AS=0.0567P AD=0.1584P
+ PS=0.675U PD=1.6U
M$5309 VSS \$4655 \$4656 VSS nfet_03v3 L=0.28U W=0.36U AS=0.1584P AD=0.0972P
+ PS=1.6U PD=0.9U
M$5310 \$4657 \$4655 VSS VSS nfet_03v3 L=0.28U W=0.36U AS=0.0972P AD=0.18P
+ PS=0.9U PD=1.72U
M$5311 \$4917 RB0 VSS VSS nfet_03v3 L=0.28U W=0.36U AS=0.1656P AD=0.1944P
+ PS=1.64U PD=1.8U
M$5312 \$4714 RA1 VSS VSS nfet_03v3 L=0.28U W=0.36U AS=0.1656P AD=0.1944P
+ PS=1.64U PD=1.8U
M$5313 \$4916 RB0 \$360 VSS nfet_03v3 L=0.28U W=0.36U AS=0.1584P AD=0.1152P
+ PS=1.6U PD=1U
M$5314 \$361 RA0 \$4916 VSS nfet_03v3 L=0.28U W=0.36U AS=0.1152P AD=0.1584P
+ PS=1U PD=1.6U
M$5315 \$4597 RA1 \$360 VSS nfet_03v3 L=0.28U W=0.36U AS=0.1584P AD=0.1152P
+ PS=1.6U PD=1U
M$5316 \$361 RB1 \$4597 VSS nfet_03v3 L=0.28U W=0.36U AS=0.1152P AD=0.1584P
+ PS=1U PD=1.6U
M$5317 VSS RB1 \$4715 VSS nfet_03v3 L=0.28U W=0.36U AS=0.1854P AD=0.1584P
+ PS=1.75U PD=1.6U
M$5318 VSS RA0 \$4918 VSS nfet_03v3 L=0.28U W=0.36U AS=0.1854P AD=0.1584P
+ PS=1.75U PD=1.6U
M$5319 \$4716 RA1 VSS VSS nfet_03v3 L=0.28U W=0.36U AS=0.1656P AD=0.1944P
+ PS=1.64U PD=1.8U
M$5320 \$4923 RB0 VSS VSS nfet_03v3 L=0.28U W=0.36U AS=0.1656P AD=0.1944P
+ PS=1.64U PD=1.8U
M$5321 \$4922 RB0 \$365 VSS nfet_03v3 L=0.28U W=0.36U AS=0.1584P AD=0.1152P
+ PS=1.6U PD=1U
M$5322 \$366 RA0 \$4922 VSS nfet_03v3 L=0.28U W=0.36U AS=0.1152P AD=0.1584P
+ PS=1U PD=1.6U
M$5323 \$4601 RA1 \$365 VSS nfet_03v3 L=0.28U W=0.36U AS=0.1584P AD=0.1152P
+ PS=1.6U PD=1U
M$5324 \$366 RB1 \$4601 VSS nfet_03v3 L=0.28U W=0.36U AS=0.1152P AD=0.1584P
+ PS=1U PD=1.6U
M$5325 VSS RB1 \$4717 VSS nfet_03v3 L=0.28U W=0.36U AS=0.1854P AD=0.1584P
+ PS=1.75U PD=1.6U
M$5326 VSS RA0 \$4924 VSS nfet_03v3 L=0.28U W=0.36U AS=0.1854P AD=0.1584P
+ PS=1.75U PD=1.6U
M$5327 \$4929 RB0 VSS VSS nfet_03v3 L=0.28U W=0.36U AS=0.1656P AD=0.1944P
+ PS=1.64U PD=1.8U
M$5328 \$4718 RA1 VSS VSS nfet_03v3 L=0.28U W=0.36U AS=0.1656P AD=0.1944P
+ PS=1.64U PD=1.8U
M$5329 \$4928 RB0 \$370 VSS nfet_03v3 L=0.28U W=0.36U AS=0.1584P AD=0.1152P
+ PS=1.6U PD=1U
M$5330 \$371 RA0 \$4928 VSS nfet_03v3 L=0.28U W=0.36U AS=0.1152P AD=0.1584P
+ PS=1U PD=1.6U
M$5331 \$4605 RA1 \$370 VSS nfet_03v3 L=0.28U W=0.36U AS=0.1584P AD=0.1152P
+ PS=1.6U PD=1U
M$5332 \$371 RB1 \$4605 VSS nfet_03v3 L=0.28U W=0.36U AS=0.1152P AD=0.1584P
+ PS=1U PD=1.6U
M$5333 VSS RB1 \$4719 VSS nfet_03v3 L=0.28U W=0.36U AS=0.1854P AD=0.1584P
+ PS=1.75U PD=1.6U
M$5334 VSS RA0 \$4930 VSS nfet_03v3 L=0.28U W=0.36U AS=0.1854P AD=0.1584P
+ PS=1.75U PD=1.6U
M$5335 \$4720 RA1 VSS VSS nfet_03v3 L=0.28U W=0.36U AS=0.1656P AD=0.1944P
+ PS=1.64U PD=1.8U
M$5336 \$4935 RB0 VSS VSS nfet_03v3 L=0.28U W=0.36U AS=0.1656P AD=0.1944P
+ PS=1.64U PD=1.8U
M$5337 \$4934 RB0 \$375 VSS nfet_03v3 L=0.28U W=0.36U AS=0.1584P AD=0.1152P
+ PS=1.6U PD=1U
M$5338 \$376 RA0 \$4934 VSS nfet_03v3 L=0.28U W=0.36U AS=0.1152P AD=0.1584P
+ PS=1U PD=1.6U
M$5339 \$4609 RA1 \$375 VSS nfet_03v3 L=0.28U W=0.36U AS=0.1584P AD=0.1152P
+ PS=1.6U PD=1U
M$5340 \$376 RB1 \$4609 VSS nfet_03v3 L=0.28U W=0.36U AS=0.1152P AD=0.1584P
+ PS=1U PD=1.6U
M$5341 VSS RB1 \$4721 VSS nfet_03v3 L=0.28U W=0.36U AS=0.1854P AD=0.1584P
+ PS=1.75U PD=1.6U
M$5342 VSS RA0 \$4936 VSS nfet_03v3 L=0.28U W=0.36U AS=0.1854P AD=0.1584P
+ PS=1.75U PD=1.6U
M$5343 \$4941 RB0 VSS VSS nfet_03v3 L=0.28U W=0.36U AS=0.1656P AD=0.1944P
+ PS=1.64U PD=1.8U
M$5344 \$4722 RA1 VSS VSS nfet_03v3 L=0.28U W=0.36U AS=0.1656P AD=0.1944P
+ PS=1.64U PD=1.8U
M$5345 \$4613 RA1 \$380 VSS nfet_03v3 L=0.28U W=0.36U AS=0.1584P AD=0.1152P
+ PS=1.6U PD=1U
M$5346 \$381 RB1 \$4613 VSS nfet_03v3 L=0.28U W=0.36U AS=0.1152P AD=0.1584P
+ PS=1U PD=1.6U
M$5347 \$4940 RB0 \$380 VSS nfet_03v3 L=0.28U W=0.36U AS=0.1584P AD=0.1152P
+ PS=1.6U PD=1U
M$5348 \$381 RA0 \$4940 VSS nfet_03v3 L=0.28U W=0.36U AS=0.1152P AD=0.1584P
+ PS=1U PD=1.6U
M$5349 VSS RA0 \$4942 VSS nfet_03v3 L=0.28U W=0.36U AS=0.1854P AD=0.1584P
+ PS=1.75U PD=1.6U
M$5350 VSS RB1 \$4723 VSS nfet_03v3 L=0.28U W=0.36U AS=0.1854P AD=0.1584P
+ PS=1.75U PD=1.6U
M$5351 \$4724 RA1 VSS VSS nfet_03v3 L=0.28U W=0.36U AS=0.1656P AD=0.1944P
+ PS=1.64U PD=1.8U
M$5352 \$4947 RB0 VSS VSS nfet_03v3 L=0.28U W=0.36U AS=0.1656P AD=0.1944P
+ PS=1.64U PD=1.8U
M$5353 \$4617 RA1 \$385 VSS nfet_03v3 L=0.28U W=0.36U AS=0.1584P AD=0.1152P
+ PS=1.6U PD=1U
M$5354 \$386 RB1 \$4617 VSS nfet_03v3 L=0.28U W=0.36U AS=0.1152P AD=0.1584P
+ PS=1U PD=1.6U
M$5355 \$4946 RB0 \$385 VSS nfet_03v3 L=0.28U W=0.36U AS=0.1584P AD=0.1152P
+ PS=1.6U PD=1U
M$5356 \$386 RA0 \$4946 VSS nfet_03v3 L=0.28U W=0.36U AS=0.1152P AD=0.1584P
+ PS=1U PD=1.6U
M$5357 VSS RB1 \$4725 VSS nfet_03v3 L=0.28U W=0.36U AS=0.1854P AD=0.1584P
+ PS=1.75U PD=1.6U
M$5358 VSS RA0 \$4948 VSS nfet_03v3 L=0.28U W=0.36U AS=0.1854P AD=0.1584P
+ PS=1.75U PD=1.6U
M$5359 \$4726 RA1 VSS VSS nfet_03v3 L=0.28U W=0.36U AS=0.1656P AD=0.1944P
+ PS=1.64U PD=1.8U
M$5360 \$4953 RB0 VSS VSS nfet_03v3 L=0.28U W=0.36U AS=0.1656P AD=0.1944P
+ PS=1.64U PD=1.8U
M$5361 \$4621 RA1 \$390 VSS nfet_03v3 L=0.28U W=0.36U AS=0.1584P AD=0.1152P
+ PS=1.6U PD=1U
M$5362 \$391 RB1 \$4621 VSS nfet_03v3 L=0.28U W=0.36U AS=0.1152P AD=0.1584P
+ PS=1U PD=1.6U
M$5363 \$4952 RB0 \$390 VSS nfet_03v3 L=0.28U W=0.36U AS=0.1584P AD=0.1152P
+ PS=1.6U PD=1U
M$5364 \$391 RA0 \$4952 VSS nfet_03v3 L=0.28U W=0.36U AS=0.1152P AD=0.1584P
+ PS=1U PD=1.6U
M$5365 VSS RA0 \$4954 VSS nfet_03v3 L=0.28U W=0.36U AS=0.1854P AD=0.1584P
+ PS=1.75U PD=1.6U
M$5366 VSS RB1 \$4727 VSS nfet_03v3 L=0.28U W=0.36U AS=0.1854P AD=0.1584P
+ PS=1.75U PD=1.6U
M$5367 \$4728 RA1 VSS VSS nfet_03v3 L=0.28U W=0.36U AS=0.1656P AD=0.1944P
+ PS=1.64U PD=1.8U
M$5368 \$4959 RB0 VSS VSS nfet_03v3 L=0.28U W=0.36U AS=0.1656P AD=0.1944P
+ PS=1.64U PD=1.8U
M$5369 \$4625 RA1 \$395 VSS nfet_03v3 L=0.28U W=0.36U AS=0.1584P AD=0.1152P
+ PS=1.6U PD=1U
M$5370 \$396 RB1 \$4625 VSS nfet_03v3 L=0.28U W=0.36U AS=0.1152P AD=0.1584P
+ PS=1U PD=1.6U
M$5371 \$4958 RB0 \$395 VSS nfet_03v3 L=0.28U W=0.36U AS=0.1584P AD=0.1152P
+ PS=1.6U PD=1U
M$5372 \$396 RA0 \$4958 VSS nfet_03v3 L=0.28U W=0.36U AS=0.1152P AD=0.1584P
+ PS=1U PD=1.6U
M$5373 VSS RB1 \$4729 VSS nfet_03v3 L=0.28U W=0.36U AS=0.1854P AD=0.1584P
+ PS=1.75U PD=1.6U
M$5374 VSS RA0 \$4960 VSS nfet_03v3 L=0.28U W=0.36U AS=0.1854P AD=0.1584P
+ PS=1.75U PD=1.6U
M$5375 \$4965 RB0 VSS VSS nfet_03v3 L=0.28U W=0.36U AS=0.1656P AD=0.1944P
+ PS=1.64U PD=1.8U
M$5376 \$4730 RA1 VSS VSS nfet_03v3 L=0.28U W=0.36U AS=0.1656P AD=0.1944P
+ PS=1.64U PD=1.8U
M$5377 \$4629 RA1 \$400 VSS nfet_03v3 L=0.28U W=0.36U AS=0.1584P AD=0.1152P
+ PS=1.6U PD=1U
M$5378 \$401 RB1 \$4629 VSS nfet_03v3 L=0.28U W=0.36U AS=0.1152P AD=0.1584P
+ PS=1U PD=1.6U
M$5379 \$4964 RB0 \$400 VSS nfet_03v3 L=0.28U W=0.36U AS=0.1584P AD=0.1152P
+ PS=1.6U PD=1U
M$5380 \$401 RA0 \$4964 VSS nfet_03v3 L=0.28U W=0.36U AS=0.1152P AD=0.1584P
+ PS=1U PD=1.6U
M$5381 VSS RB1 \$4731 VSS nfet_03v3 L=0.28U W=0.36U AS=0.1854P AD=0.1584P
+ PS=1.75U PD=1.6U
M$5382 VSS RA0 \$4966 VSS nfet_03v3 L=0.28U W=0.36U AS=0.1854P AD=0.1584P
+ PS=1.75U PD=1.6U
M$5383 \$4971 RB0 VSS VSS nfet_03v3 L=0.28U W=0.36U AS=0.1656P AD=0.1944P
+ PS=1.64U PD=1.8U
M$5384 \$4732 RA1 VSS VSS nfet_03v3 L=0.28U W=0.36U AS=0.1656P AD=0.1944P
+ PS=1.64U PD=1.8U
M$5385 \$4970 RB0 \$405 VSS nfet_03v3 L=0.28U W=0.36U AS=0.1584P AD=0.1152P
+ PS=1.6U PD=1U
M$5386 \$406 RA0 \$4970 VSS nfet_03v3 L=0.28U W=0.36U AS=0.1152P AD=0.1584P
+ PS=1U PD=1.6U
M$5387 \$4633 RA1 \$405 VSS nfet_03v3 L=0.28U W=0.36U AS=0.1584P AD=0.1152P
+ PS=1.6U PD=1U
M$5388 \$406 RB1 \$4633 VSS nfet_03v3 L=0.28U W=0.36U AS=0.1152P AD=0.1584P
+ PS=1U PD=1.6U
M$5389 VSS RB1 \$4733 VSS nfet_03v3 L=0.28U W=0.36U AS=0.1854P AD=0.1584P
+ PS=1.75U PD=1.6U
M$5390 VSS RA0 \$4972 VSS nfet_03v3 L=0.28U W=0.36U AS=0.1854P AD=0.1584P
+ PS=1.75U PD=1.6U
M$5391 \$4734 RA1 VSS VSS nfet_03v3 L=0.28U W=0.36U AS=0.1656P AD=0.1944P
+ PS=1.64U PD=1.8U
M$5392 \$4977 RB0 VSS VSS nfet_03v3 L=0.28U W=0.36U AS=0.1656P AD=0.1944P
+ PS=1.64U PD=1.8U
M$5393 \$4637 RA1 \$410 VSS nfet_03v3 L=0.28U W=0.36U AS=0.1584P AD=0.1152P
+ PS=1.6U PD=1U
M$5394 \$411 RB1 \$4637 VSS nfet_03v3 L=0.28U W=0.36U AS=0.1152P AD=0.1584P
+ PS=1U PD=1.6U
M$5395 \$4976 RB0 \$410 VSS nfet_03v3 L=0.28U W=0.36U AS=0.1584P AD=0.1152P
+ PS=1.6U PD=1U
M$5396 \$411 RA0 \$4976 VSS nfet_03v3 L=0.28U W=0.36U AS=0.1152P AD=0.1584P
+ PS=1U PD=1.6U
M$5397 VSS RA0 \$4978 VSS nfet_03v3 L=0.28U W=0.36U AS=0.1854P AD=0.1584P
+ PS=1.75U PD=1.6U
M$5398 VSS RB1 \$4735 VSS nfet_03v3 L=0.28U W=0.36U AS=0.1854P AD=0.1584P
+ PS=1.75U PD=1.6U
M$5399 \$4736 RA1 VSS VSS nfet_03v3 L=0.28U W=0.36U AS=0.1656P AD=0.1944P
+ PS=1.64U PD=1.8U
M$5400 \$4983 RB0 VSS VSS nfet_03v3 L=0.28U W=0.36U AS=0.1656P AD=0.1944P
+ PS=1.64U PD=1.8U
M$5401 \$4982 RB0 \$415 VSS nfet_03v3 L=0.28U W=0.36U AS=0.1584P AD=0.1152P
+ PS=1.6U PD=1U
M$5402 \$416 RA0 \$4982 VSS nfet_03v3 L=0.28U W=0.36U AS=0.1152P AD=0.1584P
+ PS=1U PD=1.6U
M$5403 \$4641 RA1 \$415 VSS nfet_03v3 L=0.28U W=0.36U AS=0.1584P AD=0.1152P
+ PS=1.6U PD=1U
M$5404 \$416 RB1 \$4641 VSS nfet_03v3 L=0.28U W=0.36U AS=0.1152P AD=0.1584P
+ PS=1U PD=1.6U
M$5405 VSS RB1 \$4737 VSS nfet_03v3 L=0.28U W=0.36U AS=0.1854P AD=0.1584P
+ PS=1.75U PD=1.6U
M$5406 VSS RA0 \$4984 VSS nfet_03v3 L=0.28U W=0.36U AS=0.1854P AD=0.1584P
+ PS=1.75U PD=1.6U
M$5407 \$4989 RB0 VSS VSS nfet_03v3 L=0.28U W=0.36U AS=0.1656P AD=0.1944P
+ PS=1.64U PD=1.8U
M$5408 \$4738 RA1 VSS VSS nfet_03v3 L=0.28U W=0.36U AS=0.1656P AD=0.1944P
+ PS=1.64U PD=1.8U
M$5409 \$4988 RB0 \$420 VSS nfet_03v3 L=0.28U W=0.36U AS=0.1584P AD=0.1152P
+ PS=1.6U PD=1U
M$5410 \$421 RA0 \$4988 VSS nfet_03v3 L=0.28U W=0.36U AS=0.1152P AD=0.1584P
+ PS=1U PD=1.6U
M$5411 \$4645 RA1 \$420 VSS nfet_03v3 L=0.28U W=0.36U AS=0.1584P AD=0.1152P
+ PS=1.6U PD=1U
M$5412 \$421 RB1 \$4645 VSS nfet_03v3 L=0.28U W=0.36U AS=0.1152P AD=0.1584P
+ PS=1U PD=1.6U
M$5413 VSS RA0 \$4990 VSS nfet_03v3 L=0.28U W=0.36U AS=0.1854P AD=0.1584P
+ PS=1.75U PD=1.6U
M$5414 VSS RB1 \$4739 VSS nfet_03v3 L=0.28U W=0.36U AS=0.1854P AD=0.1584P
+ PS=1.75U PD=1.6U
M$5415 \$4995 RB0 VSS VSS nfet_03v3 L=0.28U W=0.36U AS=0.1656P AD=0.1944P
+ PS=1.64U PD=1.8U
M$5416 \$4740 RA1 VSS VSS nfet_03v3 L=0.28U W=0.36U AS=0.1656P AD=0.1944P
+ PS=1.64U PD=1.8U
M$5417 \$4994 RB0 \$425 VSS nfet_03v3 L=0.28U W=0.36U AS=0.1584P AD=0.1152P
+ PS=1.6U PD=1U
M$5418 \$426 RA0 \$4994 VSS nfet_03v3 L=0.28U W=0.36U AS=0.1152P AD=0.1584P
+ PS=1U PD=1.6U
M$5419 \$4649 RA1 \$425 VSS nfet_03v3 L=0.28U W=0.36U AS=0.1584P AD=0.1152P
+ PS=1.6U PD=1U
M$5420 \$426 RB1 \$4649 VSS nfet_03v3 L=0.28U W=0.36U AS=0.1152P AD=0.1584P
+ PS=1U PD=1.6U
M$5421 VSS RB1 \$4741 VSS nfet_03v3 L=0.28U W=0.36U AS=0.1854P AD=0.1584P
+ PS=1.75U PD=1.6U
M$5422 VSS RA0 \$4996 VSS nfet_03v3 L=0.28U W=0.36U AS=0.1854P AD=0.1584P
+ PS=1.75U PD=1.6U
M$5423 \$4742 RA1 VSS VSS nfet_03v3 L=0.28U W=0.36U AS=0.1656P AD=0.1944P
+ PS=1.64U PD=1.8U
M$5424 \$5001 RB0 VSS VSS nfet_03v3 L=0.28U W=0.36U AS=0.1656P AD=0.1944P
+ PS=1.64U PD=1.8U
M$5425 \$4653 RA1 \$430 VSS nfet_03v3 L=0.28U W=0.36U AS=0.1584P AD=0.1152P
+ PS=1.6U PD=1U
M$5426 \$431 RB1 \$4653 VSS nfet_03v3 L=0.28U W=0.36U AS=0.1152P AD=0.1584P
+ PS=1U PD=1.6U
M$5427 \$5000 RB0 \$430 VSS nfet_03v3 L=0.28U W=0.36U AS=0.1584P AD=0.1152P
+ PS=1.6U PD=1U
M$5428 \$431 RA0 \$5000 VSS nfet_03v3 L=0.28U W=0.36U AS=0.1152P AD=0.1584P
+ PS=1U PD=1.6U
M$5429 VSS RA0 \$5002 VSS nfet_03v3 L=0.28U W=0.36U AS=0.1854P AD=0.1584P
+ PS=1.75U PD=1.6U
M$5430 VSS RB1 \$4743 VSS nfet_03v3 L=0.28U W=0.36U AS=0.1854P AD=0.1584P
+ PS=1.75U PD=1.6U
M$5431 \$5007 RB0 VSS VSS nfet_03v3 L=0.28U W=0.36U AS=0.1656P AD=0.1944P
+ PS=1.64U PD=1.8U
M$5432 \$4744 RA1 VSS VSS nfet_03v3 L=0.28U W=0.36U AS=0.1656P AD=0.1944P
+ PS=1.64U PD=1.8U
M$5433 \$4657 RA1 \$435 VSS nfet_03v3 L=0.28U W=0.36U AS=0.1584P AD=0.1152P
+ PS=1.6U PD=1U
M$5434 \$436 RB1 \$4657 VSS nfet_03v3 L=0.28U W=0.36U AS=0.1152P AD=0.1584P
+ PS=1U PD=1.6U
M$5435 \$5006 RB0 \$435 VSS nfet_03v3 L=0.28U W=0.36U AS=0.1584P AD=0.1152P
+ PS=1.6U PD=1U
M$5436 \$436 RA0 \$5006 VSS nfet_03v3 L=0.28U W=0.36U AS=0.1152P AD=0.1584P
+ PS=1U PD=1.6U
M$5437 VSS RB1 \$4745 VSS nfet_03v3 L=0.28U W=0.36U AS=0.1854P AD=0.1584P
+ PS=1.75U PD=1.6U
M$5438 VSS RA0 \$5008 VSS nfet_03v3 L=0.28U W=0.36U AS=0.1854P AD=0.1584P
+ PS=1.75U PD=1.6U
M$5439 \$5111 WE0 VSS VSS nfet_03v3 L=0.28U W=0.72U AS=0.3168P AD=0.1872P
+ PS=2.32U PD=1.24U
M$5440 \$4907 CLK \$5111 VSS nfet_03v3 L=0.28U W=0.72U AS=0.1872P AD=0.3168P
+ PS=1.24U PD=2.32U
M$5441 \$4909 \$4907 VSS VSS nfet_03v3 L=0.28U W=1.27U AS=0.4487P AD=0.3302P
+ PS=3.34U PD=2.31U
M$5443 \$4910 \$4909 VSS VSS nfet_03v3 L=0.28U W=1.34U AS=0.3636P AD=0.4891P
+ PS=2.44U PD=3.47U
M$5445 \$4913 \$44 VSS VSS nfet_03v3 L=0.28U W=0.36U AS=0.1584P AD=0.1188P
+ PS=1.6U PD=1.02U
M$5446 \$4914 \$4909 \$4913 VSS nfet_03v3 L=0.28U W=0.36U AS=0.1188P AD=0.1278P
+ PS=1.02U PD=1.07U
M$5447 \$5114 \$4915 \$4914 VSS nfet_03v3 L=0.28U W=0.36U AS=0.1278P AD=0.0567P
+ PS=1.07U PD=0.675U
M$5448 VSS \$4910 \$5114 VSS nfet_03v3 L=0.28U W=0.36U AS=0.0567P AD=0.1584P
+ PS=0.675U PD=1.6U
M$5449 VSS \$4914 \$4915 VSS nfet_03v3 L=0.28U W=0.36U AS=0.1584P AD=0.0972P
+ PS=1.6U PD=0.9U
M$5450 \$4916 \$4914 VSS VSS nfet_03v3 L=0.28U W=0.36U AS=0.0972P AD=0.18P
+ PS=0.9U PD=1.72U
M$5451 \$4919 \$47 VSS VSS nfet_03v3 L=0.28U W=0.36U AS=0.1584P AD=0.1188P
+ PS=1.6U PD=1.02U
M$5452 \$4920 \$4909 \$4919 VSS nfet_03v3 L=0.28U W=0.36U AS=0.1188P AD=0.1278P
+ PS=1.02U PD=1.07U
M$5453 \$5120 \$4921 \$4920 VSS nfet_03v3 L=0.28U W=0.36U AS=0.1278P AD=0.0567P
+ PS=1.07U PD=0.675U
M$5454 VSS \$4910 \$5120 VSS nfet_03v3 L=0.28U W=0.36U AS=0.0567P AD=0.1584P
+ PS=0.675U PD=1.6U
M$5455 VSS \$4920 \$4921 VSS nfet_03v3 L=0.28U W=0.36U AS=0.1584P AD=0.0972P
+ PS=1.6U PD=0.9U
M$5456 \$4922 \$4920 VSS VSS nfet_03v3 L=0.28U W=0.36U AS=0.0972P AD=0.18P
+ PS=0.9U PD=1.72U
M$5457 \$4925 \$50 VSS VSS nfet_03v3 L=0.28U W=0.36U AS=0.1584P AD=0.1188P
+ PS=1.6U PD=1.02U
M$5458 \$4926 \$4909 \$4925 VSS nfet_03v3 L=0.28U W=0.36U AS=0.1188P AD=0.1278P
+ PS=1.02U PD=1.07U
M$5459 \$5126 \$4927 \$4926 VSS nfet_03v3 L=0.28U W=0.36U AS=0.1278P AD=0.0567P
+ PS=1.07U PD=0.675U
M$5460 VSS \$4910 \$5126 VSS nfet_03v3 L=0.28U W=0.36U AS=0.0567P AD=0.1584P
+ PS=0.675U PD=1.6U
M$5461 VSS \$4926 \$4927 VSS nfet_03v3 L=0.28U W=0.36U AS=0.1584P AD=0.0972P
+ PS=1.6U PD=0.9U
M$5462 \$4928 \$4926 VSS VSS nfet_03v3 L=0.28U W=0.36U AS=0.0972P AD=0.18P
+ PS=0.9U PD=1.72U
M$5463 \$4931 \$53 VSS VSS nfet_03v3 L=0.28U W=0.36U AS=0.1584P AD=0.1188P
+ PS=1.6U PD=1.02U
M$5464 \$4932 \$4909 \$4931 VSS nfet_03v3 L=0.28U W=0.36U AS=0.1188P AD=0.1278P
+ PS=1.02U PD=1.07U
M$5465 \$5132 \$4933 \$4932 VSS nfet_03v3 L=0.28U W=0.36U AS=0.1278P AD=0.0567P
+ PS=1.07U PD=0.675U
M$5466 VSS \$4910 \$5132 VSS nfet_03v3 L=0.28U W=0.36U AS=0.0567P AD=0.1584P
+ PS=0.675U PD=1.6U
M$5467 VSS \$4932 \$4933 VSS nfet_03v3 L=0.28U W=0.36U AS=0.1584P AD=0.0972P
+ PS=1.6U PD=0.9U
M$5468 \$4934 \$4932 VSS VSS nfet_03v3 L=0.28U W=0.36U AS=0.0972P AD=0.18P
+ PS=0.9U PD=1.72U
M$5469 \$4937 \$56 VSS VSS nfet_03v3 L=0.28U W=0.36U AS=0.1584P AD=0.1188P
+ PS=1.6U PD=1.02U
M$5470 \$4938 \$4909 \$4937 VSS nfet_03v3 L=0.28U W=0.36U AS=0.1188P AD=0.1278P
+ PS=1.02U PD=1.07U
M$5471 \$5138 \$4939 \$4938 VSS nfet_03v3 L=0.28U W=0.36U AS=0.1278P AD=0.0567P
+ PS=1.07U PD=0.675U
M$5472 VSS \$4910 \$5138 VSS nfet_03v3 L=0.28U W=0.36U AS=0.0567P AD=0.1584P
+ PS=0.675U PD=1.6U
M$5473 VSS \$4938 \$4939 VSS nfet_03v3 L=0.28U W=0.36U AS=0.1584P AD=0.0972P
+ PS=1.6U PD=0.9U
M$5474 \$4940 \$4938 VSS VSS nfet_03v3 L=0.28U W=0.36U AS=0.0972P AD=0.18P
+ PS=0.9U PD=1.72U
M$5475 \$4943 \$59 VSS VSS nfet_03v3 L=0.28U W=0.36U AS=0.1584P AD=0.1188P
+ PS=1.6U PD=1.02U
M$5476 \$4944 \$4909 \$4943 VSS nfet_03v3 L=0.28U W=0.36U AS=0.1188P AD=0.1278P
+ PS=1.02U PD=1.07U
M$5477 \$5144 \$4945 \$4944 VSS nfet_03v3 L=0.28U W=0.36U AS=0.1278P AD=0.0567P
+ PS=1.07U PD=0.675U
M$5478 VSS \$4910 \$5144 VSS nfet_03v3 L=0.28U W=0.36U AS=0.0567P AD=0.1584P
+ PS=0.675U PD=1.6U
M$5479 VSS \$4944 \$4945 VSS nfet_03v3 L=0.28U W=0.36U AS=0.1584P AD=0.0972P
+ PS=1.6U PD=0.9U
M$5480 \$4946 \$4944 VSS VSS nfet_03v3 L=0.28U W=0.36U AS=0.0972P AD=0.18P
+ PS=0.9U PD=1.72U
M$5481 \$4949 \$62 VSS VSS nfet_03v3 L=0.28U W=0.36U AS=0.1584P AD=0.1188P
+ PS=1.6U PD=1.02U
M$5482 \$4950 \$4909 \$4949 VSS nfet_03v3 L=0.28U W=0.36U AS=0.1188P AD=0.1278P
+ PS=1.02U PD=1.07U
M$5483 \$5150 \$4951 \$4950 VSS nfet_03v3 L=0.28U W=0.36U AS=0.1278P AD=0.0567P
+ PS=1.07U PD=0.675U
M$5484 VSS \$4910 \$5150 VSS nfet_03v3 L=0.28U W=0.36U AS=0.0567P AD=0.1584P
+ PS=0.675U PD=1.6U
M$5485 VSS \$4950 \$4951 VSS nfet_03v3 L=0.28U W=0.36U AS=0.1584P AD=0.0972P
+ PS=1.6U PD=0.9U
M$5486 \$4952 \$4950 VSS VSS nfet_03v3 L=0.28U W=0.36U AS=0.0972P AD=0.18P
+ PS=0.9U PD=1.72U
M$5487 \$4955 \$65 VSS VSS nfet_03v3 L=0.28U W=0.36U AS=0.1584P AD=0.1188P
+ PS=1.6U PD=1.02U
M$5488 \$4956 \$4909 \$4955 VSS nfet_03v3 L=0.28U W=0.36U AS=0.1188P AD=0.1278P
+ PS=1.02U PD=1.07U
M$5489 \$5156 \$4957 \$4956 VSS nfet_03v3 L=0.28U W=0.36U AS=0.1278P AD=0.0567P
+ PS=1.07U PD=0.675U
M$5490 VSS \$4910 \$5156 VSS nfet_03v3 L=0.28U W=0.36U AS=0.0567P AD=0.1584P
+ PS=0.675U PD=1.6U
M$5491 VSS \$4956 \$4957 VSS nfet_03v3 L=0.28U W=0.36U AS=0.1584P AD=0.0972P
+ PS=1.6U PD=0.9U
M$5492 \$4958 \$4956 VSS VSS nfet_03v3 L=0.28U W=0.36U AS=0.0972P AD=0.18P
+ PS=0.9U PD=1.72U
M$5493 \$4961 \$68 VSS VSS nfet_03v3 L=0.28U W=0.36U AS=0.1584P AD=0.1188P
+ PS=1.6U PD=1.02U
M$5494 \$4962 \$4909 \$4961 VSS nfet_03v3 L=0.28U W=0.36U AS=0.1188P AD=0.1278P
+ PS=1.02U PD=1.07U
M$5495 \$5162 \$4963 \$4962 VSS nfet_03v3 L=0.28U W=0.36U AS=0.1278P AD=0.0567P
+ PS=1.07U PD=0.675U
M$5496 VSS \$4910 \$5162 VSS nfet_03v3 L=0.28U W=0.36U AS=0.0567P AD=0.1584P
+ PS=0.675U PD=1.6U
M$5497 VSS \$4962 \$4963 VSS nfet_03v3 L=0.28U W=0.36U AS=0.1584P AD=0.0972P
+ PS=1.6U PD=0.9U
M$5498 \$4964 \$4962 VSS VSS nfet_03v3 L=0.28U W=0.36U AS=0.0972P AD=0.18P
+ PS=0.9U PD=1.72U
M$5499 \$4967 \$71 VSS VSS nfet_03v3 L=0.28U W=0.36U AS=0.1584P AD=0.1188P
+ PS=1.6U PD=1.02U
M$5500 \$4968 \$4909 \$4967 VSS nfet_03v3 L=0.28U W=0.36U AS=0.1188P AD=0.1278P
+ PS=1.02U PD=1.07U
M$5501 \$5168 \$4969 \$4968 VSS nfet_03v3 L=0.28U W=0.36U AS=0.1278P AD=0.0567P
+ PS=1.07U PD=0.675U
M$5502 VSS \$4910 \$5168 VSS nfet_03v3 L=0.28U W=0.36U AS=0.0567P AD=0.1584P
+ PS=0.675U PD=1.6U
M$5503 VSS \$4968 \$4969 VSS nfet_03v3 L=0.28U W=0.36U AS=0.1584P AD=0.0972P
+ PS=1.6U PD=0.9U
M$5504 \$4970 \$4968 VSS VSS nfet_03v3 L=0.28U W=0.36U AS=0.0972P AD=0.18P
+ PS=0.9U PD=1.72U
M$5505 \$4973 \$74 VSS VSS nfet_03v3 L=0.28U W=0.36U AS=0.1584P AD=0.1188P
+ PS=1.6U PD=1.02U
M$5506 \$4974 \$4909 \$4973 VSS nfet_03v3 L=0.28U W=0.36U AS=0.1188P AD=0.1278P
+ PS=1.02U PD=1.07U
M$5507 \$5174 \$4975 \$4974 VSS nfet_03v3 L=0.28U W=0.36U AS=0.1278P AD=0.0567P
+ PS=1.07U PD=0.675U
M$5508 VSS \$4910 \$5174 VSS nfet_03v3 L=0.28U W=0.36U AS=0.0567P AD=0.1584P
+ PS=0.675U PD=1.6U
M$5509 VSS \$4974 \$4975 VSS nfet_03v3 L=0.28U W=0.36U AS=0.1584P AD=0.0972P
+ PS=1.6U PD=0.9U
M$5510 \$4976 \$4974 VSS VSS nfet_03v3 L=0.28U W=0.36U AS=0.0972P AD=0.18P
+ PS=0.9U PD=1.72U
M$5511 \$4979 \$77 VSS VSS nfet_03v3 L=0.28U W=0.36U AS=0.1584P AD=0.1188P
+ PS=1.6U PD=1.02U
M$5512 \$4980 \$4909 \$4979 VSS nfet_03v3 L=0.28U W=0.36U AS=0.1188P AD=0.1278P
+ PS=1.02U PD=1.07U
M$5513 \$5180 \$4981 \$4980 VSS nfet_03v3 L=0.28U W=0.36U AS=0.1278P AD=0.0567P
+ PS=1.07U PD=0.675U
M$5514 VSS \$4910 \$5180 VSS nfet_03v3 L=0.28U W=0.36U AS=0.0567P AD=0.1584P
+ PS=0.675U PD=1.6U
M$5515 VSS \$4980 \$4981 VSS nfet_03v3 L=0.28U W=0.36U AS=0.1584P AD=0.0972P
+ PS=1.6U PD=0.9U
M$5516 \$4982 \$4980 VSS VSS nfet_03v3 L=0.28U W=0.36U AS=0.0972P AD=0.18P
+ PS=0.9U PD=1.72U
M$5517 \$4985 \$80 VSS VSS nfet_03v3 L=0.28U W=0.36U AS=0.1584P AD=0.1188P
+ PS=1.6U PD=1.02U
M$5518 \$4986 \$4909 \$4985 VSS nfet_03v3 L=0.28U W=0.36U AS=0.1188P AD=0.1278P
+ PS=1.02U PD=1.07U
M$5519 \$5186 \$4987 \$4986 VSS nfet_03v3 L=0.28U W=0.36U AS=0.1278P AD=0.0567P
+ PS=1.07U PD=0.675U
M$5520 VSS \$4910 \$5186 VSS nfet_03v3 L=0.28U W=0.36U AS=0.0567P AD=0.1584P
+ PS=0.675U PD=1.6U
M$5521 VSS \$4986 \$4987 VSS nfet_03v3 L=0.28U W=0.36U AS=0.1584P AD=0.0972P
+ PS=1.6U PD=0.9U
M$5522 \$4988 \$4986 VSS VSS nfet_03v3 L=0.28U W=0.36U AS=0.0972P AD=0.18P
+ PS=0.9U PD=1.72U
M$5523 \$4991 \$83 VSS VSS nfet_03v3 L=0.28U W=0.36U AS=0.1584P AD=0.1188P
+ PS=1.6U PD=1.02U
M$5524 \$4992 \$4909 \$4991 VSS nfet_03v3 L=0.28U W=0.36U AS=0.1188P AD=0.1278P
+ PS=1.02U PD=1.07U
M$5525 \$5192 \$4993 \$4992 VSS nfet_03v3 L=0.28U W=0.36U AS=0.1278P AD=0.0567P
+ PS=1.07U PD=0.675U
M$5526 VSS \$4910 \$5192 VSS nfet_03v3 L=0.28U W=0.36U AS=0.0567P AD=0.1584P
+ PS=0.675U PD=1.6U
M$5527 VSS \$4992 \$4993 VSS nfet_03v3 L=0.28U W=0.36U AS=0.1584P AD=0.0972P
+ PS=1.6U PD=0.9U
M$5528 \$4994 \$4992 VSS VSS nfet_03v3 L=0.28U W=0.36U AS=0.0972P AD=0.18P
+ PS=0.9U PD=1.72U
M$5529 \$4997 \$86 VSS VSS nfet_03v3 L=0.28U W=0.36U AS=0.1584P AD=0.1188P
+ PS=1.6U PD=1.02U
M$5530 \$4998 \$4909 \$4997 VSS nfet_03v3 L=0.28U W=0.36U AS=0.1188P AD=0.1278P
+ PS=1.02U PD=1.07U
M$5531 \$5198 \$4999 \$4998 VSS nfet_03v3 L=0.28U W=0.36U AS=0.1278P AD=0.0567P
+ PS=1.07U PD=0.675U
M$5532 VSS \$4910 \$5198 VSS nfet_03v3 L=0.28U W=0.36U AS=0.0567P AD=0.1584P
+ PS=0.675U PD=1.6U
M$5533 VSS \$4998 \$4999 VSS nfet_03v3 L=0.28U W=0.36U AS=0.1584P AD=0.0972P
+ PS=1.6U PD=0.9U
M$5534 \$5000 \$4998 VSS VSS nfet_03v3 L=0.28U W=0.36U AS=0.0972P AD=0.18P
+ PS=0.9U PD=1.72U
M$5535 \$5003 \$89 VSS VSS nfet_03v3 L=0.28U W=0.36U AS=0.1584P AD=0.1188P
+ PS=1.6U PD=1.02U
M$5536 \$5004 \$4909 \$5003 VSS nfet_03v3 L=0.28U W=0.36U AS=0.1188P AD=0.1278P
+ PS=1.02U PD=1.07U
M$5537 \$5204 \$5005 \$5004 VSS nfet_03v3 L=0.28U W=0.36U AS=0.1278P AD=0.0567P
+ PS=1.07U PD=0.675U
M$5538 VSS \$4910 \$5204 VSS nfet_03v3 L=0.28U W=0.36U AS=0.0567P AD=0.1584P
+ PS=0.675U PD=1.6U
M$5539 VSS \$5004 \$5005 VSS nfet_03v3 L=0.28U W=0.36U AS=0.1584P AD=0.0972P
+ PS=1.6U PD=0.9U
M$5540 \$5006 \$5004 VSS VSS nfet_03v3 L=0.28U W=0.36U AS=0.0972P AD=0.18P
+ PS=0.9U PD=1.72U
.ENDS rf
