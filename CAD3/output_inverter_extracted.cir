* Extracted by KLayout with GF180MCU LVS runset on : 23/02/2026 04:25

.SUBCKT output_inverter VSS VDD QA QB QAb QBb
M$1 VDD QAb QA VDD pfet_03v3 L=0.28U W=0.72U AS=0.4104P AD=0.2484P PS=2.58U
+ PD=1.41U
M$2 QB QBb VDD VDD pfet_03v3 L=0.28U W=0.72U AS=0.2484P AD=0.4104P PS=1.41U
+ PD=2.58U
M$3 VSS QAb QA VSS nfet_03v3 L=0.28U W=0.36U AS=0.2052P AD=0.1242P PS=1.86U
+ PD=1.05U
M$4 QB QBb VSS VSS nfet_03v3 L=0.28U W=0.36U AS=0.1242P AD=0.2052P PS=1.05U
+ PD=1.86U
.ENDS output_inverter
