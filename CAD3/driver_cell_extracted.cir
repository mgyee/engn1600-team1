* Extracted by KLayout with GF180MCU LVS runset on : 25/02/2026 07:59

.SUBCKT driver_cell VSS CLK WECLK VDD WE WECLKb
M$1 WECLK \$4 VDD VDD pfet_03v3 L=0.28U W=2.54U AS=0.8974P AD=0.6604P PS=5.28U
+ PD=3.58U
M$3 WECLKb WECLK VDD VDD pfet_03v3 L=0.28U W=2.68U AS=0.7272P AD=0.9782P
+ PS=3.78U PD=5.48U
M$5 \$4 WE VDD VDD pfet_03v3 L=0.28U W=0.72U AS=0.3168P AD=0.1872P PS=2.32U
+ PD=1.24U
M$6 VDD CLK \$4 VDD pfet_03v3 L=0.28U W=0.72U AS=0.1872P AD=0.3168P PS=1.24U
+ PD=2.32U
M$7 \$6 WE VSS VSS nfet_03v3 L=0.28U W=0.72U AS=0.3168P AD=0.1872P PS=2.32U
+ PD=1.24U
M$8 \$4 CLK \$6 VSS nfet_03v3 L=0.28U W=0.72U AS=0.1872P AD=0.3168P PS=1.24U
+ PD=2.32U
M$9 WECLK \$4 VSS VSS nfet_03v3 L=0.28U W=1.27U AS=0.4445P AD=0.3344P PS=3.305U
+ PD=2.345U
M$11 WECLKb WECLK VSS VSS nfet_03v3 L=0.28U W=1.34U AS=0.3636P AD=0.4891P
+ PS=2.44U PD=3.47U
.ENDS driver_cell
