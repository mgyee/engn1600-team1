* Extracted by KLayout with GF180MCU LVS runset on : 23/02/2026 02:18

.SUBCKT driver_cell VDD WECLKb VSS WECLK CLK WE
M$1 VDD \$4 WECLK VDD pfet_03v3 L=0.28U W=0.72U AS=0.3168P AD=0.1872P PS=2.32U
+ PD=1.24U
M$2 WECLKb WECLK VDD VDD pfet_03v3 L=0.28U W=0.72U AS=0.1872P AD=0.36P PS=1.24U
+ PD=2.44U
M$3 \$4 WE VDD VDD pfet_03v3 L=0.28U W=0.72U AS=0.3168P AD=0.1872P PS=2.32U
+ PD=1.24U
M$4 VDD CLK \$4 VDD pfet_03v3 L=0.28U W=0.72U AS=0.1872P AD=0.3168P PS=1.24U
+ PD=2.32U
M$5 \$14 WE VSS VSS nfet_03v3 L=0.28U W=0.72U AS=0.3168P AD=0.1872P PS=2.32U
+ PD=1.24U
M$6 \$4 CLK \$14 VSS nfet_03v3 L=0.28U W=0.72U AS=0.1872P AD=0.3168P PS=1.24U
+ PD=2.32U
M$7 VSS \$4 WECLK VSS nfet_03v3 L=0.28U W=0.36U AS=0.1584P AD=0.0936P PS=1.6U
+ PD=0.88U
M$8 WECLKb WECLK VSS VSS nfet_03v3 L=0.28U W=0.36U AS=0.0936P AD=0.18P PS=0.88U
+ PD=1.72U
.ENDS driver_cell
