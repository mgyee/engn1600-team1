* NGSPICE file created from rf_WECLK_flat.ext - technology: gf180mcuD

.subckt rf_WECLK_pex WE0CLK VSS VDD CLK WE0 WE1 WE2 WE3 WE4 WE5 WE6 WE7 WE8 WE9 WE10
+ WE11 WE12 WE13 WE14 WE15 RA8 RB8 RB14 RA14 RB12 RA12 RA10 RB10 RB6 RA6 RB4 RA4 RB2
+ RA2 RB0 RA0 RB1 RA1 RA3 RB3 RA5 RB5 RA7 RB7 RA9 RB9 RA11 RB11 RA13 RB13 RA15 RB15
+ WEM QA0b QB0b QB1b QB2b QB3b QB4b QB5b QB6b QB7b QA1b QA2b QA3b QA4b QA5b QA6b QA7b
+ QA8b QA9b QA10b QA11b QA12b QA13b QA14b QA15b QB8b QB9b QB10b QB11b QB12b QB13b
+ QB14b QB15b D0 D1 D3 D2 D4 D5 D6 D7 D8 D9 D10 D11 D12 D13 D14 D15
X0 a_22909_10022# a_22140_10022# VDD VDD pfet_03v3 ad=0.36p pd=2.44u as=0.1764p ps=1.26u w=0.72u l=0.28u
X1 a_22909_6102# a_23213_6102# a_23377_n862.t13 VDD pfet_03v3 ad=0.1152p pd=1u as=0.1584p ps=1.6u w=0.36u l=0.28u
X2 a_9780_9238# a_n884_9238.t4 a_9592_9238# VDD pfet_03v3 ad=0.1278p pd=1.07u as=0.2097p ps=1.38u w=0.36u l=0.28u
X3 a_36784_4534# a_36720_n708.t4 VDD VDD pfet_03v3 ad=0.2097p pd=1.38u as=0.3168p ps=2.32u w=0.72u l=0.28u
X4 a_27084_8454# a_n884_8454.t4 a_26896_8454# VDD pfet_03v3 ad=0.1278p pd=1.07u as=0.2097p ps=1.38u w=0.36u l=0.28u
X5 a_24424_3750# a_24360_n708.t4 VDD VDD pfet_03v3 ad=0.2097p pd=1.38u as=0.3168p ps=2.32u w=0.72u l=0.28u
X6 a_4648_614# a_4584_n708.t4 VSS VSS nfet_03v3 ad=0.1188p pd=1.02u as=0.1584p ps=1.6u w=0.36u l=0.28u
X7 VDD a_n1204_9238.t4 a_90_9238# VDD pfet_03v3 ad=0.1584p pd=1.6u as=56.7f ps=0.675u w=0.36u l=0.28u
X8 a_29556_6886# a_n1204_6886.t4 a_29368_6886# VSS nfet_03v3 ad=0.1278p pd=1.07u as=0.1188p ps=1.02u w=0.36u l=0.28u
X9 a_37170_7390# a_37106_7200# a_36972_6886# VDD pfet_03v3 ad=56.7f pd=0.675u as=0.1278p ps=1.07u w=0.36u l=0.28u
X10 QB12b.t1 a_31063_n2146.t32 VSS VSS nfet_03v3 ad=0.2052p pd=1.86u as=0.1242p ps=1.05u w=0.36u l=0.28u
X11 VSS RB3.t0 a_3866_8800# VSS nfet_03v3 ad=0.1584p pd=1.6u as=0.1854p ps=1.75u w=0.36u l=0.28u
X12 a_37170_4254# a_37106_4064# a_36972_3750# VDD pfet_03v3 ad=56.7f pd=0.675u as=0.1278p ps=1.07u w=0.36u l=0.28u
X13 a_24424_614# a_24360_n708.t5 VDD VDD pfet_03v3 ad=0.2097p pd=1.38u as=0.3168p ps=2.32u w=0.72u l=0.28u
X14 a_17965_9238# a_17196_9238# VSS VSS nfet_03v3 ad=0.18p pd=1.72u as=97.2f ps=0.9u w=0.36u l=0.28u
X15 a_15493_4534# RA8.t0 a_15961_n862.t12 VSS nfet_03v3 ad=0.1152p pd=1u as=0.1584p ps=1.6u w=0.36u l=0.28u
X16 VSS a_34500_2182# a_34634_2496# VSS nfet_03v3 ad=97.2f pd=0.9u as=0.1584p ps=1.6u w=0.36u l=0.28u
X17 VSS a_24612_7670# a_24746_7860# VSS nfet_03v3 ad=97.2f pd=0.9u as=0.1584p ps=1.6u w=0.36u l=0.28u
X18 a_34500_5318# a_n884_5318.t4 a_34312_5318# VDD pfet_03v3 ad=0.1278p pd=1.07u as=0.2097p ps=1.38u w=0.36u l=0.28u
X19 a_n884_n170.t3 a_n1204_n170.t4 VSS VSS nfet_03v3 ad=0.1943p pd=1.25u as=0.1693p ps=1.19u w=0.67u l=0.28u
X20 a_37170_1118# a_37106_928# a_36972_614# VDD pfet_03v3 ad=56.7f pd=0.675u as=0.1278p ps=1.07u w=0.36u l=0.28u
X21 a_1399_n2146.t20 a_1394_10964# a_661_10806# VDD pfet_03v3 ad=0.1584p pd=1.6u as=0.1152p ps=1u w=0.36u l=0.28u
X22 VSS a_27084_10022# a_27218_10336# VSS nfet_03v3 ad=97.2f pd=0.9u as=0.1584p ps=1.6u w=0.36u l=0.28u
X23 a_17965_6102# a_17196_6102# VSS VSS nfet_03v3 ad=0.18p pd=1.72u as=97.2f ps=0.9u w=0.36u l=0.28u
X24 VSS a_24612_4534# a_24746_4724# VSS nfet_03v3 ad=97.2f pd=0.9u as=0.1584p ps=1.6u w=0.36u l=0.28u
X25 a_29754_9238# a_29690_9428# a_29556_9238# VDD pfet_03v3 ad=56.7f pd=0.675u as=0.1278p ps=1.07u w=0.36u l=0.28u
X26 a_14724_2966# a_n1204_2966.t4 a_14536_2966# VSS nfet_03v3 ad=0.1278p pd=1.07u as=0.1188p ps=1.02u w=0.36u l=0.28u
X27 VDD.t1481 RB14.t0 a_16226_n12# VDD.t722 pfet_03v3 ad=0.3168p pd=2.32u as=0.3708p ps=2.47u w=0.72u l=0.28u
X28 a_22909_1398# RA12.t0 a_23377_n862.t12 VSS nfet_03v3 ad=0.1152p pd=1u as=0.1584p ps=1.6u w=0.36u l=0.28u
X29 a_29754_10022# a_29690_10336# a_29556_10022# VSS nfet_03v3 ad=56.7f pd=0.675u as=0.1278p ps=1.07u w=0.36u l=0.28u
X30 VDD a_2364_6102# a_2498_6292# VDD pfet_03v3 ad=0.1764p pd=1.26u as=0.1584p ps=1.6u w=0.36u l=0.28u
X31 VSS a_n1652_2614# a_n1204_2182.t3 VSS nfet_03v3 ad=0.1693p pd=1.19u as=0.1651p ps=1.155u w=0.635u l=0.28u
X32 VDD a_n1204_2182.t4 a_5034_2686# VDD pfet_03v3 ad=0.1584p pd=1.6u as=56.7f ps=0.675u w=0.36u l=0.28u
X33 a_7308_10022# a_n1204_10022.t4 a_7120_10022# VSS nfet_03v3 ad=0.1278p pd=1.07u as=0.1188p ps=1.02u w=0.36u l=0.28u
X34 VSS a_7308_7670# a_7442_7860# VSS nfet_03v3 ad=97.2f pd=0.9u as=0.1584p ps=1.6u w=0.36u l=0.28u
X35 a_35269_6886# a_34500_6886# VSS VSS nfet_03v3 ad=0.18p pd=1.72u as=97.2f ps=0.9u w=0.36u l=0.28u
X36 VDD a_19668_5318# a_19802_5632# VDD pfet_03v3 ad=0.1764p pd=1.26u as=0.1584p ps=1.6u w=0.36u l=0.28u
X37 VSS a_7308_4534# a_7442_4724# VSS nfet_03v3 ad=97.2f pd=0.9u as=0.1584p ps=1.6u w=0.36u l=0.28u
X38 VDD.t1554 a_n1204_n170.t5 a_24810_n170# VDD.t1240 pfet_03v3 ad=0.1584p pd=1.6u as=56.7f ps=0.675u w=0.36u l=0.28u
X39 a_9978_1902# a_9914_1588# a_9780_1398# VSS nfet_03v3 ad=56.7f pd=0.675u as=0.1278p ps=1.07u w=0.36u l=0.28u
X40 a_21175_n2146.t17 a_21170_7232# a_20437_6886# VDD pfet_03v3 ad=0.1584p pd=1.6u as=0.1152p ps=1u w=0.36u l=0.28u
X41 a_15493_10022# RA1.t0 a_15961_n862.t10 VSS nfet_03v3 ad=0.1152p pd=1u as=0.1584p ps=1.6u w=0.36u l=0.28u
X42 a_19480_6886# a_19416_n708.t4 VDD VDD pfet_03v3 ad=0.2097p pd=1.38u as=0.3168p ps=2.32u w=0.72u l=0.28u
X43 a_32028_7670# a_n884_7670.t4 a_31840_7670# VDD pfet_03v3 ad=0.1278p pd=1.07u as=0.2097p ps=1.38u w=0.36u l=0.28u
X44 a_22909_6886# a_22140_6886# VDD VDD pfet_03v3 ad=0.36p pd=2.44u as=0.1764p ps=1.26u w=0.72u l=0.28u
X45 a_21175_n2146.t20 a_21170_4096# a_20437_3750# VDD pfet_03v3 ad=0.1584p pd=1.6u as=0.1152p ps=1u w=0.36u l=0.28u
X46 a_14984_n1738# a_14480_n1782# VSS.t1717 VSS nfet_03v3 ad=0.1584p pd=1.6u as=0.1584p ps=1.6u w=0.36u l=0.28u
X47 a_22338_5822# a_22274_5632# a_22140_5318# VDD pfet_03v3 ad=56.7f pd=0.675u as=0.1278p ps=1.07u w=0.36u l=0.28u
X48 a_32028_4534# a_n884_4534.t4 a_31840_4534# VDD pfet_03v3 ad=0.1278p pd=1.07u as=0.2097p ps=1.38u w=0.36u l=0.28u
X49 a_26832_n708.t1 a_26840_n1782# VDD VDD pfet_03v3 ad=0.3224p pd=1.76u as=0.5456p ps=3.36u w=1.24u l=0.28u
X50 a_21175_n2146.t24 a_21170_960# a_20437_614# VDD pfet_03v3 ad=0.1584p pd=1.6u as=0.1152p ps=1u w=0.36u l=0.28u
X51 VSS RB3.t1 a_36002_8800# VSS nfet_03v3 ad=0.1584p pd=1.6u as=0.1854p ps=1.75u w=0.36u l=0.28u
X52 a_965_3842# RA9.t0 VSS VSS nfet_03v3 ad=0.1944p pd=1.8u as=0.1656p ps=1.64u w=0.36u l=0.28u
X53 a_13759_n2146.t17 RB9.t0 a_13021_3750# VSS nfet_03v3 ad=0.1584p pd=1.6u as=0.1152p ps=1u w=0.36u l=0.28u
X54 a_27853_3750# RA9.t1 a_28321_n862.t17 VSS nfet_03v3 ad=0.1152p pd=1u as=0.1584p ps=1.6u w=0.36u l=0.28u
X55 a_29754_614# a_29690_928# a_29556_614# VSS nfet_03v3 ad=56.7f pd=0.675u as=0.1278p ps=1.07u w=0.36u l=0.28u
X56 a_27853_614# RA13.t0 a_28321_n862.t0 VSS nfet_03v3 ad=0.1152p pd=1u as=0.1584p ps=1.6u w=0.36u l=0.28u
X57 VSS a_n884_8454.t5 a_9978_8454# VSS nfet_03v3 ad=0.1584p pd=1.6u as=56.7f ps=0.675u w=0.36u l=0.28u
X58 a_20437_2182# RA11.t0 a_20905_n862.t14 VSS nfet_03v3 ad=0.1152p pd=1u as=0.1584p ps=1.6u w=0.36u l=0.28u
X59 a_37837_n1738# a_n884_n1738.t4 a_36728_n1782# VDD pfet_03v3 ad=0.2097p pd=1.38u as=0.1278p ps=1.07u w=0.36u l=0.28u
X60 a_5034_5822# a_4970_5632# a_4836_5318# VDD pfet_03v3 ad=56.7f pd=0.675u as=0.1278p ps=1.07u w=0.36u l=0.28u
X61 VSS a_n884_5318.t5 a_9978_5318# VSS nfet_03v3 ad=0.1584p pd=1.6u as=56.7f ps=0.675u w=0.36u l=0.28u
X62 a_34312_7670# a_34248_n708.t4 VDD VDD pfet_03v3 ad=0.2097p pd=1.38u as=0.3168p ps=2.32u w=0.72u l=0.28u
X63 VDD.t1219 a_n1204_n954.t4 a_29754_n450# VDD.t1218 pfet_03v3 ad=0.1584p pd=1.6u as=56.7f ps=0.675u w=0.36u l=0.28u
X64 a_12252_10022# a_n1204_10022.t5 a_12064_10022# VSS nfet_03v3 ad=0.1278p pd=1.07u as=0.1188p ps=1.02u w=0.36u l=0.28u
X65 a_7308_9238# a_n884_9238.t5 a_7120_9238# VDD pfet_03v3 ad=0.1278p pd=1.07u as=0.2097p ps=1.38u w=0.36u l=0.28u
X66 a_2176_7670# a_2112_n708.t4 VDD VDD pfet_03v3 ad=0.2097p pd=1.38u as=0.3168p ps=2.32u w=0.72u l=0.28u
X67 a_34312_4534# a_34248_n708.t5 VDD VDD pfet_03v3 ad=0.2097p pd=1.38u as=0.3168p ps=2.32u w=0.72u l=0.28u
X68 a_2562_2686# a_2498_2496# a_2364_2182# VDD pfet_03v3 ad=56.7f pd=0.675u as=0.1278p ps=1.07u w=0.36u l=0.28u
X69 VSS.t2484 a_n108_n954# a_26_n640# VSS nfet_03v3 ad=97.2f pd=0.9u as=0.1584p ps=1.6u w=0.36u l=0.28u
X70 VDD RB0.t0 a_3866_10964# VDD pfet_03v3 ad=0.3168p pd=2.32u as=0.3708p ps=2.47u w=0.72u l=0.28u
X71 VDD a_n1204_2182.t5 a_37170_2686# VDD pfet_03v3 ad=0.1584p pd=1.6u as=56.7f ps=0.675u w=0.36u l=0.28u
X72 a_7120_10806# a_7056_n708.t4 VSS VSS nfet_03v3 ad=0.1188p pd=1.02u as=0.1584p ps=1.6u w=0.36u l=0.28u
X73 a_28591_n2146.t17 RB7.t0 a_27853_5318# VSS nfet_03v3 ad=0.1584p pd=1.6u as=0.1152p ps=1u w=0.36u l=0.28u
X74 a_2176_4534# a_2112_n708.t5 VDD VDD pfet_03v3 ad=0.2097p pd=1.38u as=0.3168p ps=2.32u w=0.72u l=0.28u
X75 a_17965_10022# a_17196_10022# VDD VDD pfet_03v3 ad=0.36p pd=2.44u as=0.1764p ps=1.26u w=0.72u l=0.28u
X76 a_15493_9238# a_14724_9238# VSS VSS nfet_03v3 ad=0.18p pd=1.72u as=97.2f ps=0.9u w=0.36u l=0.28u
X77 a_3133_6102# a_3437_6102# a_3601_n862.t8 VDD pfet_03v3 ad=0.1152p pd=1u as=0.1584p ps=1.6u w=0.36u l=0.28u
X78 a_10853_n170# RA14.t0 VDD.t434 VDD.t433 pfet_03v3 ad=0.3888p pd=2.52u as=0.3312p ps=2.36u w=0.72u l=0.28u
X79 a_26119_n2146.t25 RB0.t1 a_25381_10806# VSS nfet_03v3 ad=0.1584p pd=1.6u as=0.1152p ps=1u w=0.36u l=0.28u
X80 a_26119_n2146.t3 RB11.t0 a_25381_2182# VSS nfet_03v3 ad=0.1584p pd=1.6u as=0.1152p ps=1u w=0.36u l=0.28u
X81 a_18269_n862# RA15.t0 VSS.t484 VSS nfet_03v3 ad=0.1944p pd=1.8u as=0.1656p ps=1.64u w=0.36u l=0.28u
X82 a_30629_10806# RA0.t0 VDD VDD pfet_03v3 ad=0.3888p pd=2.52u as=0.3312p ps=2.36u w=0.72u l=0.28u
X83 a_15493_6102# a_14724_6102# VSS VSS nfet_03v3 ad=0.18p pd=1.72u as=97.2f ps=0.9u w=0.36u l=0.28u
X84 VSS a_15961_n862.t32 QA6b.t1 VSS nfet_03v3 ad=0.1242p pd=1.05u as=0.2052p ps=1.86u w=0.36u l=0.28u
X85 a_24424_n954# a_24360_n708.t6 VSS.t2992 VSS nfet_03v3 ad=0.1188p pd=1.02u as=0.1584p ps=1.6u w=0.36u l=0.28u
X86 VDD RB4.t0 a_28586_7828# VDD pfet_03v3 ad=0.3168p pd=2.32u as=0.3708p ps=2.47u w=0.72u l=0.28u
X87 a_9780_6886# a_n1204_6886.t5 a_9592_6886# VSS nfet_03v3 ad=0.1278p pd=1.07u as=0.1188p ps=1.02u w=0.36u l=0.28u
X88 VDD a_32028_6102# a_32162_6292# VDD pfet_03v3 ad=0.1764p pd=1.26u as=0.1584p ps=1.6u w=0.36u l=0.28u
X89 QB10b.t1 a_26119_n2146.t32 VSS VSS nfet_03v3 ad=0.2052p pd=1.86u as=0.1242p ps=1.05u w=0.36u l=0.28u
X90 VSS RB14.t1 a_21170_n12# VSS nfet_03v3 ad=0.1584p pd=1.6u as=0.1854p ps=1.75u w=0.36u l=0.28u
X91 VDD RB8.t0 a_28586_4692# VDD pfet_03v3 ad=0.3168p pd=2.32u as=0.3708p ps=2.47u w=0.72u l=0.28u
X92 a_12252_2966# a_n1204_2966.t5 a_12064_2966# VSS nfet_03v3 ad=0.1278p pd=1.07u as=0.1188p ps=1.02u w=0.36u l=0.28u
X93 VDD.t1482 RB14.t2 a_13754_n12# VDD.t724 pfet_03v3 ad=0.3168p pd=2.32u as=0.3708p ps=2.47u w=0.72u l=0.28u
X94 VSS a_4836_7670# a_4970_7860# VSS nfet_03v3 ad=97.2f pd=0.9u as=0.1584p ps=1.6u w=0.36u l=0.28u
X95 VSS a_n884_6886.t4 a_90_6886# VSS nfet_03v3 ad=0.1584p pd=1.6u as=56.7f ps=0.675u w=0.36u l=0.28u
X96 a_8815_n2146.t13 RB11.t1 a_8077_2182# VSS nfet_03v3 ad=0.1584p pd=1.6u as=0.1152p ps=1u w=0.36u l=0.28u
X97 VDD.t721 RB15.t0 a_33530_n608# VDD.t720 pfet_03v3 ad=0.3168p pd=2.32u as=0.3708p ps=2.47u w=0.72u l=0.28u
X98 a_29368_10022# a_29304_n708.t4 VSS VSS nfet_03v3 ad=0.1188p pd=1.02u as=0.1584p ps=1.6u w=0.36u l=0.28u
X99 VDD RB12.t0 a_26114_1556# VDD pfet_03v3 ad=0.3168p pd=2.32u as=0.3708p ps=2.47u w=0.72u l=0.28u
X100 VSS a_4836_4534# a_4970_4724# VSS nfet_03v3 ad=97.2f pd=0.9u as=0.1584p ps=1.6u w=0.36u l=0.28u
X101 a_27853_614# a_27084_614# VSS VSS nfet_03v3 ad=0.18p pd=1.72u as=97.2f ps=0.9u w=0.36u l=0.28u
X102 a_30629_8546# RA3.t0 VSS VSS nfet_03v3 ad=0.1944p pd=1.8u as=0.1656p ps=1.64u w=0.36u l=0.28u
X103 a_3133_1398# RA12.t1 a_3601_n862.t10 VSS nfet_03v3 ad=0.1152p pd=1u as=0.1584p ps=1.6u w=0.36u l=0.28u
X104 a_7506_1902# a_7442_1588# a_7308_1398# VSS nfet_03v3 ad=56.7f pd=0.675u as=0.1278p ps=1.07u w=0.36u l=0.28u
X105 VSS.t321 D9.t0 a_23005_n1738# VSS nfet_03v3 ad=0.1584p pd=1.6u as=0.1188p ps=1.02u w=0.36u l=0.28u
X106 VDD a_n1204_1398.t4 a_34698_1398# VDD pfet_03v3 ad=0.1584p pd=1.6u as=56.7f ps=0.675u w=0.36u l=0.28u
X107 a_5605_10022# a_5909_10114# a_6073_n862.t28 VDD pfet_03v3 ad=0.1152p pd=1u as=0.1584p ps=1.6u w=0.36u l=0.28u
X108 a_4836_10806# a_n884_10806.t4 a_4648_10806# VDD pfet_03v3 ad=0.1278p pd=1.07u as=0.2097p ps=1.38u w=0.36u l=0.28u
X109 a_965_9238# RA2.t0 VDD VDD pfet_03v3 ad=0.3888p pd=2.52u as=0.3312p ps=2.36u w=0.72u l=0.28u
X110 a_13759_n2146.t23 a_13754_9396# a_13021_9238# VDD pfet_03v3 ad=0.1584p pd=1.6u as=0.1152p ps=1u w=0.36u l=0.28u
X111 a_27853_9238# a_28157_9238# a_28321_n862.t20 VDD pfet_03v3 ad=0.1152p pd=1u as=0.1584p ps=1.6u w=0.36u l=0.28u
X112 VSS RB5.t0 a_1394_7232# VSS nfet_03v3 ad=0.1584p pd=1.6u as=0.1854p ps=1.75u w=0.36u l=0.28u
X113 a_20437_6886# a_19668_6886# VDD VDD pfet_03v3 ad=0.36p pd=2.44u as=0.1764p ps=1.26u w=0.72u l=0.28u
X114 a_17394_614# a_17330_928# a_17196_614# VSS nfet_03v3 ad=56.7f pd=0.675u as=0.1278p ps=1.07u w=0.36u l=0.28u
X115 a_13021_8454# a_12252_8454# VSS VSS nfet_03v3 ad=0.18p pd=1.72u as=97.2f ps=0.9u w=0.36u l=0.28u
X116 a_29754_6886# a_29690_7200# a_29556_6886# VSS nfet_03v3 ad=56.7f pd=0.675u as=0.1278p ps=1.07u w=0.36u l=0.28u
X117 VSS a_2364_3750# a_2498_4064# VSS nfet_03v3 ad=97.2f pd=0.9u as=0.1584p ps=1.6u w=0.36u l=0.28u
X118 VSS a_33265_n862.t32 QA13b.t1 VSS nfet_03v3 ad=0.1242p pd=1.05u as=0.2052p ps=1.86u w=0.36u l=0.28u
X119 a_n296_9238# a_n360_n708.t4 VSS VSS nfet_03v3 ad=0.1188p pd=1.02u as=0.1584p ps=1.6u w=0.36u l=0.28u
X120 a_13021_5318# a_12252_5318# VSS VSS nfet_03v3 ad=0.18p pd=1.72u as=97.2f ps=0.9u w=0.36u l=0.28u
X121 VDD WE0CLK.t4 a_12450_10806# VDD pfet_03v3 ad=0.1584p pd=1.6u as=56.7f ps=0.675u w=0.36u l=0.28u
X122 a_n296_6102# a_n360_n708.t5 VSS VSS nfet_03v3 ad=0.1188p pd=1.02u as=0.1584p ps=1.6u w=0.36u l=0.28u
X123 VSS a_n1204_7670.t4 a_n884_7670.t0 VSS nfet_03v3 ad=0.2948p pd=2.22u as=0.1943p ps=1.25u w=0.67u l=0.28u
X124 a_35269_6102# a_35573_6102# a_35737_n862.t3 VDD pfet_03v3 ad=0.1152p pd=1u as=0.1584p ps=1.6u w=0.36u l=0.28u
X125 VDD a_n1204_7670.t5 a_n884_7670.t1 VDD pfet_03v3 ad=0.5896p pd=3.56u as=0.3886p ps=1.92u w=1.34u l=0.28u
X126 a_11287_n2146.t8 RB15.t1 a_10549_n954# VSS nfet_03v3 ad=0.1584p pd=1.6u as=0.1152p ps=1u w=0.36u l=0.28u
X127 a_15493_10806# RA0.t1 a_15961_n862.t5 VSS nfet_03v3 ad=0.1152p pd=1u as=0.1584p ps=1.6u w=0.36u l=0.28u
X128 a_36784_3750# a_36720_n708.t5 VDD VDD pfet_03v3 ad=0.2097p pd=1.38u as=0.3168p ps=2.32u w=0.72u l=0.28u
X129 VDD a_n1204_4534.t4 a_n884_4534.t0 VDD pfet_03v3 ad=0.5896p pd=3.56u as=0.3886p ps=1.92u w=1.34u l=0.28u
X130 VDD.t1221 a_n1204_n954.t5 a_27282_n450# VDD.t1220 pfet_03v3 ad=0.1584p pd=1.6u as=56.7f ps=0.675u w=0.36u l=0.28u
X131 VDD RB10.t0 a_11282_3124# VDD pfet_03v3 ad=0.3168p pd=2.32u as=0.3708p ps=2.47u w=0.72u l=0.28u
X132 a_36784_614# a_36720_n708.t6 VDD VDD pfet_03v3 ad=0.2097p pd=1.38u as=0.3168p ps=2.32u w=0.72u l=0.28u
X133 a_965_4534# RA8.t1 VSS VSS nfet_03v3 ad=0.1944p pd=1.8u as=0.1656p ps=1.64u w=0.36u l=0.28u
X134 a_13759_n2146.t1 RB8.t1 a_13021_4534# VSS nfet_03v3 ad=0.1584p pd=1.6u as=0.1152p ps=1u w=0.36u l=0.28u
X135 a_27853_4534# RA8.t2 a_28321_n862.t12 VSS nfet_03v3 ad=0.1152p pd=1u as=0.1584p ps=1.6u w=0.36u l=0.28u
X136 VSS a_36972_7670# a_37106_7860# VSS nfet_03v3 ad=97.2f pd=0.9u as=0.1584p ps=1.6u w=0.36u l=0.28u
X137 a_20437_2966# RA10.t0 a_20905_n862.t5 VSS nfet_03v3 ad=0.1152p pd=1u as=0.1584p ps=1.6u w=0.36u l=0.28u
X138 a_20741_10114# RA1.t1 VSS VSS nfet_03v3 ad=0.1944p pd=1.8u as=0.1656p ps=1.64u w=0.36u l=0.28u
X139 VSS a_36972_4534# a_37106_4724# VSS nfet_03v3 ad=97.2f pd=0.9u as=0.1584p ps=1.6u w=0.36u l=0.28u
X140 VSS a_34500_1398# a_34634_1588# VSS nfet_03v3 ad=97.2f pd=0.9u as=0.1584p ps=1.6u w=0.36u l=0.28u
X141 VDD a_n1204_6886.t6 a_14922_7390# VDD pfet_03v3 ad=0.1584p pd=1.6u as=56.7f ps=0.675u w=0.36u l=0.28u
X142 a_35269_1398# RA12.t2 a_35737_n862.t4 VSS nfet_03v3 ad=0.1152p pd=1u as=0.1584p ps=1.6u w=0.36u l=0.28u
X143 a_20741_1398# RA12.t3 VDD VDD pfet_03v3 ad=0.3888p pd=2.52u as=0.3312p ps=2.36u w=0.72u l=0.28u
X144 a_28591_n2146.t7 RB2.t0 a_27853_9238# VSS nfet_03v3 ad=0.1584p pd=1.6u as=0.1152p ps=1u w=0.36u l=0.28u
X145 a_7308_6886# a_n1204_6886.t7 a_7120_6886# VSS nfet_03v3 ad=0.1278p pd=1.07u as=0.1188p ps=1.02u w=0.36u l=0.28u
X146 VDD a_n1204_3750.t4 a_14922_4254# VDD pfet_03v3 ad=0.1584p pd=1.6u as=56.7f ps=0.675u w=0.36u l=0.28u
X147 a_9978_9238# a_9914_9428# a_9780_9238# VDD pfet_03v3 ad=56.7f pd=0.675u as=0.1278p ps=1.07u w=0.36u l=0.28u
X148 a_27282_8958# a_27218_8768# a_27084_8454# VDD pfet_03v3 ad=56.7f pd=0.675u as=0.1278p ps=1.07u w=0.36u l=0.28u
X149 VDD a_n1204_614.t4 a_14922_1118# VDD pfet_03v3 ad=0.1584p pd=1.6u as=56.7f ps=0.675u w=0.36u l=0.28u
X150 a_n1204_7670.t3 a_n1652_7670# VSS VSS nfet_03v3 ad=0.1651p pd=1.155u as=0.2794p ps=2.15u w=0.635u l=0.28u
X151 a_28591_n2146.t8 RB6.t0 a_27853_6102# VSS nfet_03v3 ad=0.1584p pd=1.6u as=0.1152p ps=1u w=0.36u l=0.28u
X152 a_6343_n2146.t18 RB11.t2 a_5605_2182# VSS nfet_03v3 ad=0.1584p pd=1.6u as=0.1152p ps=1u w=0.36u l=0.28u
X153 a_2364_n954# a_n884_n954.t4 a_2176_n954# VDD.t1347 pfet_03v3 ad=0.1278p pd=1.07u as=0.2097p ps=1.38u w=0.36u l=0.28u
X154 a_15493_614# a_14724_614# VSS VSS nfet_03v3 ad=0.18p pd=1.72u as=97.2f ps=0.9u w=0.36u l=0.28u
X155 a_25685_10806# RA0.t2 VDD VDD pfet_03v3 ad=0.3888p pd=2.52u as=0.3312p ps=2.36u w=0.72u l=0.28u
X156 a_n884_9238.t0 a_n1204_9238.t5 VDD VDD pfet_03v3 ad=0.3886p pd=1.92u as=0.3386p ps=1.86u w=1.34u l=0.28u
X157 a_18703_n2146.t4 RB5.t1 a_17965_6886# VSS nfet_03v3 ad=0.1584p pd=1.6u as=0.1152p ps=1u w=0.36u l=0.28u
X158 a_33535_n2146.t3 a_33530_7232# a_32797_6886# VDD pfet_03v3 ad=0.1584p pd=1.6u as=0.1152p ps=1u w=0.36u l=0.28u
X159 a_21952_5318# a_21888_n708.t4 VDD VDD pfet_03v3 ad=0.2097p pd=1.38u as=0.3168p ps=2.32u w=0.72u l=0.28u
X160 a_37520_n1234# a_n884_n1738.t5 VSS.t4 VSS nfet_03v3 ad=56.7f pd=0.675u as=0.1584p ps=1.6u w=0.36u l=0.28u
X161 a_n108_8454# a_n1204_8454.t4 a_n296_8454# VSS nfet_03v3 ad=0.1278p pd=1.07u as=0.1188p ps=1.02u w=0.36u l=0.28u
X162 a_26119_n2146.t9 RB10.t1 a_25381_2966# VSS nfet_03v3 ad=0.1584p pd=1.6u as=0.1152p ps=1u w=0.36u l=0.28u
X163 a_1399_n2146.t16 a_1394_7232# a_661_6886# VDD pfet_03v3 ad=0.1584p pd=1.6u as=0.1152p ps=1u w=0.36u l=0.28u
X164 VSS RB5.t2 a_31058_7232# VSS nfet_03v3 ad=0.1584p pd=1.6u as=0.1854p ps=1.75u w=0.36u l=0.28u
X165 a_33535_n2146.t2 a_33530_4096# a_32797_3750# VDD pfet_03v3 ad=0.1584p pd=1.6u as=0.1152p ps=1u w=0.36u l=0.28u
X166 a_21952_2182# a_21888_n708.t5 VDD VDD pfet_03v3 ad=0.2097p pd=1.38u as=0.3168p ps=2.32u w=0.72u l=0.28u
X167 a_n108_5318# a_n1204_5318.t4 a_n296_5318# VSS nfet_03v3 ad=0.1278p pd=1.07u as=0.1188p ps=1.02u w=0.36u l=0.28u
X168 a_34698_5822# a_34634_5632# a_34500_5318# VDD pfet_03v3 ad=56.7f pd=0.675u as=0.1278p ps=1.07u w=0.36u l=0.28u
X169 a_14480_n1782# a_14984_n1738# a_15272_n1738# VDD pfet_03v3 ad=0.1278p pd=1.07u as=56.7f ps=0.675u w=0.36u l=0.28u
X170 a_33535_n2146.t21 a_33530_960# a_32797_614# VDD pfet_03v3 ad=0.1584p pd=1.6u as=0.1152p ps=1u w=0.36u l=0.28u
X171 a_17008_10806# a_16944_n708.t4 VSS VSS nfet_03v3 ad=0.1188p pd=1.02u as=0.1584p ps=1.6u w=0.36u l=0.28u
X172 a_16231_n2146.t4 a_16226_10368# a_15493_10022# VDD pfet_03v3 ad=0.1584p pd=1.6u as=0.1152p ps=1u w=0.36u l=0.28u
X173 a_1399_n2146.t15 a_1394_4096# a_661_3750# VDD pfet_03v3 ad=0.1584p pd=1.6u as=0.1152p ps=1u w=0.36u l=0.28u
X174 VSS a_32028_3750# a_32162_4064# VSS nfet_03v3 ad=97.2f pd=0.9u as=0.1584p ps=1.6u w=0.36u l=0.28u
X175 VSS a_n884_614.t4 a_17394_614# VSS nfet_03v3 ad=0.1584p pd=1.6u as=56.7f ps=0.675u w=0.36u l=0.28u
X176 a_26896_10806# a_26832_n708.t4 VDD VDD pfet_03v3 ad=0.2097p pd=1.38u as=0.3168p ps=2.32u w=0.72u l=0.28u
X177 a_10549_8454# a_9780_8454# VSS VSS nfet_03v3 ad=0.18p pd=1.72u as=97.2f ps=0.9u w=0.36u l=0.28u
X178 VSS a_n884_8454.t6 a_22338_8454# VSS nfet_03v3 ad=0.1584p pd=1.6u as=56.7f ps=0.675u w=0.36u l=0.28u
X179 VDD a_n1204_7670.t6 a_19866_7670# VDD pfet_03v3 ad=0.1584p pd=1.6u as=56.7f ps=0.675u w=0.36u l=0.28u
X180 a_8815_n2146.t6 RB10.t2 a_8077_2966# VSS nfet_03v3 ad=0.1584p pd=1.6u as=0.1152p ps=1u w=0.36u l=0.28u
X181 VDD RB12.t1 a_6338_1556# VDD pfet_03v3 ad=0.3168p pd=2.32u as=0.3708p ps=2.47u w=0.72u l=0.28u
X182 VSS a_n884_10022.t4 a_90_10022# VSS nfet_03v3 ad=0.1584p pd=1.6u as=56.7f ps=0.675u w=0.36u l=0.28u
X183 a_14922_3470# a_14858_3156# a_14724_2966# VSS nfet_03v3 ad=56.7f pd=0.675u as=0.1278p ps=1.07u w=0.36u l=0.28u
X184 a_27949_n1738# WEM.t0 a_26840_n1782# VSS nfet_03v3 ad=0.1188p pd=1.02u as=0.1278p ps=1.07u w=0.36u l=0.28u
X185 a_1399_n2146.t30 a_1394_960# a_661_614# VDD pfet_03v3 ad=0.1584p pd=1.6u as=0.1152p ps=1u w=0.36u l=0.28u
X186 a_10549_5318# a_9780_5318# VSS VSS nfet_03v3 ad=0.18p pd=1.72u as=97.2f ps=0.9u w=0.36u l=0.28u
X187 VSS a_n884_5318.t6 a_22338_5318# VSS nfet_03v3 ad=0.1584p pd=1.6u as=56.7f ps=0.675u w=0.36u l=0.28u
X188 VDD a_n1204_4534.t5 a_19866_4534# VDD pfet_03v3 ad=0.1584p pd=1.6u as=56.7f ps=0.675u w=0.36u l=0.28u
X189 VSS a_17196_614# a_17330_928# VSS nfet_03v3 ad=97.2f pd=0.9u as=0.1584p ps=1.6u w=0.36u l=0.28u
X190 VDD a_17196_2182# a_17330_2496# VDD pfet_03v3 ad=0.1764p pd=1.26u as=0.1584p ps=1.6u w=0.36u l=0.28u
X191 VDD a_14480_n1782# a_14472_n708.t1 VDD pfet_03v3 ad=0.5456p pd=3.36u as=0.3224p ps=1.76u w=1.24u l=0.28u
X192 a_13021_n954# a_12252_n954# VDD.t3326 VDD.t3325 pfet_03v3 ad=0.36p pd=2.44u as=0.1764p ps=1.26u w=0.72u l=0.28u
X193 a_17394_6102# a_17330_6292# a_17196_6102# VDD pfet_03v3 ad=56.7f pd=0.675u as=0.1278p ps=1.07u w=0.36u l=0.28u
X194 a_32797_6102# a_33101_6102# a_33265_n862.t27 VDD pfet_03v3 ad=0.1152p pd=1u as=0.1584p ps=1.6u w=0.36u l=0.28u
X195 a_11287_n2146.t5 a_11282_8800# a_10549_8454# VDD pfet_03v3 ad=0.1584p pd=1.6u as=0.1152p ps=1u w=0.36u l=0.28u
X196 a_18269_5410# RA7.t0 VDD VDD pfet_03v3 ad=0.3888p pd=2.52u as=0.3312p ps=2.36u w=0.72u l=0.28u
X197 a_34312_3750# a_34248_n708.t6 VDD VDD pfet_03v3 ad=0.2097p pd=1.38u as=0.3168p ps=2.32u w=0.72u l=0.28u
X198 VDD RB1.t0 a_3866_10368# VDD pfet_03v3 ad=0.3168p pd=2.32u as=0.3708p ps=2.47u w=0.72u l=0.28u
X199 a_18269_2274# RA11.t1 VDD VDD pfet_03v3 ad=0.3888p pd=2.52u as=0.3312p ps=2.36u w=0.72u l=0.28u
X200 a_34312_614# a_34248_n708.t7 VDD VDD pfet_03v3 ad=0.2097p pd=1.38u as=0.3168p ps=2.32u w=0.72u l=0.28u
X201 a_17008_7670# a_16944_n708.t5 VSS VSS nfet_03v3 ad=0.1188p pd=1.02u as=0.1584p ps=1.6u w=0.36u l=0.28u
X202 a_2176_3750# a_2112_n708.t6 VDD VDD pfet_03v3 ad=0.2097p pd=1.38u as=0.3168p ps=2.32u w=0.72u l=0.28u
X203 a_31784_n1782# a_32288_n1738# a_32576_n1738# VDD pfet_03v3 ad=0.1278p pd=1.07u as=56.7f ps=0.675u w=0.36u l=0.28u
X204 a_33535_n2146.t29 a_33530_10368# a_32797_10022# VDD pfet_03v3 ad=0.1584p pd=1.6u as=0.1152p ps=1u w=0.36u l=0.28u
X205 a_17008_4534# a_16944_n708.t6 VSS VSS nfet_03v3 ad=0.1188p pd=1.02u as=0.1584p ps=1.6u w=0.36u l=0.28u
X206 a_36784_n954# a_36720_n708.t7 VSS.t2055 VSS nfet_03v3 ad=0.1188p pd=1.02u as=0.1584p ps=1.6u w=0.36u l=0.28u
X207 a_9592_614# a_9528_n708.t4 VSS VSS nfet_03v3 ad=0.1188p pd=1.02u as=0.1584p ps=1.6u w=0.36u l=0.28u
X208 a_2176_614# a_2112_n708.t7 VDD VDD pfet_03v3 ad=0.2097p pd=1.38u as=0.3168p ps=2.32u w=0.72u l=0.28u
X209 a_30629_10114# RA1.t2 VDD VDD pfet_03v3 ad=0.3888p pd=2.52u as=0.3312p ps=2.36u w=0.72u l=0.28u
X210 a_661_5318# a_965_5410# a_1129_n862.t29 VDD pfet_03v3 ad=0.1152p pd=1u as=0.1584p ps=1.6u w=0.36u l=0.28u
X211 VDD.t1223 a_n1204_n954.t6 a_7506_n450# VDD.t1222 pfet_03v3 ad=0.1584p pd=1.6u as=56.7f ps=0.675u w=0.36u l=0.28u
X212 VSS a_n884_614.t5 a_90_614# VSS nfet_03v3 ad=0.1584p pd=1.6u as=56.7f ps=0.675u w=0.36u l=0.28u
X213 VSS a_n1204_10022.t6 a_n884_10022.t3 VSS nfet_03v3 ad=0.2948p pd=2.22u as=0.1943p ps=1.25u w=0.67u l=0.28u
X214 VDD RB9.t1 a_28586_4096# VDD pfet_03v3 ad=0.3168p pd=2.32u as=0.3708p ps=2.47u w=0.72u l=0.28u
X215 a_24612_2966# a_n1204_2966.t6 a_24424_2966# VSS nfet_03v3 ad=0.1278p pd=1.07u as=0.1188p ps=1.02u w=0.36u l=0.28u
X216 VDD a_31784_n1782# a_31776_n708.t1 VDD pfet_03v3 ad=0.5456p pd=3.36u as=0.3224p ps=1.76u w=1.24u l=0.28u
X217 VDD.t1483 RB14.t3 a_26114_n12# VDD.t726 pfet_03v3 ad=0.3168p pd=2.32u as=0.3708p ps=2.47u w=0.72u l=0.28u
X218 a_32797_1398# RA12.t4 a_33265_n862.t6 VSS nfet_03v3 ad=0.1152p pd=1u as=0.1584p ps=1.6u w=0.36u l=0.28u
X219 VDD a_29556_5318# a_29690_5632# VDD pfet_03v3 ad=0.1764p pd=1.26u as=0.1584p ps=1.6u w=0.36u l=0.28u
X220 a_9536_n1782# a_10040_n1738# a_10328_n1234# VSS nfet_03v3 ad=0.1278p pd=1.07u as=56.7f ps=0.675u w=0.36u l=0.28u
X221 VSS a_n108_614# a_26_928# VSS nfet_03v3 ad=97.2f pd=0.9u as=0.1584p ps=1.6u w=0.36u l=0.28u
X222 a_7506_9238# a_7442_9428# a_7308_9238# VDD pfet_03v3 ad=56.7f pd=0.675u as=0.1278p ps=1.07u w=0.36u l=0.28u
X223 VDD.t1544 a_n1204_n170.t6 a_34698_n170# VDD.t1242 pfet_03v3 ad=0.1584p pd=1.6u as=56.7f ps=0.675u w=0.36u l=0.28u
X224 VDD RB13.t0 a_28586_960# VDD pfet_03v3 ad=0.3168p pd=2.32u as=0.3708p ps=2.47u w=0.72u l=0.28u
X225 a_24810_10526# a_24746_10336# a_24612_10022# VDD pfet_03v3 ad=56.7f pd=0.675u as=0.1278p ps=1.07u w=0.36u l=0.28u
X226 a_27084_6102# a_n884_6102.t4 a_26896_6102# VDD pfet_03v3 ad=0.1278p pd=1.07u as=0.2097p ps=1.38u w=0.36u l=0.28u
X227 VDD a_n1652_7318# a_n1204_6886.t1 VDD pfet_03v3 ad=0.3386p pd=1.86u as=0.3302p ps=1.79u w=1.27u l=0.28u
X228 a_16231_n2146.t5 RB5.t3 a_15493_6886# VSS nfet_03v3 ad=0.1584p pd=1.6u as=0.1152p ps=1u w=0.36u l=0.28u
X229 a_31063_n2146.t17 a_31058_7232# a_30325_6886# VDD pfet_03v3 ad=0.1584p pd=1.6u as=0.1152p ps=1u w=0.36u l=0.28u
X230 VSS a_9780_2966# a_9914_3156# VSS nfet_03v3 ad=97.2f pd=0.9u as=0.1584p ps=1.6u w=0.36u l=0.28u
X231 a_20741_10806# RA0.t3 VSS VSS nfet_03v3 ad=0.1944p pd=1.8u as=0.1656p ps=1.64u w=0.36u l=0.28u
X232 a_29368_6886# a_29304_n708.t5 VDD VDD pfet_03v3 ad=0.2097p pd=1.38u as=0.3168p ps=2.32u w=0.72u l=0.28u
X233 VSS RB14.t4 a_38474_n12# VSS nfet_03v3 ad=0.1584p pd=1.6u as=0.1854p ps=1.75u w=0.36u l=0.28u
X234 VSS a_24612_10806# a_24746_10996# VSS nfet_03v3 ad=97.2f pd=0.9u as=0.1584p ps=1.6u w=0.36u l=0.28u
X235 a_32797_6886# a_32028_6886# VDD VDD pfet_03v3 ad=0.36p pd=2.44u as=0.1764p ps=1.26u w=0.72u l=0.28u
X236 a_31063_n2146.t27 a_31058_4096# a_30325_3750# VDD pfet_03v3 ad=0.1584p pd=1.6u as=0.1152p ps=1u w=0.36u l=0.28u
X237 a_32226_5822# a_32162_5632# a_32028_5318# VDD pfet_03v3 ad=56.7f pd=0.675u as=0.1278p ps=1.07u w=0.36u l=0.28u
X238 a_n1652_2966# WE10.t0 VDD VDD pfet_03v3 ad=0.1872p pd=1.24u as=0.3168p ps=2.32u w=0.72u l=0.28u
X239 a_30325_2966# a_29556_2966# VSS VSS nfet_03v3 ad=0.18p pd=1.72u as=97.2f ps=0.9u w=0.36u l=0.28u
X240 a_32797_n170# RA14.t1 a_33265_n862.t13 VSS nfet_03v3 ad=0.1152p pd=1u as=0.1584p ps=1.6u w=0.36u l=0.28u
X241 QB8b.t0 a_21175_n2146.t32 VDD VDD pfet_03v3 ad=0.4104p pd=2.58u as=0.2484p ps=1.41u w=0.72u l=0.28u
X242 a_31063_n2146.t18 a_31058_960# a_30325_614# VDD pfet_03v3 ad=0.1584p pd=1.6u as=0.1152p ps=1u w=0.36u l=0.28u
X243 a_9978_6886# a_9914_7200# a_9780_6886# VSS nfet_03v3 ad=56.7f pd=0.675u as=0.1278p ps=1.07u w=0.36u l=0.28u
X244 a_661_5318# a_n108_5318# VDD VDD pfet_03v3 ad=0.36p pd=2.44u as=0.1764p ps=1.26u w=0.72u l=0.28u
X245 VDD RB12.t2 a_3866_1556# VDD pfet_03v3 ad=0.3168p pd=2.32u as=0.3708p ps=2.47u w=0.72u l=0.28u
X246 a_19668_9238# a_n1204_9238.t6 a_19480_9238# VSS nfet_03v3 ad=0.1278p pd=1.07u as=0.1188p ps=1.02u w=0.36u l=0.28u
X247 VDD a_n1204_7670.t7 a_17394_7670# VDD pfet_03v3 ad=0.1584p pd=1.6u as=56.7f ps=0.675u w=0.36u l=0.28u
X248 a_6343_n2146.t13 RB10.t3 a_5605_2966# VSS nfet_03v3 ad=0.1584p pd=1.6u as=0.1152p ps=1u w=0.36u l=0.28u
X249 a_12450_3470# a_12386_3156# a_12252_2966# VSS nfet_03v3 ad=56.7f pd=0.675u as=0.1278p ps=1.07u w=0.36u l=0.28u
X250 a_661_2182# a_n108_2182# VDD VDD pfet_03v3 ad=0.36p pd=2.44u as=0.1764p ps=1.26u w=0.72u l=0.28u
X251 a_30325_2182# RA11.t2 a_30793_n862.t9 VSS nfet_03v3 ad=0.1152p pd=1u as=0.1584p ps=1.6u w=0.36u l=0.28u
X252 a_23647_n2146.t1 RB15.t2 a_22909_n954# VSS nfet_03v3 ad=0.1584p pd=1.6u as=0.1152p ps=1u w=0.36u l=0.28u
X253 a_20437_n170# RA14.t2 a_20905_n862.t1 VSS nfet_03v3 ad=0.1152p pd=1u as=0.1584p ps=1.6u w=0.36u l=0.28u
X254 VDD a_n1204_4534.t6 a_17394_4534# VDD pfet_03v3 ad=0.1584p pd=1.6u as=56.7f ps=0.675u w=0.36u l=0.28u
X255 a_2912_n1234# a_n884_n1738.t6 VSS.t5 VSS nfet_03v3 ad=56.7f pd=0.675u as=0.1584p ps=1.6u w=0.36u l=0.28u
X256 a_n884_6886.t3 a_n1204_6886.t8 VSS VSS nfet_03v3 ad=0.1943p pd=1.25u as=0.1693p ps=1.19u w=0.67u l=0.28u
X257 a_19668_6102# a_n1204_6102.t4 a_19480_6102# VSS nfet_03v3 ad=0.1278p pd=1.07u as=0.1188p ps=1.02u w=0.36u l=0.28u
X258 VSS a_n108_2182# a_26_2496# VSS nfet_03v3 ad=97.2f pd=0.9u as=0.1584p ps=1.6u w=0.36u l=0.28u
X259 VDD a_14724_2182# a_14858_2496# VDD pfet_03v3 ad=0.1764p pd=1.26u as=0.1584p ps=1.6u w=0.36u l=0.28u
X260 a_32028_n954# a_n1204_n954.t7 a_31840_n954# VSS nfet_03v3 ad=0.1278p pd=1.07u as=0.1188p ps=1.02u w=0.36u l=0.28u
X261 a_10549_n954# a_9780_n954# VDD.t2774 VDD.t2773 pfet_03v3 ad=0.36p pd=2.44u as=0.1764p ps=1.26u w=0.72u l=0.28u
X262 VDD RB10.t4 a_23642_3124# VDD pfet_03v3 ad=0.3168p pd=2.32u as=0.3708p ps=2.47u w=0.72u l=0.28u
X263 VSS a_n884_8454.t7 a_2562_8454# VSS nfet_03v3 ad=0.1584p pd=1.6u as=56.7f ps=0.675u w=0.36u l=0.28u
X264 a_36007_n2146.t18 a_36002_7828# a_35269_7670# VDD pfet_03v3 ad=0.1584p pd=1.6u as=0.1152p ps=1u w=0.36u l=0.28u
X265 VDD a_34500_9238# a_34634_9428# VDD pfet_03v3 ad=0.1764p pd=1.26u as=0.1584p ps=1.6u w=0.36u l=0.28u
X266 VSS a_n884_5318.t7 a_2562_5318# VSS nfet_03v3 ad=0.1584p pd=1.6u as=56.7f ps=0.675u w=0.36u l=0.28u
X267 a_38479_n2146.t16 RB7.t1 a_37741_5318# VSS nfet_03v3 ad=0.1584p pd=1.6u as=0.1152p ps=1u w=0.36u l=0.28u
X268 a_36007_n2146.t17 a_36002_4692# a_35269_4534# VDD pfet_03v3 ad=0.1584p pd=1.6u as=0.1152p ps=1u w=0.36u l=0.28u
X269 a_24424_2182# a_24360_n708.t7 VSS VSS nfet_03v3 ad=0.1188p pd=1.02u as=0.1584p ps=1.6u w=0.36u l=0.28u
X270 a_25381_9238# a_24612_9238# VSS VSS nfet_03v3 ad=0.18p pd=1.72u as=97.2f ps=0.9u w=0.36u l=0.28u
X271 a_14536_7670# a_14472_n708.t4 VSS VSS nfet_03v3 ad=0.1188p pd=1.02u as=0.1584p ps=1.6u w=0.36u l=0.28u
X272 a_28157_n862# RA15.t1 VSS.t485 VSS nfet_03v3 ad=0.1944p pd=1.8u as=0.1656p ps=1.64u w=0.36u l=0.28u
X273 a_20741_n170# RA14.t3 VDD.t396 VDD.t395 pfet_03v3 ad=0.3888p pd=2.52u as=0.3312p ps=2.36u w=0.72u l=0.28u
X274 a_25381_6102# a_24612_6102# VSS VSS nfet_03v3 ad=0.18p pd=1.72u as=97.2f ps=0.9u w=0.36u l=0.28u
X275 a_14536_4534# a_14472_n708.t5 VSS VSS nfet_03v3 ad=0.1188p pd=1.02u as=0.1584p ps=1.6u w=0.36u l=0.28u
X276 a_34312_n954# a_34248_n708.t8 VSS.t1121 VSS nfet_03v3 ad=0.1188p pd=1.02u as=0.1584p ps=1.6u w=0.36u l=0.28u
X277 a_2112_n708.t1 a_2120_n1782# VDD VDD pfet_03v3 ad=0.3224p pd=1.76u as=0.5456p ps=3.36u w=1.24u l=0.28u
X278 VDD RB4.t1 a_38474_7828# VDD pfet_03v3 ad=0.3168p pd=2.32u as=0.3708p ps=2.47u w=0.72u l=0.28u
X279 VDD.t1225 a_n1204_n954.t8 a_5034_n450# VDD.t1224 pfet_03v3 ad=0.1584p pd=1.6u as=56.7f ps=0.675u w=0.36u l=0.28u
X280 VDD a_n1652_9238# a_n1204_9238.t1 VDD pfet_03v3 ad=0.3386p pd=1.86u as=0.3302p ps=1.79u w=1.27u l=0.28u
X281 a_17394_3750# a_17330_4064# a_17196_3750# VSS nfet_03v3 ad=56.7f pd=0.675u as=0.1278p ps=1.07u w=0.36u l=0.28u
X282 a_2176_n954# a_2112_n708.t8 VSS.t1088 VSS nfet_03v3 ad=0.1188p pd=1.02u as=0.1584p ps=1.6u w=0.36u l=0.28u
X283 VDD RB8.t2 a_38474_4692# VDD pfet_03v3 ad=0.3168p pd=2.32u as=0.3708p ps=2.47u w=0.72u l=0.28u
X284 a_22140_2966# a_n1204_2966.t7 a_21952_2966# VSS nfet_03v3 ad=0.1278p pd=1.07u as=0.1188p ps=1.02u w=0.36u l=0.28u
X285 a_22140_614# a_n1204_614.t5 a_21952_614# VSS nfet_03v3 ad=0.1278p pd=1.07u as=0.1188p ps=1.02u w=0.36u l=0.28u
X286 a_17965_2182# a_18269_2274# a_18433_n862.t0 VDD pfet_03v3 ad=0.1152p pd=1u as=0.1584p ps=1.6u w=0.36u l=0.28u
X287 VDD RB12.t3 a_36002_1556# VDD pfet_03v3 ad=0.3168p pd=2.32u as=0.3708p ps=2.47u w=0.72u l=0.28u
X288 a_25685_10114# RA1.t3 VDD VDD pfet_03v3 ad=0.3888p pd=2.52u as=0.3312p ps=2.36u w=0.72u l=0.28u
X289 VSS RB14.t5 a_26114_n12# VSS nfet_03v3 ad=0.1584p pd=1.6u as=0.1854p ps=1.75u w=0.36u l=0.28u
X290 a_8077_2966# a_7308_2966# VDD VDD pfet_03v3 ad=0.36p pd=2.44u as=0.1764p ps=1.26u w=0.72u l=0.28u
X291 VDD.t1484 RB14.t6 a_6338_n12# VDD.t728 pfet_03v3 ad=0.3168p pd=2.32u as=0.3708p ps=2.47u w=0.72u l=0.28u
X292 a_19480_8454# a_19416_n708.t5 VSS VSS nfet_03v3 ad=0.1188p pd=1.02u as=0.1584p ps=1.6u w=0.36u l=0.28u
X293 a_22909_8454# a_22140_8454# VSS VSS nfet_03v3 ad=0.18p pd=1.72u as=97.2f ps=0.9u w=0.36u l=0.28u
X294 a_26896_10022# a_26832_n708.t5 VDD VDD pfet_03v3 ad=0.2097p pd=1.38u as=0.3168p ps=2.32u w=0.72u l=0.28u
X295 a_19480_5318# a_19416_n708.t6 VSS VSS nfet_03v3 ad=0.1188p pd=1.02u as=0.1584p ps=1.6u w=0.36u l=0.28u
X296 a_10549_10806# a_10853_10806# a_11017_n862.t30 VDD pfet_03v3 ad=0.1152p pd=1u as=0.1584p ps=1.6u w=0.36u l=0.28u
X297 a_22909_5318# a_22140_5318# VSS VSS nfet_03v3 ad=0.18p pd=1.72u as=97.2f ps=0.9u w=0.36u l=0.28u
X298 VSS RB14.t7 a_8810_n12# VSS nfet_03v3 ad=0.1584p pd=1.6u as=0.1854p ps=1.75u w=0.36u l=0.28u
X299 a_15493_7670# RA4.t0 a_15961_n862.t15 VSS nfet_03v3 ad=0.1152p pd=1u as=0.1584p ps=1.6u w=0.36u l=0.28u
X300 a_9592_6886# a_9528_n708.t5 VDD VDD pfet_03v3 ad=0.2097p pd=1.38u as=0.3168p ps=2.32u w=0.72u l=0.28u
X301 a_7506_6886# a_7442_7200# a_7308_6886# VSS nfet_03v3 ad=56.7f pd=0.675u as=0.1278p ps=1.07u w=0.36u l=0.28u
X302 a_27084_3750# a_n1204_3750.t5 a_26896_3750# VSS nfet_03v3 ad=0.1278p pd=1.07u as=0.1188p ps=1.02u w=0.36u l=0.28u
X303 a_17196_9238# a_n1204_9238.t7 a_17008_9238# VSS nfet_03v3 ad=0.1278p pd=1.07u as=0.1188p ps=1.02u w=0.36u l=0.28u
X304 a_90_2686# a_26_2496# a_n108_2182# VDD pfet_03v3 ad=56.7f pd=0.675u as=0.1278p ps=1.07u w=0.36u l=0.28u
X305 a_21175_n2146.t7 RB15.t3 a_20437_n954# VSS nfet_03v3 ad=0.1584p pd=1.6u as=0.1152p ps=1u w=0.36u l=0.28u
X306 a_17965_1398# a_17196_1398# VDD VDD pfet_03v3 ad=0.36p pd=2.44u as=0.1764p ps=1.26u w=0.72u l=0.28u
X307 a_9978_10022# a_9914_10336# a_9780_10022# VSS nfet_03v3 ad=56.7f pd=0.675u as=0.1278p ps=1.07u w=0.36u l=0.28u
X308 VSS a_n884_10022.t5 a_34698_10022# VSS nfet_03v3 ad=0.1584p pd=1.6u as=56.7f ps=0.675u w=0.36u l=0.28u
X309 a_23647_n2146.t25 a_23642_8800# a_22909_8454# VDD pfet_03v3 ad=0.1584p pd=1.6u as=0.1152p ps=1u w=0.36u l=0.28u
X310 a_17196_6102# a_n1204_6102.t5 a_17008_6102# VSS nfet_03v3 ad=0.1278p pd=1.07u as=0.1188p ps=1.02u w=0.36u l=0.28u
X311 a_2562_n450# a_2498_n640# a_2364_n954# VDD.t2032 pfet_03v3 ad=56.7f pd=0.675u as=0.1278p ps=1.07u w=0.36u l=0.28u
X312 VSS a_n884_8454.t8 a_32226_8454# VSS nfet_03v3 ad=0.1584p pd=1.6u as=56.7f ps=0.675u w=0.36u l=0.28u
X313 a_n1652_7670# CLK a_n1652_8110# VSS nfet_03v3 ad=0.3168p pd=2.32u as=0.1872p ps=1.24u w=0.72u l=0.28u
X314 a_3871_n2146.t13 RB9.t2 a_3133_3750# VSS nfet_03v3 ad=0.1584p pd=1.6u as=0.1152p ps=1u w=0.36u l=0.28u
X315 VDD.t1227 a_n1204_n954.t9 a_37170_n450# VDD.t1226 pfet_03v3 ad=0.1584p pd=1.6u as=56.7f ps=0.675u w=0.36u l=0.28u
X316 QB6b.t0 a_16231_n2146.t32 VDD VDD pfet_03v3 ad=0.4104p pd=2.58u as=0.2484p ps=1.41u w=0.72u l=0.28u
X317 VDD RB10.t5 a_21170_3124# VDD pfet_03v3 ad=0.3168p pd=2.32u as=0.3708p ps=2.47u w=0.72u l=0.28u
X318 a_14536_n170# a_14472_n708.t6 VSS VSS nfet_03v3 ad=0.1188p pd=1.02u as=0.1584p ps=1.6u w=0.36u l=0.28u
X319 VSS a_n884_5318.t8 a_32226_5318# VSS nfet_03v3 ad=0.1584p pd=1.6u as=56.7f ps=0.675u w=0.36u l=0.28u
X320 a_30325_2966# RA10.t1 a_30793_n862.t2 VSS nfet_03v3 ad=0.1152p pd=1u as=0.1584p ps=1.6u w=0.36u l=0.28u
X321 VSS.t1119 a_n1204_n954.t10 a_n884_n954.t3 VSS nfet_03v3 ad=0.2948p pd=2.22u as=0.1943p ps=1.25u w=0.67u l=0.28u
X322 VSS RB1.t1 a_8810_10368# VSS nfet_03v3 ad=0.1584p pd=1.6u as=0.1854p ps=1.75u w=0.36u l=0.28u
X323 VDD a_n1204_6886.t9 a_24810_7390# VDD pfet_03v3 ad=0.1584p pd=1.6u as=56.7f ps=0.675u w=0.36u l=0.28u
X324 a_n1204_6102.t1 a_n1652_6102# VDD VDD pfet_03v3 ad=0.3302p pd=1.79u as=0.5588p ps=3.42u w=1.27u l=0.28u
X325 a_21952_6102# a_21888_n708.t6 VDD VDD pfet_03v3 ad=0.2097p pd=1.38u as=0.3168p ps=2.32u w=0.72u l=0.28u
X326 a_36972_2966# a_n1204_2966.t8 a_36784_2966# VSS nfet_03v3 ad=0.1278p pd=1.07u as=0.1188p ps=1.02u w=0.36u l=0.28u
X327 a_30629_1398# RA12.t5 VDD VDD pfet_03v3 ad=0.3888p pd=2.52u as=0.3312p ps=2.36u w=0.72u l=0.28u
X328 a_38479_n2146.t0 RB2.t1 a_37741_9238# VSS nfet_03v3 ad=0.1584p pd=1.6u as=0.1152p ps=1u w=0.36u l=0.28u
X329 a_24424_8454# a_24360_n708.t8 VDD VDD pfet_03v3 ad=0.2097p pd=1.38u as=0.3168p ps=2.32u w=0.72u l=0.28u
X330 VDD a_n1204_3750.t6 a_24810_4254# VDD pfet_03v3 ad=0.1584p pd=1.6u as=56.7f ps=0.675u w=0.36u l=0.28u
X331 VSS RB13.t1 a_21170_960# VSS nfet_03v3 ad=0.1584p pd=1.6u as=0.1854p ps=1.75u w=0.36u l=0.28u
X332 VSS a_12252_10022# a_12386_10336# VSS nfet_03v3 ad=97.2f pd=0.9u as=0.1584p ps=1.6u w=0.36u l=0.28u
X333 VSS RB14.t8 a_3866_n12# VSS nfet_03v3 ad=0.1584p pd=1.6u as=0.1854p ps=1.75u w=0.36u l=0.28u
X334 a_5605_9238# a_4836_9238# VSS VSS nfet_03v3 ad=0.18p pd=1.72u as=97.2f ps=0.9u w=0.36u l=0.28u
X335 a_37170_8958# a_37106_8768# a_36972_8454# VDD pfet_03v3 ad=56.7f pd=0.675u as=0.1278p ps=1.07u w=0.36u l=0.28u
X336 a_38479_n2146.t5 RB6.t1 a_37741_6102# VSS nfet_03v3 ad=0.1584p pd=1.6u as=0.1152p ps=1u w=0.36u l=0.28u
X337 a_8381_n862# RA15.t2 VSS.t486 VSS nfet_03v3 ad=0.1944p pd=1.8u as=0.1656p ps=1.64u w=0.36u l=0.28u
X338 VDD a_n1204_614.t6 a_24810_1118# VDD pfet_03v3 ad=0.1584p pd=1.6u as=56.7f ps=0.675u w=0.36u l=0.28u
X339 a_14922_10022# a_14858_10336# a_14724_10022# VSS nfet_03v3 ad=56.7f pd=0.675u as=0.1278p ps=1.07u w=0.36u l=0.28u
X340 VSS a_34500_6886# a_34634_7200# VSS nfet_03v3 ad=97.2f pd=0.9u as=0.1584p ps=1.6u w=0.36u l=0.28u
X341 a_5605_6102# a_4836_6102# VSS VSS nfet_03v3 ad=0.18p pd=1.72u as=97.2f ps=0.9u w=0.36u l=0.28u
X342 a_31840_5318# a_31776_n708.t4 VDD VDD pfet_03v3 ad=0.2097p pd=1.38u as=0.3168p ps=2.32u w=0.72u l=0.28u
X343 a_8173_n1738# a_n884_n1738.t7 a_7064_n1782# VDD pfet_03v3 ad=0.2097p pd=1.38u as=0.1278p ps=1.07u w=0.36u l=0.28u
X344 a_37741_10806# a_36972_10806# VSS VSS nfet_03v3 ad=0.18p pd=1.72u as=97.2f ps=0.9u w=0.36u l=0.28u
X345 a_31840_2182# a_31776_n708.t5 VDD VDD pfet_03v3 ad=0.2097p pd=1.38u as=0.3168p ps=2.32u w=0.72u l=0.28u
X346 a_32576_n1738# WEM.t1 VDD VDD pfet_03v3 ad=56.7f pd=0.675u as=0.1584p ps=1.6u w=0.36u l=0.28u
X347 VDD.t1485 RB14.t9 a_3866_n12# VDD.t730 pfet_03v3 ad=0.3168p pd=2.32u as=0.3708p ps=2.47u w=0.72u l=0.28u
X348 a_n1652_9678# WE2.t0 VSS VSS nfet_03v3 ad=0.1872p pd=1.24u as=0.3168p ps=2.32u w=0.72u l=0.28u
X349 a_20437_8454# a_19668_8454# VSS VSS nfet_03v3 ad=0.18p pd=1.72u as=97.2f ps=0.9u w=0.36u l=0.28u
X350 VSS a_n1652_7318# a_n1204_6886.t3 VSS nfet_03v3 ad=0.1693p pd=1.19u as=0.1651p ps=1.155u w=0.635u l=0.28u
X351 VSS a_n884_10806.t5 a_7506_11310# VSS nfet_03v3 ad=0.1584p pd=1.6u as=56.7f ps=0.675u w=0.36u l=0.28u
X352 VDD a_n1204_7670.t8 a_29754_7670# VDD pfet_03v3 ad=0.1584p pd=1.6u as=56.7f ps=0.675u w=0.36u l=0.28u
X353 a_18269_6102# RA6.t0 VDD VDD pfet_03v3 ad=0.3888p pd=2.52u as=0.3312p ps=2.36u w=0.72u l=0.28u
X354 a_24810_3470# a_24746_3156# a_24612_2966# VSS nfet_03v3 ad=56.7f pd=0.675u as=0.1278p ps=1.07u w=0.36u l=0.28u
X355 a_20437_5318# a_19668_5318# VSS VSS nfet_03v3 ad=0.18p pd=1.72u as=97.2f ps=0.9u w=0.36u l=0.28u
X356 VDD a_n1204_4534.t7 a_29754_4534# VDD pfet_03v3 ad=0.1584p pd=1.6u as=56.7f ps=0.675u w=0.36u l=0.28u
X357 a_32028_10806# WE0CLK.t5 a_31840_10806# VSS nfet_03v3 ad=0.1278p pd=1.07u as=0.1188p ps=1.02u w=0.36u l=0.28u
X358 VSS RB1.t2 a_13754_10368# VSS nfet_03v3 ad=0.1584p pd=1.6u as=0.1854p ps=1.75u w=0.36u l=0.28u
X359 VDD a_27084_2182# a_27218_2496# VDD pfet_03v3 ad=0.1764p pd=1.26u as=0.1584p ps=1.6u w=0.36u l=0.28u
X360 a_19480_n954# a_19416_n708.t7 VDD.t1787 VDD.t1786 pfet_03v3 ad=0.2097p pd=1.38u as=0.3168p ps=2.32u w=0.72u l=0.28u
X361 a_3871_n2146.t27 a_3866_9396# a_3133_9238# VDD pfet_03v3 ad=0.1584p pd=1.6u as=0.1152p ps=1u w=0.36u l=0.28u
X362 a_7120_6886# a_7056_n708.t5 VDD VDD pfet_03v3 ad=0.2097p pd=1.38u as=0.3168p ps=2.32u w=0.72u l=0.28u
X363 a_27282_6102# a_27218_6292# a_27084_6102# VDD pfet_03v3 ad=56.7f pd=0.675u as=0.1278p ps=1.07u w=0.36u l=0.28u
X364 a_22909_n954# a_22140_n954# VDD.t2383 VDD.t2382 pfet_03v3 ad=0.36p pd=2.44u as=0.1764p ps=1.26u w=0.72u l=0.28u
X365 a_15493_1398# a_14724_1398# VDD VDD pfet_03v3 ad=0.36p pd=2.44u as=0.1764p ps=1.26u w=0.72u l=0.28u
X366 a_21175_n2146.t19 a_21170_8800# a_20437_8454# VDD pfet_03v3 ad=0.1584p pd=1.6u as=0.1152p ps=1u w=0.36u l=0.28u
X367 a_28157_5410# RA7.t1 VDD VDD pfet_03v3 ad=0.3888p pd=2.52u as=0.3312p ps=2.36u w=0.72u l=0.28u
X368 VSS a_n108_1398# a_26_1588# VSS nfet_03v3 ad=97.2f pd=0.9u as=0.1584p ps=1.6u w=0.36u l=0.28u
X369 a_28157_2274# RA11.t3 VDD VDD pfet_03v3 ad=0.3888p pd=2.52u as=0.3312p ps=2.36u w=0.72u l=0.28u
X370 VSS.t1248 a_n884_n954.t5 a_19866_n954# VSS nfet_03v3 ad=0.1584p pd=1.6u as=56.7f ps=0.675u w=0.36u l=0.28u
X371 VDD RB0.t2 a_18698_10964# VDD pfet_03v3 ad=0.3168p pd=2.32u as=0.3708p ps=2.47u w=0.72u l=0.28u
X372 a_26896_7670# a_26832_n708.t6 VSS VSS nfet_03v3 ad=0.1188p pd=1.02u as=0.1584p ps=1.6u w=0.36u l=0.28u
X373 a_13021_5318# RA7.t2 a_13489_n862.t10 VSS nfet_03v3 ad=0.1152p pd=1u as=0.1584p ps=1.6u w=0.36u l=0.28u
X374 a_36784_2182# a_36720_n708.t8 VSS VSS nfet_03v3 ad=0.1188p pd=1.02u as=0.1584p ps=1.6u w=0.36u l=0.28u
X375 a_20437_6886# RA5.t0 a_20905_n862.t12 VSS nfet_03v3 ad=0.1152p pd=1u as=0.1584p ps=1.6u w=0.36u l=0.28u
X376 VSS a_n884_10022.t6 a_29754_10022# VSS nfet_03v3 ad=0.1584p pd=1.6u as=56.7f ps=0.675u w=0.36u l=0.28u
X377 a_26896_4534# a_26832_n708.t7 VSS VSS nfet_03v3 ad=0.1188p pd=1.02u as=0.1584p ps=1.6u w=0.36u l=0.28u
X378 a_10549_2182# RA11.t4 a_11017_n862.t8 VSS nfet_03v3 ad=0.1152p pd=1u as=0.1584p ps=1.6u w=0.36u l=0.28u
X379 a_34248_n708.t3 a_34256_n1782# VSS.t2347 VSS nfet_03v3 ad=0.1612p pd=1.14u as=0.2728p ps=2.12u w=0.62u l=0.28u
X380 a_18269_1398# RA12.t6 VSS VSS nfet_03v3 ad=0.1944p pd=1.8u as=0.1656p ps=1.64u w=0.36u l=0.28u
X381 a_24424_1398# a_24360_n708.t9 VSS VSS nfet_03v3 ad=0.1188p pd=1.02u as=0.1584p ps=1.6u w=0.36u l=0.28u
X382 a_2176_10806# a_2112_n708.t9 VDD VDD pfet_03v3 ad=0.2097p pd=1.38u as=0.3168p ps=2.32u w=0.72u l=0.28u
X383 VSS RB1.t3 a_31058_10368# VSS nfet_03v3 ad=0.1584p pd=1.6u as=0.1854p ps=1.75u w=0.36u l=0.28u
X384 a_19866_9742# a_19802_9428# a_19668_9238# VSS nfet_03v3 ad=56.7f pd=0.675u as=0.1278p ps=1.07u w=0.36u l=0.28u
X385 a_3871_n2146.t26 RB8.t3 a_3133_4534# VSS nfet_03v3 ad=0.1584p pd=1.6u as=0.1152p ps=1u w=0.36u l=0.28u
X386 a_34500_2966# a_n1204_2966.t9 a_34312_2966# VSS nfet_03v3 ad=0.1278p pd=1.07u as=0.1188p ps=1.02u w=0.36u l=0.28u
X387 a_3229_n1738# WEM.t2 a_2120_n1782# VSS nfet_03v3 ad=0.1188p pd=1.02u as=0.1278p ps=1.07u w=0.36u l=0.28u
X388 VDD.t1486 RB14.t10 a_36002_n12# VDD.t732 pfet_03v3 ad=0.3168p pd=2.32u as=0.3708p ps=2.47u w=0.72u l=0.28u
X389 a_19866_6606# a_19802_6292# a_19668_6102# VSS nfet_03v3 ad=56.7f pd=0.675u as=0.1278p ps=1.07u w=0.36u l=0.28u
X390 VDD RB9.t3 a_38474_4096# VDD pfet_03v3 ad=0.3168p pd=2.32u as=0.3708p ps=2.47u w=0.72u l=0.28u
X391 a_3133_9238# a_2364_9238# VSS VSS nfet_03v3 ad=0.18p pd=1.72u as=97.2f ps=0.9u w=0.36u l=0.28u
X392 a_11287_n2146.t15 a_11282_6260# a_10549_6102# VDD pfet_03v3 ad=0.1584p pd=1.6u as=0.1152p ps=1u w=0.36u l=0.28u
X393 a_n296_1398# a_n360_n708.t6 VDD VDD pfet_03v3 ad=0.2097p pd=1.38u as=0.3168p ps=2.32u w=0.72u l=0.28u
X394 VDD RB13.t2 a_38474_960# VDD pfet_03v3 ad=0.3168p pd=2.32u as=0.3708p ps=2.47u w=0.72u l=0.28u
X395 a_26119_n2146.t0 RB5.t4 a_25381_6886# VSS nfet_03v3 ad=0.1584p pd=1.6u as=0.1152p ps=1u w=0.36u l=0.28u
X396 a_661_6102# a_n108_6102# VDD VDD pfet_03v3 ad=0.36p pd=2.44u as=0.1764p ps=1.26u w=0.72u l=0.28u
X397 VDD a_n1204_2966.t10 a_12450_2966# VDD pfet_03v3 ad=0.1584p pd=1.6u as=56.7f ps=0.675u w=0.36u l=0.28u
X398 a_3133_6102# a_2364_6102# VSS VSS nfet_03v3 ad=0.18p pd=1.72u as=97.2f ps=0.9u w=0.36u l=0.28u
X399 VSS a_19668_2966# a_19802_3156# VSS nfet_03v3 ad=97.2f pd=0.9u as=0.1584p ps=1.6u w=0.36u l=0.28u
X400 VSS RB0.t3 a_8810_10964# VSS nfet_03v3 ad=0.1584p pd=1.6u as=0.1854p ps=1.75u w=0.36u l=0.28u
X401 a_n1204_3750.t3 a_n1652_4182# VSS VSS nfet_03v3 ad=0.1651p pd=1.155u as=0.2794p ps=2.15u w=0.635u l=0.28u
X402 VDD RB4.t2 a_18698_7828# VDD pfet_03v3 ad=0.3168p pd=2.32u as=0.3708p ps=2.47u w=0.72u l=0.28u
X403 a_21952_3750# a_21888_n708.t7 VSS VSS nfet_03v3 ad=0.1188p pd=1.02u as=0.1584p ps=1.6u w=0.36u l=0.28u
X404 a_15797_2274# RA11.t5 VSS VSS nfet_03v3 ad=0.1944p pd=1.8u as=0.1656p ps=1.64u w=0.36u l=0.28u
X405 a_19668_10806# a_n884_10806.t6 a_19480_10806# VDD pfet_03v3 ad=0.1278p pd=1.07u as=0.2097p ps=1.38u w=0.36u l=0.28u
X406 a_965_7670# RA4.t1 VSS VSS nfet_03v3 ad=0.1944p pd=1.8u as=0.1656p ps=1.64u w=0.36u l=0.28u
X407 a_13759_n2146.t2 RB4.t3 a_13021_7670# VSS nfet_03v3 ad=0.1584p pd=1.6u as=0.1152p ps=1u w=0.36u l=0.28u
X408 a_8815_n2146.t0 RB5.t5 a_8077_6886# VSS nfet_03v3 ad=0.1584p pd=1.6u as=0.1152p ps=1u w=0.36u l=0.28u
X409 VDD RB8.t4 a_18698_4692# VDD pfet_03v3 ad=0.3168p pd=2.32u as=0.3708p ps=2.47u w=0.72u l=0.28u
X410 a_17965_n170# a_17196_n170# VDD.t2375 VDD.t2374 pfet_03v3 ad=0.36p pd=2.44u as=0.1764p ps=1.26u w=0.72u l=0.28u
X411 a_27853_7670# RA4.t2 a_28321_n862.t15 VSS nfet_03v3 ad=0.1152p pd=1u as=0.1584p ps=1.6u w=0.36u l=0.28u
X412 VDD a_n1204_7670.t9 a_27282_7670# VDD pfet_03v3 ad=0.1584p pd=1.6u as=56.7f ps=0.675u w=0.36u l=0.28u
X413 VDD.t3197 a_17196_n954# a_17330_n640# VDD.t2372 pfet_03v3 ad=0.1764p pd=1.26u as=0.1584p ps=1.6u w=0.36u l=0.28u
X414 a_29556_9238# a_n1204_9238.t8 a_29368_9238# VSS nfet_03v3 ad=0.1278p pd=1.07u as=0.1188p ps=1.02u w=0.36u l=0.28u
X415 a_22338_3470# a_22274_3156# a_22140_2966# VSS nfet_03v3 ad=56.7f pd=0.675u as=0.1278p ps=1.07u w=0.36u l=0.28u
X416 a_32028_2182# a_n1204_2182.t6 a_31840_2182# VSS nfet_03v3 ad=0.1278p pd=1.07u as=0.1188p ps=1.02u w=0.36u l=0.28u
X417 a_33535_n2146.t5 RB15.t4 a_32797_n954# VSS nfet_03v3 ad=0.1584p pd=1.6u as=0.1152p ps=1u w=0.36u l=0.28u
X418 a_29556_6102# a_n1204_6102.t6 a_29368_6102# VSS nfet_03v3 ad=0.1278p pd=1.07u as=0.1188p ps=1.02u w=0.36u l=0.28u
X419 VDD a_n1204_4534.t8 a_27282_4534# VDD pfet_03v3 ad=0.1584p pd=1.6u as=56.7f ps=0.675u w=0.36u l=0.28u
X420 a_11287_n2146.t10 RB12.t4 a_10549_1398# VSS nfet_03v3 ad=0.1584p pd=1.6u as=0.1152p ps=1u w=0.36u l=0.28u
X421 VDD a_24612_2182# a_24746_2496# VDD pfet_03v3 ad=0.1764p pd=1.26u as=0.1584p ps=1.6u w=0.36u l=0.28u
X422 a_20437_n954# a_19668_n954# VDD.t2371 VDD.t2370 pfet_03v3 ad=0.36p pd=2.44u as=0.1764p ps=1.26u w=0.72u l=0.28u
X423 a_1399_n2146.t7 RB15.t5 a_661_n954# VSS nfet_03v3 ad=0.1584p pd=1.6u as=0.1152p ps=1u w=0.36u l=0.28u
X424 VDD RB10.t6 a_33530_3124# VDD pfet_03v3 ad=0.3168p pd=2.32u as=0.3708p ps=2.47u w=0.72u l=0.28u
X425 a_5034_3470# a_4970_3156# a_4836_2966# VSS nfet_03v3 ad=56.7f pd=0.675u as=0.1278p ps=1.07u w=0.36u l=0.28u
X426 a_25381_n170# RA14.t4 a_25849_n862.t9 VSS nfet_03v3 ad=0.1152p pd=1u as=0.1584p ps=1.6u w=0.36u l=0.28u
X427 VDD a_7308_2182# a_7442_2496# VDD pfet_03v3 ad=0.1764p pd=1.26u as=0.1584p ps=1.6u w=0.36u l=0.28u
X428 VSS.t1249 a_n884_n954.t6 a_17394_n954# VSS nfet_03v3 ad=0.1584p pd=1.6u as=56.7f ps=0.675u w=0.36u l=0.28u
X429 VSS RB0.t4 a_13754_10964# VSS nfet_03v3 ad=0.1584p pd=1.6u as=0.1854p ps=1.75u w=0.36u l=0.28u
X430 a_36972_10806# a_n884_10806.t7 a_36784_10806# VDD pfet_03v3 ad=0.1278p pd=1.07u as=0.2097p ps=1.38u w=0.36u l=0.28u
X431 a_35269_9238# a_34500_9238# VSS VSS nfet_03v3 ad=0.18p pd=1.72u as=97.2f ps=0.9u w=0.36u l=0.28u
X432 a_34312_2182# a_34248_n708.t9 VSS VSS nfet_03v3 ad=0.1188p pd=1.02u as=0.1584p ps=1.6u w=0.36u l=0.28u
X433 VSS.t1946 D15.t0 a_37837_n1738# VSS nfet_03v3 ad=0.1584p pd=1.6u as=0.1188p ps=1.02u w=0.36u l=0.28u
X434 a_30629_n170# RA14.t5 VDD.t1078 VDD.t443 pfet_03v3 ad=0.3888p pd=2.52u as=0.3312p ps=2.36u w=0.72u l=0.28u
X435 a_19668_614# a_n1204_614.t7 a_19480_614# VSS nfet_03v3 ad=0.1278p pd=1.07u as=0.1188p ps=1.02u w=0.36u l=0.28u
X436 a_35269_6102# a_34500_6102# VSS VSS nfet_03v3 ad=0.18p pd=1.72u as=97.2f ps=0.9u w=0.36u l=0.28u
X437 a_8381_5410# RA7.t3 VDD VDD pfet_03v3 ad=0.3888p pd=2.52u as=0.3312p ps=2.36u w=0.72u l=0.28u
X438 a_2176_2182# a_2112_n708.t10 VSS VSS nfet_03v3 ad=0.1188p pd=1.02u as=0.1584p ps=1.6u w=0.36u l=0.28u
X439 a_36784_8454# a_36720_n708.t9 VDD VDD pfet_03v3 ad=0.2097p pd=1.38u as=0.3168p ps=2.32u w=0.72u l=0.28u
X440 a_2364_7670# a_n884_7670.t5 a_2176_7670# VDD pfet_03v3 ad=0.1278p pd=1.07u as=0.2097p ps=1.38u w=0.36u l=0.28u
X441 a_27282_3750# a_27218_4064# a_27084_3750# VSS nfet_03v3 ad=56.7f pd=0.675u as=0.1278p ps=1.07u w=0.36u l=0.28u
X442 a_8077_n170# RA14.t6 a_8545_n862.t11 VSS nfet_03v3 ad=0.1152p pd=1u as=0.1584p ps=1.6u w=0.36u l=0.28u
X443 a_13021_9238# RA2.t1 a_13489_n862.t17 VSS nfet_03v3 ad=0.1152p pd=1u as=0.1584p ps=1.6u w=0.36u l=0.28u
X444 a_2364_4534# a_n884_4534.t5 a_2176_4534# VDD pfet_03v3 ad=0.1278p pd=1.07u as=0.2097p ps=1.38u w=0.36u l=0.28u
X445 a_8381_2274# RA11.t6 VDD VDD pfet_03v3 ad=0.3888p pd=2.52u as=0.3312p ps=2.36u w=0.72u l=0.28u
X446 a_13021_6102# RA6.t1 a_13489_n862.t26 VSS nfet_03v3 ad=0.1152p pd=1u as=0.1584p ps=1.6u w=0.36u l=0.28u
X447 a_13325_7670# RA4.t3 VDD VDD pfet_03v3 ad=0.3888p pd=2.52u as=0.3312p ps=2.36u w=0.72u l=0.28u
X448 VDD a_14724_10022# a_14858_10336# VDD pfet_03v3 ad=0.1764p pd=1.26u as=0.1584p ps=1.6u w=0.36u l=0.28u
X449 a_10549_2966# RA10.t2 a_11017_n862.t2 VSS nfet_03v3 ad=0.1152p pd=1u as=0.1584p ps=1.6u w=0.36u l=0.28u
X450 VDD a_n1204_2966.t11 a_9978_2966# VDD pfet_03v3 ad=0.1584p pd=1.6u as=56.7f ps=0.675u w=0.36u l=0.28u
X451 VSS a_12252_8454# a_12386_8768# VSS nfet_03v3 ad=97.2f pd=0.9u as=0.1584p ps=1.6u w=0.36u l=0.28u
X452 a_13325_4534# RA8.t3 VDD VDD pfet_03v3 ad=0.3888p pd=2.52u as=0.3312p ps=2.36u w=0.72u l=0.28u
X453 VSS RB0.t5 a_31058_10964# VSS nfet_03v3 ad=0.1584p pd=1.6u as=0.1854p ps=1.75u w=0.36u l=0.28u
X454 a_29368_8454# a_29304_n708.t6 VSS VSS nfet_03v3 ad=0.1188p pd=1.02u as=0.1584p ps=1.6u w=0.36u l=0.28u
X455 VSS a_12252_5318# a_12386_5632# VSS nfet_03v3 ad=97.2f pd=0.9u as=0.1584p ps=1.6u w=0.36u l=0.28u
X456 a_22688_n1234# a_n884_n1738.t8 VSS.t6 VSS nfet_03v3 ad=56.7f pd=0.675u as=0.1584p ps=1.6u w=0.36u l=0.28u
X457 a_27084_614# a_n1204_614.t8 a_26896_614# VSS nfet_03v3 ad=0.1278p pd=1.07u as=0.1188p ps=1.02u w=0.36u l=0.28u
X458 VDD a_n1204_8454.t5 a_14922_8958# VDD pfet_03v3 ad=0.1584p pd=1.6u as=56.7f ps=0.675u w=0.36u l=0.28u
X459 a_32797_8454# a_32028_8454# VSS VSS nfet_03v3 ad=0.18p pd=1.72u as=97.2f ps=0.9u w=0.36u l=0.28u
X460 VSS RB13.t3 a_38474_960# VSS nfet_03v3 ad=0.1584p pd=1.6u as=0.1854p ps=1.75u w=0.36u l=0.28u
X461 a_29368_5318# a_29304_n708.t7 VSS VSS nfet_03v3 ad=0.1188p pd=1.02u as=0.1584p ps=1.6u w=0.36u l=0.28u
X462 a_32797_614# RA13.t1 a_33265_n862.t8 VSS nfet_03v3 ad=0.1152p pd=1u as=0.1584p ps=1.6u w=0.36u l=0.28u
X463 a_32797_5318# a_32028_5318# VSS VSS nfet_03v3 ad=0.18p pd=1.72u as=97.2f ps=0.9u w=0.36u l=0.28u
X464 a_15493_n170# a_14724_n170# VDD.t3120 VDD.t3119 pfet_03v3 ad=0.36p pd=2.44u as=0.1764p ps=1.26u w=0.72u l=0.28u
X465 a_14724_614# a_n1204_614.t9 a_14536_614# VSS nfet_03v3 ad=0.1278p pd=1.07u as=0.1188p ps=1.02u w=0.36u l=0.28u
X466 a_6343_n2146.t5 RB5.t6 a_5605_6886# VSS nfet_03v3 ad=0.1584p pd=1.6u as=0.1152p ps=1u w=0.36u l=0.28u
X467 VDD.t3239 a_14724_n954# a_14858_n640# VDD.t3117 pfet_03v3 ad=0.1764p pd=1.26u as=0.1584p ps=1.6u w=0.36u l=0.28u
X468 VDD a_n108_9238# a_26_9428# VDD pfet_03v3 ad=0.1764p pd=1.26u as=0.1584p ps=1.6u w=0.36u l=0.28u
X469 a_31063_n2146.t7 RB15.t6 a_30325_n954# VSS nfet_03v3 ad=0.1584p pd=1.6u as=0.1152p ps=1u w=0.36u l=0.28u
X470 a_20437_614# RA13.t2 a_20905_n862.t11 VSS nfet_03v3 ad=0.1152p pd=1u as=0.1584p ps=1.6u w=0.36u l=0.28u
X471 a_33535_n2146.t17 a_33530_8800# a_32797_8454# VDD pfet_03v3 ad=0.1584p pd=1.6u as=0.1152p ps=1u w=0.36u l=0.28u
X472 a_12064_5318# a_12000_n708.t4 VDD VDD pfet_03v3 ad=0.2097p pd=1.38u as=0.3168p ps=2.32u w=0.72u l=0.28u
X473 a_661_3750# a_n108_3750# VSS VSS nfet_03v3 ad=0.18p pd=1.72u as=97.2f ps=0.9u w=0.36u l=0.28u
X474 a_3133_n170# RA14.t7 a_3601_n862.t6 VSS nfet_03v3 ad=0.1152p pd=1u as=0.1584p ps=1.6u w=0.36u l=0.28u
X475 VDD a_32028_10022# a_32162_10336# VDD pfet_03v3 ad=0.1764p pd=1.26u as=0.1584p ps=1.6u w=0.36u l=0.28u
X476 a_1399_n2146.t31 a_1394_8800# a_661_8454# VDD pfet_03v3 ad=0.1584p pd=1.6u as=0.1152p ps=1u w=0.36u l=0.28u
X477 a_15797_2966# RA10.t3 VSS VSS nfet_03v3 ad=0.1944p pd=1.8u as=0.1656p ps=1.64u w=0.36u l=0.28u
X478 a_12064_2182# a_12000_n708.t5 VDD VDD pfet_03v3 ad=0.2097p pd=1.38u as=0.3168p ps=2.32u w=0.72u l=0.28u
X479 VDD a_n1204_7670.t10 a_7506_7670# VDD pfet_03v3 ad=0.1584p pd=1.6u as=56.7f ps=0.675u w=0.36u l=0.28u
X480 a_25381_5318# RA7.t4 a_25849_n862.t10 VSS nfet_03v3 ad=0.1152p pd=1u as=0.1584p ps=1.6u w=0.36u l=0.28u
X481 VDD RB1.t4 a_18698_10368# VDD pfet_03v3 ad=0.3168p pd=2.32u as=0.3708p ps=2.47u w=0.72u l=0.28u
X482 a_9780_9238# a_n1204_9238.t9 a_9592_9238# VSS nfet_03v3 ad=0.1278p pd=1.07u as=0.1188p ps=1.02u w=0.36u l=0.28u
X483 a_24424_9238# a_24360_n708.t10 VDD VDD pfet_03v3 ad=0.2097p pd=1.38u as=0.3168p ps=2.32u w=0.72u l=0.28u
X484 VSS a_n1204_2182.t7 a_n884_2182.t3 VSS nfet_03v3 ad=0.2948p pd=2.22u as=0.1943p ps=1.25u w=0.67u l=0.28u
X485 VDD a_n1204_4534.t9 a_7506_4534# VDD pfet_03v3 ad=0.1584p pd=1.6u as=56.7f ps=0.675u w=0.36u l=0.28u
X486 VSS a_n884_9238.t6 a_90_9742# VSS nfet_03v3 ad=0.1584p pd=1.6u as=56.7f ps=0.675u w=0.36u l=0.28u
X487 a_9780_6102# a_n1204_6102.t7 a_9592_6102# VSS nfet_03v3 ad=0.1278p pd=1.07u as=0.1188p ps=1.02u w=0.36u l=0.28u
X488 VDD a_4836_2182# a_4970_2496# VDD pfet_03v3 ad=0.1764p pd=1.26u as=0.1584p ps=1.6u w=0.36u l=0.28u
X489 a_36784_1398# a_36720_n708.t10 VSS VSS nfet_03v3 ad=0.1188p pd=1.02u as=0.1584p ps=1.6u w=0.36u l=0.28u
X490 a_19480_n170# a_19416_n708.t8 VSS VSS nfet_03v3 ad=0.1188p pd=1.02u as=0.1584p ps=1.6u w=0.36u l=0.28u
X491 a_2176_10022# a_2112_n708.t11 VDD VDD pfet_03v3 ad=0.2097p pd=1.38u as=0.3168p ps=2.32u w=0.72u l=0.28u
X492 VDD a_n1204_6886.t10 a_34698_7390# VDD pfet_03v3 ad=0.1584p pd=1.6u as=56.7f ps=0.675u w=0.36u l=0.28u
X493 VSS a_n884_6102.t5 a_90_6606# VSS nfet_03v3 ad=0.1584p pd=1.6u as=56.7f ps=0.675u w=0.36u l=0.28u
X494 a_31840_6102# a_31776_n708.t6 VDD VDD pfet_03v3 ad=0.2097p pd=1.38u as=0.3168p ps=2.32u w=0.72u l=0.28u
X495 a_7506_11310# a_7442_10996# a_7308_10806# VSS nfet_03v3 ad=56.7f pd=0.675u as=0.1278p ps=1.07u w=0.36u l=0.28u
X496 a_34312_8454# a_34248_n708.t10 VDD VDD pfet_03v3 ad=0.2097p pd=1.38u as=0.3168p ps=2.32u w=0.72u l=0.28u
X497 a_n296_n170# a_n360_n708.t7 VDD.t235 VDD.t234 pfet_03v3 ad=0.2097p pd=1.38u as=0.3168p ps=2.32u w=0.72u l=0.28u
X498 VDD a_n1204_3750.t7 a_34698_4254# VDD pfet_03v3 ad=0.1584p pd=1.6u as=56.7f ps=0.675u w=0.36u l=0.28u
X499 a_17965_n954# a_18269_n862# a_18433_n862.t2 VDD.t2018 pfet_03v3 ad=0.1152p pd=1u as=0.1584p ps=1.6u w=0.36u l=0.28u
X500 a_2176_8454# a_2112_n708.t12 VDD VDD pfet_03v3 ad=0.2097p pd=1.38u as=0.3168p ps=2.32u w=0.72u l=0.28u
X501 a_4648_7670# a_4584_n708.t5 VSS VSS nfet_03v3 ad=0.1188p pd=1.02u as=0.1584p ps=1.6u w=0.36u l=0.28u
X502 a_23647_n2146.t26 a_23642_6260# a_22909_6102# VDD pfet_03v3 ad=0.1584p pd=1.6u as=0.1152p ps=1u w=0.36u l=0.28u
X503 a_13021_2966# a_12252_2966# VDD VDD pfet_03v3 ad=0.36p pd=2.44u as=0.1764p ps=1.26u w=0.72u l=0.28u
X504 VSS.t2314 a_21896_n1782# a_21888_n708.t3 VSS nfet_03v3 ad=0.2728p pd=2.12u as=0.1612p ps=1.14u w=0.62u l=0.28u
X505 VDD a_n1204_614.t10 a_34698_1118# VDD pfet_03v3 ad=0.1584p pd=1.6u as=56.7f ps=0.675u w=0.36u l=0.28u
X506 a_29754_9742# a_29690_9428# a_29556_9238# VSS nfet_03v3 ad=56.7f pd=0.675u as=0.1278p ps=1.07u w=0.36u l=0.28u
X507 a_4648_4534# a_4584_n708.t6 VSS VSS nfet_03v3 ad=0.1188p pd=1.02u as=0.1584p ps=1.6u w=0.36u l=0.28u
X508 a_29754_6606# a_29690_6292# a_29556_6102# VSS nfet_03v3 ad=56.7f pd=0.675u as=0.1278p ps=1.07u w=0.36u l=0.28u
X509 VSS RB13.t4 a_26114_960# VSS nfet_03v3 ad=0.1584p pd=1.6u as=0.1854p ps=1.75u w=0.36u l=0.28u
X510 a_19668_1398# a_n884_1398.t4 a_19480_1398# VDD pfet_03v3 ad=0.1278p pd=1.07u as=0.2097p ps=1.38u w=0.36u l=0.28u
X511 a_31063_n2146.t25 a_31058_10964# a_30325_10806# VDD pfet_03v3 ad=0.1584p pd=1.6u as=0.1152p ps=1u w=0.36u l=0.28u
X512 VDD RB3.t2 a_28586_8800# VDD pfet_03v3 ad=0.3168p pd=2.32u as=0.3708p ps=2.47u w=0.72u l=0.28u
X513 a_22338_614# a_22274_928# a_22140_614# VSS nfet_03v3 ad=56.7f pd=0.675u as=0.1278p ps=1.07u w=0.36u l=0.28u
X514 a_n1652_10806# WE0.t0 VDD VDD pfet_03v3 ad=0.1872p pd=1.24u as=0.3168p ps=2.32u w=0.72u l=0.28u
X515 a_27853_7670# a_27084_7670# VDD VDD pfet_03v3 ad=0.36p pd=2.44u as=0.1764p ps=1.26u w=0.72u l=0.28u
X516 a_28157_6102# RA6.t2 VDD VDD pfet_03v3 ad=0.3888p pd=2.52u as=0.3312p ps=2.36u w=0.72u l=0.28u
X517 VDD RB9.t4 a_18698_4096# VDD pfet_03v3 ad=0.3168p pd=2.32u as=0.3708p ps=2.47u w=0.72u l=0.28u
X518 a_8077_2182# a_8381_2274# a_8545_n862.t9 VDD pfet_03v3 ad=0.1152p pd=1u as=0.1584p ps=1.6u w=0.36u l=0.28u
X519 a_27853_4534# a_27084_4534# VDD VDD pfet_03v3 ad=0.36p pd=2.44u as=0.1764p ps=1.26u w=0.72u l=0.28u
X520 a_34698_3470# a_34634_3156# a_34500_2966# VSS nfet_03v3 ad=56.7f pd=0.675u as=0.1278p ps=1.07u w=0.36u l=0.28u
X521 a_90_n450# a_26_n640# a_n108_n954# VDD.t2002 pfet_03v3 ad=56.7f pd=0.675u as=0.1278p ps=1.07u w=0.36u l=0.28u
X522 a_29368_n954# a_29304_n708.t8 VDD.t692 VDD.t691 pfet_03v3 ad=0.2097p pd=1.38u as=0.3168p ps=2.32u w=0.72u l=0.28u
X523 VDD RB13.t5 a_18698_960# VDD pfet_03v3 ad=0.3168p pd=2.32u as=0.3708p ps=2.47u w=0.72u l=0.28u
X524 a_23647_n2146.t3 RB12.t5 a_22909_1398# VSS nfet_03v3 ad=0.1584p pd=1.6u as=0.1152p ps=1u w=0.36u l=0.28u
X525 a_12450_11310# a_12386_10996# a_12252_10806# VSS nfet_03v3 ad=56.7f pd=0.675u as=0.1278p ps=1.07u w=0.36u l=0.28u
X526 a_9592_8454# a_9528_n708.t6 VSS VSS nfet_03v3 ad=0.1188p pd=1.02u as=0.1584p ps=1.6u w=0.36u l=0.28u
X527 a_15493_8454# RA3.t1 a_15961_n862.t3 VSS nfet_03v3 ad=0.1152p pd=1u as=0.1584p ps=1.6u w=0.36u l=0.28u
X528 VDD a_36972_2182# a_37106_2496# VDD pfet_03v3 ad=0.1764p pd=1.26u as=0.1584p ps=1.6u w=0.36u l=0.28u
X529 a_32797_n954# a_32028_n954# VDD.t2762 VDD.t2761 pfet_03v3 ad=0.36p pd=2.44u as=0.1764p ps=1.26u w=0.72u l=0.28u
X530 VSS RB13.t6 a_8810_960# VSS nfet_03v3 ad=0.1584p pd=1.6u as=0.1854p ps=1.75u w=0.36u l=0.28u
X531 a_22338_10806# a_22274_10996# a_22140_10806# VDD pfet_03v3 ad=56.7f pd=0.675u as=0.1278p ps=1.07u w=0.36u l=0.28u
X532 a_37170_6102# a_37106_6292# a_36972_6102# VDD pfet_03v3 ad=56.7f pd=0.675u as=0.1278p ps=1.07u w=0.36u l=0.28u
X533 a_32028_1398# a_n1204_1398.t5 a_31840_1398# VSS nfet_03v3 ad=0.1278p pd=1.07u as=0.1188p ps=1.02u w=0.36u l=0.28u
X534 a_25381_1398# a_24612_1398# VDD VDD pfet_03v3 ad=0.36p pd=2.44u as=0.1764p ps=1.26u w=0.72u l=0.28u
X535 a_31063_n2146.t16 a_31058_8800# a_30325_8454# VDD pfet_03v3 ad=0.1584p pd=1.6u as=0.1152p ps=1u w=0.36u l=0.28u
X536 a_9592_5318# a_9528_n708.t7 VSS VSS nfet_03v3 ad=0.1188p pd=1.02u as=0.1584p ps=1.6u w=0.36u l=0.28u
X537 VSS a_n884_2182.t4 a_19866_2182# VSS nfet_03v3 ad=0.1584p pd=1.6u as=56.7f ps=0.675u w=0.36u l=0.28u
X538 a_22909_5318# RA7.t5 a_23377_n862.t6 VSS nfet_03v3 ad=0.1152p pd=1u as=0.1584p ps=1.6u w=0.36u l=0.28u
X539 VSS.t1250 a_n884_n954.t7 a_29754_n954# VSS nfet_03v3 ad=0.1584p pd=1.6u as=56.7f ps=0.675u w=0.36u l=0.28u
X540 a_30325_10806# a_30629_10806# a_30793_n862.t6 VDD pfet_03v3 ad=0.1152p pd=1u as=0.1584p ps=1.6u w=0.36u l=0.28u
X541 a_7308_9238# a_n1204_9238.t10 a_7120_9238# VSS nfet_03v3 ad=0.1278p pd=1.07u as=0.1188p ps=1.02u w=0.36u l=0.28u
X542 VDD a_n1204_7670.t11 a_5034_7670# VDD pfet_03v3 ad=0.1584p pd=1.6u as=56.7f ps=0.675u w=0.36u l=0.28u
X543 a_30325_6886# RA5.t1 a_30793_n862.t8 VSS nfet_03v3 ad=0.1152p pd=1u as=0.1584p ps=1.6u w=0.36u l=0.28u
X544 a_28157_1398# RA12.t7 VSS VSS nfet_03v3 ad=0.1944p pd=1.8u as=0.1656p ps=1.64u w=0.36u l=0.28u
X545 VSS a_n108_6886# a_26_7200# VSS nfet_03v3 ad=97.2f pd=0.9u as=0.1584p ps=1.6u w=0.36u l=0.28u
X546 a_7308_6102# a_n1204_6102.t8 a_7120_6102# VSS nfet_03v3 ad=0.1278p pd=1.07u as=0.1188p ps=1.02u w=0.36u l=0.28u
X547 VDD a_n1204_4534.t10 a_5034_4534# VDD pfet_03v3 ad=0.1584p pd=1.6u as=56.7f ps=0.675u w=0.36u l=0.28u
X548 a_34312_1398# a_34248_n708.t11 VSS VSS nfet_03v3 ad=0.1188p pd=1.02u as=0.1584p ps=1.6u w=0.36u l=0.28u
X549 a_25381_9238# RA2.t2 a_25849_n862.t18 VSS nfet_03v3 ad=0.1152p pd=1u as=0.1584p ps=1.6u w=0.36u l=0.28u
X550 a_n108_2966# a_n884_2966.t4 a_n296_2966# VDD pfet_03v3 ad=0.1278p pd=1.07u as=0.2097p ps=1.38u w=0.36u l=0.28u
X551 a_2176_1398# a_2112_n708.t13 VSS VSS nfet_03v3 ad=0.1188p pd=1.02u as=0.1584p ps=1.6u w=0.36u l=0.28u
X552 a_25381_6102# RA6.t3 a_25849_n862.t25 VSS nfet_03v3 ad=0.1152p pd=1u as=0.1584p ps=1.6u w=0.36u l=0.28u
X553 a_25685_7670# RA4.t4 VDD VDD pfet_03v3 ad=0.3888p pd=2.52u as=0.3312p ps=2.36u w=0.72u l=0.28u
X554 a_21175_n2146.t22 a_21170_6260# a_20437_6102# VDD pfet_03v3 ad=0.1584p pd=1.6u as=0.1152p ps=1u w=0.36u l=0.28u
X555 VSS RB13.t7 a_3866_960# VSS nfet_03v3 ad=0.1584p pd=1.6u as=0.1854p ps=1.75u w=0.36u l=0.28u
X556 a_n884_10022.t1 a_n1204_10022.t7 VDD VDD pfet_03v3 ad=0.3886p pd=1.92u as=0.3386p ps=1.86u w=1.34u l=0.28u
X557 a_24424_6886# a_24360_n708.t11 VSS VSS nfet_03v3 ad=0.1188p pd=1.02u as=0.1584p ps=1.6u w=0.36u l=0.28u
X558 a_10549_2966# a_9780_2966# VDD VDD pfet_03v3 ad=0.36p pd=2.44u as=0.1764p ps=1.26u w=0.72u l=0.28u
X559 VDD a_n1204_2966.t12 a_22338_2966# VDD pfet_03v3 ad=0.1584p pd=1.6u as=56.7f ps=0.675u w=0.36u l=0.28u
X560 VSS.t741 RB15.t7 a_16226_n608# VSS nfet_03v3 ad=0.1584p pd=1.6u as=0.1854p ps=1.75u w=0.36u l=0.28u
X561 a_20437_614# a_19668_614# VSS VSS nfet_03v3 ad=0.18p pd=1.72u as=97.2f ps=0.9u w=0.36u l=0.28u
X562 a_25685_4534# RA8.t4 VDD VDD pfet_03v3 ad=0.3888p pd=2.52u as=0.3312p ps=2.36u w=0.72u l=0.28u
X563 VSS a_29556_2966# a_29690_3156# VSS nfet_03v3 ad=97.2f pd=0.9u as=0.1584p ps=1.6u w=0.36u l=0.28u
X564 VSS a_n884_10806.t8 a_27282_11310# VSS nfet_03v3 ad=0.1584p pd=1.6u as=56.7f ps=0.675u w=0.36u l=0.28u
X565 a_21175_n2146.t5 RB1.t5 a_20437_10022# VSS nfet_03v3 ad=0.1584p pd=1.6u as=0.1152p ps=1u w=0.36u l=0.28u
X566 a_35269_10022# a_34500_10022# VSS VSS nfet_03v3 ad=0.18p pd=1.72u as=97.2f ps=0.9u w=0.36u l=0.28u
X567 a_13325_3842# RA9.t2 VDD VDD pfet_03v3 ad=0.3888p pd=2.52u as=0.3312p ps=2.36u w=0.72u l=0.28u
X568 VDD WE0CLK.t6 a_37170_10806# VDD pfet_03v3 ad=0.1584p pd=1.6u as=56.7f ps=0.675u w=0.36u l=0.28u
X569 a_n884_2182.t1 a_n1204_2182.t8 VDD VDD pfet_03v3 ad=0.3886p pd=1.92u as=0.3386p ps=1.86u w=1.34u l=0.28u
X570 a_17196_1398# a_n884_1398.t5 a_17008_1398# VDD pfet_03v3 ad=0.1278p pd=1.07u as=0.2097p ps=1.38u w=0.36u l=0.28u
X571 a_4836_8454# a_n1204_8454.t6 a_4648_8454# VSS nfet_03v3 ad=0.1278p pd=1.07u as=0.1188p ps=1.02u w=0.36u l=0.28u
X572 a_31840_3750# a_31776_n708.t7 VSS VSS nfet_03v3 ad=0.1188p pd=1.02u as=0.1584p ps=1.6u w=0.36u l=0.28u
X573 a_37741_2182# a_38045_2274# a_38209_n862.t26 VDD pfet_03v3 ad=0.1152p pd=1u as=0.1584p ps=1.6u w=0.36u l=0.28u
X574 a_13325_706# RA13.t3 VDD VDD pfet_03v3 ad=0.3888p pd=2.52u as=0.3312p ps=2.36u w=0.72u l=0.28u
X575 a_2562_7670# a_2498_7860# a_2364_7670# VDD pfet_03v3 ad=56.7f pd=0.675u as=0.1278p ps=1.07u w=0.36u l=0.28u
X576 a_4836_5318# a_n1204_5318.t5 a_4648_5318# VSS nfet_03v3 ad=0.1278p pd=1.07u as=0.1188p ps=1.02u w=0.36u l=0.28u
X577 VSS a_22140_8454# a_22274_8768# VSS nfet_03v3 ad=97.2f pd=0.9u as=0.1584p ps=1.6u w=0.36u l=0.28u
X578 a_5605_2182# a_5909_2274# a_6073_n862.t18 VDD pfet_03v3 ad=0.1152p pd=1u as=0.1584p ps=1.6u w=0.36u l=0.28u
X579 VDD.t2465 a_27084_n954# a_27218_n640# VDD.t2464 pfet_03v3 ad=0.1764p pd=1.26u as=0.1584p ps=1.6u w=0.36u l=0.28u
X580 VDD a_n1204_7670.t12 a_37170_7670# VDD pfet_03v3 ad=0.1584p pd=1.6u as=56.7f ps=0.675u w=0.36u l=0.28u
X581 a_2562_4534# a_2498_4724# a_2364_4534# VDD pfet_03v3 ad=56.7f pd=0.675u as=0.1278p ps=1.07u w=0.36u l=0.28u
X582 a_32226_3470# a_32162_3156# a_32028_2966# VSS nfet_03v3 ad=56.7f pd=0.675u as=0.1278p ps=1.07u w=0.36u l=0.28u
X583 a_n296_10806# a_n360_n708.t8 VSS VSS nfet_03v3 ad=0.1188p pd=1.02u as=0.1584p ps=1.6u w=0.36u l=0.28u
X584 VSS a_22140_5318# a_22274_5632# VSS nfet_03v3 ad=97.2f pd=0.9u as=0.1584p ps=1.6u w=0.36u l=0.28u
X585 VDD a_n1204_4534.t11 a_37170_4534# VDD pfet_03v3 ad=0.1584p pd=1.6u as=56.7f ps=0.675u w=0.36u l=0.28u
X586 a_21175_n2146.t6 RB12.t6 a_20437_1398# VSS nfet_03v3 ad=0.1584p pd=1.6u as=0.1152p ps=1u w=0.36u l=0.28u
X587 VDD D6.t0 a_15589_n1738# VDD pfet_03v3 ad=0.3168p pd=2.32u as=0.2097p ps=1.38u w=0.72u l=0.28u
X588 a_31840_614# a_31776_n708.t8 VSS VSS nfet_03v3 ad=0.1188p pd=1.02u as=0.1584p ps=1.6u w=0.36u l=0.28u
X589 a_3437_10806# RA0.t4 VDD VDD pfet_03v3 ad=0.3888p pd=2.52u as=0.3312p ps=2.36u w=0.72u l=0.28u
X590 VSS a_22140_10022# a_22274_10336# VSS nfet_03v3 ad=97.2f pd=0.9u as=0.1584p ps=1.6u w=0.36u l=0.28u
X591 a_7120_8454# a_7056_n708.t6 VSS VSS nfet_03v3 ad=0.1188p pd=1.02u as=0.1584p ps=1.6u w=0.36u l=0.28u
X592 a_8381_6102# RA6.t4 VDD VDD pfet_03v3 ad=0.3888p pd=2.52u as=0.3312p ps=2.36u w=0.72u l=0.28u
X593 VSS a_n884_2182.t5 a_17394_2182# VSS nfet_03v3 ad=0.1584p pd=1.6u as=56.7f ps=0.675u w=0.36u l=0.28u
X594 a_36784_9238# a_36720_n708.t11 VDD VDD pfet_03v3 ad=0.2097p pd=1.38u as=0.3168p ps=2.32u w=0.72u l=0.28u
X595 a_7120_5318# a_7056_n708.t7 VSS VSS nfet_03v3 ad=0.1188p pd=1.02u as=0.1584p ps=1.6u w=0.36u l=0.28u
X596 a_20437_10022# RA1.t4 a_20905_n862.t8 VSS nfet_03v3 ad=0.1152p pd=1u as=0.1584p ps=1.6u w=0.36u l=0.28u
X597 VSS.t1251 a_n884_n954.t8 a_27282_n954# VSS nfet_03v3 ad=0.1584p pd=1.6u as=56.7f ps=0.675u w=0.36u l=0.28u
X598 a_9592_n954# a_9528_n708.t8 VDD.t168 VDD.t167 pfet_03v3 ad=0.2097p pd=1.38u as=0.3168p ps=2.32u w=0.72u l=0.28u
X599 a_28591_n2146.t24 a_28586_3124# a_27853_2966# VDD pfet_03v3 ad=0.1584p pd=1.6u as=0.1152p ps=1u w=0.36u l=0.28u
X600 a_17394_10806# a_17330_10996# a_17196_10806# VDD pfet_03v3 ad=56.7f pd=0.675u as=0.1278p ps=1.07u w=0.36u l=0.28u
X601 a_5605_1398# a_4836_1398# VDD VDD pfet_03v3 ad=0.36p pd=2.44u as=0.1764p ps=1.26u w=0.72u l=0.28u
X602 VDD CLK a_n1652_5750# VDD pfet_03v3 ad=0.3168p pd=2.32u as=0.1872p ps=1.24u w=0.72u l=0.28u
X603 a_37170_3750# a_37106_4064# a_36972_3750# VSS nfet_03v3 ad=56.7f pd=0.675u as=0.1278p ps=1.07u w=0.36u l=0.28u
X604 a_22909_9238# RA2.t3 a_23377_n862.t3 VSS nfet_03v3 ad=0.1152p pd=1u as=0.1584p ps=1.6u w=0.36u l=0.28u
X605 a_10853_n862# RA15.t3 VSS.t487 VSS nfet_03v3 ad=0.1944p pd=1.8u as=0.1656p ps=1.64u w=0.36u l=0.28u
X606 a_25381_10806# a_25685_10806# a_25849_n862.t1 VDD pfet_03v3 ad=0.1152p pd=1u as=0.1584p ps=1.6u w=0.36u l=0.28u
X607 a_3133_5318# RA7.t6 a_3601_n862.t3 VSS nfet_03v3 ad=0.1152p pd=1u as=0.1584p ps=1.6u w=0.36u l=0.28u
X608 VDD CLK a_n1652_2614# VDD pfet_03v3 ad=0.3168p pd=2.32u as=0.1872p ps=1.24u w=0.72u l=0.28u
X609 a_14724_7670# a_n1204_7670.t13 a_14536_7670# VSS nfet_03v3 ad=0.1278p pd=1.07u as=0.1188p ps=1.02u w=0.36u l=0.28u
X610 a_22909_6102# RA6.t5 a_23377_n862.t17 VSS nfet_03v3 ad=0.1152p pd=1u as=0.1584p ps=1.6u w=0.36u l=0.28u
X611 a_8381_1398# RA12.t8 VSS VSS nfet_03v3 ad=0.1944p pd=1.8u as=0.1656p ps=1.64u w=0.36u l=0.28u
X612 a_21888_n708.t1 a_21896_n1782# VDD VDD pfet_03v3 ad=0.3224p pd=1.76u as=0.5456p ps=3.36u w=1.24u l=0.28u
X613 VSS a_6073_n862.t32 QA2b.t1 VSS nfet_03v3 ad=0.1242p pd=1.05u as=0.2052p ps=1.86u w=0.36u l=0.28u
X614 a_19668_n170# a_n884_n170.t4 a_19480_n170# VDD.t1357 pfet_03v3 ad=0.1278p pd=1.07u as=0.2097p ps=1.38u w=0.36u l=0.28u
X615 VDD RB0.t6 a_38474_10964# VDD pfet_03v3 ad=0.3168p pd=2.32u as=0.3708p ps=2.47u w=0.72u l=0.28u
X616 a_661_2182# RA11.t7 a_1129_n862.t9 VSS nfet_03v3 ad=0.1152p pd=1u as=0.1584p ps=1.6u w=0.36u l=0.28u
X617 a_9978_9742# a_9914_9428# a_9780_9238# VSS nfet_03v3 ad=56.7f pd=0.675u as=0.1278p ps=1.07u w=0.36u l=0.28u
X618 a_23213_7670# RA4.t5 VDD VDD pfet_03v3 ad=0.3888p pd=2.52u as=0.3312p ps=2.36u w=0.72u l=0.28u
X619 a_n884_4534.t1 a_n1204_4534.t12 VSS VSS nfet_03v3 ad=0.1943p pd=1.25u as=0.1693p ps=1.19u w=0.67u l=0.28u
X620 a_14724_4534# a_n1204_4534.t13 a_14536_4534# VSS nfet_03v3 ad=0.1278p pd=1.07u as=0.1188p ps=1.02u w=0.36u l=0.28u
X621 VSS.t742 RB15.t8 a_13754_n608# VSS nfet_03v3 ad=0.1584p pd=1.6u as=0.1854p ps=1.75u w=0.36u l=0.28u
X622 VSS RB9.t5 a_28586_4096# VSS nfet_03v3 ad=0.1584p pd=1.6u as=0.1854p ps=1.75u w=0.36u l=0.28u
X623 a_9978_6606# a_9914_6292# a_9780_6102# VSS nfet_03v3 ad=56.7f pd=0.675u as=0.1278p ps=1.07u w=0.36u l=0.28u
X624 a_23213_4534# RA8.t5 VDD VDD pfet_03v3 ad=0.3888p pd=2.52u as=0.3312p ps=2.36u w=0.72u l=0.28u
X625 a_2364_n954# a_n1204_n954.t11 a_2176_n954# VSS nfet_03v3 ad=0.1278p pd=1.07u as=0.1188p ps=1.02u w=0.36u l=0.28u
X626 VSS a_n884_614.t6 a_9978_614# VSS nfet_03v3 ad=0.1584p pd=1.6u as=56.7f ps=0.675u w=0.36u l=0.28u
X627 a_2364_10806# WE0CLK.t7 a_2176_10806# VSS nfet_03v3 ad=0.1278p pd=1.07u as=0.1188p ps=1.02u w=0.36u l=0.28u
X628 VDD a_n1204_8454.t7 a_24810_8958# VDD pfet_03v3 ad=0.1584p pd=1.6u as=56.7f ps=0.675u w=0.36u l=0.28u
X629 a_12064_6102# a_12000_n708.t6 VDD VDD pfet_03v3 ad=0.2097p pd=1.38u as=0.3168p ps=2.32u w=0.72u l=0.28u
X630 a_n1652_10454# WE1.t0 VDD VDD pfet_03v3 ad=0.1872p pd=1.24u as=0.3168p ps=2.32u w=0.72u l=0.28u
X631 VDD a_n1204_2966.t13 a_2562_2966# VDD pfet_03v3 ad=0.1584p pd=1.6u as=56.7f ps=0.675u w=0.36u l=0.28u
X632 a_22909_10806# a_22140_10806# VSS VSS nfet_03v3 ad=0.18p pd=1.72u as=97.2f ps=0.9u w=0.36u l=0.28u
X633 a_32028_9238# a_n884_9238.t7 a_31840_9238# VDD pfet_03v3 ad=0.1278p pd=1.07u as=0.2097p ps=1.38u w=0.36u l=0.28u
X634 a_27853_3750# a_27084_3750# VDD VDD pfet_03v3 ad=0.36p pd=2.44u as=0.1764p ps=1.26u w=0.72u l=0.28u
X635 a_38045_2274# RA11.t8 VSS VSS nfet_03v3 ad=0.1944p pd=1.8u as=0.1656p ps=1.64u w=0.36u l=0.28u
X636 a_25381_n170# a_24612_n170# VDD.t2843 VDD.t2789 pfet_03v3 ad=0.36p pd=2.44u as=0.1764p ps=1.26u w=0.72u l=0.28u
X637 a_32797_10806# a_32028_10806# VDD VDD pfet_03v3 ad=0.36p pd=2.44u as=0.1764p ps=1.26u w=0.72u l=0.28u
X638 a_965_8546# RA3.t2 VSS VSS nfet_03v3 ad=0.1944p pd=1.8u as=0.1656p ps=1.64u w=0.36u l=0.28u
X639 a_13759_n2146.t16 RB3.t3 a_13021_8454# VSS nfet_03v3 ad=0.1584p pd=1.6u as=0.1152p ps=1u w=0.36u l=0.28u
X640 a_27853_8454# RA3.t3 a_28321_n862.t5 VSS nfet_03v3 ad=0.1152p pd=1u as=0.1584p ps=1.6u w=0.36u l=0.28u
X641 VDD.t2792 a_24612_n954# a_24746_n640# VDD.t2791 pfet_03v3 ad=0.1764p pd=1.26u as=0.1584p ps=1.6u w=0.36u l=0.28u
X642 a_5909_2274# RA11.t9 VSS VSS nfet_03v3 ad=0.1944p pd=1.8u as=0.1656p ps=1.64u w=0.36u l=0.28u
X643 a_27853_614# a_27084_614# VDD VDD pfet_03v3 ad=0.36p pd=2.44u as=0.1764p ps=1.26u w=0.72u l=0.28u
X644 a_21175_n2146.t11 RB0.t7 a_20437_10806# VSS nfet_03v3 ad=0.1584p pd=1.6u as=0.1152p ps=1u w=0.36u l=0.28u
X645 VDD WE0CLK.t8 a_2562_10806# VDD pfet_03v3 ad=0.1584p pd=1.6u as=56.7f ps=0.675u w=0.36u l=0.28u
X646 a_3871_n2146.t14 RB4.t4 a_3133_7670# VSS nfet_03v3 ad=0.1584p pd=1.6u as=0.1152p ps=1u w=0.36u l=0.28u
X647 a_35269_5318# RA7.t7 a_35737_n862.t0 VSS nfet_03v3 ad=0.1152p pd=1u as=0.1584p ps=1.6u w=0.36u l=0.28u
X648 VDD.t2962 a_7308_n954# a_7442_n640# VDD.t2862 pfet_03v3 ad=0.1764p pd=1.26u as=0.1584p ps=1.6u w=0.36u l=0.28u
X649 a_19866_1398# a_19802_1588# a_19668_1398# VDD pfet_03v3 ad=56.7f pd=0.675u as=0.1278p ps=1.07u w=0.36u l=0.28u
X650 a_25381_614# RA13.t4 a_25849_n862.t5 VSS nfet_03v3 ad=0.1152p pd=1u as=0.1584p ps=1.6u w=0.36u l=0.28u
X651 VSS a_n884_1398.t6 a_19866_1902# VSS nfet_03v3 ad=0.1584p pd=1.6u as=56.7f ps=0.675u w=0.36u l=0.28u
X652 a_34312_9238# a_34248_n708.t12 VDD VDD pfet_03v3 ad=0.2097p pd=1.38u as=0.3168p ps=2.32u w=0.72u l=0.28u
X653 VSS RB11.t3 a_8810_2528# VSS nfet_03v3 ad=0.1584p pd=1.6u as=0.1854p ps=1.75u w=0.36u l=0.28u
X654 a_2176_614# a_2112_n708.t14 VSS VSS nfet_03v3 ad=0.1188p pd=1.02u as=0.1584p ps=1.6u w=0.36u l=0.28u
X655 VDD a_n1204_6102.t9 a_14922_6102# VDD pfet_03v3 ad=0.1584p pd=1.6u as=56.7f ps=0.675u w=0.36u l=0.28u
X656 a_17456_n1738# a_16952_n1782# VDD VDD pfet_03v3 ad=0.1584p pd=1.6u as=0.1584p ps=1.6u w=0.36u l=0.28u
X657 a_7120_n954# a_7056_n708.t8 VDD.t1123 VDD.t1122 pfet_03v3 ad=0.2097p pd=1.38u as=0.3168p ps=2.32u w=0.72u l=0.28u
X658 a_24424_10022# a_24360_n708.t12 VSS VSS nfet_03v3 ad=0.1188p pd=1.02u as=0.1584p ps=1.6u w=0.36u l=0.28u
X659 a_2176_9238# a_2112_n708.t15 VDD VDD pfet_03v3 ad=0.2097p pd=1.38u as=0.3168p ps=2.32u w=0.72u l=0.28u
X660 a_3133_1398# a_2364_1398# VDD VDD pfet_03v3 ad=0.36p pd=2.44u as=0.1764p ps=1.26u w=0.72u l=0.28u
X661 VDD RB7.t2 a_16226_5664# VDD pfet_03v3 ad=0.3168p pd=2.32u as=0.3708p ps=2.47u w=0.72u l=0.28u
X662 VDD RB11.t4 a_16226_2528# VDD pfet_03v3 ad=0.3168p pd=2.32u as=0.3708p ps=2.47u w=0.72u l=0.28u
X663 a_33535_n2146.t30 a_33530_6260# a_32797_6102# VDD pfet_03v3 ad=0.1584p pd=1.6u as=0.1152p ps=1u w=0.36u l=0.28u
X664 a_19480_2966# a_19416_n708.t9 VDD VDD pfet_03v3 ad=0.2097p pd=1.38u as=0.3168p ps=2.32u w=0.72u l=0.28u
X665 a_18061_n1738# WEM.t3 a_16952_n1782# VSS nfet_03v3 ad=0.1188p pd=1.02u as=0.1278p ps=1.07u w=0.36u l=0.28u
X666 VSS.t1252 a_n884_n954.t9 a_7506_n954# VSS nfet_03v3 ad=0.1584p pd=1.6u as=56.7f ps=0.675u w=0.36u l=0.28u
X667 a_8077_614# RA13.t5 a_8545_n862.t4 VSS nfet_03v3 ad=0.1152p pd=1u as=0.1584p ps=1.6u w=0.36u l=0.28u
X668 a_20437_10806# RA0.t5 a_20905_n862.t2 VSS nfet_03v3 ad=0.1152p pd=1u as=0.1584p ps=1.6u w=0.36u l=0.28u
X669 VSS RB1.t6 a_28586_10368# VSS nfet_03v3 ad=0.1584p pd=1.6u as=0.1854p ps=1.75u w=0.36u l=0.28u
X670 VDD RB2.t2 a_28586_9396# VDD pfet_03v3 ad=0.3168p pd=2.32u as=0.3708p ps=2.47u w=0.72u l=0.28u
X671 a_12252_7670# a_n1204_7670.t14 a_12064_7670# VSS nfet_03v3 ad=0.1278p pd=1.07u as=0.1188p ps=1.02u w=0.36u l=0.28u
X672 a_36784_6886# a_36720_n708.t12 VSS VSS nfet_03v3 ad=0.1188p pd=1.02u as=0.1584p ps=1.6u w=0.36u l=0.28u
X673 a_22909_2966# a_22140_2966# VDD VDD pfet_03v3 ad=0.36p pd=2.44u as=0.1764p ps=1.26u w=0.72u l=0.28u
X674 a_19866_614# a_19802_928# a_19668_614# VSS nfet_03v3 ad=56.7f pd=0.675u as=0.1278p ps=1.07u w=0.36u l=0.28u
X675 a_10549_6886# RA5.t2 a_11017_n862.t7 VSS nfet_03v3 ad=0.1152p pd=1u as=0.1584p ps=1.6u w=0.36u l=0.28u
X676 a_1399_n2146.t25 a_1394_6260# a_661_6102# VDD pfet_03v3 ad=0.1584p pd=1.6u as=0.1152p ps=1u w=0.36u l=0.28u
X677 a_17196_n170# a_n884_n170.t5 a_17008_n170# VDD.t1358 pfet_03v3 ad=0.1278p pd=1.07u as=0.2097p ps=1.38u w=0.36u l=0.28u
X678 a_12252_4534# a_n1204_4534.t14 a_12064_4534# VSS nfet_03v3 ad=0.1278p pd=1.07u as=0.1188p ps=1.02u w=0.36u l=0.28u
X679 a_25685_3842# RA9.t3 VDD VDD pfet_03v3 ad=0.3888p pd=2.52u as=0.3312p ps=2.36u w=0.72u l=0.28u
X680 a_3133_9238# RA2.t4 a_3601_n862.t0 VSS nfet_03v3 ad=0.1152p pd=1u as=0.1584p ps=1.6u w=0.36u l=0.28u
X681 a_7506_9742# a_7442_9428# a_7308_9238# VSS nfet_03v3 ad=56.7f pd=0.675u as=0.1278p ps=1.07u w=0.36u l=0.28u
X682 VDD a_17196_7670# a_17330_7860# VDD pfet_03v3 ad=0.1764p pd=1.26u as=0.1584p ps=1.6u w=0.36u l=0.28u
X683 a_34760_n1738# a_34256_n1782# VDD VDD pfet_03v3 ad=0.1584p pd=1.6u as=0.1584p ps=1.6u w=0.36u l=0.28u
X684 a_29556_1398# a_n884_1398.t7 a_29368_1398# VDD pfet_03v3 ad=0.1278p pd=1.07u as=0.2097p ps=1.38u w=0.36u l=0.28u
X685 a_25685_706# RA13.t6 VDD VDD pfet_03v3 ad=0.3888p pd=2.52u as=0.3312p ps=2.36u w=0.72u l=0.28u
X686 VDD RB3.t4 a_38474_8800# VDD pfet_03v3 ad=0.3168p pd=2.32u as=0.3708p ps=2.47u w=0.72u l=0.28u
X687 a_3133_6102# RA6.t6 a_3601_n862.t18 VSS nfet_03v3 ad=0.1152p pd=1u as=0.1584p ps=1.6u w=0.36u l=0.28u
X688 a_7506_6606# a_7442_6292# a_7308_6102# VSS nfet_03v3 ad=56.7f pd=0.675u as=0.1278p ps=1.07u w=0.36u l=0.28u
X689 VDD a_17196_4534# a_17330_4724# VDD pfet_03v3 ad=0.1764p pd=1.26u as=0.1584p ps=1.6u w=0.36u l=0.28u
X690 a_37741_7670# a_36972_7670# VDD VDD pfet_03v3 ad=0.36p pd=2.44u as=0.1764p ps=1.26u w=0.72u l=0.28u
X691 VDD a_n1204_2966.t14 a_32226_2966# VDD pfet_03v3 ad=0.1584p pd=1.6u as=56.7f ps=0.675u w=0.36u l=0.28u
X692 a_661_2966# RA10.t4 a_1129_n862.t2 VSS nfet_03v3 ad=0.1152p pd=1u as=0.1584p ps=1.6u w=0.36u l=0.28u
X693 a_37741_614# a_36972_614# VSS VSS nfet_03v3 ad=0.18p pd=1.72u as=97.2f ps=0.9u w=0.36u l=0.28u
X694 VSS a_2364_8454# a_2498_8768# VSS nfet_03v3 ad=97.2f pd=0.9u as=0.1584p ps=1.6u w=0.36u l=0.28u
X695 a_37741_4534# a_36972_4534# VDD VDD pfet_03v3 ad=0.36p pd=2.44u as=0.1764p ps=1.26u w=0.72u l=0.28u
X696 a_4592_n1782# a_5096_n1738# a_5384_n1738# VDD pfet_03v3 ad=0.1278p pd=1.07u as=56.7f ps=0.675u w=0.36u l=0.28u
X697 a_35365_n1738# WEM.t4 a_34256_n1782# VSS nfet_03v3 ad=0.1188p pd=1.02u as=0.1278p ps=1.07u w=0.36u l=0.28u
X698 a_33535_n2146.t8 RB12.t7 a_32797_1398# VSS nfet_03v3 ad=0.1584p pd=1.6u as=0.1152p ps=1u w=0.36u l=0.28u
X699 a_6343_n2146.t31 a_6338_10368# a_5605_10022# VDD pfet_03v3 ad=0.1584p pd=1.6u as=0.1152p ps=1u w=0.36u l=0.28u
X700 VSS RB8.t5 a_28586_4692# VSS nfet_03v3 ad=0.1584p pd=1.6u as=0.1854p ps=1.75u w=0.36u l=0.28u
X701 VSS a_2364_5318# a_2498_5632# VSS nfet_03v3 ad=97.2f pd=0.9u as=0.1584p ps=1.6u w=0.36u l=0.28u
X702 a_1399_n2146.t6 RB12.t8 a_661_1398# VSS nfet_03v3 ad=0.1584p pd=1.6u as=0.1152p ps=1u w=0.36u l=0.28u
X703 a_27282_614# a_27218_928# a_27084_614# VSS nfet_03v3 ad=56.7f pd=0.675u as=0.1278p ps=1.07u w=0.36u l=0.28u
X704 a_35269_1398# a_34500_1398# VDD VDD pfet_03v3 ad=0.36p pd=2.44u as=0.1764p ps=1.26u w=0.72u l=0.28u
X705 a_3437_10114# RA1.t5 VDD VDD pfet_03v3 ad=0.3888p pd=2.52u as=0.3312p ps=2.36u w=0.72u l=0.28u
X706 a_15797_6978# RA5.t3 VSS VSS nfet_03v3 ad=0.1944p pd=1.8u as=0.1656p ps=1.64u w=0.36u l=0.28u
X707 a_3437_2274# RA11.t10 VSS VSS nfet_03v3 ad=0.1944p pd=1.8u as=0.1656p ps=1.64u w=0.36u l=0.28u
X708 VSS a_n884_2182.t6 a_29754_2182# VSS nfet_03v3 ad=0.1584p pd=1.6u as=56.7f ps=0.675u w=0.36u l=0.28u
X709 a_3133_614# RA13.t7 a_3601_n862.t12 VSS nfet_03v3 ad=0.1152p pd=1u as=0.1584p ps=1.6u w=0.36u l=0.28u
X710 a_14922_614# a_14858_928# a_14724_614# VSS nfet_03v3 ad=56.7f pd=0.675u as=0.1278p ps=1.07u w=0.36u l=0.28u
X711 a_17965_10806# a_17196_10806# VSS VSS nfet_03v3 ad=0.18p pd=1.72u as=97.2f ps=0.9u w=0.36u l=0.28u
X712 VDD a_n1204_9238.t11 a_n884_9238.t1 VDD pfet_03v3 ad=0.5896p pd=3.56u as=0.3886p ps=1.92u w=1.34u l=0.28u
X713 a_12064_3750# a_12000_n708.t7 VSS VSS nfet_03v3 ad=0.1188p pd=1.02u as=0.1584p ps=1.6u w=0.36u l=0.28u
X714 a_27853_n954# a_27084_n954# VSS.t2295 VSS nfet_03v3 ad=0.18p pd=1.72u as=97.2f ps=0.9u w=0.36u l=0.28u
X715 a_152_n1738# a_n352_n1782# VDD VDD pfet_03v3 ad=0.1584p pd=1.6u as=0.1584p ps=1.6u w=0.36u l=0.28u
X716 VDD a_4592_n1782# a_4584_n708.t3 VDD pfet_03v3 ad=0.5456p pd=3.36u as=0.3224p ps=1.76u w=1.24u l=0.28u
X717 a_5605_n170# a_4836_n170# VDD.t3195 VDD.t2522 pfet_03v3 ad=0.36p pd=2.44u as=0.1764p ps=1.26u w=0.72u l=0.28u
X718 a_10853_5410# RA7.t8 VDD VDD pfet_03v3 ad=0.3888p pd=2.52u as=0.3312p ps=2.36u w=0.72u l=0.28u
X719 a_32797_5318# RA7.t9 a_33265_n862.t0 VSS nfet_03v3 ad=0.1152p pd=1u as=0.1584p ps=1.6u w=0.36u l=0.28u
X720 VDD.t2525 a_4836_n954# a_4970_n640# VDD.t2524 pfet_03v3 ad=0.1764p pd=1.26u as=0.1584p ps=1.6u w=0.36u l=0.28u
X721 VSS a_n884_1398.t8 a_17394_1902# VSS nfet_03v3 ad=0.1584p pd=1.6u as=56.7f ps=0.675u w=0.36u l=0.28u
X722 a_38045_2966# RA10.t5 VSS VSS nfet_03v3 ad=0.1944p pd=1.8u as=0.1656p ps=1.64u w=0.36u l=0.28u
X723 a_32028_6886# a_n1204_6886.t11 a_31840_6886# VSS nfet_03v3 ad=0.1278p pd=1.07u as=0.1188p ps=1.02u w=0.36u l=0.28u
X724 a_10853_2274# RA11.t11 VDD VDD pfet_03v3 ad=0.3888p pd=2.52u as=0.3312p ps=2.36u w=0.72u l=0.28u
X725 VSS a_34500_9238# a_34634_9428# VSS nfet_03v3 ad=97.2f pd=0.9u as=0.1584p ps=1.6u w=0.36u l=0.28u
X726 a_5909_2966# RA10.t6 VSS VSS nfet_03v3 ad=0.1944p pd=1.8u as=0.1656p ps=1.64u w=0.36u l=0.28u
X727 VDD a_n108_10806# a_26_10996# VDD pfet_03v3 ad=0.1764p pd=1.26u as=0.1584p ps=1.6u w=0.36u l=0.28u
X728 a_35269_9238# RA2.t5 a_35737_n862.t17 VSS nfet_03v3 ad=0.1152p pd=1u as=0.1584p ps=1.6u w=0.36u l=0.28u
X729 VSS a_34500_6102# a_34634_6292# VSS nfet_03v3 ad=97.2f pd=0.9u as=0.1584p ps=1.6u w=0.36u l=0.28u
X730 VDD RB7.t3 a_13754_5664# VDD pfet_03v3 ad=0.3168p pd=2.32u as=0.3708p ps=2.47u w=0.72u l=0.28u
X731 a_35269_6102# RA6.t7 a_35737_n862.t12 VSS nfet_03v3 ad=0.1152p pd=1u as=0.1584p ps=1.6u w=0.36u l=0.28u
X732 a_11287_n2146.t24 a_11282_10368# a_10549_10022# VDD pfet_03v3 ad=0.1584p pd=1.6u as=0.1152p ps=1u w=0.36u l=0.28u
X733 a_31063_n2146.t21 a_31058_6260# a_30325_6102# VDD pfet_03v3 ad=0.1584p pd=1.6u as=0.1152p ps=1u w=0.36u l=0.28u
X734 VDD RB11.t5 a_13754_2528# VDD pfet_03v3 ad=0.3168p pd=2.32u as=0.3708p ps=2.47u w=0.72u l=0.28u
X735 VSS.t1253 a_n884_n954.t10 a_5034_n954# VSS nfet_03v3 ad=0.1584p pd=1.6u as=56.7f ps=0.675u w=0.36u l=0.28u
X736 a_21952_10806# a_21888_n708.t8 VDD VDD pfet_03v3 ad=0.2097p pd=1.38u as=0.3168p ps=2.32u w=0.72u l=0.28u
X737 VDD RB1.t7 a_38474_10368# VDD pfet_03v3 ad=0.3168p pd=2.32u as=0.3708p ps=2.47u w=0.72u l=0.28u
X738 a_35573_7670# RA4.t6 VDD VDD pfet_03v3 ad=0.3888p pd=2.52u as=0.3312p ps=2.36u w=0.72u l=0.28u
X739 a_34312_6886# a_34248_n708.t13 VSS VSS nfet_03v3 ad=0.1188p pd=1.02u as=0.1584p ps=1.6u w=0.36u l=0.28u
X740 VSS RB10.t7 a_8810_3124# VSS nfet_03v3 ad=0.1584p pd=1.6u as=0.1854p ps=1.75u w=0.36u l=0.28u
X741 a_20437_2966# a_19668_2966# VDD VDD pfet_03v3 ad=0.36p pd=2.44u as=0.1764p ps=1.26u w=0.72u l=0.28u
X742 VSS.t743 RB15.t9 a_26114_n608# VSS nfet_03v3 ad=0.1584p pd=1.6u as=0.1854p ps=1.75u w=0.36u l=0.28u
X743 a_2176_6886# a_2112_n708.t16 VSS VSS nfet_03v3 ad=0.1188p pd=1.02u as=0.1584p ps=1.6u w=0.36u l=0.28u
X744 a_35573_4534# RA8.t6 VDD VDD pfet_03v3 ad=0.3888p pd=2.52u as=0.3312p ps=2.36u w=0.72u l=0.28u
X745 VSS a_n884_3750.t4 a_14922_3750# VSS nfet_03v3 ad=0.1584p pd=1.6u as=56.7f ps=0.675u w=0.36u l=0.28u
X746 a_23213_3842# RA9.t4 VDD VDD pfet_03v3 ad=0.3888p pd=2.52u as=0.3312p ps=2.36u w=0.72u l=0.28u
X747 a_15493_1398# a_15797_1398# a_15961_n862.t22 VDD pfet_03v3 ad=0.1152p pd=1u as=0.1584p ps=1.6u w=0.36u l=0.28u
X748 VDD a_14724_7670# a_14858_7860# VDD pfet_03v3 ad=0.1764p pd=1.26u as=0.1584p ps=1.6u w=0.36u l=0.28u
X749 a_8077_n954# a_8381_n862# a_8545_n862.t8 VDD.t2309 pfet_03v3 ad=0.1152p pd=1u as=0.1584p ps=1.6u w=0.36u l=0.28u
X750 a_23213_706# RA13.t8 VDD VDD pfet_03v3 ad=0.3888p pd=2.52u as=0.3312p ps=2.36u w=0.72u l=0.28u
X751 a_21952_6886# a_21888_n708.t9 VDD VDD pfet_03v3 ad=0.2097p pd=1.38u as=0.3168p ps=2.32u w=0.72u l=0.28u
X752 a_25381_614# a_24612_614# VSS VSS nfet_03v3 ad=0.18p pd=1.72u as=97.2f ps=0.9u w=0.36u l=0.28u
X753 VDD a_14724_4534# a_14858_4724# VDD pfet_03v3 ad=0.1764p pd=1.26u as=0.1584p ps=1.6u w=0.36u l=0.28u
X754 VSS RB0.t8 a_28586_10964# VSS nfet_03v3 ad=0.1584p pd=1.6u as=0.1854p ps=1.75u w=0.36u l=0.28u
X755 VSS a_32028_8454# a_32162_8768# VSS nfet_03v3 ad=97.2f pd=0.9u as=0.1584p ps=1.6u w=0.36u l=0.28u
X756 VDD.t2555 a_36972_n954# a_37106_n640# VDD.t2554 pfet_03v3 ad=0.1764p pd=1.26u as=0.1584p ps=1.6u w=0.36u l=0.28u
X757 a_32797_10022# a_32028_10022# VDD VDD pfet_03v3 ad=0.36p pd=2.44u as=0.1764p ps=1.26u w=0.72u l=0.28u
X758 VSS a_32028_5318# a_32162_5632# VSS nfet_03v3 ad=97.2f pd=0.9u as=0.1584p ps=1.6u w=0.36u l=0.28u
X759 a_13021_614# a_12252_614# VSS VSS nfet_03v3 ad=0.18p pd=1.72u as=97.2f ps=0.9u w=0.36u l=0.28u
X760 a_31063_n2146.t6 RB12.t9 a_30325_1398# VSS nfet_03v3 ad=0.1584p pd=1.6u as=0.1152p ps=1u w=0.36u l=0.28u
X761 a_9780_1398# a_n884_1398.t9 a_9592_1398# VDD pfet_03v3 ad=0.1278p pd=1.07u as=0.2097p ps=1.38u w=0.36u l=0.28u
X762 a_14922_8174# a_14858_7860# a_14724_7670# VSS nfet_03v3 ad=56.7f pd=0.675u as=0.1278p ps=1.07u w=0.36u l=0.28u
X763 a_19866_n170# a_19802_20# a_19668_n170# VDD.t3026 pfet_03v3 ad=56.7f pd=0.675u as=0.1278p ps=1.07u w=0.36u l=0.28u
X764 VDD a_n1204_9238.t12 a_19866_9238# VDD pfet_03v3 ad=0.1584p pd=1.6u as=56.7f ps=0.675u w=0.36u l=0.28u
X765 a_14922_5038# a_14858_4724# a_14724_4534# VSS nfet_03v3 ad=56.7f pd=0.675u as=0.1278p ps=1.07u w=0.36u l=0.28u
X766 VDD a_n1204_1398.t6 a_90_1398# VDD pfet_03v3 ad=0.1584p pd=1.6u as=56.7f ps=0.675u w=0.36u l=0.28u
X767 VSS a_n884_614.t7 a_27282_614# VSS nfet_03v3 ad=0.1584p pd=1.6u as=56.7f ps=0.675u w=0.36u l=0.28u
X768 a_18703_n2146.t30 a_18698_2528# a_17965_2182# VDD pfet_03v3 ad=0.1584p pd=1.6u as=0.1152p ps=1u w=0.36u l=0.28u
X769 a_8077_614# a_7308_614# VSS VSS nfet_03v3 ad=0.18p pd=1.72u as=97.2f ps=0.9u w=0.36u l=0.28u
X770 VDD CLK a_n1652_6102# VDD pfet_03v3 ad=0.3168p pd=2.32u as=0.1872p ps=1.24u w=0.72u l=0.28u
X771 VSS a_n884_2182.t7 a_27282_2182# VSS nfet_03v3 ad=0.1584p pd=1.6u as=56.7f ps=0.675u w=0.36u l=0.28u
X772 VSS a_n884_614.t8 a_14922_614# VSS nfet_03v3 ad=0.1584p pd=1.6u as=56.7f ps=0.675u w=0.36u l=0.28u
X773 a_n1652_4182# CLK a_n1652_3742# VSS nfet_03v3 ad=0.3168p pd=2.32u as=0.1872p ps=1.24u w=0.72u l=0.28u
X774 a_2562_n954# a_2498_n640# a_2364_n954# VSS nfet_03v3 ad=56.7f pd=0.675u as=0.1278p ps=1.07u w=0.36u l=0.28u
X775 a_3133_n170# a_2364_n170# VDD.t2534 VDD.t2324 pfet_03v3 ad=0.36p pd=2.44u as=0.1764p ps=1.26u w=0.72u l=0.28u
X776 VSS a_27084_614# a_27218_928# VSS nfet_03v3 ad=97.2f pd=0.9u as=0.1584p ps=1.6u w=0.36u l=0.28u
X777 a_38479_n2146.t23 a_38474_3124# a_37741_2966# VDD pfet_03v3 ad=0.1584p pd=1.6u as=0.1152p ps=1u w=0.36u l=0.28u
X778 VSS.t1254 a_n884_n954.t11 a_37170_n954# VSS nfet_03v3 ad=0.1584p pd=1.6u as=56.7f ps=0.675u w=0.36u l=0.28u
X779 a_36784_614# a_36720_n708.t13 VSS VSS nfet_03v3 ad=0.1188p pd=1.02u as=0.1584p ps=1.6u w=0.36u l=0.28u
X780 a_18269_6978# RA5.t4 VDD VDD pfet_03v3 ad=0.3888p pd=2.52u as=0.3312p ps=2.36u w=0.72u l=0.28u
X781 a_27084_10022# a_n884_10022.t7 a_26896_10022# VDD pfet_03v3 ad=0.1278p pd=1.07u as=0.2097p ps=1.38u w=0.36u l=0.28u
X782 VSS a_36972_10022# a_37106_10336# VSS nfet_03v3 ad=97.2f pd=0.9u as=0.1584p ps=1.6u w=0.36u l=0.28u
X783 a_17965_7670# a_18269_7670# a_18433_n862.t31 VDD pfet_03v3 ad=0.1152p pd=1u as=0.1584p ps=1.6u w=0.36u l=0.28u
X784 a_29754_1398# a_29690_1588# a_29556_1398# VDD pfet_03v3 ad=56.7f pd=0.675u as=0.1278p ps=1.07u w=0.36u l=0.28u
X785 VDD a_n1204_5318.t6 a_12450_5822# VDD pfet_03v3 ad=0.1584p pd=1.6u as=56.7f ps=0.675u w=0.36u l=0.28u
X786 a_36007_n2146.t10 RB9.t6 a_35269_3750# VSS nfet_03v3 ad=0.1584p pd=1.6u as=0.1152p ps=1u w=0.36u l=0.28u
X787 a_17965_4534# a_18269_4534# a_18433_n862.t26 VDD pfet_03v3 ad=0.1152p pd=1u as=0.1584p ps=1.6u w=0.36u l=0.28u
X788 a_3437_2966# RA10.t7 VSS VSS nfet_03v3 ad=0.1944p pd=1.8u as=0.1656p ps=1.64u w=0.36u l=0.28u
X789 a_20741_n862# RA15.t4 VSS.t488 VSS nfet_03v3 ad=0.1944p pd=1.8u as=0.1656p ps=1.64u w=0.36u l=0.28u
X790 a_32797_9238# RA2.t6 a_33265_n862.t19 VSS nfet_03v3 ad=0.1152p pd=1u as=0.1584p ps=1.6u w=0.36u l=0.28u
X791 a_24612_7670# a_n1204_7670.t15 a_24424_7670# VSS nfet_03v3 ad=0.1278p pd=1.07u as=0.1188p ps=1.02u w=0.36u l=0.28u
X792 VDD a_n1204_10022.t8 a_17394_10526# VDD pfet_03v3 ad=0.1584p pd=1.6u as=56.7f ps=0.675u w=0.36u l=0.28u
X793 VSS a_n1204_6886.t12 a_n884_6886.t2 VSS nfet_03v3 ad=0.2948p pd=2.22u as=0.1943p ps=1.25u w=0.67u l=0.28u
X794 a_32797_6102# RA6.t8 a_33265_n862.t14 VSS nfet_03v3 ad=0.1152p pd=1u as=0.1584p ps=1.6u w=0.36u l=0.28u
X795 a_29556_n170# a_n884_n170.t6 a_29368_n170# VDD.t1359 pfet_03v3 ad=0.1278p pd=1.07u as=0.2097p ps=1.38u w=0.36u l=0.28u
X796 a_33101_7670# RA4.t7 VDD VDD pfet_03v3 ad=0.3888p pd=2.52u as=0.3312p ps=2.36u w=0.72u l=0.28u
X797 a_24612_4534# a_n1204_4534.t15 a_24424_4534# VSS nfet_03v3 ad=0.1278p pd=1.07u as=0.1188p ps=1.02u w=0.36u l=0.28u
X798 a_2364_2182# a_n1204_2182.t9 a_2176_2182# VSS nfet_03v3 ad=0.1278p pd=1.07u as=0.1188p ps=1.02u w=0.36u l=0.28u
X799 VSS a_34500_614# a_34634_928# VSS nfet_03v3 ad=97.2f pd=0.9u as=0.1584p ps=1.6u w=0.36u l=0.28u
X800 VSS RB9.t7 a_38474_4096# VSS nfet_03v3 ad=0.1584p pd=1.6u as=0.1854p ps=1.75u w=0.36u l=0.28u
X801 a_33101_4534# RA8.t7 VDD VDD pfet_03v3 ad=0.3888p pd=2.52u as=0.3312p ps=2.36u w=0.72u l=0.28u
X802 a_37741_n954# a_38045_n862# a_38209_n862.t17 VDD.t2206 pfet_03v3 ad=0.1152p pd=1u as=0.1584p ps=1.6u w=0.36u l=0.28u
X803 VSS.t2811 a_19424_n1782# a_19416_n708.t3 VSS nfet_03v3 ad=0.2728p pd=2.12u as=0.1612p ps=1.14u w=0.62u l=0.28u
X804 a_24872_n1738# a_24368_n1782# VSS.t2635 VSS nfet_03v3 ad=0.1584p pd=1.6u as=0.1584p ps=1.6u w=0.36u l=0.28u
X805 a_3133_614# a_2364_614# VSS VSS nfet_03v3 ad=0.18p pd=1.72u as=97.2f ps=0.9u w=0.36u l=0.28u
X806 a_90_7670# a_26_7860# a_n108_7670# VDD pfet_03v3 ad=56.7f pd=0.675u as=0.1278p ps=1.07u w=0.36u l=0.28u
X807 VSS a_9780_7670# a_9914_7860# VSS nfet_03v3 ad=97.2f pd=0.9u as=0.1584p ps=1.6u w=0.36u l=0.28u
X808 VSS a_22140_614# a_22274_928# VSS nfet_03v3 ad=97.2f pd=0.9u as=0.1584p ps=1.6u w=0.36u l=0.28u
X809 VDD a_n1204_8454.t8 a_34698_8958# VDD pfet_03v3 ad=0.1584p pd=1.6u as=56.7f ps=0.675u w=0.36u l=0.28u
X810 a_5605_n954# a_5909_n862# a_6073_n862.t27 VDD.t2467 pfet_03v3 ad=0.1152p pd=1u as=0.1584p ps=1.6u w=0.36u l=0.28u
X811 a_90_4534# a_26_4724# a_n108_4534# VDD pfet_03v3 ad=56.7f pd=0.675u as=0.1278p ps=1.07u w=0.36u l=0.28u
X812 VSS a_9780_4534# a_9914_4724# VSS nfet_03v3 ad=97.2f pd=0.9u as=0.1584p ps=1.6u w=0.36u l=0.28u
X813 VSS.t744 RB15.t10 a_6338_n608# VSS nfet_03v3 ad=0.1584p pd=1.6u as=0.1854p ps=1.75u w=0.36u l=0.28u
X814 a_n296_614# a_n360_n708.t9 VSS VSS nfet_03v3 ad=0.1188p pd=1.02u as=0.1584p ps=1.6u w=0.36u l=0.28u
X815 a_28591_n2146.t25 a_28586_10964# a_27853_10806# VDD pfet_03v3 ad=0.1584p pd=1.6u as=0.1152p ps=1u w=0.36u l=0.28u
X816 a_30325_7670# a_29556_7670# VSS VSS nfet_03v3 ad=0.18p pd=1.72u as=97.2f ps=0.9u w=0.36u l=0.28u
X817 a_35269_n170# a_34500_n170# VDD.t2513 VDD.t2452 pfet_03v3 ad=0.36p pd=2.44u as=0.1764p ps=1.26u w=0.72u l=0.28u
X818 a_37741_3750# a_36972_3750# VDD VDD pfet_03v3 ad=0.36p pd=2.44u as=0.1764p ps=1.26u w=0.72u l=0.28u
X819 VSS a_n884_614.t9 a_5034_614# VSS nfet_03v3 ad=0.1584p pd=1.6u as=56.7f ps=0.675u w=0.36u l=0.28u
X820 a_30325_4534# a_29556_4534# VSS VSS nfet_03v3 ad=0.18p pd=1.72u as=97.2f ps=0.9u w=0.36u l=0.28u
X821 a_7308_1398# a_n884_1398.t10 a_7120_1398# VDD pfet_03v3 ad=0.1278p pd=1.07u as=0.2097p ps=1.38u w=0.36u l=0.28u
X822 a_661_10806# a_965_10806# a_1129_n862.t24 VDD pfet_03v3 ad=0.1152p pd=1u as=0.1584p ps=1.6u w=0.36u l=0.28u
X823 a_12450_8174# a_12386_7860# a_12252_7670# VSS nfet_03v3 ad=56.7f pd=0.675u as=0.1278p ps=1.07u w=0.36u l=0.28u
X824 a_661_6886# a_n108_6886# VDD VDD pfet_03v3 ad=0.36p pd=2.44u as=0.1764p ps=1.26u w=0.72u l=0.28u
X825 a_37741_614# a_36972_614# VDD VDD pfet_03v3 ad=0.36p pd=2.44u as=0.1764p ps=1.26u w=0.72u l=0.28u
X826 a_22140_10022# a_n1204_10022.t9 a_21952_10022# VSS nfet_03v3 ad=0.1278p pd=1.07u as=0.1188p ps=1.02u w=0.36u l=0.28u
X827 VDD a_n1204_9238.t13 a_17394_9238# VDD pfet_03v3 ad=0.1584p pd=1.6u as=56.7f ps=0.675u w=0.36u l=0.28u
X828 VSS a_4836_614# a_4970_928# VSS nfet_03v3 ad=97.2f pd=0.9u as=0.1584p ps=1.6u w=0.36u l=0.28u
X829 a_12450_5038# a_12386_4724# a_12252_4534# VSS nfet_03v3 ad=56.7f pd=0.675u as=0.1278p ps=1.07u w=0.36u l=0.28u
X830 a_16231_n2146.t25 a_16226_2528# a_15493_2182# VDD pfet_03v3 ad=0.1584p pd=1.6u as=0.1152p ps=1u w=0.36u l=0.28u
X831 VSS.t1979 a_36728_n1782# a_36720_n708.t1 VSS nfet_03v3 ad=0.2728p pd=2.12u as=0.1612p ps=1.14u w=0.62u l=0.28u
X832 a_30325_n170# RA14.t8 a_30793_n862.t13 VSS nfet_03v3 ad=0.1152p pd=1u as=0.1584p ps=1.6u w=0.36u l=0.28u
X833 VDD RB6.t2 a_16226_6260# VDD pfet_03v3 ad=0.3168p pd=2.32u as=0.3708p ps=2.47u w=0.72u l=0.28u
X834 VSS a_n884_1398.t11 a_29754_1902# VSS nfet_03v3 ad=0.1584p pd=1.6u as=56.7f ps=0.675u w=0.36u l=0.28u
X835 VDD RB3.t5 a_18698_8800# VDD pfet_03v3 ad=0.3168p pd=2.32u as=0.3708p ps=2.47u w=0.72u l=0.28u
X836 a_1399_n2146.t5 RB1.t8 a_661_10022# VSS nfet_03v3 ad=0.1584p pd=1.6u as=0.1152p ps=1u w=0.36u l=0.28u
X837 VDD a_n1204_6102.t10 a_24810_6102# VDD pfet_03v3 ad=0.1584p pd=1.6u as=56.7f ps=0.675u w=0.36u l=0.28u
X838 a_36007_n2146.t23 a_36002_9396# a_35269_9238# VDD pfet_03v3 ad=0.1584p pd=1.6u as=0.1152p ps=1u w=0.36u l=0.28u
X839 QB14b.t1 a_36007_n2146.t32 VSS VSS nfet_03v3 ad=0.2052p pd=1.86u as=0.1242p ps=1.05u w=0.36u l=0.28u
X840 VSS a_n884_6886.t5 a_19866_6886# VSS nfet_03v3 ad=0.1584p pd=1.6u as=56.7f ps=0.675u w=0.36u l=0.28u
X841 VDD RB7.t4 a_26114_5664# VDD pfet_03v3 ad=0.3168p pd=2.32u as=0.3708p ps=2.47u w=0.72u l=0.28u
X842 VSS a_n884_2182.t8 a_7506_2182# VSS nfet_03v3 ad=0.1584p pd=1.6u as=56.7f ps=0.675u w=0.36u l=0.28u
X843 VDD a_n1204_5318.t7 a_9978_5822# VDD pfet_03v3 ad=0.1584p pd=1.6u as=56.7f ps=0.675u w=0.36u l=0.28u
X844 VDD a_12252_2966# a_12386_3156# VDD pfet_03v3 ad=0.1764p pd=1.26u as=0.1584p ps=1.6u w=0.36u l=0.28u
X845 VDD a_n1204_10022.t10 a_n884_10022.t0 VDD pfet_03v3 ad=0.5896p pd=3.56u as=0.3886p ps=1.92u w=1.34u l=0.28u
X846 a_17394_8454# a_17330_8768# a_17196_8454# VSS nfet_03v3 ad=56.7f pd=0.675u as=0.1278p ps=1.07u w=0.36u l=0.28u
X847 a_29368_2966# a_29304_n708.t9 VDD VDD pfet_03v3 ad=0.2097p pd=1.38u as=0.3168p ps=2.32u w=0.72u l=0.28u
X848 VDD RB11.t6 a_26114_2528# VDD pfet_03v3 ad=0.3168p pd=2.32u as=0.3708p ps=2.47u w=0.72u l=0.28u
X849 a_32797_2966# a_32028_2966# VDD VDD pfet_03v3 ad=0.36p pd=2.44u as=0.1764p ps=1.26u w=0.72u l=0.28u
X850 a_21952_10022# a_21888_n708.t10 VDD VDD pfet_03v3 ad=0.2097p pd=1.38u as=0.3168p ps=2.32u w=0.72u l=0.28u
X851 VDD RB2.t3 a_38474_9396# VDD pfet_03v3 ad=0.3168p pd=2.32u as=0.3708p ps=2.47u w=0.72u l=0.28u
X852 a_22140_7670# a_n1204_7670.t16 a_21952_7670# VSS nfet_03v3 ad=0.1278p pd=1.07u as=0.1188p ps=1.02u w=0.36u l=0.28u
X853 a_17394_5318# a_17330_5632# a_17196_5318# VSS nfet_03v3 ad=56.7f pd=0.675u as=0.1278p ps=1.07u w=0.36u l=0.28u
X854 a_15493_n170# a_15797_n170# a_15961_n862.t26 VDD.t3048 pfet_03v3 ad=0.1152p pd=1u as=0.1584p ps=1.6u w=0.36u l=0.28u
X855 VSS RB12.t10 a_16226_1556# VSS nfet_03v3 ad=0.1584p pd=1.6u as=0.1854p ps=1.75u w=0.36u l=0.28u
X856 a_35573_3842# RA9.t5 VDD VDD pfet_03v3 ad=0.3888p pd=2.52u as=0.3312p ps=2.36u w=0.72u l=0.28u
X857 VSS.t2632 D13.t0 a_32893_n1738# VSS nfet_03v3 ad=0.1584p pd=1.6u as=0.1188p ps=1.02u w=0.36u l=0.28u
X858 a_13759_n2146.t20 a_13754_1556# a_13021_1398# VDD pfet_03v3 ad=0.1584p pd=1.6u as=0.1152p ps=1u w=0.36u l=0.28u
X859 a_4836_10806# WE0CLK.t9 a_4648_10806# VSS nfet_03v3 ad=0.1278p pd=1.07u as=0.1188p ps=1.02u w=0.36u l=0.28u
X860 VSS a_2364_10022# a_2498_10336# VSS nfet_03v3 ad=97.2f pd=0.9u as=0.1584p ps=1.6u w=0.36u l=0.28u
X861 a_22140_4534# a_n1204_4534.t16 a_21952_4534# VSS nfet_03v3 ad=0.1278p pd=1.07u as=0.1188p ps=1.02u w=0.36u l=0.28u
X862 a_965_1398# RA12.t9 VDD VDD pfet_03v3 ad=0.3888p pd=2.52u as=0.3312p ps=2.36u w=0.72u l=0.28u
X863 VSS a_9780_614# a_9914_928# VSS nfet_03v3 ad=97.2f pd=0.9u as=0.1584p ps=1.6u w=0.36u l=0.28u
X864 a_27853_1398# a_28157_1398# a_28321_n862.t27 VDD pfet_03v3 ad=0.1152p pd=1u as=0.1584p ps=1.6u w=0.36u l=0.28u
X865 VDD a_27084_7670# a_27218_7860# VDD pfet_03v3 ad=0.1764p pd=1.26u as=0.1584p ps=1.6u w=0.36u l=0.28u
X866 a_36007_n2146.t26 RB8.t6 a_35269_4534# VSS nfet_03v3 ad=0.1584p pd=1.6u as=0.1152p ps=1u w=0.36u l=0.28u
X867 a_35573_706# RA13.t9 VDD VDD pfet_03v3 ad=0.3888p pd=2.52u as=0.3312p ps=2.36u w=0.72u l=0.28u
X868 a_5034_10022# a_4970_10336# a_4836_10022# VSS nfet_03v3 ad=56.7f pd=0.675u as=0.1278p ps=1.07u w=0.36u l=0.28u
X869 VDD a_27084_4534# a_27218_4724# VDD pfet_03v3 ad=0.1764p pd=1.26u as=0.1584p ps=1.6u w=0.36u l=0.28u
X870 a_9780_n170# a_n884_n170.t7 a_9592_n170# VDD.t1360 pfet_03v3 ad=0.1278p pd=1.07u as=0.2097p ps=1.38u w=0.36u l=0.28u
X871 VSS a_n884_10806.t9 a_12450_11310# VSS nfet_03v3 ad=0.1584p pd=1.6u as=56.7f ps=0.675u w=0.36u l=0.28u
X872 VSS RB14.t11 a_36002_n12# VSS nfet_03v3 ad=0.1584p pd=1.6u as=0.1854p ps=1.75u w=0.36u l=0.28u
X873 VDD WE0CLK.t10 a_22338_10806# VDD pfet_03v3 ad=0.1584p pd=1.6u as=56.7f ps=0.675u w=0.36u l=0.28u
X874 VSS.t745 RB15.t11 a_3866_n608# VSS nfet_03v3 ad=0.1584p pd=1.6u as=0.1854p ps=1.75u w=0.36u l=0.28u
X875 VDD.t1553 a_n1204_n170.t7 a_90_n170# VDD.t1244 pfet_03v3 ad=0.1584p pd=1.6u as=56.7f ps=0.675u w=0.36u l=0.28u
X876 a_n108_n170# a_n1204_n170.t8 a_n296_n170# VSS nfet_03v3 ad=0.1278p pd=1.07u as=0.1188p ps=1.02u w=0.36u l=0.28u
X877 VSS RB14.t12 a_23642_n12# VSS nfet_03v3 ad=0.1584p pd=1.6u as=0.1854p ps=1.75u w=0.36u l=0.28u
X878 a_10853_6102# RA6.t9 VDD VDD pfet_03v3 ad=0.3888p pd=2.52u as=0.3312p ps=2.36u w=0.72u l=0.28u
X879 VSS RB8.t7 a_38474_4692# VSS nfet_03v3 ad=0.1584p pd=1.6u as=0.1854p ps=1.75u w=0.36u l=0.28u
X880 VDD a_n352_n1782# a_n360_n708.t1 VDD pfet_03v3 ad=0.5456p pd=3.36u as=0.3224p ps=1.76u w=1.24u l=0.28u
X881 a_7056_n708.t3 a_7064_n1782# VSS.t2130 VSS nfet_03v3 ad=0.1612p pd=1.14u as=0.2728p ps=2.12u w=0.62u l=0.28u
X882 a_13325_8546# RA3.t4 VDD VDD pfet_03v3 ad=0.3888p pd=2.52u as=0.3312p ps=2.36u w=0.72u l=0.28u
X883 a_27084_8454# a_n1204_8454.t9 a_26896_8454# VSS nfet_03v3 ad=0.1278p pd=1.07u as=0.1188p ps=1.02u w=0.36u l=0.28u
X884 a_18269_5410# RA7.t10 VSS VSS nfet_03v3 ad=0.1944p pd=1.8u as=0.1656p ps=1.64u w=0.36u l=0.28u
X885 a_27853_2182# a_27084_2182# VSS VSS nfet_03v3 ad=0.18p pd=1.72u as=97.2f ps=0.9u w=0.36u l=0.28u
X886 a_10328_n1738# WEM.t5 VDD VDD pfet_03v3 ad=56.7f pd=0.675u as=0.1584p ps=1.6u w=0.36u l=0.28u
X887 VSS.t3030 a_17196_n954# a_17330_n640# VSS nfet_03v3 ad=97.2f pd=0.9u as=0.1584p ps=1.6u w=0.36u l=0.28u
X888 VSS RB1.t9 a_3866_10368# VSS nfet_03v3 ad=0.1584p pd=1.6u as=0.1854p ps=1.75u w=0.36u l=0.28u
X889 a_18269_10806# RA0.t6 VDD VDD pfet_03v3 ad=0.3888p pd=2.52u as=0.3312p ps=2.36u w=0.72u l=0.28u
X890 a_27084_5318# a_n1204_5318.t8 a_26896_5318# VSS nfet_03v3 ad=0.1278p pd=1.07u as=0.1188p ps=1.02u w=0.36u l=0.28u
X891 a_37741_n954# a_36972_n954# VSS.t2366 VSS nfet_03v3 ad=0.18p pd=1.72u as=97.2f ps=0.9u w=0.36u l=0.28u
X892 a_3871_n2146.t12 RB3.t6 a_3133_8454# VSS nfet_03v3 ad=0.1584p pd=1.6u as=0.1152p ps=1u w=0.36u l=0.28u
X893 VDD RB6.t3 a_13754_6260# VDD pfet_03v3 ad=0.3168p pd=2.32u as=0.3708p ps=2.47u w=0.72u l=0.28u
X894 a_29754_n170# a_29690_20# a_29556_n170# VDD.t3047 pfet_03v3 ad=56.7f pd=0.675u as=0.1278p ps=1.07u w=0.36u l=0.28u
X895 VSS a_n884_1398.t12 a_27282_1902# VSS nfet_03v3 ad=0.1584p pd=1.6u as=56.7f ps=0.675u w=0.36u l=0.28u
X896 a_20741_5410# RA7.t11 VDD VDD pfet_03v3 ad=0.3888p pd=2.52u as=0.3312p ps=2.36u w=0.72u l=0.28u
X897 a_13021_2966# a_13325_2966# a_13489_n862.t29 VDD pfet_03v3 ad=0.1152p pd=1u as=0.1584p ps=1.6u w=0.36u l=0.28u
X898 a_30629_10114# RA1.t6 VSS VSS nfet_03v3 ad=0.1944p pd=1.8u as=0.1656p ps=1.64u w=0.36u l=0.28u
X899 a_20741_2274# RA11.t12 VDD VDD pfet_03v3 ad=0.3888p pd=2.52u as=0.3312p ps=2.36u w=0.72u l=0.28u
X900 a_19668_6886# a_n884_6886.t6 a_19480_6886# VDD pfet_03v3 ad=0.1278p pd=1.07u as=0.2097p ps=1.38u w=0.36u l=0.28u
X901 a_9978_1398# a_9914_1588# a_9780_1398# VDD pfet_03v3 ad=56.7f pd=0.675u as=0.1278p ps=1.07u w=0.36u l=0.28u
X902 a_19668_3750# a_n884_3750.t5 a_19480_3750# VDD pfet_03v3 ad=0.1278p pd=1.07u as=0.2097p ps=1.38u w=0.36u l=0.28u
X903 VSS a_n884_2182.t9 a_5034_2182# VSS nfet_03v3 ad=0.1584p pd=1.6u as=56.7f ps=0.675u w=0.36u l=0.28u
X904 VSS RB14.t13 a_31058_n12# VSS nfet_03v3 ad=0.1584p pd=1.6u as=0.1854p ps=1.75u w=0.36u l=0.28u
X905 a_10853_1398# RA12.t10 VSS VSS nfet_03v3 ad=0.1944p pd=1.8u as=0.1656p ps=1.64u w=0.36u l=0.28u
X906 a_36972_7670# a_n1204_7670.t17 a_36784_7670# VSS nfet_03v3 ad=0.1278p pd=1.07u as=0.1188p ps=1.02u w=0.36u l=0.28u
X907 VSS a_n884_6886.t7 a_17394_6886# VSS nfet_03v3 ad=0.1584p pd=1.6u as=56.7f ps=0.675u w=0.36u l=0.28u
X908 a_n884_1398.t1 a_n1204_1398.t7 VDD VDD pfet_03v3 ad=0.3886p pd=1.92u as=0.3386p ps=1.86u w=1.34u l=0.28u
X909 a_19668_614# a_n884_614.t10 a_19480_614# VDD pfet_03v3 ad=0.1278p pd=1.07u as=0.2097p ps=1.38u w=0.36u l=0.28u
X910 a_35573_10806# RA0.t7 VDD VDD pfet_03v3 ad=0.3888p pd=2.52u as=0.3312p ps=2.36u w=0.72u l=0.28u
X911 a_36972_4534# a_n1204_4534.t17 a_36784_4534# VSS nfet_03v3 ad=0.1278p pd=1.07u as=0.1188p ps=1.02u w=0.36u l=0.28u
X912 a_1399_n2146.t11 RB0.t9 a_661_10806# VSS nfet_03v3 ad=0.1584p pd=1.6u as=0.1152p ps=1u w=0.36u l=0.28u
X913 VSS.t746 RB15.t12 a_36002_n608# VSS nfet_03v3 ad=0.1584p pd=1.6u as=0.1854p ps=1.75u w=0.36u l=0.28u
X914 VSS RB12.t11 a_13754_1556# VSS nfet_03v3 ad=0.1584p pd=1.6u as=0.1854p ps=1.75u w=0.36u l=0.28u
X915 VDD RB7.t5 a_6338_5664# VDD pfet_03v3 ad=0.3168p pd=2.32u as=0.3708p ps=2.47u w=0.72u l=0.28u
X916 VSS a_n884_3750.t6 a_24810_3750# VSS nfet_03v3 ad=0.1584p pd=1.6u as=56.7f ps=0.675u w=0.36u l=0.28u
X917 VDD RB0.t10 a_23642_10964# VDD pfet_03v3 ad=0.3168p pd=2.32u as=0.3708p ps=2.47u w=0.72u l=0.28u
X918 a_33101_3842# RA9.t6 VDD VDD pfet_03v3 ad=0.3888p pd=2.52u as=0.3312p ps=2.36u w=0.72u l=0.28u
X919 a_2364_1398# a_n1204_1398.t8 a_2176_1398# VSS nfet_03v3 ad=0.1278p pd=1.07u as=0.1188p ps=1.02u w=0.36u l=0.28u
X920 a_24368_n1782# a_24872_n1738# a_25160_n1738# VDD pfet_03v3 ad=0.1278p pd=1.07u as=56.7f ps=0.675u w=0.36u l=0.28u
X921 QB0b.t1 a_1399_n2146.t32 VSS VSS nfet_03v3 ad=0.2052p pd=1.86u as=0.1242p ps=1.05u w=0.36u l=0.28u
X922 a_26896_10806# a_26832_n708.t8 VSS VSS nfet_03v3 ad=0.1188p pd=1.02u as=0.1584p ps=1.6u w=0.36u l=0.28u
X923 VDD a_24612_7670# a_24746_7860# VDD pfet_03v3 ad=0.1764p pd=1.26u as=0.1584p ps=1.6u w=0.36u l=0.28u
X924 a_11287_n2146.t18 RB7.t6 a_10549_5318# VSS nfet_03v3 ad=0.1584p pd=1.6u as=0.1152p ps=1u w=0.36u l=0.28u
X925 a_9592_2966# a_9528_n708.t9 VDD VDD pfet_03v3 ad=0.2097p pd=1.38u as=0.3168p ps=2.32u w=0.72u l=0.28u
X926 VDD RB11.t7 a_6338_2528# VDD pfet_03v3 ad=0.3168p pd=2.32u as=0.3708p ps=2.47u w=0.72u l=0.28u
X927 a_26119_n2146.t26 a_26114_10368# a_25381_10022# VDD pfet_03v3 ad=0.1584p pd=1.6u as=0.1152p ps=1u w=0.36u l=0.28u
X928 a_33101_706# RA13.t10 VDD VDD pfet_03v3 ad=0.3888p pd=2.52u as=0.3312p ps=2.36u w=0.72u l=0.28u
X929 a_31840_6886# a_31776_n708.t9 VDD VDD pfet_03v3 ad=0.2097p pd=1.38u as=0.3168p ps=2.32u w=0.72u l=0.28u
X930 VDD a_24612_4534# a_24746_4724# VDD pfet_03v3 ad=0.1764p pd=1.26u as=0.1584p ps=1.6u w=0.36u l=0.28u
X931 a_27344_n1738# a_26840_n1782# VDD VDD pfet_03v3 ad=0.1584p pd=1.6u as=0.1584p ps=1.6u w=0.36u l=0.28u
X932 a_37837_n1738# WEM.t6 a_36728_n1782# VSS nfet_03v3 ad=0.1188p pd=1.02u as=0.1278p ps=1.07u w=0.36u l=0.28u
X933 a_7308_n170# a_n884_n170.t8 a_7120_n170# VDD.t1361 pfet_03v3 ad=0.1278p pd=1.07u as=0.2097p ps=1.38u w=0.36u l=0.28u
X934 a_661_6886# RA5.t5 a_1129_n862.t7 VSS nfet_03v3 ad=0.1152p pd=1u as=0.1584p ps=1.6u w=0.36u l=0.28u
X935 a_9780_10806# a_n884_10806.t10 a_9592_10806# VDD pfet_03v3 ad=0.1278p pd=1.07u as=0.2097p ps=1.38u w=0.36u l=0.28u
X936 VDD a_7308_7670# a_7442_7860# VDD pfet_03v3 ad=0.1764p pd=1.26u as=0.1584p ps=1.6u w=0.36u l=0.28u
X937 a_24810_8174# a_24746_7860# a_24612_7670# VSS nfet_03v3 ad=56.7f pd=0.675u as=0.1278p ps=1.07u w=0.36u l=0.28u
X938 VDD a_n1204_9238.t14 a_29754_9238# VDD pfet_03v3 ad=0.1584p pd=1.6u as=56.7f ps=0.675u w=0.36u l=0.28u
X939 VSS RB9.t8 a_18698_4096# VSS nfet_03v3 ad=0.1584p pd=1.6u as=0.1854p ps=1.75u w=0.36u l=0.28u
X940 VDD a_7308_4534# a_7442_4724# VDD pfet_03v3 ad=0.1764p pd=1.26u as=0.1584p ps=1.6u w=0.36u l=0.28u
X941 a_24810_5038# a_24746_4724# a_24612_4534# VSS nfet_03v3 ad=56.7f pd=0.675u as=0.1278p ps=1.07u w=0.36u l=0.28u
X942 a_2562_2182# a_2498_2496# a_2364_2182# VSS nfet_03v3 ad=56.7f pd=0.675u as=0.1278p ps=1.07u w=0.36u l=0.28u
X943 VSS RB11.t8 a_11282_2528# VSS nfet_03v3 ad=0.1584p pd=1.6u as=0.1854p ps=1.75u w=0.36u l=0.28u
X944 VSS.t3069 a_14724_n954# a_14858_n640# VSS nfet_03v3 ad=97.2f pd=0.9u as=0.1584p ps=1.6u w=0.36u l=0.28u
X945 VSS a_n108_9238# a_26_9428# VSS nfet_03v3 ad=97.2f pd=0.9u as=0.1584p ps=1.6u w=0.36u l=0.28u
X946 VSS a_n884_2182.t10 a_37170_2182# VSS nfet_03v3 ad=0.1584p pd=1.6u as=56.7f ps=0.675u w=0.36u l=0.28u
X947 VSS a_n108_6102# a_26_6292# VSS nfet_03v3 ad=97.2f pd=0.9u as=0.1584p ps=1.6u w=0.36u l=0.28u
X948 a_n108_5318# a_n884_5318.t9 a_n296_5318# VDD pfet_03v3 ad=0.1278p pd=1.07u as=0.2097p ps=1.38u w=0.36u l=0.28u
X949 a_17965_614# a_17196_614# VSS VSS nfet_03v3 ad=0.18p pd=1.72u as=97.2f ps=0.9u w=0.36u l=0.28u
X950 a_27853_8454# a_27084_8454# VDD VDD pfet_03v3 ad=0.36p pd=2.44u as=0.1764p ps=1.26u w=0.72u l=0.28u
X951 a_28157_6978# RA5.t6 VDD VDD pfet_03v3 ad=0.3888p pd=2.52u as=0.3312p ps=2.36u w=0.72u l=0.28u
X952 a_38045_6978# RA5.t7 VSS VSS nfet_03v3 ad=0.1944p pd=1.8u as=0.1656p ps=1.64u w=0.36u l=0.28u
X953 a_18269_9238# RA2.t7 VSS VSS nfet_03v3 ad=0.1944p pd=1.8u as=0.1656p ps=1.64u w=0.36u l=0.28u
X954 a_24424_9238# a_24360_n708.t13 VSS VSS nfet_03v3 ad=0.1188p pd=1.02u as=0.1584p ps=1.6u w=0.36u l=0.28u
X955 a_5909_6978# RA5.t8 VSS VSS nfet_03v3 ad=0.1944p pd=1.8u as=0.1656p ps=1.64u w=0.36u l=0.28u
X956 VSS a_n884_614.t11 a_19866_614# VSS nfet_03v3 ad=0.1584p pd=1.6u as=56.7f ps=0.675u w=0.36u l=0.28u
X957 a_17196_6886# a_n884_6886.t8 a_17008_6886# VDD pfet_03v3 ad=0.1278p pd=1.07u as=0.2097p ps=1.38u w=0.36u l=0.28u
X958 a_18269_6102# RA6.t10 VSS VSS nfet_03v3 ad=0.1944p pd=1.8u as=0.1656p ps=1.64u w=0.36u l=0.28u
X959 VDD a_n1204_5318.t9 a_22338_5822# VDD pfet_03v3 ad=0.1584p pd=1.6u as=56.7f ps=0.675u w=0.36u l=0.28u
X960 VSS RB0.t11 a_3866_10964# VSS nfet_03v3 ad=0.1584p pd=1.6u as=0.1854p ps=1.75u w=0.36u l=0.28u
X961 a_24424_6102# a_24360_n708.t14 VSS VSS nfet_03v3 ad=0.1188p pd=1.02u as=0.1584p ps=1.6u w=0.36u l=0.28u
X962 a_30629_n862# RA15.t5 VSS.t489 VSS nfet_03v3 ad=0.1944p pd=1.8u as=0.1656p ps=1.64u w=0.36u l=0.28u
X963 a_7506_1398# a_7442_1588# a_7308_1398# VDD pfet_03v3 ad=56.7f pd=0.675u as=0.1278p ps=1.07u w=0.36u l=0.28u
X964 a_17196_3750# a_n884_3750.t7 a_17008_3750# VDD pfet_03v3 ad=0.1278p pd=1.07u as=0.2097p ps=1.38u w=0.36u l=0.28u
X965 a_4836_2966# a_n884_2966.t5 a_4648_2966# VDD pfet_03v3 ad=0.1278p pd=1.07u as=0.2097p ps=1.38u w=0.36u l=0.28u
X966 VSS a_n884_1398.t13 a_7506_1902# VSS nfet_03v3 ad=0.1584p pd=1.6u as=56.7f ps=0.675u w=0.36u l=0.28u
X967 a_13759_n2146.t13 a_13754_n12# a_13021_n170# VDD.t2007 pfet_03v3 ad=0.1584p pd=1.6u as=0.1152p ps=1u w=0.36u l=0.28u
X968 a_14724_10806# a_n884_10806.t11 a_14536_10806# VDD pfet_03v3 ad=0.1278p pd=1.07u as=0.2097p ps=1.38u w=0.36u l=0.28u
X969 a_15493_10022# a_15797_10114# a_15961_n862.t19 VDD pfet_03v3 ad=0.1152p pd=1u as=0.1584p ps=1.6u w=0.36u l=0.28u
X970 a_25685_10114# RA1.t7 VSS VSS nfet_03v3 ad=0.1944p pd=1.8u as=0.1656p ps=1.64u w=0.36u l=0.28u
X971 a_34500_7670# a_n1204_7670.t18 a_34312_7670# VSS nfet_03v3 ad=0.1278p pd=1.07u as=0.1188p ps=1.02u w=0.36u l=0.28u
X972 a_27853_n170# a_28157_n170# a_28321_n862.t24 VDD.t2866 pfet_03v3 ad=0.1152p pd=1u as=0.1584p ps=1.6u w=0.36u l=0.28u
X973 a_965_n170# RA14.t9 VDD.t1079 VDD.t445 pfet_03v3 ad=0.3888p pd=2.52u as=0.3312p ps=2.36u w=0.72u l=0.28u
X974 a_34698_10526# a_34634_10336# a_34500_10022# VDD pfet_03v3 ad=56.7f pd=0.675u as=0.1278p ps=1.07u w=0.36u l=0.28u
X975 VSS RB5.t7 a_8810_7232# VSS nfet_03v3 ad=0.1584p pd=1.6u as=0.1854p ps=1.75u w=0.36u l=0.28u
X976 a_17196_614# a_n884_614.t12 a_17008_614# VDD pfet_03v3 ad=0.1278p pd=1.07u as=0.2097p ps=1.38u w=0.36u l=0.28u
X977 a_30629_10806# RA0.t8 VSS VSS nfet_03v3 ad=0.1944p pd=1.8u as=0.1656p ps=1.64u w=0.36u l=0.28u
X978 a_34500_4534# a_n1204_4534.t18 a_34312_4534# VSS nfet_03v3 ad=0.1278p pd=1.07u as=0.1188p ps=1.02u w=0.36u l=0.28u
X979 VDD a_22140_2966# a_22274_3156# VDD pfet_03v3 ad=0.1764p pd=1.26u as=0.1584p ps=1.6u w=0.36u l=0.28u
X980 a_16944_n708.t3 a_16952_n1782# VSS.t2591 VSS nfet_03v3 ad=0.1612p pd=1.14u as=0.2728p ps=2.12u w=0.62u l=0.28u
X981 VSS RB4.t5 a_28586_7828# VSS nfet_03v3 ad=0.1584p pd=1.6u as=0.1854p ps=1.75u w=0.36u l=0.28u
X982 a_661_614# a_n108_614# VSS VSS nfet_03v3 ad=0.18p pd=1.72u as=97.2f ps=0.9u w=0.36u l=0.28u
X983 VDD RB7.t7 a_3866_5664# VDD pfet_03v3 ad=0.3168p pd=2.32u as=0.3708p ps=2.47u w=0.72u l=0.28u
X984 a_20437_2182# a_20741_2274# a_20905_n862.t21 VDD pfet_03v3 ad=0.1152p pd=1u as=0.1584p ps=1.6u w=0.36u l=0.28u
X985 VDD a_4836_10022# a_4970_10336# VDD pfet_03v3 ad=0.1764p pd=1.26u as=0.1584p ps=1.6u w=0.36u l=0.28u
X986 VSS a_19668_7670# a_19802_7860# VSS nfet_03v3 ad=97.2f pd=0.9u as=0.1584p ps=1.6u w=0.36u l=0.28u
X987 VDD RB11.t9 a_3866_2528# VDD pfet_03v3 ad=0.3168p pd=2.32u as=0.3708p ps=2.47u w=0.72u l=0.28u
X988 QB12b.t0 a_31063_n2146.t33 VDD VDD pfet_03v3 ad=0.4104p pd=2.58u as=0.2484p ps=1.41u w=0.72u l=0.28u
X989 a_n1204_8454.t3 a_n1652_8886# VSS VSS nfet_03v3 ad=0.1651p pd=1.155u as=0.2794p ps=2.15u w=0.635u l=0.28u
X990 VSS a_19668_4534# a_19802_4724# VSS nfet_03v3 ad=97.2f pd=0.9u as=0.1584p ps=1.6u w=0.36u l=0.28u
X991 a_7120_2966# a_7056_n708.t9 VDD VDD pfet_03v3 ad=0.2097p pd=1.38u as=0.3168p ps=2.32u w=0.72u l=0.28u
X992 a_21952_8454# a_21888_n708.t11 VSS VSS nfet_03v3 ad=0.1188p pd=1.02u as=0.1584p ps=1.6u w=0.36u l=0.28u
X993 a_13325_3842# RA9.t7 VSS VSS nfet_03v3 ad=0.1944p pd=1.8u as=0.1656p ps=1.64u w=0.36u l=0.28u
X994 a_n1204_5318.t3 a_n1652_5750# VSS VSS nfet_03v3 ad=0.1651p pd=1.155u as=0.2794p ps=2.15u w=0.635u l=0.28u
X995 VDD RB2.t4 a_18698_9396# VDD pfet_03v3 ad=0.3168p pd=2.32u as=0.3708p ps=2.47u w=0.72u l=0.28u
X996 a_25685_8546# RA3.t5 VDD VDD pfet_03v3 ad=0.3888p pd=2.52u as=0.3312p ps=2.36u w=0.72u l=0.28u
X997 a_21952_5318# a_21888_n708.t12 VSS VSS nfet_03v3 ad=0.1188p pd=1.02u as=0.1584p ps=1.6u w=0.36u l=0.28u
X998 a_11287_n2146.t1 RB2.t5 a_10549_9238# VSS nfet_03v3 ad=0.1584p pd=1.6u as=0.1152p ps=1u w=0.36u l=0.28u
X999 a_28591_n2146.t29 a_28586_5664# a_27853_5318# VDD pfet_03v3 ad=0.1584p pd=1.6u as=0.1152p ps=1u w=0.36u l=0.28u
X1000 a_18703_n2146.t26 a_18698_n608# a_17965_n954# VDD.t2971 pfet_03v3 ad=0.1584p pd=1.6u as=0.1152p ps=1u w=0.36u l=0.28u
X1001 VDD a_4836_7670# a_4970_7860# VDD pfet_03v3 ad=0.1764p pd=1.26u as=0.1584p ps=1.6u w=0.36u l=0.28u
X1002 a_22338_8174# a_22274_7860# a_22140_7670# VSS nfet_03v3 ad=56.7f pd=0.675u as=0.1278p ps=1.07u w=0.36u l=0.28u
X1003 a_11287_n2146.t2 RB6.t4 a_10549_6102# VSS nfet_03v3 ad=0.1584p pd=1.6u as=0.1152p ps=1u w=0.36u l=0.28u
X1004 a_90_n954# a_26_n640# a_n108_n954# VSS nfet_03v3 ad=56.7f pd=0.675u as=0.1278p ps=1.07u w=0.36u l=0.28u
X1005 VDD a_n1204_9238.t15 a_27282_9238# VDD pfet_03v3 ad=0.1584p pd=1.6u as=56.7f ps=0.675u w=0.36u l=0.28u
X1006 VDD a_4836_4534# a_4970_4724# VDD pfet_03v3 ad=0.1764p pd=1.26u as=0.1584p ps=1.6u w=0.36u l=0.28u
X1007 a_22338_5038# a_22274_4724# a_22140_4534# VSS nfet_03v3 ad=56.7f pd=0.675u as=0.1278p ps=1.07u w=0.36u l=0.28u
X1008 a_26119_n2146.t21 a_26114_2528# a_25381_2182# VDD pfet_03v3 ad=0.1584p pd=1.6u as=0.1152p ps=1u w=0.36u l=0.28u
X1009 VDD a_34500_1398# a_34634_1588# VDD pfet_03v3 ad=0.1764p pd=1.26u as=0.1584p ps=1.6u w=0.36u l=0.28u
X1010 a_18269_10114# RA1.t8 VDD VDD pfet_03v3 ad=0.3888p pd=2.52u as=0.3312p ps=2.36u w=0.72u l=0.28u
X1011 VDD RB6.t5 a_26114_6260# VDD pfet_03v3 ad=0.3168p pd=2.32u as=0.3708p ps=2.47u w=0.72u l=0.28u
X1012 a_27853_1398# a_27084_1398# VSS VSS nfet_03v3 ad=0.18p pd=1.72u as=97.2f ps=0.9u w=0.36u l=0.28u
X1013 a_25381_2966# a_25685_2966# a_25849_n862.t16 VDD pfet_03v3 ad=0.1152p pd=1u as=0.1584p ps=1.6u w=0.36u l=0.28u
X1014 a_5034_8174# a_4970_7860# a_4836_7670# VSS nfet_03v3 ad=56.7f pd=0.675u as=0.1278p ps=1.07u w=0.36u l=0.28u
X1015 a_9978_n170# a_9914_20# a_9780_n170# VDD.t2819 pfet_03v3 ad=56.7f pd=0.675u as=0.1278p ps=1.07u w=0.36u l=0.28u
X1016 VDD a_n1204_6102.t11 a_34698_6102# VDD pfet_03v3 ad=0.1584p pd=1.6u as=56.7f ps=0.675u w=0.36u l=0.28u
X1017 a_14724_2182# a_n884_2182.t11 a_14536_2182# VDD pfet_03v3 ad=0.1278p pd=1.07u as=0.2097p ps=1.38u w=0.36u l=0.28u
X1018 a_5034_5038# a_4970_4724# a_4836_4534# VSS nfet_03v3 ad=56.7f pd=0.675u as=0.1278p ps=1.07u w=0.36u l=0.28u
X1019 a_8815_n2146.t18 a_8810_2528# a_8077_2182# VDD pfet_03v3 ad=0.1584p pd=1.6u as=0.1152p ps=1u w=0.36u l=0.28u
X1020 VDD a_n1652_1398# a_n1204_1398.t1 VDD pfet_03v3 ad=0.3386p pd=1.86u as=0.3302p ps=1.79u w=1.27u l=0.28u
X1021 a_35269_n170# RA14.t10 a_35737_n862.t11 VSS nfet_03v3 ad=0.1152p pd=1u as=0.1584p ps=1.6u w=0.36u l=0.28u
X1022 a_3437_6978# RA5.t9 VSS VSS nfet_03v3 ad=0.1944p pd=1.8u as=0.1656p ps=1.64u w=0.36u l=0.28u
X1023 VDD RB7.t8 a_36002_5664# VDD pfet_03v3 ad=0.3168p pd=2.32u as=0.3708p ps=2.47u w=0.72u l=0.28u
X1024 VSS RB8.t8 a_18698_4692# VSS nfet_03v3 ad=0.1584p pd=1.6u as=0.1854p ps=1.75u w=0.36u l=0.28u
X1025 a_n884_n170.t1 a_n1204_n170.t9 VDD.t1555 VDD.t1246 pfet_03v3 ad=0.3886p pd=1.92u as=0.3386p ps=1.86u w=1.34u l=0.28u
X1026 VSS a_n884_6886.t9 a_29754_6886# VSS nfet_03v3 ad=0.1584p pd=1.6u as=56.7f ps=0.675u w=0.36u l=0.28u
X1027 VSS RB10.t8 a_11282_3124# VSS nfet_03v3 ad=0.1584p pd=1.6u as=0.1854p ps=1.75u w=0.36u l=0.28u
X1028 VDD RB11.t10 a_36002_2528# VDD pfet_03v3 ad=0.3168p pd=2.32u as=0.3708p ps=2.47u w=0.72u l=0.28u
X1029 a_27282_8454# a_27218_8768# a_27084_8454# VSS nfet_03v3 ad=56.7f pd=0.675u as=0.1278p ps=1.07u w=0.36u l=0.28u
X1030 VSS a_n884_1398.t14 a_5034_1902# VSS nfet_03v3 ad=0.1584p pd=1.6u as=56.7f ps=0.675u w=0.36u l=0.28u
X1031 a_29556_614# a_n1204_614.t11 a_29368_614# VSS nfet_03v3 ad=0.1278p pd=1.07u as=0.1188p ps=1.02u w=0.36u l=0.28u
X1032 a_35573_10114# RA1.t9 VDD VDD pfet_03v3 ad=0.3888p pd=2.52u as=0.3312p ps=2.36u w=0.72u l=0.28u
X1033 a_2364_9238# a_n884_9238.t8 a_2176_9238# VDD pfet_03v3 ad=0.1278p pd=1.07u as=0.2097p ps=1.38u w=0.36u l=0.28u
X1034 a_8077_7670# a_8381_7670# a_8545_n862.t19 VDD pfet_03v3 ad=0.1152p pd=1u as=0.1584p ps=1.6u w=0.36u l=0.28u
X1035 a_8381_6978# RA5.t10 VDD VDD pfet_03v3 ad=0.3888p pd=2.52u as=0.3312p ps=2.36u w=0.72u l=0.28u
X1036 VSS RB12.t12 a_26114_1556# VSS nfet_03v3 ad=0.1584p pd=1.6u as=0.1854p ps=1.75u w=0.36u l=0.28u
X1037 a_27282_5318# a_27218_5632# a_27084_5318# VSS nfet_03v3 ad=56.7f pd=0.675u as=0.1278p ps=1.07u w=0.36u l=0.28u
X1038 VDD a_n1204_5318.t10 a_2562_5822# VDD pfet_03v3 ad=0.1584p pd=1.6u as=56.7f ps=0.675u w=0.36u l=0.28u
X1039 a_8077_4534# a_8381_4534# a_8545_n862.t25 VDD pfet_03v3 ad=0.1152p pd=1u as=0.1584p ps=1.6u w=0.36u l=0.28u
X1040 a_8077_2966# a_7308_2966# VSS VSS nfet_03v3 ad=0.18p pd=1.72u as=97.2f ps=0.9u w=0.36u l=0.28u
X1041 VDD RB1.t10 a_23642_10368# VDD pfet_03v3 ad=0.3168p pd=2.32u as=0.3708p ps=2.47u w=0.72u l=0.28u
X1042 VDD a_36972_7670# a_37106_7860# VDD pfet_03v3 ad=0.1764p pd=1.26u as=0.1584p ps=1.6u w=0.36u l=0.28u
X1043 a_23647_n2146.t13 RB7.t9 a_22909_5318# VSS nfet_03v3 ad=0.1584p pd=1.6u as=0.1152p ps=1u w=0.36u l=0.28u
X1044 a_14480_n1782# a_14984_n1738# a_15272_n1234# VSS nfet_03v3 ad=0.1278p pd=1.07u as=56.7f ps=0.675u w=0.36u l=0.28u
X1045 a_13325_9238# RA2.t8 VDD VDD pfet_03v3 ad=0.3888p pd=2.52u as=0.3312p ps=2.36u w=0.72u l=0.28u
X1046 a_19866_7390# a_19802_7200# a_19668_6886# VDD pfet_03v3 ad=56.7f pd=0.675u as=0.1278p ps=1.07u w=0.36u l=0.28u
X1047 a_17965_5318# a_17196_5318# VDD VDD pfet_03v3 ad=0.36p pd=2.44u as=0.1764p ps=1.26u w=0.72u l=0.28u
X1048 VDD a_36972_4534# a_37106_4724# VDD pfet_03v3 ad=0.1764p pd=1.26u as=0.1584p ps=1.6u w=0.36u l=0.28u
X1049 a_25685_10806# RA0.t9 VSS VSS nfet_03v3 ad=0.1944p pd=1.8u as=0.1656p ps=1.64u w=0.36u l=0.28u
X1050 a_19866_4254# a_19802_4064# a_19668_3750# VDD pfet_03v3 ad=56.7f pd=0.675u as=0.1278p ps=1.07u w=0.36u l=0.28u
X1051 a_17965_2182# a_17196_2182# VDD VDD pfet_03v3 ad=0.36p pd=2.44u as=0.1764p ps=1.26u w=0.72u l=0.28u
X1052 VSS a_17196_2182# a_17330_2496# VSS nfet_03v3 ad=97.2f pd=0.9u as=0.1584p ps=1.6u w=0.36u l=0.28u
X1053 a_20741_6102# RA6.t11 VDD VDD pfet_03v3 ad=0.3888p pd=2.52u as=0.3312p ps=2.36u w=0.72u l=0.28u
X1054 a_19866_1118# a_19802_928# a_19668_614# VDD pfet_03v3 ad=56.7f pd=0.675u as=0.1278p ps=1.07u w=0.36u l=0.28u
X1055 a_23213_8546# RA3.t6 VDD VDD pfet_03v3 ad=0.3888p pd=2.52u as=0.3312p ps=2.36u w=0.72u l=0.28u
X1056 a_28157_5410# RA7.t12 VSS VSS nfet_03v3 ad=0.1944p pd=1.8u as=0.1656p ps=1.64u w=0.36u l=0.28u
X1057 VSS RB11.t11 a_23642_2528# VSS nfet_03v3 ad=0.1584p pd=1.6u as=0.1854p ps=1.75u w=0.36u l=0.28u
X1058 VSS.t2294 a_27084_n954# a_27218_n640# VSS nfet_03v3 ad=97.2f pd=0.9u as=0.1584p ps=1.6u w=0.36u l=0.28u
X1059 QB10b.t0 a_26119_n2146.t33 VDD VDD pfet_03v3 ad=0.4104p pd=2.58u as=0.2484p ps=1.41u w=0.72u l=0.28u
X1060 VDD a_15961_n862.t33 QA6b.t0 VDD pfet_03v3 ad=0.2484p pd=1.41u as=0.4104p ps=2.58u w=0.72u l=0.28u
X1061 a_16231_n2146.t23 a_16226_n608# a_15493_n954# VDD.t2051 pfet_03v3 ad=0.1584p pd=1.6u as=0.1152p ps=1u w=0.36u l=0.28u
X1062 a_37741_2182# a_36972_2182# VSS VSS nfet_03v3 ad=0.18p pd=1.72u as=97.2f ps=0.9u w=0.36u l=0.28u
X1063 a_21952_n954# a_21888_n708.t13 VDD.t1319 VDD.t1318 pfet_03v3 ad=0.2097p pd=1.38u as=0.3168p ps=2.32u w=0.72u l=0.28u
X1064 a_24612_614# a_n1204_614.t12 a_24424_614# VSS nfet_03v3 ad=0.1278p pd=1.07u as=0.1188p ps=1.02u w=0.36u l=0.28u
X1065 a_661_8454# a_n108_8454# VSS VSS nfet_03v3 ad=0.18p pd=1.72u as=97.2f ps=0.9u w=0.36u l=0.28u
X1066 a_661_5318# a_n108_5318# VSS VSS nfet_03v3 ad=0.18p pd=1.72u as=97.2f ps=0.9u w=0.36u l=0.28u
X1067 a_2562_1902# a_2498_1588# a_2364_1398# VSS nfet_03v3 ad=56.7f pd=0.675u as=0.1278p ps=1.07u w=0.36u l=0.28u
X1068 a_31784_n1782# a_32288_n1738# a_32576_n1234# VSS nfet_03v3 ad=0.1278p pd=1.07u as=56.7f ps=0.675u w=0.36u l=0.28u
X1069 a_12064_6886# a_12000_n708.t8 VDD VDD pfet_03v3 ad=0.2097p pd=1.38u as=0.3168p ps=2.32u w=0.72u l=0.28u
X1070 a_30629_5410# RA7.t13 VDD VDD pfet_03v3 ad=0.3888p pd=2.52u as=0.3312p ps=2.36u w=0.72u l=0.28u
X1071 a_13325_4534# RA8.t8 VSS VSS nfet_03v3 ad=0.1944p pd=1.8u as=0.1656p ps=1.64u w=0.36u l=0.28u
X1072 a_22909_2966# a_23213_2966# a_23377_n862.t25 VDD pfet_03v3 ad=0.1152p pd=1u as=0.1584p ps=1.6u w=0.36u l=0.28u
X1073 a_30325_614# RA13.t11 a_30793_n862.t7 VSS nfet_03v3 ad=0.1152p pd=1u as=0.1584p ps=1.6u w=0.36u l=0.28u
X1074 VSS a_n884_1398.t15 a_37170_1902# VSS nfet_03v3 ad=0.1584p pd=1.6u as=56.7f ps=0.675u w=0.36u l=0.28u
X1075 a_661_10022# a_n108_10022# VSS VSS nfet_03v3 ad=0.18p pd=1.72u as=97.2f ps=0.9u w=0.36u l=0.28u
X1076 a_36784_9238# a_36720_n708.t14 VSS VSS nfet_03v3 ad=0.1188p pd=1.02u as=0.1584p ps=1.6u w=0.36u l=0.28u
X1077 a_12252_2182# a_n884_2182.t12 a_12064_2182# VDD pfet_03v3 ad=0.1278p pd=1.07u as=0.2097p ps=1.38u w=0.36u l=0.28u
X1078 a_30629_2274# RA11.t13 VDD VDD pfet_03v3 ad=0.3888p pd=2.52u as=0.3312p ps=2.36u w=0.72u l=0.28u
X1079 a_7506_n170# a_7442_20# a_7308_n170# VDD.t2953 pfet_03v3 ad=56.7f pd=0.675u as=0.1278p ps=1.07u w=0.36u l=0.28u
X1080 VDD a_n1204_9238.t16 a_7506_9238# VDD pfet_03v3 ad=0.1584p pd=1.6u as=56.7f ps=0.675u w=0.36u l=0.28u
X1081 a_29556_6886# a_n884_6886.t10 a_29368_6886# VDD pfet_03v3 ad=0.1278p pd=1.07u as=0.2097p ps=1.38u w=0.36u l=0.28u
X1082 a_36784_6102# a_36720_n708.t15 VSS VSS nfet_03v3 ad=0.1188p pd=1.02u as=0.1584p ps=1.6u w=0.36u l=0.28u
X1083 a_6343_n2146.t27 a_6338_2528# a_5605_2182# VDD pfet_03v3 ad=0.1584p pd=1.6u as=0.1152p ps=1u w=0.36u l=0.28u
X1084 a_7308_614# a_n1204_614.t13 a_7120_614# VSS nfet_03v3 ad=0.1278p pd=1.07u as=0.1188p ps=1.02u w=0.36u l=0.28u
X1085 a_20741_1398# RA12.t11 VSS VSS nfet_03v3 ad=0.1944p pd=1.8u as=0.1656p ps=1.64u w=0.36u l=0.28u
X1086 a_8077_10022# a_7308_10022# VSS VSS nfet_03v3 ad=0.18p pd=1.72u as=97.2f ps=0.9u w=0.36u l=0.28u
X1087 VSS a_n884_6886.t11 a_27282_6886# VSS nfet_03v3 ad=0.1584p pd=1.6u as=56.7f ps=0.675u w=0.36u l=0.28u
X1088 VDD RB6.t6 a_6338_6260# VDD pfet_03v3 ad=0.3168p pd=2.32u as=0.3708p ps=2.47u w=0.72u l=0.28u
X1089 a_29556_3750# a_n884_3750.t8 a_29368_3750# VDD pfet_03v3 ad=0.1278p pd=1.07u as=0.2097p ps=1.38u w=0.36u l=0.28u
X1090 VDD a_33265_n862.t33 QA13b.t0 VDD pfet_03v3 ad=0.2484p pd=1.41u as=0.4104p ps=2.58u w=0.72u l=0.28u
X1091 a_37741_7670# a_38045_7670# a_38209_n862.t15 VDD pfet_03v3 ad=0.1152p pd=1u as=0.1584p ps=1.6u w=0.36u l=0.28u
X1092 a_18269_n862# RA15.t6 VDD.t436 VDD.t435 pfet_03v3 ad=0.3888p pd=2.52u as=0.3312p ps=2.36u w=0.72u l=0.28u
X1093 a_29556_614# a_n884_614.t13 a_29368_614# VDD pfet_03v3 ad=0.1278p pd=1.07u as=0.2097p ps=1.38u w=0.36u l=0.28u
X1094 a_24810_10022# a_24746_10336# a_24612_10022# VSS nfet_03v3 ad=56.7f pd=0.675u as=0.1278p ps=1.07u w=0.36u l=0.28u
X1095 VDD a_n1204_5318.t11 a_32226_5822# VDD pfet_03v3 ad=0.1584p pd=1.6u as=56.7f ps=0.675u w=0.36u l=0.28u
X1096 a_29368_n170# a_29304_n708.t10 VSS VSS nfet_03v3 ad=0.1188p pd=1.02u as=0.1584p ps=1.6u w=0.36u l=0.28u
X1097 a_5605_7670# a_5909_7670# a_6073_n862.t30 VDD pfet_03v3 ad=0.1152p pd=1u as=0.1584p ps=1.6u w=0.36u l=0.28u
X1098 a_37741_4534# a_38045_4534# a_38209_n862.t18 VDD pfet_03v3 ad=0.1152p pd=1u as=0.1584p ps=1.6u w=0.36u l=0.28u
X1099 VSS a_n884_3750.t9 a_34698_3750# VSS nfet_03v3 ad=0.1584p pd=1.6u as=56.7f ps=0.675u w=0.36u l=0.28u
X1100 VDD a_2364_2966# a_2498_3156# VDD pfet_03v3 ad=0.1764p pd=1.26u as=0.1584p ps=1.6u w=0.36u l=0.28u
X1101 a_17008_7670# a_16944_n708.t7 VDD VDD pfet_03v3 ad=0.2097p pd=1.38u as=0.3168p ps=2.32u w=0.72u l=0.28u
X1102 a_21175_n2146.t10 RB7.t10 a_20437_5318# VSS nfet_03v3 ad=0.1584p pd=1.6u as=0.1152p ps=1u w=0.36u l=0.28u
X1103 a_5605_4534# a_5909_4534# a_6073_n862.t24 VDD pfet_03v3 ad=0.1152p pd=1u as=0.1584p ps=1.6u w=0.36u l=0.28u
X1104 a_17008_n170# a_16944_n708.t8 VSS VSS nfet_03v3 ad=0.1188p pd=1.02u as=0.1584p ps=1.6u w=0.36u l=0.28u
X1105 a_17008_4534# a_16944_n708.t9 VDD VDD pfet_03v3 ad=0.2097p pd=1.38u as=0.3168p ps=2.32u w=0.72u l=0.28u
X1106 a_10549_10022# RA1.t10 a_11017_n862.t0 VSS nfet_03v3 ad=0.1152p pd=1u as=0.1584p ps=1.6u w=0.36u l=0.28u
X1107 a_15493_5318# a_14724_5318# VDD VDD pfet_03v3 ad=0.36p pd=2.44u as=0.1764p ps=1.26u w=0.72u l=0.28u
X1108 a_25685_3842# RA9.t8 VSS VSS nfet_03v3 ad=0.1944p pd=1.8u as=0.1656p ps=1.64u w=0.36u l=0.28u
X1109 VSS RB12.t13 a_6338_1556# VSS nfet_03v3 ad=0.1584p pd=1.6u as=0.1854p ps=1.75u w=0.36u l=0.28u
X1110 a_15493_2182# a_14724_2182# VDD VDD pfet_03v3 ad=0.36p pd=2.44u as=0.1764p ps=1.26u w=0.72u l=0.28u
X1111 a_3871_n2146.t25 a_3866_1556# a_3133_1398# VDD pfet_03v3 ad=0.1584p pd=1.6u as=0.1152p ps=1u w=0.36u l=0.28u
X1112 VSS RB13.t8 a_36002_960# VSS nfet_03v3 ad=0.1584p pd=1.6u as=0.1854p ps=1.75u w=0.36u l=0.28u
X1113 a_23647_n2146.t0 RB2.t6 a_22909_9238# VSS nfet_03v3 ad=0.1584p pd=1.6u as=0.1152p ps=1u w=0.36u l=0.28u
X1114 a_34698_8174# a_34634_7860# a_34500_7670# VSS nfet_03v3 ad=56.7f pd=0.675u as=0.1278p ps=1.07u w=0.36u l=0.28u
X1115 a_2364_6886# a_n1204_6886.t13 a_2176_6886# VSS nfet_03v3 ad=0.1278p pd=1.07u as=0.1188p ps=1.02u w=0.36u l=0.28u
X1116 VDD.t2512 a_34500_n170# a_34634_20# VDD.t2450 pfet_03v3 ad=0.1764p pd=1.26u as=0.1584p ps=1.6u w=0.36u l=0.28u
X1117 a_13759_n2146.t24 a_13754_10964# a_13021_10806# VDD pfet_03v3 ad=0.1584p pd=1.6u as=0.1152p ps=1u w=0.36u l=0.28u
X1118 a_27853_9238# a_27084_9238# VDD VDD pfet_03v3 ad=0.36p pd=2.44u as=0.1764p ps=1.26u w=0.72u l=0.28u
X1119 a_23647_n2146.t5 RB6.t7 a_22909_6102# VSS nfet_03v3 ad=0.1584p pd=1.6u as=0.1152p ps=1u w=0.36u l=0.28u
X1120 VSS a_14724_2182# a_14858_2496# VSS nfet_03v3 ad=97.2f pd=0.9u as=0.1584p ps=1.6u w=0.36u l=0.28u
X1121 a_32226_614# a_32162_928# a_32028_614# VSS nfet_03v3 ad=56.7f pd=0.675u as=0.1278p ps=1.07u w=0.36u l=0.28u
X1122 a_32028_9238# a_n1204_9238.t17 a_31840_9238# VSS nfet_03v3 ad=0.1278p pd=1.07u as=0.1188p ps=1.02u w=0.36u l=0.28u
X1123 a_34698_5038# a_34634_4724# a_34500_4534# VSS nfet_03v3 ad=56.7f pd=0.675u as=0.1278p ps=1.07u w=0.36u l=0.28u
X1124 VSS RB14.t14 a_6338_n12# VSS nfet_03v3 ad=0.1584p pd=1.6u as=0.1854p ps=1.75u w=0.36u l=0.28u
X1125 VSS RB13.t9 a_23642_960# VSS nfet_03v3 ad=0.1584p pd=1.6u as=0.1854p ps=1.75u w=0.36u l=0.28u
X1126 VSS RB11.t12 a_21170_2528# VSS nfet_03v3 ad=0.1584p pd=1.6u as=0.1854p ps=1.75u w=0.36u l=0.28u
X1127 a_12000_n708.t1 a_12008_n1782# VDD VDD pfet_03v3 ad=0.3224p pd=1.76u as=0.5456p ps=3.36u w=1.24u l=0.28u
X1128 VSS.t2560 a_24612_n954# a_24746_n640# VSS nfet_03v3 ad=97.2f pd=0.9u as=0.1584p ps=1.6u w=0.36u l=0.28u
X1129 VSS a_14724_n170# a_14858_20# VSS nfet_03v3 ad=97.2f pd=0.9u as=0.1584p ps=1.6u w=0.36u l=0.28u
X1130 a_32028_6102# a_n1204_6102.t12 a_31840_6102# VSS nfet_03v3 ad=0.1278p pd=1.07u as=0.1188p ps=1.02u w=0.36u l=0.28u
X1131 VDD D2.t0 a_5701_n1738# VDD pfet_03v3 ad=0.3168p pd=2.32u as=0.2097p ps=1.38u w=0.72u l=0.28u
X1132 a_661_n170# RA14.t11 a_1129_n862.t15 VSS nfet_03v3 ad=0.1152p pd=1u as=0.1584p ps=1.6u w=0.36u l=0.28u
X1133 a_24424_n170# a_24360_n708.t15 VSS VSS nfet_03v3 ad=0.1188p pd=1.02u as=0.1584p ps=1.6u w=0.36u l=0.28u
X1134 VDD.t3172 a_n1652_n170# a_n1204_n170.t1 VDD.t1365 pfet_03v3 ad=0.3386p pd=1.86u as=0.3302p ps=1.79u w=1.27u l=0.28u
X1135 a_37741_8454# a_36972_8454# VDD VDD pfet_03v3 ad=0.36p pd=2.44u as=0.1764p ps=1.26u w=0.72u l=0.28u
X1136 a_2176_10806# a_2112_n708.t17 VSS VSS nfet_03v3 ad=0.1188p pd=1.02u as=0.1584p ps=1.6u w=0.36u l=0.28u
X1137 a_28157_9238# RA2.t9 VSS VSS nfet_03v3 ad=0.1944p pd=1.8u as=0.1656p ps=1.64u w=0.36u l=0.28u
X1138 VDD a_n1204_2182.t10 a_n884_2182.t0 VDD pfet_03v3 ad=0.5896p pd=3.56u as=0.3886p ps=1.92u w=1.34u l=0.28u
X1139 VSS.t2714 a_7308_n954# a_7442_n640# VSS nfet_03v3 ad=97.2f pd=0.9u as=0.1584p ps=1.6u w=0.36u l=0.28u
X1140 a_661_n954# a_n108_n954# VDD.t2678 VDD.t2677 pfet_03v3 ad=0.36p pd=2.44u as=0.1764p ps=1.26u w=0.72u l=0.28u
X1141 a_34312_9238# a_34248_n708.t14 VSS VSS nfet_03v3 ad=0.1188p pd=1.02u as=0.1584p ps=1.6u w=0.36u l=0.28u
X1142 a_8381_5410# RA7.t14 VSS VSS nfet_03v3 ad=0.1944p pd=1.8u as=0.1656p ps=1.64u w=0.36u l=0.28u
X1143 a_n1204_10022.t3 a_n1652_10454# VSS VSS nfet_03v3 ad=0.1651p pd=1.155u as=0.2794p ps=2.15u w=0.635u l=0.28u
X1144 VDD a_n1204_9238.t18 a_5034_9238# VDD pfet_03v3 ad=0.1584p pd=1.6u as=56.7f ps=0.675u w=0.36u l=0.28u
X1145 a_15493_6886# a_15797_6978# a_15961_n862.t28 VDD pfet_03v3 ad=0.1152p pd=1u as=0.1584p ps=1.6u w=0.36u l=0.28u
X1146 a_28157_6102# RA6.t12 VSS VSS nfet_03v3 ad=0.1944p pd=1.8u as=0.1656p ps=1.64u w=0.36u l=0.28u
X1147 VSS RB10.t9 a_23642_3124# VSS nfet_03v3 ad=0.1584p pd=1.6u as=0.1854p ps=1.75u w=0.36u l=0.28u
X1148 a_30325_10022# a_29556_10022# VSS VSS nfet_03v3 ad=0.18p pd=1.72u as=97.2f ps=0.9u w=0.36u l=0.28u
X1149 a_36007_n2146.t11 RB4.t6 a_35269_7670# VSS nfet_03v3 ad=0.1584p pd=1.6u as=0.1152p ps=1u w=0.36u l=0.28u
X1150 a_34312_6102# a_34248_n708.t15 VSS VSS nfet_03v3 ad=0.1188p pd=1.02u as=0.1584p ps=1.6u w=0.36u l=0.28u
X1151 a_n296_5318# a_n360_n708.t10 VDD VDD pfet_03v3 ad=0.2097p pd=1.38u as=0.3168p ps=2.32u w=0.72u l=0.28u
X1152 VDD WE0CLK.t11 a_32226_10806# VDD pfet_03v3 ad=0.1584p pd=1.6u as=56.7f ps=0.675u w=0.36u l=0.28u
X1153 a_2176_9238# a_2112_n708.t18 VSS VSS nfet_03v3 ad=0.1188p pd=1.02u as=0.1584p ps=1.6u w=0.36u l=0.28u
X1154 VDD RB6.t8 a_3866_6260# VDD pfet_03v3 ad=0.3168p pd=2.32u as=0.3708p ps=2.47u w=0.72u l=0.28u
X1155 a_15493_3750# a_15797_3842# a_15961_n862.t27 VDD pfet_03v3 ad=0.1152p pd=1u as=0.1584p ps=1.6u w=0.36u l=0.28u
X1156 a_n296_2182# a_n360_n708.t11 VDD VDD pfet_03v3 ad=0.2097p pd=1.38u as=0.3168p ps=2.32u w=0.72u l=0.28u
X1157 VSS a_11017_n862.t32 QA4b.t1 VSS nfet_03v3 ad=0.1242p pd=1.05u as=0.2052p ps=1.86u w=0.36u l=0.28u
X1158 a_7120_n170# a_7056_n708.t10 VSS VSS nfet_03v3 ad=0.1188p pd=1.02u as=0.1584p ps=1.6u w=0.36u l=0.28u
X1159 a_2176_6102# a_2112_n708.t19 VSS VSS nfet_03v3 ad=0.1188p pd=1.02u as=0.1584p ps=1.6u w=0.36u l=0.28u
X1160 a_3133_2966# a_3437_2966# a_3601_n862.t27 VDD pfet_03v3 ad=0.1152p pd=1u as=0.1584p ps=1.6u w=0.36u l=0.28u
X1161 VSS a_n884_2966.t6 a_12450_3470# VSS nfet_03v3 ad=0.1584p pd=1.6u as=56.7f ps=0.675u w=0.36u l=0.28u
X1162 VSS RB13.t10 a_31058_960# VSS nfet_03v3 ad=0.1584p pd=1.6u as=0.1854p ps=1.75u w=0.36u l=0.28u
X1163 a_15493_614# a_15797_706# a_15961_n862.t23 VDD pfet_03v3 ad=0.1152p pd=1u as=0.1584p ps=1.6u w=0.36u l=0.28u
X1164 a_90_10806# a_26_10996# a_n108_10806# VDD pfet_03v3 ad=56.7f pd=0.675u as=0.1278p ps=1.07u w=0.36u l=0.28u
X1165 a_9780_6886# a_n884_6886.t12 a_9592_6886# VDD pfet_03v3 ad=0.1278p pd=1.07u as=0.2097p ps=1.38u w=0.36u l=0.28u
X1166 VDD a_32028_2966# a_32162_3156# VDD pfet_03v3 ad=0.1764p pd=1.26u as=0.1584p ps=1.6u w=0.36u l=0.28u
X1167 VSS RB4.t7 a_38474_7828# VSS nfet_03v3 ad=0.1584p pd=1.6u as=0.1854p ps=1.75u w=0.36u l=0.28u
X1168 VDD a_n1204_6886.t14 a_90_7390# VDD pfet_03v3 ad=0.1584p pd=1.6u as=56.7f ps=0.675u w=0.36u l=0.28u
X1169 VSS a_n884_6886.t13 a_7506_6886# VSS nfet_03v3 ad=0.1584p pd=1.6u as=56.7f ps=0.675u w=0.36u l=0.28u
X1170 a_9780_3750# a_n884_3750.t10 a_9592_3750# VDD pfet_03v3 ad=0.1278p pd=1.07u as=0.2097p ps=1.38u w=0.36u l=0.28u
X1171 a_14922_2686# a_14858_2496# a_14724_2182# VDD pfet_03v3 ad=56.7f pd=0.675u as=0.1278p ps=1.07u w=0.36u l=0.28u
X1172 a_30325_2182# a_30629_2274# a_30793_n862.t24 VDD pfet_03v3 ad=0.1152p pd=1u as=0.1584p ps=1.6u w=0.36u l=0.28u
X1173 a_19668_10806# WE0CLK.t12 a_19480_10806# VSS nfet_03v3 ad=0.1278p pd=1.07u as=0.1188p ps=1.02u w=0.36u l=0.28u
X1174 a_25685_9238# RA2.t10 VDD VDD pfet_03v3 ad=0.3888p pd=2.52u as=0.3312p ps=2.36u w=0.72u l=0.28u
X1175 a_14536_7670# a_14472_n708.t7 VDD VDD pfet_03v3 ad=0.2097p pd=1.38u as=0.3168p ps=2.32u w=0.72u l=0.28u
X1176 VSS a_29556_7670# a_29690_7860# VSS nfet_03v3 ad=97.2f pd=0.9u as=0.1584p ps=1.6u w=0.36u l=0.28u
X1177 VDD D4.t0 a_10645_n1738# VDD pfet_03v3 ad=0.3168p pd=2.32u as=0.2097p ps=1.38u w=0.72u l=0.28u
X1178 a_29556_10806# a_n884_10806.t12 a_29368_10806# VDD pfet_03v3 ad=0.1278p pd=1.07u as=0.2097p ps=1.38u w=0.36u l=0.28u
X1179 VDD a_n1204_3750.t8 a_90_4254# VDD pfet_03v3 ad=0.1584p pd=1.6u as=56.7f ps=0.675u w=0.36u l=0.28u
X1180 a_9780_614# a_n884_614.t14 a_9592_614# VDD pfet_03v3 ad=0.1278p pd=1.07u as=0.2097p ps=1.38u w=0.36u l=0.28u
X1181 a_n884_6886.t1 a_n1204_6886.t15 VDD VDD pfet_03v3 ad=0.3886p pd=1.92u as=0.3386p ps=1.86u w=1.34u l=0.28u
X1182 a_14536_4534# a_14472_n708.t8 VDD VDD pfet_03v3 ad=0.2097p pd=1.38u as=0.3168p ps=2.32u w=0.72u l=0.28u
X1183 VSS a_29556_4534# a_29690_4724# VSS nfet_03v3 ad=97.2f pd=0.9u as=0.1584p ps=1.6u w=0.36u l=0.28u
X1184 a_31840_8454# a_31776_n708.t10 VSS VSS nfet_03v3 ad=0.1188p pd=1.02u as=0.1584p ps=1.6u w=0.36u l=0.28u
X1185 a_23213_3842# RA9.t9 VSS VSS nfet_03v3 ad=0.1944p pd=1.8u as=0.1656p ps=1.64u w=0.36u l=0.28u
X1186 VSS RB12.t14 a_3866_1556# VSS nfet_03v3 ad=0.1584p pd=1.6u as=0.1854p ps=1.75u w=0.36u l=0.28u
X1187 VDD a_n1204_614.t14 a_90_1118# VDD pfet_03v3 ad=0.1584p pd=1.6u as=56.7f ps=0.675u w=0.36u l=0.28u
X1188 VDD a_9780_10806# a_9914_10996# VDD pfet_03v3 ad=0.1764p pd=1.26u as=0.1584p ps=1.6u w=0.36u l=0.28u
X1189 a_n884_3750.t1 a_n1204_3750.t9 VDD VDD pfet_03v3 ad=0.3886p pd=1.92u as=0.3386p ps=1.86u w=1.34u l=0.28u
X1190 a_90_2182# a_26_2496# a_n108_2182# VSS nfet_03v3 ad=56.7f pd=0.675u as=0.1278p ps=1.07u w=0.36u l=0.28u
X1191 a_21175_n2146.t9 RB2.t7 a_20437_9238# VSS nfet_03v3 ad=0.1584p pd=1.6u as=0.1152p ps=1u w=0.36u l=0.28u
X1192 a_35573_8546# RA3.t7 VDD VDD pfet_03v3 ad=0.3888p pd=2.52u as=0.3312p ps=2.36u w=0.72u l=0.28u
X1193 VSS a_n1652_6102# a_n1204_6102.t3 VSS nfet_03v3 ad=0.1693p pd=1.19u as=0.1651p ps=1.155u w=0.635u l=0.28u
X1194 a_31840_5318# a_31776_n708.t11 VSS VSS nfet_03v3 ad=0.1188p pd=1.02u as=0.1584p ps=1.6u w=0.36u l=0.28u
X1195 a_2562_9238# a_2498_9428# a_2364_9238# VDD pfet_03v3 ad=56.7f pd=0.675u as=0.1278p ps=1.07u w=0.36u l=0.28u
X1196 a_32226_8174# a_32162_7860# a_32028_7670# VSS nfet_03v3 ad=56.7f pd=0.675u as=0.1278p ps=1.07u w=0.36u l=0.28u
X1197 a_29754_7390# a_29690_7200# a_29556_6886# VDD pfet_03v3 ad=56.7f pd=0.675u as=0.1278p ps=1.07u w=0.36u l=0.28u
X1198 a_38479_n2146.t19 a_38474_5664# a_37741_5318# VDD pfet_03v3 ad=0.1584p pd=1.6u as=0.1152p ps=1u w=0.36u l=0.28u
X1199 VSS a_17196_1398# a_17330_1588# VSS nfet_03v3 ad=97.2f pd=0.9u as=0.1584p ps=1.6u w=0.36u l=0.28u
X1200 VDD a_n1204_9238.t19 a_37170_9238# VDD pfet_03v3 ad=0.1584p pd=1.6u as=56.7f ps=0.675u w=0.36u l=0.28u
X1201 a_21175_n2146.t8 RB6.t9 a_20437_6102# VSS nfet_03v3 ad=0.1584p pd=1.6u as=0.1152p ps=1u w=0.36u l=0.28u
X1202 VSS a_n1652_2966# a_n1204_2966.t3 VSS nfet_03v3 ad=0.1693p pd=1.19u as=0.1651p ps=1.155u w=0.635u l=0.28u
X1203 a_12064_n170# a_12000_n708.t9 VSS VSS nfet_03v3 ad=0.1188p pd=1.02u as=0.1584p ps=1.6u w=0.36u l=0.28u
X1204 a_32226_5038# a_32162_4724# a_32028_4534# VSS nfet_03v3 ad=56.7f pd=0.675u as=0.1278p ps=1.07u w=0.36u l=0.28u
X1205 a_29754_4254# a_29690_4064# a_29556_3750# VDD pfet_03v3 ad=56.7f pd=0.675u as=0.1278p ps=1.07u w=0.36u l=0.28u
X1206 a_10549_10806# RA0.t10 a_11017_n862.t16 VSS nfet_03v3 ad=0.1152p pd=1u as=0.1584p ps=1.6u w=0.36u l=0.28u
X1207 a_36972_10806# WE0CLK.t13 a_36784_10806# VSS nfet_03v3 ad=0.1278p pd=1.07u as=0.1188p ps=1.02u w=0.36u l=0.28u
X1208 VSS RB1.t11 a_18698_10368# VSS nfet_03v3 ad=0.1584p pd=1.6u as=0.1854p ps=1.75u w=0.36u l=0.28u
X1209 VDD RB6.t10 a_36002_6260# VDD pfet_03v3 ad=0.3168p pd=2.32u as=0.3708p ps=2.47u w=0.72u l=0.28u
X1210 VSS a_n1204_4534.t19 a_n884_4534.t2 VSS nfet_03v3 ad=0.2948p pd=2.22u as=0.1943p ps=1.25u w=0.67u l=0.28u
X1211 a_25685_4534# RA8.t9 VSS VSS nfet_03v3 ad=0.1944p pd=1.8u as=0.1656p ps=1.64u w=0.36u l=0.28u
X1212 a_35269_2966# a_35573_2966# a_35737_n862.t21 VDD pfet_03v3 ad=0.1152p pd=1u as=0.1584p ps=1.6u w=0.36u l=0.28u
X1213 a_29754_1118# a_29690_928# a_29556_614# VDD pfet_03v3 ad=56.7f pd=0.675u as=0.1278p ps=1.07u w=0.36u l=0.28u
X1214 a_37741_1398# a_36972_1398# VSS VSS nfet_03v3 ad=0.18p pd=1.72u as=97.2f ps=0.9u w=0.36u l=0.28u
X1215 a_10549_10806# a_9780_10806# VDD VDD pfet_03v3 ad=0.36p pd=2.44u as=0.1764p ps=1.26u w=0.72u l=0.28u
X1216 a_24612_2182# a_n884_2182.t13 a_24424_2182# VDD pfet_03v3 ad=0.1278p pd=1.07u as=0.2097p ps=1.38u w=0.36u l=0.28u
X1217 VSS.t2344 a_4836_n954# a_4970_n640# VSS nfet_03v3 ad=97.2f pd=0.9u as=0.1584p ps=1.6u w=0.36u l=0.28u
X1218 a_27853_6886# a_27084_6886# VSS VSS nfet_03v3 ad=0.18p pd=1.72u as=97.2f ps=0.9u w=0.36u l=0.28u
X1219 a_7568_n1738# a_7064_n1782# VDD VDD pfet_03v3 ad=0.1584p pd=1.6u as=0.1584p ps=1.6u w=0.36u l=0.28u
X1220 VSS RB10.t10 a_21170_3124# VSS nfet_03v3 ad=0.1584p pd=1.6u as=0.1854p ps=1.75u w=0.36u l=0.28u
X1221 a_37170_8454# a_37106_8768# a_36972_8454# VSS nfet_03v3 ad=56.7f pd=0.675u as=0.1278p ps=1.07u w=0.36u l=0.28u
X1222 VDD a_9780_2182# a_9914_2496# VDD pfet_03v3 ad=0.1764p pd=1.26u as=0.1584p ps=1.6u w=0.36u l=0.28u
X1223 a_8381_9238# RA2.t11 VSS VSS nfet_03v3 ad=0.1944p pd=1.8u as=0.1656p ps=1.64u w=0.36u l=0.28u
X1224 VDD CLK a_n1652_7318# VDD pfet_03v3 ad=0.3168p pd=2.32u as=0.1872p ps=1.24u w=0.72u l=0.28u
X1225 a_17965_6102# a_17196_6102# VDD VDD pfet_03v3 ad=0.36p pd=2.44u as=0.1764p ps=1.26u w=0.72u l=0.28u
X1226 VDD a_24612_10022# a_24746_10336# VDD pfet_03v3 ad=0.1764p pd=1.26u as=0.1584p ps=1.6u w=0.36u l=0.28u
X1227 a_37170_5318# a_37106_5632# a_36972_5318# VSS nfet_03v3 ad=56.7f pd=0.675u as=0.1278p ps=1.07u w=0.36u l=0.28u
X1228 VSS a_n884_2966.t7 a_9978_3470# VSS nfet_03v3 ad=0.1584p pd=1.6u as=56.7f ps=0.675u w=0.36u l=0.28u
X1229 VSS RB12.t15 a_36002_1556# VSS nfet_03v3 ad=0.1584p pd=1.6u as=0.1854p ps=1.75u w=0.36u l=0.28u
X1230 a_8381_6102# RA6.t13 VSS VSS nfet_03v3 ad=0.1944p pd=1.8u as=0.1656p ps=1.64u w=0.36u l=0.28u
X1231 a_8173_n1738# WEM.t7 a_7064_n1782# VSS nfet_03v3 ad=0.1188p pd=1.02u as=0.1278p ps=1.07u w=0.36u l=0.28u
X1232 a_20437_n954# a_20741_n862# a_20905_n862.t27 VDD.t3177 pfet_03v3 ad=0.1152p pd=1u as=0.1584p ps=1.6u w=0.36u l=0.28u
X1233 a_7308_6886# a_n884_6886.t14 a_7120_6886# VDD pfet_03v3 ad=0.1278p pd=1.07u as=0.2097p ps=1.38u w=0.36u l=0.28u
X1234 a_33535_n2146.t20 RB7.t11 a_32797_5318# VSS nfet_03v3 ad=0.1584p pd=1.6u as=0.1152p ps=1u w=0.36u l=0.28u
X1235 a_32576_n1234# a_n884_n1738.t9 VSS.t7 VSS nfet_03v3 ad=56.7f pd=0.675u as=0.1584p ps=1.6u w=0.36u l=0.28u
X1236 a_23213_9238# RA2.t12 VDD VDD pfet_03v3 ad=0.3888p pd=2.52u as=0.3312p ps=2.36u w=0.72u l=0.28u
X1237 a_19668_8454# a_n884_8454.t9 a_19480_8454# VDD pfet_03v3 ad=0.1278p pd=1.07u as=0.2097p ps=1.38u w=0.36u l=0.28u
X1238 VSS RB3.t7 a_28586_8800# VSS nfet_03v3 ad=0.1584p pd=1.6u as=0.1854p ps=1.75u w=0.36u l=0.28u
X1239 VSS a_n884_6886.t15 a_5034_6886# VSS nfet_03v3 ad=0.1584p pd=1.6u as=56.7f ps=0.675u w=0.36u l=0.28u
X1240 a_1399_n2146.t10 RB7.t12 a_661_5318# VSS nfet_03v3 ad=0.1584p pd=1.6u as=0.1152p ps=1u w=0.36u l=0.28u
X1241 a_7308_3750# a_n884_3750.t11 a_7120_3750# VDD pfet_03v3 ad=0.1278p pd=1.07u as=0.2097p ps=1.38u w=0.36u l=0.28u
X1242 a_17008_3750# a_16944_n708.t10 VDD VDD pfet_03v3 ad=0.2097p pd=1.38u as=0.3168p ps=2.32u w=0.72u l=0.28u
X1243 a_12450_2686# a_12386_2496# a_12252_2182# VDD pfet_03v3 ad=56.7f pd=0.675u as=0.1278p ps=1.07u w=0.36u l=0.28u
X1244 a_3871_n2146.t15 a_3866_n12# a_3133_n170# VDD.t2400 pfet_03v3 ad=0.1584p pd=1.6u as=0.1152p ps=1u w=0.36u l=0.28u
X1245 a_7308_614# a_n884_614.t15 a_7120_614# VDD pfet_03v3 ad=0.1278p pd=1.07u as=0.2097p ps=1.38u w=0.36u l=0.28u
X1246 VDD a_n108_1398# a_26_1588# VDD pfet_03v3 ad=0.1764p pd=1.26u as=0.1584p ps=1.6u w=0.36u l=0.28u
X1247 a_17008_614# a_16944_n708.t11 VDD VDD pfet_03v3 ad=0.2097p pd=1.38u as=0.3168p ps=2.32u w=0.72u l=0.28u
X1248 a_n1652_606# WE13.t0 VSS VSS nfet_03v3 ad=0.1872p pd=1.24u as=0.3168p ps=2.32u w=0.72u l=0.28u
X1249 VDD RB4.t8 a_1394_7828# VDD pfet_03v3 ad=0.3168p pd=2.32u as=0.3708p ps=2.47u w=0.72u l=0.28u
X1250 VSS a_27084_2182# a_27218_2496# VSS nfet_03v3 ad=97.2f pd=0.9u as=0.1584p ps=1.6u w=0.36u l=0.28u
X1251 a_33101_8546# RA3.t8 VDD VDD pfet_03v3 ad=0.3888p pd=2.52u as=0.3312p ps=2.36u w=0.72u l=0.28u
X1252 a_30629_6102# RA6.t14 VDD VDD pfet_03v3 ad=0.3888p pd=2.52u as=0.3312p ps=2.36u w=0.72u l=0.28u
X1253 a_12512_n1738# a_12008_n1782# VDD VDD pfet_03v3 ad=0.1584p pd=1.6u as=0.1584p ps=1.6u w=0.36u l=0.28u
X1254 VDD RB8.t9 a_1394_4692# VDD pfet_03v3 ad=0.3168p pd=2.32u as=0.3708p ps=2.47u w=0.72u l=0.28u
X1255 VSS RB11.t13 a_33530_2528# VSS nfet_03v3 ad=0.1584p pd=1.6u as=0.1854p ps=1.75u w=0.36u l=0.28u
X1256 a_31840_n954# a_31776_n708.t12 VDD.t1294 VDD.t1293 pfet_03v3 ad=0.2097p pd=1.38u as=0.3168p ps=2.32u w=0.72u l=0.28u
X1257 VSS.t2365 a_36972_n954# a_37106_n640# VSS nfet_03v3 ad=97.2f pd=0.9u as=0.1584p ps=1.6u w=0.36u l=0.28u
X1258 a_26119_n2146.t19 a_26114_n608# a_25381_n954# VDD.t2405 pfet_03v3 ad=0.1584p pd=1.6u as=0.1152p ps=1u w=0.36u l=0.28u
X1259 VSS a_14724_1398# a_14858_1588# VSS nfet_03v3 ad=97.2f pd=0.9u as=0.1584p ps=1.6u w=0.36u l=0.28u
X1260 a_24424_1398# a_24360_n708.t16 VDD VDD pfet_03v3 ad=0.2097p pd=1.38u as=0.3168p ps=2.32u w=0.72u l=0.28u
X1261 a_12064_10806# a_12000_n708.t10 VDD VDD pfet_03v3 ad=0.2097p pd=1.38u as=0.3168p ps=2.32u w=0.72u l=0.28u
X1262 VSS a_n884_9238.t9 a_19866_9742# VSS nfet_03v3 ad=0.1584p pd=1.6u as=56.7f ps=0.675u w=0.36u l=0.28u
X1263 VDD a_12252_5318# a_12386_5632# VDD pfet_03v3 ad=0.1764p pd=1.26u as=0.1584p ps=1.6u w=0.36u l=0.28u
X1264 a_23213_4534# RA8.t10 VSS VSS nfet_03v3 ad=0.1944p pd=1.8u as=0.1656p ps=1.64u w=0.36u l=0.28u
X1265 a_14724_n954# a_n884_n954.t12 a_14536_n954# VDD.t1348 pfet_03v3 ad=0.1278p pd=1.07u as=0.2097p ps=1.38u w=0.36u l=0.28u
X1266 VSS a_n884_6102.t6 a_19866_6606# VSS nfet_03v3 ad=0.1584p pd=1.6u as=56.7f ps=0.675u w=0.36u l=0.28u
X1267 a_17394_2966# a_17330_3156# a_17196_2966# VDD pfet_03v3 ad=56.7f pd=0.675u as=0.1278p ps=1.07u w=0.36u l=0.28u
X1268 a_32797_2966# a_33101_2966# a_33265_n862.t24 VDD pfet_03v3 ad=0.1152p pd=1u as=0.1584p ps=1.6u w=0.36u l=0.28u
X1269 a_8815_n2146.t15 a_8810_n608# a_8077_n954# VDD.t2490 pfet_03v3 ad=0.1584p pd=1.6u as=0.1152p ps=1u w=0.36u l=0.28u
X1270 a_13759_n2146.t25 a_13754_7232# a_13021_6886# VDD pfet_03v3 ad=0.1584p pd=1.6u as=0.1152p ps=1u w=0.36u l=0.28u
X1271 a_27853_6886# a_28157_6978# a_28321_n862.t25 VDD pfet_03v3 ad=0.1152p pd=1u as=0.1584p ps=1.6u w=0.36u l=0.28u
X1272 a_22140_2182# a_n884_2182.t14 a_21952_2182# VDD pfet_03v3 ad=0.1278p pd=1.07u as=0.2097p ps=1.38u w=0.36u l=0.28u
X1273 a_2562_6886# a_2498_7200# a_2364_6886# VSS nfet_03v3 ad=56.7f pd=0.675u as=0.1278p ps=1.07u w=0.36u l=0.28u
X1274 VSS RB5.t8 a_11282_7232# VSS nfet_03v3 ad=0.1584p pd=1.6u as=0.1854p ps=1.75u w=0.36u l=0.28u
X1275 a_13759_n2146.t28 a_13754_4096# a_13021_3750# VDD pfet_03v3 ad=0.1584p pd=1.6u as=0.1152p ps=1u w=0.36u l=0.28u
X1276 a_27853_3750# a_28157_3842# a_28321_n862.t26 VDD pfet_03v3 ad=0.1152p pd=1u as=0.1584p ps=1.6u w=0.36u l=0.28u
X1277 a_35269_614# RA13.t12 a_35737_n862.t6 VSS nfet_03v3 ad=0.1152p pd=1u as=0.1584p ps=1.6u w=0.36u l=0.28u
X1278 a_30629_1398# RA12.t12 VSS VSS nfet_03v3 ad=0.1944p pd=1.8u as=0.1656p ps=1.64u w=0.36u l=0.28u
X1279 VSS a_n884_6886.t16 a_37170_6886# VSS nfet_03v3 ad=0.1584p pd=1.6u as=56.7f ps=0.675u w=0.36u l=0.28u
X1280 a_13021_2966# a_12252_2966# VSS VSS nfet_03v3 ad=0.18p pd=1.72u as=97.2f ps=0.9u w=0.36u l=0.28u
X1281 a_13759_n2146.t26 a_13754_960# a_13021_614# VDD pfet_03v3 ad=0.1584p pd=1.6u as=0.1152p ps=1u w=0.36u l=0.28u
X1282 VSS RB0.t12 a_18698_10964# VSS nfet_03v3 ad=0.1584p pd=1.6u as=0.1854p ps=1.75u w=0.36u l=0.28u
X1283 a_28157_n862# RA15.t7 VDD.t438 VDD.t437 pfet_03v3 ad=0.3888p pd=2.52u as=0.3312p ps=2.36u w=0.72u l=0.28u
X1284 a_27853_614# a_28157_706# a_28321_n862.t23 VDD pfet_03v3 ad=0.1152p pd=1u as=0.1584p ps=1.6u w=0.36u l=0.28u
X1285 VDD RB5.t9 a_16226_7232# VDD pfet_03v3 ad=0.3168p pd=2.32u as=0.3708p ps=2.47u w=0.72u l=0.28u
X1286 a_15493_6102# a_14724_6102# VDD VDD pfet_03v3 ad=0.36p pd=2.44u as=0.1764p ps=1.26u w=0.72u l=0.28u
X1287 a_26896_7670# a_26832_n708.t9 VDD VDD pfet_03v3 ad=0.2097p pd=1.38u as=0.3168p ps=2.32u w=0.72u l=0.28u
X1288 a_31063_n2146.t10 RB7.t13 a_30325_5318# VSS nfet_03v3 ad=0.1584p pd=1.6u as=0.1152p ps=1u w=0.36u l=0.28u
X1289 a_17196_8454# a_n884_8454.t10 a_17008_8454# VDD pfet_03v3 ad=0.1278p pd=1.07u as=0.2097p ps=1.38u w=0.36u l=0.28u
X1290 a_18703_n2146.t31 a_18698_7828# a_17965_7670# VDD pfet_03v3 ad=0.1584p pd=1.6u as=0.1152p ps=1u w=0.36u l=0.28u
X1291 a_26896_4534# a_26832_n708.t10 VDD VDD pfet_03v3 ad=0.2097p pd=1.38u as=0.3168p ps=2.32u w=0.72u l=0.28u
X1292 a_27084_2966# a_n884_2966.t8 a_26896_2966# VDD pfet_03v3 ad=0.1278p pd=1.07u as=0.2097p ps=1.38u w=0.36u l=0.28u
X1293 a_25381_5318# a_24612_5318# VDD VDD pfet_03v3 ad=0.36p pd=2.44u as=0.1764p ps=1.26u w=0.72u l=0.28u
X1294 a_14536_3750# a_14472_n708.t9 VDD VDD pfet_03v3 ad=0.2097p pd=1.38u as=0.3168p ps=2.32u w=0.72u l=0.28u
X1295 a_35573_3842# RA9.t10 VSS VSS nfet_03v3 ad=0.1944p pd=1.8u as=0.1656p ps=1.64u w=0.36u l=0.28u
X1296 VDD a_17196_9238# a_17330_9428# VDD pfet_03v3 ad=0.1764p pd=1.26u as=0.1584p ps=1.6u w=0.36u l=0.28u
X1297 VDD RB4.t9 a_31058_7828# VDD pfet_03v3 ad=0.3168p pd=2.32u as=0.3708p ps=2.47u w=0.72u l=0.28u
X1298 a_18703_n2146.t19 a_18698_4692# a_17965_4534# VDD pfet_03v3 ad=0.1584p pd=1.6u as=0.1152p ps=1u w=0.36u l=0.28u
X1299 a_14536_614# a_14472_n708.t10 VDD VDD pfet_03v3 ad=0.2097p pd=1.38u as=0.3168p ps=2.32u w=0.72u l=0.28u
X1300 a_33535_n2146.t4 RB2.t8 a_32797_9238# VSS nfet_03v3 ad=0.1584p pd=1.6u as=0.1152p ps=1u w=0.36u l=0.28u
X1301 a_17965_3750# a_17196_3750# VSS VSS nfet_03v3 ad=0.18p pd=1.72u as=97.2f ps=0.9u w=0.36u l=0.28u
X1302 a_25381_2182# a_24612_2182# VDD VDD pfet_03v3 ad=0.36p pd=2.44u as=0.1764p ps=1.26u w=0.72u l=0.28u
X1303 a_22338_11310# a_22274_10996# a_22140_10806# VSS nfet_03v3 ad=56.7f pd=0.675u as=0.1278p ps=1.07u w=0.36u l=0.28u
X1304 a_13021_5318# a_13325_5410# a_13489_n862.t21 VDD pfet_03v3 ad=0.1152p pd=1u as=0.1584p ps=1.6u w=0.36u l=0.28u
X1305 VDD RB8.t10 a_31058_4692# VDD pfet_03v3 ad=0.3168p pd=2.32u as=0.3708p ps=2.47u w=0.72u l=0.28u
X1306 VSS a_24612_2182# a_24746_2496# VSS nfet_03v3 ad=97.2f pd=0.9u as=0.1584p ps=1.6u w=0.36u l=0.28u
X1307 a_32226_10806# a_32162_10996# a_32028_10806# VDD pfet_03v3 ad=56.7f pd=0.675u as=0.1278p ps=1.07u w=0.36u l=0.28u
X1308 a_1399_n2146.t9 RB2.t9 a_661_9238# VSS nfet_03v3 ad=0.1584p pd=1.6u as=0.1152p ps=1u w=0.36u l=0.28u
X1309 a_37741_9238# a_36972_9238# VDD VDD pfet_03v3 ad=0.36p pd=2.44u as=0.1764p ps=1.26u w=0.72u l=0.28u
X1310 a_33535_n2146.t10 RB6.t11 a_32797_6102# VSS nfet_03v3 ad=0.1584p pd=1.6u as=0.1152p ps=1u w=0.36u l=0.28u
X1311 a_90_1902# a_26_1588# a_n108_1398# VSS nfet_03v3 ad=56.7f pd=0.675u as=0.1278p ps=1.07u w=0.36u l=0.28u
X1312 a_17008_n954# a_16944_n708.t12 VSS.t924 VSS nfet_03v3 ad=0.1188p pd=1.02u as=0.1584p ps=1.6u w=0.36u l=0.28u
X1313 VSS RB4.t10 a_18698_7828# VSS nfet_03v3 ad=0.1584p pd=1.6u as=0.1854p ps=1.75u w=0.36u l=0.28u
X1314 a_9978_7390# a_9914_7200# a_9780_6886# VDD pfet_03v3 ad=56.7f pd=0.675u as=0.1278p ps=1.07u w=0.36u l=0.28u
X1315 a_10549_2182# a_10853_2274# a_11017_n862.t28 VDD pfet_03v3 ad=0.1152p pd=1u as=0.1584p ps=1.6u w=0.36u l=0.28u
X1316 a_1399_n2146.t8 RB6.t12 a_661_6102# VSS nfet_03v3 ad=0.1584p pd=1.6u as=0.1152p ps=1u w=0.36u l=0.28u
X1317 a_n296_6102# a_n360_n708.t12 VDD VDD pfet_03v3 ad=0.2097p pd=1.38u as=0.3168p ps=2.32u w=0.72u l=0.28u
X1318 a_9978_4254# a_9914_4064# a_9780_3750# VDD pfet_03v3 ad=56.7f pd=0.675u as=0.1278p ps=1.07u w=0.36u l=0.28u
X1319 a_10549_10022# a_9780_10022# VDD VDD pfet_03v3 ad=0.36p pd=2.44u as=0.1764p ps=1.26u w=0.72u l=0.28u
X1320 VSS a_n884_9238.t10 a_17394_9742# VSS nfet_03v3 ad=0.1584p pd=1.6u as=56.7f ps=0.675u w=0.36u l=0.28u
X1321 VSS a_7308_2182# a_7442_2496# VSS nfet_03v3 ad=97.2f pd=0.9u as=0.1584p ps=1.6u w=0.36u l=0.28u
X1322 a_36972_2182# a_n884_2182.t15 a_36784_2182# VDD pfet_03v3 ad=0.1278p pd=1.07u as=0.2097p ps=1.38u w=0.36u l=0.28u
X1323 a_12252_n954# a_n884_n954.t13 a_12064_n954# VDD.t1349 pfet_03v3 ad=0.1278p pd=1.07u as=0.2097p ps=1.38u w=0.36u l=0.28u
X1324 a_37170_614# a_37106_928# a_36972_614# VSS nfet_03v3 ad=56.7f pd=0.675u as=0.1278p ps=1.07u w=0.36u l=0.28u
X1325 a_9978_1118# a_9914_928# a_9780_614# VDD pfet_03v3 ad=56.7f pd=0.675u as=0.1278p ps=1.07u w=0.36u l=0.28u
X1326 a_12064_8454# a_12000_n708.t11 VSS VSS nfet_03v3 ad=0.1188p pd=1.02u as=0.1584p ps=1.6u w=0.36u l=0.28u
X1327 VSS a_n884_6102.t7 a_17394_6606# VSS nfet_03v3 ad=0.1584p pd=1.6u as=56.7f ps=0.675u w=0.36u l=0.28u
X1328 a_n108_2966# a_n1204_2966.t15 a_n296_2966# VSS nfet_03v3 ad=0.1278p pd=1.07u as=0.1188p ps=1.02u w=0.36u l=0.28u
X1329 a_6343_n2146.t25 a_6338_n608# a_5605_n954# VDD.t3049 pfet_03v3 ad=0.1584p pd=1.6u as=0.1152p ps=1u w=0.36u l=0.28u
X1330 a_12064_5318# a_12000_n708.t12 VSS VSS nfet_03v3 ad=0.1188p pd=1.02u as=0.1584p ps=1.6u w=0.36u l=0.28u
X1331 a_24810_614# a_24746_928# a_24612_614# VSS nfet_03v3 ad=56.7f pd=0.675u as=0.1278p ps=1.07u w=0.36u l=0.28u
X1332 a_10853_6978# RA5.t11 VDD VDD pfet_03v3 ad=0.3888p pd=2.52u as=0.3312p ps=2.36u w=0.72u l=0.28u
X1333 VSS RB10.t11 a_33530_3124# VSS nfet_03v3 ad=0.1584p pd=1.6u as=0.1854p ps=1.75u w=0.36u l=0.28u
X1334 a_10549_2966# a_9780_2966# VSS VSS nfet_03v3 ad=0.18p pd=1.72u as=97.2f ps=0.9u w=0.36u l=0.28u
X1335 VSS a_n884_2966.t9 a_22338_3470# VSS nfet_03v3 ad=0.1584p pd=1.6u as=56.7f ps=0.675u w=0.36u l=0.28u
X1336 VSS a_14724_10022# a_14858_10336# VSS nfet_03v3 ad=97.2f pd=0.9u as=0.1584p ps=1.6u w=0.36u l=0.28u
X1337 a_17965_3750# RA9.t11 a_18433_n862.t12 VSS nfet_03v3 ad=0.1152p pd=1u as=0.1584p ps=1.6u w=0.36u l=0.28u
X1338 VSS a_n884_10806.t13 a_37170_11310# VSS nfet_03v3 ad=0.1584p pd=1.6u as=56.7f ps=0.675u w=0.36u l=0.28u
X1339 a_31063_n2146.t5 RB1.t12 a_30325_10022# VSS nfet_03v3 ad=0.1584p pd=1.6u as=0.1152p ps=1u w=0.36u l=0.28u
X1340 VDD RB5.t10 a_13754_7232# VDD pfet_03v3 ad=0.3168p pd=2.32u as=0.3708p ps=2.47u w=0.72u l=0.28u
X1341 a_7506_614# a_7442_928# a_7308_614# VSS nfet_03v3 ad=56.7f pd=0.675u as=0.1278p ps=1.07u w=0.36u l=0.28u
X1342 VDD a_n1204_10022.t11 a_7506_10526# VDD pfet_03v3 ad=0.1584p pd=1.6u as=56.7f ps=0.675u w=0.36u l=0.28u
X1343 a_35573_9238# RA2.t13 VDD VDD pfet_03v3 ad=0.3888p pd=2.52u as=0.3312p ps=2.36u w=0.72u l=0.28u
X1344 VSS a_n884_8454.t11 a_14922_8454# VSS nfet_03v3 ad=0.1584p pd=1.6u as=56.7f ps=0.675u w=0.36u l=0.28u
X1345 a_24810_2686# a_24746_2496# a_24612_2182# VDD pfet_03v3 ad=56.7f pd=0.675u as=0.1278p ps=1.07u w=0.36u l=0.28u
X1346 VDD.t2788 a_n108_n170# a_26_20# VDD.t2675 pfet_03v3 ad=0.1764p pd=1.26u as=0.1584p ps=1.6u w=0.36u l=0.28u
X1347 a_8381_n862# RA15.t8 VDD.t440 VDD.t439 pfet_03v3 ad=0.3888p pd=2.52u as=0.3312p ps=2.36u w=0.72u l=0.28u
X1348 a_32028_10022# a_n884_10022.t8 a_31840_10022# VDD pfet_03v3 ad=0.1278p pd=1.07u as=0.2097p ps=1.38u w=0.36u l=0.28u
X1349 VSS a_n884_5318.t10 a_14922_5318# VSS nfet_03v3 ad=0.1584p pd=1.6u as=56.7f ps=0.675u w=0.36u l=0.28u
X1350 VSS.t2854 a_9536_n1782# a_9528_n708.t3 VSS nfet_03v3 ad=0.2728p pd=2.12u as=0.1612p ps=1.14u w=0.62u l=0.28u
X1351 a_16231_n2146.t19 a_16226_7828# a_15493_7670# VDD pfet_03v3 ad=0.1584p pd=1.6u as=0.1152p ps=1u w=0.36u l=0.28u
X1352 a_33101_3842# RA9.t12 VSS VSS nfet_03v3 ad=0.1944p pd=1.8u as=0.1656p ps=1.64u w=0.36u l=0.28u
X1353 a_36007_n2146.t29 a_36002_10964# a_35269_10806# VDD pfet_03v3 ad=0.1584p pd=1.6u as=0.1152p ps=1u w=0.36u l=0.28u
X1354 a_13325_7670# RA4.t8 VSS VSS nfet_03v3 ad=0.1944p pd=1.8u as=0.1656p ps=1.64u w=0.36u l=0.28u
X1355 a_16231_n2146.t17 a_16226_4692# a_15493_4534# VDD pfet_03v3 ad=0.1584p pd=1.6u as=0.1152p ps=1u w=0.36u l=0.28u
X1356 VDD a_14724_9238# a_14858_9428# VDD pfet_03v3 ad=0.1764p pd=1.26u as=0.1584p ps=1.6u w=0.36u l=0.28u
X1357 a_15493_3750# a_14724_3750# VSS VSS nfet_03v3 ad=0.18p pd=1.72u as=97.2f ps=0.9u w=0.36u l=0.28u
X1358 a_24424_n170# a_24360_n708.t17 VDD.t1731 VDD.t1730 pfet_03v3 ad=0.2097p pd=1.38u as=0.3168p ps=2.32u w=0.72u l=0.28u
X1359 a_17965_10806# a_18269_10806# a_18433_n862.t25 VDD pfet_03v3 ad=0.1152p pd=1u as=0.1584p ps=1.6u w=0.36u l=0.28u
X1360 VSS a_32028_10022# a_32162_10336# VSS nfet_03v3 ad=97.2f pd=0.9u as=0.1584p ps=1.6u w=0.36u l=0.28u
X1361 a_31063_n2146.t9 RB2.t10 a_30325_9238# VSS nfet_03v3 ad=0.1584p pd=1.6u as=0.1152p ps=1u w=0.36u l=0.28u
X1362 a_14472_n708.t0 a_14480_n1782# VDD VDD pfet_03v3 ad=0.3224p pd=1.76u as=0.5456p ps=3.36u w=1.24u l=0.28u
X1363 VSS a_27084_1398# a_27218_1588# VSS nfet_03v3 ad=97.2f pd=0.9u as=0.1584p ps=1.6u w=0.36u l=0.28u
X1364 a_31063_n2146.t8 RB6.t13 a_30325_6102# VSS nfet_03v3 ad=0.1584p pd=1.6u as=0.1152p ps=1u w=0.36u l=0.28u
X1365 VDD RB9.t9 a_1394_4096# VDD pfet_03v3 ad=0.3168p pd=2.32u as=0.3708p ps=2.47u w=0.72u l=0.28u
X1366 a_14536_n954# a_14472_n708.t11 VSS.t891 VSS nfet_03v3 ad=0.1188p pd=1.02u as=0.1584p ps=1.6u w=0.36u l=0.28u
X1367 a_35269_614# a_34500_614# VSS VSS nfet_03v3 ad=0.18p pd=1.72u as=97.2f ps=0.9u w=0.36u l=0.28u
X1368 a_36784_1398# a_36720_n708.t16 VDD VDD pfet_03v3 ad=0.2097p pd=1.38u as=0.3168p ps=2.32u w=0.72u l=0.28u
X1369 a_7506_7390# a_7442_7200# a_7308_6886# VDD pfet_03v3 ad=56.7f pd=0.675u as=0.1278p ps=1.07u w=0.36u l=0.28u
X1370 a_5605_5318# a_4836_5318# VDD VDD pfet_03v3 ad=0.36p pd=2.44u as=0.1764p ps=1.26u w=0.72u l=0.28u
X1371 a_30325_10022# RA1.t11 a_30793_n862.t0 VSS nfet_03v3 ad=0.1152p pd=1u as=0.1584p ps=1.6u w=0.36u l=0.28u
X1372 a_35573_4534# RA8.t11 VSS VSS nfet_03v3 ad=0.1944p pd=1.8u as=0.1656p ps=1.64u w=0.36u l=0.28u
X1373 a_22909_614# a_22140_614# VSS VSS nfet_03v3 ad=0.18p pd=1.72u as=97.2f ps=0.9u w=0.36u l=0.28u
X1374 VSS RB13.t11 a_6338_960# VSS nfet_03v3 ad=0.1584p pd=1.6u as=0.1854p ps=1.75u w=0.36u l=0.28u
X1375 VDD RB13.t12 a_1394_960# VDD pfet_03v3 ad=0.3168p pd=2.32u as=0.3708p ps=2.47u w=0.72u l=0.28u
X1376 a_12064_10022# a_12000_n708.t13 VDD VDD pfet_03v3 ad=0.2097p pd=1.38u as=0.3168p ps=2.32u w=0.72u l=0.28u
X1377 a_7506_4254# a_7442_4064# a_7308_3750# VDD pfet_03v3 ad=56.7f pd=0.675u as=0.1278p ps=1.07u w=0.36u l=0.28u
X1378 a_5605_2182# a_4836_2182# VDD VDD pfet_03v3 ad=0.36p pd=2.44u as=0.1764p ps=1.26u w=0.72u l=0.28u
X1379 a_17394_11310# a_17330_10996# a_17196_10806# VSS nfet_03v3 ad=56.7f pd=0.675u as=0.1278p ps=1.07u w=0.36u l=0.28u
X1380 a_19866_8958# a_19802_8768# a_19668_8454# VDD pfet_03v3 ad=56.7f pd=0.675u as=0.1278p ps=1.07u w=0.36u l=0.28u
X1381 VSS a_4836_2182# a_4970_2496# VSS nfet_03v3 ad=97.2f pd=0.9u as=0.1584p ps=1.6u w=0.36u l=0.28u
X1382 VSS a_n884_614.t16 a_37170_614# VSS nfet_03v3 ad=0.1584p pd=1.6u as=56.7f ps=0.675u w=0.36u l=0.28u
X1383 a_661_614# RA13.t13 a_1129_n862.t5 VSS nfet_03v3 ad=0.1152p pd=1u as=0.1584p ps=1.6u w=0.36u l=0.28u
X1384 a_27282_10806# a_27218_10996# a_27084_10806# VDD pfet_03v3 ad=56.7f pd=0.675u as=0.1278p ps=1.07u w=0.36u l=0.28u
X1385 a_n1652_8886# CLK a_n1652_8446# VSS nfet_03v3 ad=0.3168p pd=2.32u as=0.1872p ps=1.24u w=0.72u l=0.28u
X1386 VSS a_17196_6886# a_17330_7200# VSS nfet_03v3 ad=97.2f pd=0.9u as=0.1584p ps=1.6u w=0.36u l=0.28u
X1387 a_4836_5318# a_n884_5318.t11 a_4648_5318# VDD pfet_03v3 ad=0.1278p pd=1.07u as=0.2097p ps=1.38u w=0.36u l=0.28u
X1388 a_n1652_4534# CLK a_n1652_4974# VSS nfet_03v3 ad=0.3168p pd=2.32u as=0.1872p ps=1.24u w=0.72u l=0.28u
X1389 a_34500_2182# a_n884_2182.t16 a_34312_2182# VDD pfet_03v3 ad=0.1278p pd=1.07u as=0.2097p ps=1.38u w=0.36u l=0.28u
X1390 a_7506_1118# a_7442_928# a_7308_614# VDD pfet_03v3 ad=56.7f pd=0.675u as=0.1278p ps=1.07u w=0.36u l=0.28u
X1391 VSS RB7.t14 a_16226_5664# VSS nfet_03v3 ad=0.1584p pd=1.6u as=0.1854p ps=1.75u w=0.36u l=0.28u
X1392 VSS RB5.t11 a_23642_7232# VSS nfet_03v3 ad=0.1584p pd=1.6u as=0.1854p ps=1.75u w=0.36u l=0.28u
X1393 a_37741_6886# a_36972_6886# VSS VSS nfet_03v3 ad=0.18p pd=1.72u as=97.2f ps=0.9u w=0.36u l=0.28u
X1394 VDD a_22140_5318# a_22274_5632# VDD pfet_03v3 ad=0.1764p pd=1.26u as=0.1584p ps=1.6u w=0.36u l=0.28u
X1395 a_n1652_1398# CLK a_n1652_1838# VSS nfet_03v3 ad=0.3168p pd=2.32u as=0.1872p ps=1.24u w=0.72u l=0.28u
X1396 VSS a_36972_614# a_37106_928# VSS nfet_03v3 ad=97.2f pd=0.9u as=0.1584p ps=1.6u w=0.36u l=0.28u
X1397 VSS a_n884_614.t17 a_24810_614# VSS nfet_03v3 ad=0.1584p pd=1.6u as=56.7f ps=0.675u w=0.36u l=0.28u
X1398 a_35269_10806# a_35573_10806# a_35737_n862.t18 VDD pfet_03v3 ad=0.1152p pd=1u as=0.1584p ps=1.6u w=0.36u l=0.28u
X1399 a_17965_9238# a_18269_9238# a_18433_n862.t29 VDD pfet_03v3 ad=0.1152p pd=1u as=0.1584p ps=1.6u w=0.36u l=0.28u
X1400 a_36007_n2146.t9 RB3.t8 a_35269_8454# VSS nfet_03v3 ad=0.1584p pd=1.6u as=0.1152p ps=1u w=0.36u l=0.28u
X1401 VDD a_19668_2182# a_19802_2496# VDD pfet_03v3 ad=0.1764p pd=1.26u as=0.1584p ps=1.6u w=0.36u l=0.28u
X1402 a_31776_n708.t0 a_31784_n1782# VDD VDD pfet_03v3 ad=0.3224p pd=1.76u as=0.5456p ps=3.36u w=1.24u l=0.28u
X1403 a_12064_n954# a_12000_n708.t14 VDD.t2099 VDD.t2098 pfet_03v3 ad=0.2097p pd=1.38u as=0.3168p ps=2.32u w=0.72u l=0.28u
X1404 a_17196_n170# a_n1204_n170.t10 a_17008_n170# VSS nfet_03v3 ad=0.1278p pd=1.07u as=0.1188p ps=1.02u w=0.36u l=0.28u
X1405 a_n296_3750# a_n360_n708.t13 VSS VSS nfet_03v3 ad=0.1188p pd=1.02u as=0.1584p ps=1.6u w=0.36u l=0.28u
X1406 a_n1204_2966.t1 a_n1652_2966# VDD VDD pfet_03v3 ad=0.3302p pd=1.79u as=0.5588p ps=3.42u w=1.27u l=0.28u
X1407 a_21952_2966# a_21888_n708.t14 VDD VDD pfet_03v3 ad=0.2097p pd=1.38u as=0.3168p ps=2.32u w=0.72u l=0.28u
X1408 a_30325_n954# a_30629_n862# a_30793_n862.t26 VDD.t3062 pfet_03v3 ad=0.1152p pd=1u as=0.1584p ps=1.6u w=0.36u l=0.28u
X1409 a_30325_614# a_29556_614# VSS VSS nfet_03v3 ad=0.18p pd=1.72u as=97.2f ps=0.9u w=0.36u l=0.28u
X1410 a_14922_n450# a_14858_n640# a_14724_n954# VDD.t2803 pfet_03v3 ad=56.7f pd=0.675u as=0.1278p ps=1.07u w=0.36u l=0.28u
X1411 a_15493_n954# RA15.t9 a_15961_n862.t6 VSS nfet_03v3 ad=0.1152p pd=1u as=0.1584p ps=1.6u w=0.36u l=0.28u
X1412 a_29556_8454# a_n884_8454.t12 a_29368_8454# VDD pfet_03v3 ad=0.1278p pd=1.07u as=0.2097p ps=1.38u w=0.36u l=0.28u
X1413 VSS RB3.t9 a_38474_8800# VSS nfet_03v3 ad=0.1584p pd=1.6u as=0.1854p ps=1.75u w=0.36u l=0.28u
X1414 a_22338_2686# a_22274_2496# a_22140_2182# VDD pfet_03v3 ad=56.7f pd=0.675u as=0.1278p ps=1.07u w=0.36u l=0.28u
X1415 a_n360_n708.t3 a_n352_n1782# VSS.t2712 VSS nfet_03v3 ad=0.1612p pd=1.14u as=0.2728p ps=2.12u w=0.62u l=0.28u
X1416 a_33101_9238# RA2.t14 VDD VDD pfet_03v3 ad=0.3888p pd=2.52u as=0.3312p ps=2.36u w=0.72u l=0.28u
X1417 VDD a_34500_6886# a_34634_7200# VDD pfet_03v3 ad=0.1764p pd=1.26u as=0.1584p ps=1.6u w=0.36u l=0.28u
X1418 a_26896_3750# a_26832_n708.t11 VDD VDD pfet_03v3 ad=0.2097p pd=1.38u as=0.3168p ps=2.32u w=0.72u l=0.28u
X1419 VSS a_n884_2966.t10 a_2562_3470# VSS nfet_03v3 ad=0.1584p pd=1.6u as=56.7f ps=0.675u w=0.36u l=0.28u
X1420 a_32028_1398# a_n884_1398.t16 a_31840_1398# VDD pfet_03v3 ad=0.1278p pd=1.07u as=0.2097p ps=1.38u w=0.36u l=0.28u
X1421 a_32797_10806# a_32028_10806# VSS VSS nfet_03v3 ad=0.18p pd=1.72u as=97.2f ps=0.9u w=0.36u l=0.28u
X1422 VSS a_n884_614.t18 a_32226_614# VSS nfet_03v3 ad=0.1584p pd=1.6u as=56.7f ps=0.675u w=0.36u l=0.28u
X1423 a_26896_614# a_26832_n708.t12 VDD VDD pfet_03v3 ad=0.2097p pd=1.38u as=0.3168p ps=2.32u w=0.72u l=0.28u
X1424 a_90_9238# a_26_9428# a_n108_9238# VDD pfet_03v3 ad=56.7f pd=0.675u as=0.1278p ps=1.07u w=0.36u l=0.28u
X1425 a_17965_4534# RA8.t12 a_18433_n862.t6 VSS nfet_03v3 ad=0.1152p pd=1u as=0.1584p ps=1.6u w=0.36u l=0.28u
X1426 VDD a_34500_3750# a_34634_4064# VDD pfet_03v3 ad=0.1764p pd=1.26u as=0.1584p ps=1.6u w=0.36u l=0.28u
X1427 a_25381_5318# a_25685_5410# a_25849_n862.t22 VDD pfet_03v3 ad=0.1152p pd=1u as=0.1584p ps=1.6u w=0.36u l=0.28u
X1428 VSS a_36972_2182# a_37106_2496# VSS nfet_03v3 ad=97.2f pd=0.9u as=0.1584p ps=1.6u w=0.36u l=0.28u
X1429 VDD a_34500_614# a_34634_928# VDD pfet_03v3 ad=0.1764p pd=1.26u as=0.1584p ps=1.6u w=0.36u l=0.28u
X1430 VSS a_n884_10806.t14 a_2562_11310# VSS nfet_03v3 ad=0.1584p pd=1.6u as=56.7f ps=0.675u w=0.36u l=0.28u
X1431 a_31063_n2146.t11 RB0.t13 a_30325_10806# VSS nfet_03v3 ad=0.1584p pd=1.6u as=0.1152p ps=1u w=0.36u l=0.28u
X1432 VDD RB9.t10 a_31058_4096# VDD pfet_03v3 ad=0.3168p pd=2.32u as=0.3708p ps=2.47u w=0.72u l=0.28u
X1433 a_5034_2686# a_4970_2496# a_4836_2182# VDD pfet_03v3 ad=56.7f pd=0.675u as=0.1278p ps=1.07u w=0.36u l=0.28u
X1434 VSS a_32028_614# a_32162_928# VSS nfet_03v3 ad=97.2f pd=0.9u as=0.1584p ps=1.6u w=0.36u l=0.28u
X1435 a_3437_10114# RA1.t12 VSS VSS nfet_03v3 ad=0.1944p pd=1.8u as=0.1656p ps=1.64u w=0.36u l=0.28u
X1436 a_4648_7670# a_4584_n708.t7 VDD VDD pfet_03v3 ad=0.2097p pd=1.38u as=0.3168p ps=2.32u w=0.72u l=0.28u
X1437 a_12252_n170# a_n1204_n170.t11 a_12064_n170# VSS nfet_03v3 ad=0.1278p pd=1.07u as=0.1188p ps=1.02u w=0.36u l=0.28u
X1438 a_4648_4534# a_4584_n708.t8 VDD VDD pfet_03v3 ad=0.2097p pd=1.38u as=0.3168p ps=2.32u w=0.72u l=0.28u
X1439 a_18269_2966# RA10.t8 VDD VDD pfet_03v3 ad=0.3888p pd=2.52u as=0.3312p ps=2.36u w=0.72u l=0.28u
X1440 VDD RB13.t13 a_31058_960# VDD pfet_03v3 ad=0.3168p pd=2.32u as=0.3708p ps=2.47u w=0.72u l=0.28u
X1441 a_34312_1398# a_34248_n708.t16 VDD VDD pfet_03v3 ad=0.2097p pd=1.38u as=0.3168p ps=2.32u w=0.72u l=0.28u
X1442 VSS a_24612_1398# a_24746_1588# VSS nfet_03v3 ad=97.2f pd=0.9u as=0.1584p ps=1.6u w=0.36u l=0.28u
X1443 a_965_10806# RA0.t11 VDD VDD pfet_03v3 ad=0.3888p pd=2.52u as=0.3312p ps=2.36u w=0.72u l=0.28u
X1444 VSS a_n884_9238.t11 a_29754_9742# VSS nfet_03v3 ad=0.1584p pd=1.6u as=56.7f ps=0.675u w=0.36u l=0.28u
X1445 a_n1652_5310# WE7.t0 VSS VSS nfet_03v3 ad=0.1872p pd=1.24u as=0.3168p ps=2.32u w=0.72u l=0.28u
X1446 a_3133_5318# a_2364_5318# VDD VDD pfet_03v3 ad=0.36p pd=2.44u as=0.1764p ps=1.26u w=0.72u l=0.28u
X1447 a_10853_5410# RA7.t15 VSS VSS nfet_03v3 ad=0.1944p pd=1.8u as=0.1656p ps=1.64u w=0.36u l=0.28u
X1448 a_24612_n954# a_n884_n954.t14 a_24424_n954# VDD.t1350 pfet_03v3 ad=0.1278p pd=1.07u as=0.2097p ps=1.38u w=0.36u l=0.28u
X1449 a_33101_4534# RA8.t13 VSS VSS nfet_03v3 ad=0.1944p pd=1.8u as=0.1656p ps=1.64u w=0.36u l=0.28u
X1450 a_3133_2182# a_2364_2182# VDD VDD pfet_03v3 ad=0.36p pd=2.44u as=0.1764p ps=1.26u w=0.72u l=0.28u
X1451 a_28591_n2146.t3 RB11.t14 a_27853_2182# VSS nfet_03v3 ad=0.1584p pd=1.6u as=0.1152p ps=1u w=0.36u l=0.28u
X1452 a_2176_1398# a_2112_n708.t20 VDD VDD pfet_03v3 ad=0.2097p pd=1.38u as=0.3168p ps=2.32u w=0.72u l=0.28u
X1453 a_8381_10806# RA0.t12 VDD VDD pfet_03v3 ad=0.3888p pd=2.52u as=0.3312p ps=2.36u w=0.72u l=0.28u
X1454 a_34312_10022# a_34248_n708.t17 VSS VSS nfet_03v3 ad=0.1188p pd=1.02u as=0.1584p ps=1.6u w=0.36u l=0.28u
X1455 a_19668_6102# a_n884_6102.t8 a_19480_6102# VDD pfet_03v3 ad=0.1278p pd=1.07u as=0.2097p ps=1.38u w=0.36u l=0.28u
X1456 VSS a_n884_6102.t9 a_29754_6606# VSS nfet_03v3 ad=0.1584p pd=1.6u as=56.7f ps=0.675u w=0.36u l=0.28u
X1457 a_27282_2966# a_27218_3156# a_27084_2966# VDD pfet_03v3 ad=56.7f pd=0.675u as=0.1278p ps=1.07u w=0.36u l=0.28u
X1458 VSS a_7308_1398# a_7442_1588# VSS nfet_03v3 ad=97.2f pd=0.9u as=0.1584p ps=1.6u w=0.36u l=0.28u
X1459 VSS a_14724_6886# a_14858_7200# VSS nfet_03v3 ad=97.2f pd=0.9u as=0.1584p ps=1.6u w=0.36u l=0.28u
X1460 VSS a_n884_614.t19 a_12450_614# VSS nfet_03v3 ad=0.1584p pd=1.6u as=56.7f ps=0.675u w=0.36u l=0.28u
X1461 a_25381_10022# RA1.t13 a_25849_n862.t0 VSS nfet_03v3 ad=0.1152p pd=1u as=0.1584p ps=1.6u w=0.36u l=0.28u
X1462 VSS RB5.t12 a_21170_7232# VSS nfet_03v3 ad=0.1584p pd=1.6u as=0.1854p ps=1.75u w=0.36u l=0.28u
X1463 VSS RB7.t15 a_13754_5664# VSS nfet_03v3 ad=0.1584p pd=1.6u as=0.1854p ps=1.75u w=0.36u l=0.28u
X1464 a_19480_2966# a_19416_n708.t10 VSS VSS nfet_03v3 ad=0.1188p pd=1.02u as=0.1584p ps=1.6u w=0.36u l=0.28u
X1465 VDD.t2772 a_9780_n954# a_9914_n640# VDD.t2771 pfet_03v3 ad=0.1764p pd=1.26u as=0.1584p ps=1.6u w=0.36u l=0.28u
X1466 a_22909_2966# a_22140_2966# VSS VSS nfet_03v3 ad=0.18p pd=1.72u as=97.2f ps=0.9u w=0.36u l=0.28u
X1467 VSS a_12252_614# a_12386_928# VSS nfet_03v3 ad=97.2f pd=0.9u as=0.1584p ps=1.6u w=0.36u l=0.28u
X1468 VDD RB12.t16 a_28586_1556# VDD pfet_03v3 ad=0.3168p pd=2.32u as=0.3708p ps=2.47u w=0.72u l=0.28u
X1469 a_30325_10806# RA0.t13 a_30793_n862.t16 VSS nfet_03v3 ad=0.1152p pd=1u as=0.1584p ps=1.6u w=0.36u l=0.28u
X1470 VSS RB1.t13 a_38474_10368# VSS nfet_03v3 ad=0.1584p pd=1.6u as=0.1854p ps=1.75u w=0.36u l=0.28u
X1471 a_27853_10022# a_27084_10022# VSS VSS nfet_03v3 ad=0.18p pd=1.72u as=97.2f ps=0.9u w=0.36u l=0.28u
X1472 VSS RB2.t11 a_16226_9396# VSS nfet_03v3 ad=0.1584p pd=1.6u as=0.1854p ps=1.75u w=0.36u l=0.28u
X1473 VDD RB5.t13 a_26114_7232# VDD pfet_03v3 ad=0.3168p pd=2.32u as=0.3708p ps=2.47u w=0.72u l=0.28u
X1474 a_25381_6102# a_24612_6102# VDD VDD pfet_03v3 ad=0.36p pd=2.44u as=0.1764p ps=1.26u w=0.72u l=0.28u
X1475 VSS RB6.t14 a_16226_6260# VSS nfet_03v3 ad=0.1584p pd=1.6u as=0.1854p ps=1.75u w=0.36u l=0.28u
X1476 QB7b.t1 a_18703_n2146.t32 VSS VSS nfet_03v3 ad=0.2052p pd=1.86u as=0.1242p ps=1.05u w=0.36u l=0.28u
X1477 a_12450_n450# a_12386_n640# a_12252_n954# VDD.t2804 pfet_03v3 ad=56.7f pd=0.675u as=0.1278p ps=1.07u w=0.36u l=0.28u
X1478 VSS a_n884_2966.t11 a_32226_3470# VSS nfet_03v3 ad=0.1584p pd=1.6u as=56.7f ps=0.675u w=0.36u l=0.28u
X1479 a_11287_n2146.t6 a_11282_3124# a_10549_2966# VDD pfet_03v3 ad=0.1584p pd=1.6u as=0.1152p ps=1u w=0.36u l=0.28u
X1480 a_15493_8454# a_15797_8546# a_15961_n862.t18 VDD pfet_03v3 ad=0.1152p pd=1u as=0.1584p ps=1.6u w=0.36u l=0.28u
X1481 a_35269_5318# a_34500_5318# VDD VDD pfet_03v3 ad=0.36p pd=2.44u as=0.1764p ps=1.26u w=0.72u l=0.28u
X1482 a_661_2966# a_n108_2966# VDD VDD pfet_03v3 ad=0.36p pd=2.44u as=0.1764p ps=1.26u w=0.72u l=0.28u
X1483 a_13325_10806# RA0.t14 VDD VDD pfet_03v3 ad=0.3888p pd=2.52u as=0.3312p ps=2.36u w=0.72u l=0.28u
X1484 VDD a_27084_9238# a_27218_9428# VDD pfet_03v3 ad=0.1764p pd=1.26u as=0.1584p ps=1.6u w=0.36u l=0.28u
X1485 a_25685_7670# RA4.t9 VSS VSS nfet_03v3 ad=0.1944p pd=1.8u as=0.1656p ps=1.64u w=0.36u l=0.28u
X1486 a_17008_2182# a_16944_n708.t13 VSS VSS nfet_03v3 ad=0.1188p pd=1.02u as=0.1584p ps=1.6u w=0.36u l=0.28u
X1487 a_35269_2182# a_34500_2182# VDD VDD pfet_03v3 ad=0.36p pd=2.44u as=0.1764p ps=1.26u w=0.72u l=0.28u
X1488 a_36784_n170# a_36720_n708.t17 VDD.t1764 VDD.t1763 pfet_03v3 ad=0.2097p pd=1.38u as=0.3168p ps=2.32u w=0.72u l=0.28u
X1489 VSS a_19668_614# a_19802_928# VSS nfet_03v3 ad=97.2f pd=0.9u as=0.1584p ps=1.6u w=0.36u l=0.28u
X1490 VSS.t2139 D6.t1 a_15589_n1738# VSS nfet_03v3 ad=0.1584p pd=1.6u as=0.1188p ps=1.02u w=0.36u l=0.28u
X1491 a_22909_5318# a_23213_5410# a_23377_n862.t26 VDD pfet_03v3 ad=0.1152p pd=1u as=0.1584p ps=1.6u w=0.36u l=0.28u
X1492 a_26896_n954# a_26832_n708.t13 VSS.t160 VSS nfet_03v3 ad=0.1188p pd=1.02u as=0.1584p ps=1.6u w=0.36u l=0.28u
X1493 a_9780_8454# a_n884_8454.t13 a_9592_8454# VDD pfet_03v3 ad=0.1278p pd=1.07u as=0.2097p ps=1.38u w=0.36u l=0.28u
X1494 VDD a_n1204_1398.t9 a_n884_1398.t0 VDD pfet_03v3 ad=0.5896p pd=3.56u as=0.3886p ps=1.92u w=1.34u l=0.28u
X1495 a_14536_10806# a_14472_n708.t12 VDD VDD pfet_03v3 ad=0.2097p pd=1.38u as=0.3168p ps=2.32u w=0.72u l=0.28u
X1496 VSS a_25849_n862.t32 QA10b.t1 VSS nfet_03v3 ad=0.1242p pd=1.05u as=0.2052p ps=1.86u w=0.36u l=0.28u
X1497 VDD a_n1204_8454.t10 a_90_8958# VDD pfet_03v3 ad=0.1584p pd=1.6u as=56.7f ps=0.675u w=0.36u l=0.28u
X1498 VSS RB14.t15 a_33530_n12# VSS nfet_03v3 ad=0.1584p pd=1.6u as=0.1854p ps=1.75u w=0.36u l=0.28u
X1499 VSS a_n884_9238.t12 a_27282_9742# VSS nfet_03v3 ad=0.1584p pd=1.6u as=56.7f ps=0.675u w=0.36u l=0.28u
X1500 a_22140_n954# a_n884_n954.t15 a_21952_n954# VDD.t1351 pfet_03v3 ad=0.1278p pd=1.07u as=0.2097p ps=1.38u w=0.36u l=0.28u
X1501 VSS a_n108_10806# a_26_10996# VSS nfet_03v3 ad=97.2f pd=0.9u as=0.1584p ps=1.6u w=0.36u l=0.28u
X1502 a_7506_10526# a_7442_10336# a_7308_10022# VDD pfet_03v3 ad=56.7f pd=0.675u as=0.1278p ps=1.07u w=0.36u l=0.28u
X1503 a_90_6886# a_26_7200# a_n108_6886# VSS nfet_03v3 ad=56.7f pd=0.675u as=0.1278p ps=1.07u w=0.36u l=0.28u
X1504 a_17196_6102# a_n884_6102.t10 a_17008_6102# VDD pfet_03v3 ad=0.1278p pd=1.07u as=0.2097p ps=1.38u w=0.36u l=0.28u
X1505 VSS a_n884_6102.t11 a_27282_6606# VSS nfet_03v3 ad=0.1584p pd=1.6u as=56.7f ps=0.675u w=0.36u l=0.28u
X1506 a_3437_10806# RA0.t15 VSS VSS nfet_03v3 ad=0.1944p pd=1.8u as=0.1656p ps=1.64u w=0.36u l=0.28u
X1507 VSS a_4836_1398# a_4970_1588# VSS nfet_03v3 ad=97.2f pd=0.9u as=0.1584p ps=1.6u w=0.36u l=0.28u
X1508 a_20741_6978# RA5.t12 VDD VDD pfet_03v3 ad=0.3888p pd=2.52u as=0.3312p ps=2.36u w=0.72u l=0.28u
X1509 a_10853_9238# RA2.t15 VSS VSS nfet_03v3 ad=0.1944p pd=1.8u as=0.1656p ps=1.64u w=0.36u l=0.28u
X1510 a_29754_8958# a_29690_8768# a_29556_8454# VDD pfet_03v3 ad=56.7f pd=0.675u as=0.1278p ps=1.07u w=0.36u l=0.28u
X1511 a_20437_7670# a_20741_7670# a_20905_n862.t30 VDD pfet_03v3 ad=0.1152p pd=1u as=0.1584p ps=1.6u w=0.36u l=0.28u
X1512 a_19424_n1782# a_19928_n1738# a_20216_n1738# VDD pfet_03v3 ad=0.1278p pd=1.07u as=56.7f ps=0.675u w=0.36u l=0.28u
X1513 a_21952_10806# a_21888_n708.t15 VSS VSS nfet_03v3 ad=0.1188p pd=1.02u as=0.1584p ps=1.6u w=0.36u l=0.28u
X1514 a_21175_n2146.t28 a_21170_10368# a_20437_10022# VDD pfet_03v3 ad=0.1584p pd=1.6u as=0.1152p ps=1u w=0.36u l=0.28u
X1515 VDD a_2364_5318# a_2498_5632# VDD pfet_03v3 ad=0.1764p pd=1.26u as=0.1584p ps=1.6u w=0.36u l=0.28u
X1516 a_31840_10806# a_31776_n708.t13 VDD VDD pfet_03v3 ad=0.2097p pd=1.38u as=0.3168p ps=2.32u w=0.72u l=0.28u
X1517 a_10853_6102# RA6.t15 VSS VSS nfet_03v3 ad=0.1944p pd=1.8u as=0.1656p ps=1.64u w=0.36u l=0.28u
X1518 a_20437_4534# a_20741_4534# a_20905_n862.t28 VDD pfet_03v3 ad=0.1152p pd=1u as=0.1584p ps=1.6u w=0.36u l=0.28u
X1519 a_20437_2966# a_19668_2966# VSS VSS nfet_03v3 ad=0.18p pd=1.72u as=97.2f ps=0.9u w=0.36u l=0.28u
X1520 a_28591_n2146.t9 RB10.t12 a_27853_2966# VSS nfet_03v3 ad=0.1584p pd=1.6u as=0.1152p ps=1u w=0.36u l=0.28u
X1521 a_n1652_270# WE14.t0 VSS VSS nfet_03v3 ad=0.1872p pd=1.24u as=0.3168p ps=2.32u w=0.72u l=0.28u
X1522 a_3871_n2146.t0 a_3866_7232# a_3133_6886# VDD pfet_03v3 ad=0.1584p pd=1.6u as=0.1152p ps=1u w=0.36u l=0.28u
X1523 a_19668_3750# a_n1204_3750.t10 a_19480_3750# VSS nfet_03v3 ad=0.1278p pd=1.07u as=0.1188p ps=1.02u w=0.36u l=0.28u
X1524 VSS RB2.t12 a_13754_9396# VSS nfet_03v3 ad=0.1584p pd=1.6u as=0.1854p ps=1.75u w=0.36u l=0.28u
X1525 a_3871_n2146.t24 a_3866_4096# a_3133_3750# VDD pfet_03v3 ad=0.1584p pd=1.6u as=0.1152p ps=1u w=0.36u l=0.28u
X1526 a_27853_n954# RA15.t10 a_28321_n862.t4 VSS nfet_03v3 ad=0.1152p pd=1u as=0.1584p ps=1.6u w=0.36u l=0.28u
X1527 a_13759_n2146.t6 RB15.t13 a_13021_n954# VSS nfet_03v3 ad=0.1584p pd=1.6u as=0.1152p ps=1u w=0.36u l=0.28u
X1528 a_965_n862# RA15.t11 VSS.t490 VSS nfet_03v3 ad=0.1944p pd=1.8u as=0.1656p ps=1.64u w=0.36u l=0.28u
X1529 a_32028_n170# a_n884_n170.t9 a_31840_n170# VDD.t1362 pfet_03v3 ad=0.1278p pd=1.07u as=0.2097p ps=1.38u w=0.36u l=0.28u
X1530 a_2364_9238# a_n1204_9238.t20 a_2176_9238# VSS nfet_03v3 ad=0.1278p pd=1.07u as=0.1188p ps=1.02u w=0.36u l=0.28u
X1531 VSS RB6.t15 a_13754_6260# VSS nfet_03v3 ad=0.1584p pd=1.6u as=0.1854p ps=1.75u w=0.36u l=0.28u
X1532 a_34698_2686# a_34634_2496# a_34500_2182# VDD pfet_03v3 ad=56.7f pd=0.675u as=0.1278p ps=1.07u w=0.36u l=0.28u
X1533 a_25381_10806# RA0.t16 a_25849_n862.t11 VSS nfet_03v3 ad=0.1152p pd=1u as=0.1584p ps=1.6u w=0.36u l=0.28u
X1534 VSS a_n884_8454.t14 a_24810_8454# VSS nfet_03v3 ad=0.1584p pd=1.6u as=56.7f ps=0.675u w=0.36u l=0.28u
X1535 a_3871_n2146.t31 a_3866_960# a_3133_614# VDD pfet_03v3 ad=0.1584p pd=1.6u as=0.1152p ps=1u w=0.36u l=0.28u
X1536 a_2364_6102# a_n1204_6102.t13 a_2176_6102# VSS nfet_03v3 ad=0.1278p pd=1.07u as=0.1188p ps=1.02u w=0.36u l=0.28u
X1537 VDD.t3264 CLK a_n1652_n522# VDD.t3244 pfet_03v3 ad=0.3168p pd=2.32u as=0.1872p ps=1.24u w=0.72u l=0.28u
X1538 VSS RB0.t14 a_38474_10964# VSS nfet_03v3 ad=0.1584p pd=1.6u as=0.1854p ps=1.75u w=0.36u l=0.28u
X1539 a_12450_10526# a_12386_10336# a_12252_10022# VDD pfet_03v3 ad=56.7f pd=0.675u as=0.1278p ps=1.07u w=0.36u l=0.28u
X1540 a_26119_n2146.t30 a_26114_7828# a_25381_7670# VDD pfet_03v3 ad=0.1584p pd=1.6u as=0.1152p ps=1u w=0.36u l=0.28u
X1541 VDD RB5.t14 a_6338_7232# VDD pfet_03v3 ad=0.3168p pd=2.32u as=0.3708p ps=2.47u w=0.72u l=0.28u
X1542 VSS a_n884_5318.t12 a_24810_5318# VSS nfet_03v3 ad=0.1584p pd=1.6u as=56.7f ps=0.675u w=0.36u l=0.28u
X1543 a_23213_7670# RA4.t10 VSS VSS nfet_03v3 ad=0.1944p pd=1.8u as=0.1656p ps=1.64u w=0.36u l=0.28u
X1544 a_5605_6102# a_4836_6102# VDD VDD pfet_03v3 ad=0.36p pd=2.44u as=0.1764p ps=1.26u w=0.72u l=0.28u
X1545 VDD a_24612_9238# a_24746_9428# VDD pfet_03v3 ad=0.1764p pd=1.26u as=0.1584p ps=1.6u w=0.36u l=0.28u
X1546 a_26119_n2146.t29 a_26114_4692# a_25381_4534# VDD pfet_03v3 ad=0.1584p pd=1.6u as=0.1152p ps=1u w=0.36u l=0.28u
X1547 a_34312_n170# a_34248_n708.t18 VDD.t1269 VDD.t1268 pfet_03v3 ad=0.2097p pd=1.38u as=0.3168p ps=2.32u w=0.72u l=0.28u
X1548 VDD a_n1204_1398.t10 a_19866_1398# VDD pfet_03v3 ad=0.1584p pd=1.6u as=56.7f ps=0.675u w=0.36u l=0.28u
X1549 a_14724_7670# a_n884_7670.t6 a_14536_7670# VDD pfet_03v3 ad=0.1278p pd=1.07u as=0.2097p ps=1.38u w=0.36u l=0.28u
X1550 a_25381_3750# a_24612_3750# VSS VSS nfet_03v3 ad=0.18p pd=1.72u as=97.2f ps=0.9u w=0.36u l=0.28u
X1551 a_14536_2182# a_14472_n708.t13 VSS VSS nfet_03v3 ad=0.1188p pd=1.02u as=0.1584p ps=1.6u w=0.36u l=0.28u
X1552 a_20437_10022# a_20741_10114# a_20905_n862.t7 VDD pfet_03v3 ad=0.1152p pd=1u as=0.1584p ps=1.6u w=0.36u l=0.28u
X1553 a_10549_n954# a_10853_n862# a_11017_n862.t20 VDD.t2560 pfet_03v3 ad=0.1152p pd=1u as=0.1584p ps=1.6u w=0.36u l=0.28u
X1554 VSS a_36972_1398# a_37106_1588# VSS nfet_03v3 ad=97.2f pd=0.9u as=0.1584p ps=1.6u w=0.36u l=0.28u
X1555 a_7308_8454# a_n884_8454.t15 a_7120_8454# VDD pfet_03v3 ad=0.1278p pd=1.07u as=0.2097p ps=1.38u w=0.36u l=0.28u
X1556 a_8815_n2146.t29 a_8810_7828# a_8077_7670# VDD pfet_03v3 ad=0.1584p pd=1.6u as=0.1152p ps=1u w=0.36u l=0.28u
X1557 a_14724_4534# a_n884_4534.t6 a_14536_4534# VDD pfet_03v3 ad=0.1278p pd=1.07u as=0.2097p ps=1.38u w=0.36u l=0.28u
X1558 a_4648_3750# a_4584_n708.t9 VDD VDD pfet_03v3 ad=0.2097p pd=1.38u as=0.3168p ps=2.32u w=0.72u l=0.28u
X1559 a_2176_n170# a_2112_n708.t21 VDD.t1202 VDD.t1201 pfet_03v3 ad=0.2097p pd=1.38u as=0.3168p ps=2.32u w=0.72u l=0.28u
X1560 a_17008_8454# a_16944_n708.t14 VDD VDD pfet_03v3 ad=0.2097p pd=1.38u as=0.3168p ps=2.32u w=0.72u l=0.28u
X1561 VSS RB3.t10 a_18698_8800# VSS nfet_03v3 ad=0.1584p pd=1.6u as=0.1854p ps=1.75u w=0.36u l=0.28u
X1562 a_36972_n954# a_n884_n954.t16 a_36784_n954# VDD.t1352 pfet_03v3 ad=0.1278p pd=1.07u as=0.2097p ps=1.38u w=0.36u l=0.28u
X1563 a_965_10114# RA1.t14 VDD VDD pfet_03v3 ad=0.3888p pd=2.52u as=0.3312p ps=2.36u w=0.72u l=0.28u
X1564 VDD a_7308_9238# a_7442_9428# VDD pfet_03v3 ad=0.1764p pd=1.26u as=0.1584p ps=1.6u w=0.36u l=0.28u
X1565 a_8815_n2146.t28 a_8810_4692# a_8077_4534# VDD pfet_03v3 ad=0.1584p pd=1.6u as=0.1152p ps=1u w=0.36u l=0.28u
X1566 a_4648_614# a_4584_n708.t10 VDD VDD pfet_03v3 ad=0.2097p pd=1.38u as=0.3168p ps=2.32u w=0.72u l=0.28u
X1567 a_17456_n1738# a_16952_n1782# VSS.t2590 VSS nfet_03v3 ad=0.1584p pd=1.6u as=0.1584p ps=1.6u w=0.36u l=0.28u
X1568 a_8381_10114# RA1.t15 VDD VDD pfet_03v3 ad=0.3888p pd=2.52u as=0.3312p ps=2.36u w=0.72u l=0.28u
X1569 VSS a_27084_6886# a_27218_7200# VSS nfet_03v3 ad=97.2f pd=0.9u as=0.1584p ps=1.6u w=0.36u l=0.28u
X1570 a_3133_5318# a_3437_5410# a_3601_n862.t9 VDD pfet_03v3 ad=0.1152p pd=1u as=0.1584p ps=1.6u w=0.36u l=0.28u
X1571 VSS RB7.t16 a_26114_5664# VSS nfet_03v3 ad=0.1584p pd=1.6u as=0.1854p ps=1.75u w=0.36u l=0.28u
X1572 VDD.t1487 RB14.t16 a_28586_n12# VDD.t734 pfet_03v3 ad=0.3168p pd=2.32u as=0.3708p ps=2.47u w=0.72u l=0.28u
X1573 VSS RB5.t15 a_33530_7232# VSS nfet_03v3 ad=0.1584p pd=1.6u as=0.1854p ps=1.75u w=0.36u l=0.28u
X1574 a_661_2182# a_965_2274# a_1129_n862.t28 VDD pfet_03v3 ad=0.1152p pd=1u as=0.1584p ps=1.6u w=0.36u l=0.28u
X1575 VDD a_32028_5318# a_32162_5632# VDD pfet_03v3 ad=0.1764p pd=1.26u as=0.1584p ps=1.6u w=0.36u l=0.28u
X1576 VSS a_n884_9238.t13 a_7506_9742# VSS nfet_03v3 ad=0.1584p pd=1.6u as=56.7f ps=0.675u w=0.36u l=0.28u
X1577 VDD a_29556_2182# a_29690_2496# VDD pfet_03v3 ad=0.1764p pd=1.26u as=0.1584p ps=1.6u w=0.36u l=0.28u
X1578 VDD a_n1204_10022.t12 a_27282_10526# VDD pfet_03v3 ad=0.1584p pd=1.6u as=56.7f ps=0.675u w=0.36u l=0.28u
X1579 VSS a_n884_6102.t12 a_7506_6606# VSS nfet_03v3 ad=0.1584p pd=1.6u as=56.7f ps=0.675u w=0.36u l=0.28u
X1580 VSS a_n884_614.t20 a_29754_614# VSS nfet_03v3 ad=0.1584p pd=1.6u as=56.7f ps=0.675u w=0.36u l=0.28u
X1581 a_31840_2966# a_31776_n708.t14 VDD VDD pfet_03v3 ad=0.2097p pd=1.38u as=0.3168p ps=2.32u w=0.72u l=0.28u
X1582 VSS.t3033 a_29312_n1782# a_29304_n708.t3 VSS nfet_03v3 ad=0.2728p pd=2.12u as=0.1612p ps=1.14u w=0.62u l=0.28u
X1583 a_24810_n450# a_24746_n640# a_24612_n954# VDD.t2595 pfet_03v3 ad=56.7f pd=0.675u as=0.1278p ps=1.07u w=0.36u l=0.28u
X1584 a_19866_6102# a_19802_6292# a_19668_6102# VDD pfet_03v3 ad=56.7f pd=0.675u as=0.1278p ps=1.07u w=0.36u l=0.28u
X1585 a_17196_3750# a_n1204_3750.t11 a_17008_3750# VSS nfet_03v3 ad=0.1278p pd=1.07u as=0.1188p ps=1.02u w=0.36u l=0.28u
X1586 a_34760_n1738# a_34256_n1782# VSS.t2346 VSS nfet_03v3 ad=0.1584p pd=1.6u as=0.1584p ps=1.6u w=0.36u l=0.28u
X1587 a_13759_n2146.t14 a_13754_8800# a_13021_8454# VDD pfet_03v3 ad=0.1584p pd=1.6u as=0.1152p ps=1u w=0.36u l=0.28u
X1588 a_23647_n2146.t29 a_23642_3124# a_22909_2966# VDD pfet_03v3 ad=0.1584p pd=1.6u as=0.1152p ps=1u w=0.36u l=0.28u
X1589 a_27853_8454# a_28157_8546# a_28321_n862.t28 VDD pfet_03v3 ad=0.1152p pd=1u as=0.1584p ps=1.6u w=0.36u l=0.28u
X1590 a_32226_2686# a_32162_2496# a_32028_2182# VDD pfet_03v3 ad=56.7f pd=0.675u as=0.1278p ps=1.07u w=0.36u l=0.28u
X1591 a_38479_n2146.t27 a_38474_10964# a_37741_10806# VDD pfet_03v3 ad=0.1584p pd=1.6u as=0.1152p ps=1u w=0.36u l=0.28u
X1592 a_13325_10114# RA1.t16 VDD VDD pfet_03v3 ad=0.3888p pd=2.52u as=0.3312p ps=2.36u w=0.72u l=0.28u
X1593 a_8077_3750# RA9.t13 a_8545_n862.t10 VSS nfet_03v3 ad=0.1152p pd=1u as=0.1584p ps=1.6u w=0.36u l=0.28u
X1594 VDD.t723 RB15.t14 a_16226_n608# VDD.t722 pfet_03v3 ad=0.3168p pd=2.32u as=0.3708p ps=2.47u w=0.72u l=0.28u
X1595 VDD RB5.t16 a_3866_7232# VDD pfet_03v3 ad=0.3168p pd=2.32u as=0.3708p ps=2.47u w=0.72u l=0.28u
X1596 a_4592_n1782# a_5096_n1738# a_5384_n1234# VSS nfet_03v3 ad=0.1278p pd=1.07u as=56.7f ps=0.675u w=0.36u l=0.28u
X1597 a_3133_6102# a_2364_6102# VDD VDD pfet_03v3 ad=0.36p pd=2.44u as=0.1764p ps=1.26u w=0.72u l=0.28u
X1598 VDD.t1557 a_n1204_n170.t12 a_n884_n170.t0 VDD.t1252 pfet_03v3 ad=0.5896p pd=3.56u as=0.3886p ps=1.92u w=1.34u l=0.28u
X1599 a_13325_8546# RA3.t9 VSS VSS nfet_03v3 ad=0.1944p pd=1.8u as=0.1656p ps=1.64u w=0.36u l=0.28u
X1600 a_35269_5318# a_35573_5410# a_35737_n862.t29 VDD pfet_03v3 ad=0.1152p pd=1u as=0.1584p ps=1.6u w=0.36u l=0.28u
X1601 VDD a_n1204_1398.t11 a_17394_1398# VDD pfet_03v3 ad=0.1584p pd=1.6u as=56.7f ps=0.675u w=0.36u l=0.28u
X1602 a_17008_1398# a_16944_n708.t15 VSS VSS nfet_03v3 ad=0.1188p pd=1.02u as=0.1584p ps=1.6u w=0.36u l=0.28u
X1603 a_12252_7670# a_n884_7670.t7 a_12064_7670# VDD pfet_03v3 ad=0.1278p pd=1.07u as=0.2097p ps=1.38u w=0.36u l=0.28u
X1604 a_28157_2966# RA10.t9 VDD VDD pfet_03v3 ad=0.3888p pd=2.52u as=0.3312p ps=2.36u w=0.72u l=0.28u
X1605 a_14536_10022# a_14472_n708.t14 VDD VDD pfet_03v3 ad=0.2097p pd=1.38u as=0.3168p ps=2.32u w=0.72u l=0.28u
X1606 a_6343_n2146.t29 a_6338_7828# a_5605_7670# VDD pfet_03v3 ad=0.1584p pd=1.6u as=0.1152p ps=1u w=0.36u l=0.28u
X1607 a_152_n1738# a_n352_n1782# VSS.t2711 VSS nfet_03v3 ad=0.1584p pd=1.6u as=0.1584p ps=1.6u w=0.36u l=0.28u
X1608 VDD D7.t0 a_18061_n1738# VDD pfet_03v3 ad=0.3168p pd=2.32u as=0.2097p ps=1.38u w=0.72u l=0.28u
X1609 a_27853_9238# a_27084_9238# VSS VSS nfet_03v3 ad=0.18p pd=1.72u as=97.2f ps=0.9u w=0.36u l=0.28u
X1610 a_14536_8454# a_14472_n708.t15 VDD VDD pfet_03v3 ad=0.2097p pd=1.38u as=0.3168p ps=2.32u w=0.72u l=0.28u
X1611 a_20741_5410# RA7.t16 VSS VSS nfet_03v3 ad=0.1944p pd=1.8u as=0.1656p ps=1.64u w=0.36u l=0.28u
X1612 a_12252_4534# a_n884_4534.t7 a_12064_4534# VDD pfet_03v3 ad=0.1278p pd=1.07u as=0.2097p ps=1.38u w=0.36u l=0.28u
X1613 VDD a_6073_n862.t33 QA2b.t0 VDD pfet_03v3 ad=0.2484p pd=1.41u as=0.4104p ps=2.58u w=0.72u l=0.28u
X1614 VDD a_4836_9238# a_4970_9428# VDD pfet_03v3 ad=0.1764p pd=1.26u as=0.1584p ps=1.6u w=0.36u l=0.28u
X1615 a_6343_n2146.t10 a_6338_4692# a_5605_4534# VDD pfet_03v3 ad=0.1584p pd=1.6u as=0.1152p ps=1u w=0.36u l=0.28u
X1616 a_38479_n2146.t15 RB11.t15 a_37741_2182# VSS nfet_03v3 ad=0.1584p pd=1.6u as=0.1152p ps=1u w=0.36u l=0.28u
X1617 a_34500_n954# a_n884_n954.t17 a_34312_n954# VDD.t1353 pfet_03v3 ad=0.1278p pd=1.07u as=0.2097p ps=1.38u w=0.36u l=0.28u
X1618 a_36007_n2146.t25 a_36002_1556# a_35269_1398# VDD pfet_03v3 ad=0.1584p pd=1.6u as=0.1152p ps=1u w=0.36u l=0.28u
X1619 a_27853_6102# a_27084_6102# VSS VSS nfet_03v3 ad=0.18p pd=1.72u as=97.2f ps=0.9u w=0.36u l=0.28u
X1620 a_29556_6102# a_n884_6102.t13 a_29368_6102# VDD pfet_03v3 ad=0.1278p pd=1.07u as=0.2097p ps=1.38u w=0.36u l=0.28u
X1621 a_5605_3750# a_4836_3750# VSS VSS nfet_03v3 ad=0.18p pd=1.72u as=97.2f ps=0.9u w=0.36u l=0.28u
X1622 a_37170_2966# a_37106_3156# a_36972_2966# VDD pfet_03v3 ad=56.7f pd=0.675u as=0.1278p ps=1.07u w=0.36u l=0.28u
X1623 a_5605_614# a_4836_614# VSS VSS nfet_03v3 ad=0.18p pd=1.72u as=97.2f ps=0.9u w=0.36u l=0.28u
X1624 VSS a_24612_6886# a_24746_7200# VSS nfet_03v3 ad=97.2f pd=0.9u as=0.1584p ps=1.6u w=0.36u l=0.28u
X1625 VSS a_12252_2966# a_12386_3156# VSS nfet_03v3 ad=97.2f pd=0.9u as=0.1584p ps=1.6u w=0.36u l=0.28u
X1626 a_4648_n954# a_4584_n708.t11 VSS.t1750 VSS nfet_03v3 ad=0.1188p pd=1.02u as=0.1584p ps=1.6u w=0.36u l=0.28u
X1627 a_29368_2966# a_29304_n708.t11 VSS VSS nfet_03v3 ad=0.1188p pd=1.02u as=0.1584p ps=1.6u w=0.36u l=0.28u
X1628 a_n1204_3750.t1 a_n1652_4182# VDD VDD pfet_03v3 ad=0.3302p pd=1.79u as=0.5588p ps=3.42u w=1.27u l=0.28u
X1629 VDD.t2369 a_19668_n954# a_19802_n640# VDD.t2368 pfet_03v3 ad=0.1764p pd=1.26u as=0.1584p ps=1.6u w=0.36u l=0.28u
X1630 a_9978_8958# a_9914_8768# a_9780_8454# VDD pfet_03v3 ad=56.7f pd=0.675u as=0.1278p ps=1.07u w=0.36u l=0.28u
X1631 a_965_5410# RA7.t17 VDD VDD pfet_03v3 ad=0.3888p pd=2.52u as=0.3312p ps=2.36u w=0.72u l=0.28u
X1632 a_32797_2966# a_32028_2966# VSS VSS nfet_03v3 ad=0.18p pd=1.72u as=97.2f ps=0.9u w=0.36u l=0.28u
X1633 VSS a_n884_614.t21 a_7506_614# VSS nfet_03v3 ad=0.1584p pd=1.6u as=56.7f ps=0.675u w=0.36u l=0.28u
X1634 VDD RB12.t17 a_38474_1556# VDD pfet_03v3 ad=0.3168p pd=2.32u as=0.3708p ps=2.47u w=0.72u l=0.28u
X1635 a_31840_10022# a_31776_n708.t15 VDD VDD pfet_03v3 ad=0.2097p pd=1.38u as=0.3168p ps=2.32u w=0.72u l=0.28u
X1636 VSS a_n884_9238.t14 a_5034_9742# VSS nfet_03v3 ad=0.1584p pd=1.6u as=56.7f ps=0.675u w=0.36u l=0.28u
X1637 VDD a_n108_6886# a_26_7200# VDD pfet_03v3 ad=0.1764p pd=1.26u as=0.1584p ps=1.6u w=0.36u l=0.28u
X1638 VSS a_7308_6886# a_7442_7200# VSS nfet_03v3 ad=97.2f pd=0.9u as=0.1584p ps=1.6u w=0.36u l=0.28u
X1639 VDD D14.t0 a_35365_n1738# VDD pfet_03v3 ad=0.3168p pd=2.32u as=0.2097p ps=1.38u w=0.72u l=0.28u
X1640 a_n884_614.t3 a_n1204_614.t15 VSS VSS nfet_03v3 ad=0.1943p pd=1.25u as=0.1693p ps=1.19u w=0.67u l=0.28u
X1641 VSS RB2.t13 a_26114_9396# VSS nfet_03v3 ad=0.1584p pd=1.6u as=0.1854p ps=1.75u w=0.36u l=0.28u
X1642 VDD RB5.t17 a_36002_7232# VDD pfet_03v3 ad=0.3168p pd=2.32u as=0.3708p ps=2.47u w=0.72u l=0.28u
X1643 a_965_2274# RA11.t14 VDD VDD pfet_03v3 ad=0.3888p pd=2.52u as=0.3312p ps=2.36u w=0.72u l=0.28u
X1644 a_2364_10022# a_n884_10022.t9 a_2176_10022# VDD pfet_03v3 ad=0.1278p pd=1.07u as=0.2097p ps=1.38u w=0.36u l=0.28u
X1645 VSS a_n884_6102.t14 a_5034_6606# VSS nfet_03v3 ad=0.1584p pd=1.6u as=56.7f ps=0.675u w=0.36u l=0.28u
X1646 a_35269_6102# a_34500_6102# VDD VDD pfet_03v3 ad=0.36p pd=2.44u as=0.1764p ps=1.26u w=0.72u l=0.28u
X1647 VSS RB7.t17 a_6338_5664# VSS nfet_03v3 ad=0.1584p pd=1.6u as=0.1854p ps=1.75u w=0.36u l=0.28u
X1648 VDD a_n108_3750# a_26_4064# VDD pfet_03v3 ad=0.1764p pd=1.26u as=0.1584p ps=1.6u w=0.36u l=0.28u
X1649 VSS a_7308_614# a_7442_928# VSS nfet_03v3 ad=97.2f pd=0.9u as=0.1584p ps=1.6u w=0.36u l=0.28u
X1650 VSS RB6.t16 a_26114_6260# VSS nfet_03v3 ad=0.1584p pd=1.6u as=0.1854p ps=1.75u w=0.36u l=0.28u
X1651 a_10853_n862# RA15.t12 VDD.t441 VDD.t433 pfet_03v3 ad=0.3888p pd=2.52u as=0.3312p ps=2.36u w=0.72u l=0.28u
X1652 VDD a_34500_10806# a_34634_10996# VDD pfet_03v3 ad=0.1764p pd=1.26u as=0.1584p ps=1.6u w=0.36u l=0.28u
X1653 a_22338_n450# a_22274_n640# a_22140_n954# VDD.t2598 pfet_03v3 ad=56.7f pd=0.675u as=0.1278p ps=1.07u w=0.36u l=0.28u
X1654 VDD a_n108_614# a_26_928# VDD pfet_03v3 ad=0.1764p pd=1.26u as=0.1584p ps=1.6u w=0.36u l=0.28u
X1655 a_8077_9238# a_8381_9238# a_8545_n862.t20 VDD pfet_03v3 ad=0.1152p pd=1u as=0.1584p ps=1.6u w=0.36u l=0.28u
X1656 a_8077_7670# a_7308_7670# VSS VSS nfet_03v3 ad=0.18p pd=1.72u as=97.2f ps=0.9u w=0.36u l=0.28u
X1657 a_21175_n2146.t27 a_21170_3124# a_20437_2966# VDD pfet_03v3 ad=0.1584p pd=1.6u as=0.1152p ps=1u w=0.36u l=0.28u
X1658 VSS a_n884_10806.t15 a_22338_11310# VSS nfet_03v3 ad=0.1584p pd=1.6u as=56.7f ps=0.675u w=0.36u l=0.28u
X1659 a_28591_n2146.t4 RB1.t14 a_27853_10022# VSS nfet_03v3 ad=0.1584p pd=1.6u as=0.1152p ps=1u w=0.36u l=0.28u
X1660 a_8077_4534# a_7308_4534# VSS VSS nfet_03v3 ad=0.18p pd=1.72u as=97.2f ps=0.9u w=0.36u l=0.28u
X1661 a_37741_3750# RA9.t14 a_38209_n862.t11 VSS nfet_03v3 ad=0.1152p pd=1u as=0.1584p ps=1.6u w=0.36u l=0.28u
X1662 VDD.t1547 a_n1204_n170.t13 a_19866_n170# VDD.t1248 pfet_03v3 ad=0.1584p pd=1.6u as=56.7f ps=0.675u w=0.36u l=0.28u
X1663 a_35573_7670# RA4.t11 VSS VSS nfet_03v3 ad=0.1944p pd=1.8u as=0.1656p ps=1.64u w=0.36u l=0.28u
X1664 VDD a_36972_9238# a_37106_9428# VDD pfet_03v3 ad=0.1764p pd=1.26u as=0.1584p ps=1.6u w=0.36u l=0.28u
X1665 a_5605_3750# RA9.t15 a_6073_n862.t11 VSS nfet_03v3 ad=0.1152p pd=1u as=0.1584p ps=1.6u w=0.36u l=0.28u
X1666 VDD.t725 RB15.t15 a_13754_n608# VDD.t724 pfet_03v3 ad=0.3168p pd=2.32u as=0.3708p ps=2.47u w=0.72u l=0.28u
X1667 a_5034_n450# a_4970_n640# a_4836_n954# VDD.t2526 pfet_03v3 ad=56.7f pd=0.675u as=0.1278p ps=1.07u w=0.36u l=0.28u
X1668 a_26896_2182# a_26832_n708.t14 VSS VSS nfet_03v3 ad=0.1188p pd=1.02u as=0.1584p ps=1.6u w=0.36u l=0.28u
X1669 a_661_10022# RA1.t17 a_1129_n862.t0 VSS nfet_03v3 ad=0.1152p pd=1u as=0.1584p ps=1.6u w=0.36u l=0.28u
X1670 a_17965_6886# a_17196_6886# VDD VDD pfet_03v3 ad=0.36p pd=2.44u as=0.1764p ps=1.26u w=0.72u l=0.28u
X1671 a_32797_5318# a_33101_5410# a_33265_n862.t2 VDD pfet_03v3 ad=0.1152p pd=1u as=0.1584p ps=1.6u w=0.36u l=0.28u
X1672 a_20216_n1738# WEM.t8 VDD VDD pfet_03v3 ad=56.7f pd=0.675u as=0.1584p ps=1.6u w=0.36u l=0.28u
X1673 a_17394_5822# a_17330_5632# a_17196_5318# VDD pfet_03v3 ad=56.7f pd=0.675u as=0.1278p ps=1.07u w=0.36u l=0.28u
X1674 a_28591_n2146.t13 RB14.t17 a_27853_n170# VSS nfet_03v3 ad=0.1584p pd=1.6u as=0.1152p ps=1u w=0.36u l=0.28u
X1675 a_14536_1398# a_14472_n708.t16 VSS VSS nfet_03v3 ad=0.1188p pd=1.02u as=0.1584p ps=1.6u w=0.36u l=0.28u
X1676 a_28157_10806# RA0.t17 VDD VDD pfet_03v3 ad=0.3888p pd=2.52u as=0.3312p ps=2.36u w=0.72u l=0.28u
X1677 a_19866_3750# a_19802_4064# a_19668_3750# VSS nfet_03v3 ad=56.7f pd=0.675u as=0.1278p ps=1.07u w=0.36u l=0.28u
X1678 a_3133_10022# a_2364_10022# VSS VSS nfet_03v3 ad=0.18p pd=1.72u as=97.2f ps=0.9u w=0.36u l=0.28u
X1679 a_3871_n2146.t10 a_3866_10964# a_3133_10806# VDD pfet_03v3 ad=0.1584p pd=1.6u as=0.1152p ps=1u w=0.36u l=0.28u
X1680 VDD WE0CLK.t14 a_5034_10806# VDD pfet_03v3 ad=0.1584p pd=1.6u as=56.7f ps=0.675u w=0.36u l=0.28u
X1681 a_2562_9742# a_2498_9428# a_2364_9238# VSS nfet_03v3 ad=56.7f pd=0.675u as=0.1278p ps=1.07u w=0.36u l=0.28u
X1682 a_8077_4534# RA8.t14 a_8545_n862.t3 VSS nfet_03v3 ad=0.1152p pd=1u as=0.1584p ps=1.6u w=0.36u l=0.28u
X1683 VSS a_n884_9238.t15 a_37170_9742# VSS nfet_03v3 ad=0.1584p pd=1.6u as=56.7f ps=0.675u w=0.36u l=0.28u
X1684 a_2562_6606# a_2498_6292# a_2364_6102# VSS nfet_03v3 ad=56.7f pd=0.675u as=0.1278p ps=1.07u w=0.36u l=0.28u
X1685 a_27084_10022# a_n1204_10022.t13 a_26896_10022# VSS nfet_03v3 ad=0.1278p pd=1.07u as=0.1188p ps=1.02u w=0.36u l=0.28u
X1686 a_15493_6102# a_15797_6102# a_15961_n862.t24 VDD pfet_03v3 ad=0.1152p pd=1u as=0.1584p ps=1.6u w=0.36u l=0.28u
X1687 VSS a_n884_6102.t15 a_37170_6606# VSS nfet_03v3 ad=0.1584p pd=1.6u as=56.7f ps=0.675u w=0.36u l=0.28u
X1688 a_3133_3750# a_2364_3750# VSS VSS nfet_03v3 ad=0.18p pd=1.72u as=97.2f ps=0.9u w=0.36u l=0.28u
X1689 a_12450_334# a_12386_20# a_12252_n170# VSS nfet_03v3 ad=56.7f pd=0.675u as=0.1278p ps=1.07u w=0.36u l=0.28u
X1690 a_34500_614# a_n1204_614.t16 a_34312_614# VSS nfet_03v3 ad=0.1278p pd=1.07u as=0.1188p ps=1.02u w=0.36u l=0.28u
X1691 VDD RB3.t11 a_1394_8800# VDD pfet_03v3 ad=0.3168p pd=2.32u as=0.3708p ps=2.47u w=0.72u l=0.28u
X1692 a_8381_2966# RA10.t10 VDD VDD pfet_03v3 ad=0.3888p pd=2.52u as=0.3312p ps=2.36u w=0.72u l=0.28u
X1693 a_20741_9238# RA2.t16 VSS VSS nfet_03v3 ad=0.1944p pd=1.8u as=0.1656p ps=1.64u w=0.36u l=0.28u
X1694 a_30629_6978# RA5.t13 VDD VDD pfet_03v3 ad=0.3888p pd=2.52u as=0.3312p ps=2.36u w=0.72u l=0.28u
X1695 a_14922_7670# a_14858_7860# a_14724_7670# VDD pfet_03v3 ad=56.7f pd=0.675u as=0.1278p ps=1.07u w=0.36u l=0.28u
X1696 a_30325_7670# a_30629_7670# a_30793_n862.t21 VDD pfet_03v3 ad=0.1152p pd=1u as=0.1584p ps=1.6u w=0.36u l=0.28u
X1697 a_9780_6102# a_n884_6102.t16 a_9592_6102# VDD pfet_03v3 ad=0.1278p pd=1.07u as=0.2097p ps=1.38u w=0.36u l=0.28u
X1698 a_20741_6102# RA6.t16 VSS VSS nfet_03v3 ad=0.1944p pd=1.8u as=0.1656p ps=1.64u w=0.36u l=0.28u
X1699 VSS a_n884_10022.t10 a_17394_10022# VSS nfet_03v3 ad=0.1584p pd=1.6u as=56.7f ps=0.675u w=0.36u l=0.28u
X1700 a_7506_8958# a_7442_8768# a_7308_8454# VDD pfet_03v3 ad=56.7f pd=0.675u as=0.1278p ps=1.07u w=0.36u l=0.28u
X1701 a_27084_5318# a_n884_5318.t13 a_26896_5318# VDD pfet_03v3 ad=0.1278p pd=1.07u as=0.2097p ps=1.38u w=0.36u l=0.28u
X1702 a_14922_4534# a_14858_4724# a_14724_4534# VDD pfet_03v3 ad=56.7f pd=0.675u as=0.1278p ps=1.07u w=0.36u l=0.28u
X1703 a_30325_4534# a_30629_4534# a_30793_n862.t20 VDD pfet_03v3 ad=0.1152p pd=1u as=0.1584p ps=1.6u w=0.36u l=0.28u
X1704 a_38479_n2146.t7 RB10.t13 a_37741_2966# VSS nfet_03v3 ad=0.1584p pd=1.6u as=0.1152p ps=1u w=0.36u l=0.28u
X1705 a_17965_7670# RA4.t12 a_18433_n862.t11 VSS nfet_03v3 ad=0.1152p pd=1u as=0.1584p ps=1.6u w=0.36u l=0.28u
X1706 VSS a_4836_6886# a_4970_7200# VSS nfet_03v3 ad=97.2f pd=0.9u as=0.1584p ps=1.6u w=0.36u l=0.28u
X1707 VDD a_n1204_6102.t14 a_90_6102# VDD pfet_03v3 ad=0.1584p pd=1.6u as=56.7f ps=0.675u w=0.36u l=0.28u
X1708 VSS RB7.t18 a_3866_5664# VSS nfet_03v3 ad=0.1584p pd=1.6u as=0.1854p ps=1.75u w=0.36u l=0.28u
X1709 a_29556_3750# a_n1204_3750.t12 a_29368_3750# VSS nfet_03v3 ad=0.1278p pd=1.07u as=0.1188p ps=1.02u w=0.36u l=0.28u
X1710 VSS a_1129_n862.t32 QA0b.t1 VSS nfet_03v3 ad=0.1242p pd=1.05u as=0.2052p ps=1.86u w=0.36u l=0.28u
X1711 VDD RB0.t15 a_33530_10964# VDD pfet_03v3 ad=0.3168p pd=2.32u as=0.3708p ps=2.47u w=0.72u l=0.28u
X1712 a_37741_9238# a_38045_9238# a_38209_n862.t21 VDD pfet_03v3 ad=0.1152p pd=1u as=0.1584p ps=1.6u w=0.36u l=0.28u
X1713 a_9592_2966# a_9528_n708.t10 VSS VSS nfet_03v3 ad=0.1188p pd=1.02u as=0.1584p ps=1.6u w=0.36u l=0.28u
X1714 a_34256_n1782# a_34760_n1738# a_35048_n1738# VDD pfet_03v3 ad=0.1278p pd=1.07u as=56.7f ps=0.675u w=0.36u l=0.28u
X1715 a_15493_1398# RA12.t13 a_15961_n862.t11 VSS nfet_03v3 ad=0.1152p pd=1u as=0.1584p ps=1.6u w=0.36u l=0.28u
X1716 VSS a_n884_8454.t16 a_34698_8454# VSS nfet_03v3 ad=0.1584p pd=1.6u as=56.7f ps=0.675u w=0.36u l=0.28u
X1717 a_4836_614# a_n1204_614.t17 a_4648_614# VSS nfet_03v3 ad=0.1278p pd=1.07u as=0.1188p ps=1.02u w=0.36u l=0.28u
X1718 a_37232_n1738# a_36728_n1782# VDD VDD pfet_03v3 ad=0.1584p pd=1.6u as=0.1584p ps=1.6u w=0.36u l=0.28u
X1719 a_5605_9238# a_5909_9238# a_6073_n862.t22 VDD pfet_03v3 ad=0.1152p pd=1u as=0.1584p ps=1.6u w=0.36u l=0.28u
X1720 VSS a_n884_5318.t14 a_34698_5318# VSS nfet_03v3 ad=0.1584p pd=1.6u as=56.7f ps=0.675u w=0.36u l=0.28u
X1721 VDD.t1556 a_n1204_n170.t14 a_17394_n170# VDD.t1250 pfet_03v3 ad=0.1584p pd=1.6u as=56.7f ps=0.675u w=0.36u l=0.28u
X1722 VDD CLK a_n1652_10806# VDD pfet_03v3 ad=0.3168p pd=2.32u as=0.1872p ps=1.24u w=0.72u l=0.28u
X1723 a_9780_10806# WE0CLK.t15 a_9592_10806# VSS nfet_03v3 ad=0.1278p pd=1.07u as=0.1188p ps=1.02u w=0.36u l=0.28u
X1724 VSS RB2.t14 a_6338_9396# VSS nfet_03v3 ad=0.1584p pd=1.6u as=0.1854p ps=1.75u w=0.36u l=0.28u
X1725 a_17008_9238# a_16944_n708.t16 VDD VDD pfet_03v3 ad=0.2097p pd=1.38u as=0.3168p ps=2.32u w=0.72u l=0.28u
X1726 a_25685_8546# RA3.t10 VSS VSS nfet_03v3 ad=0.1944p pd=1.8u as=0.1656p ps=1.64u w=0.36u l=0.28u
X1727 a_33101_7670# RA4.t13 VSS VSS nfet_03v3 ad=0.1944p pd=1.8u as=0.1656p ps=1.64u w=0.36u l=0.28u
X1728 VSS RB6.t17 a_6338_6260# VSS nfet_03v3 ad=0.1584p pd=1.6u as=0.1854p ps=1.75u w=0.36u l=0.28u
X1729 a_29754_6102# a_29690_6292# a_29556_6102# VDD pfet_03v3 ad=56.7f pd=0.675u as=0.1278p ps=1.07u w=0.36u l=0.28u
X1730 a_16231_n2146.t10 RB14.t18 a_15493_n170# VSS nfet_03v3 ad=0.1584p pd=1.6u as=0.1152p ps=1u w=0.36u l=0.28u
X1731 VDD a_n1204_1398.t12 a_29754_1398# VDD pfet_03v3 ad=0.1584p pd=1.6u as=56.7f ps=0.675u w=0.36u l=0.28u
X1732 a_35269_3750# a_34500_3750# VSS VSS nfet_03v3 ad=0.18p pd=1.72u as=97.2f ps=0.9u w=0.36u l=0.28u
X1733 a_26896_n170# a_26832_n708.t15 VSS VSS nfet_03v3 ad=0.1188p pd=1.02u as=0.1584p ps=1.6u w=0.36u l=0.28u
X1734 a_24612_7670# a_n884_7670.t8 a_24424_7670# VDD pfet_03v3 ad=0.1278p pd=1.07u as=0.2097p ps=1.38u w=0.36u l=0.28u
X1735 a_15493_6886# a_14724_6886# VDD VDD pfet_03v3 ad=0.36p pd=2.44u as=0.1764p ps=1.26u w=0.72u l=0.28u
X1736 a_12064_2966# a_12000_n708.t15 VDD VDD pfet_03v3 ad=0.2097p pd=1.38u as=0.3168p ps=2.32u w=0.72u l=0.28u
X1737 a_18269_10114# RA1.t18 VSS VSS nfet_03v3 ad=0.1944p pd=1.8u as=0.1656p ps=1.64u w=0.36u l=0.28u
X1738 a_36007_n2146.t31 a_36002_n12# a_35269_n170# VDD.t2809 pfet_03v3 ad=0.1584p pd=1.6u as=0.1152p ps=1u w=0.36u l=0.28u
X1739 a_26896_8454# a_26832_n708.t16 VDD VDD pfet_03v3 ad=0.2097p pd=1.38u as=0.3168p ps=2.32u w=0.72u l=0.28u
X1740 a_24612_4534# a_n884_4534.t8 a_24424_4534# VDD pfet_03v3 ad=0.1278p pd=1.07u as=0.2097p ps=1.38u w=0.36u l=0.28u
X1741 a_37741_4534# RA8.t15 a_38209_n862.t4 VSS nfet_03v3 ad=0.1152p pd=1u as=0.1584p ps=1.6u w=0.36u l=0.28u
X1742 a_10549_n170# a_9780_n170# VSS VSS nfet_03v3 ad=0.18p pd=1.72u as=97.2f ps=0.9u w=0.36u l=0.28u
X1743 a_28591_n2146.t21 RB0.t16 a_27853_10806# VSS nfet_03v3 ad=0.1584p pd=1.6u as=0.1152p ps=1u w=0.36u l=0.28u
X1744 VDD a_34500_8454# a_34634_8768# VDD pfet_03v3 ad=0.1764p pd=1.26u as=0.1584p ps=1.6u w=0.36u l=0.28u
X1745 a_13021_2182# RA11.t15 a_13489_n862.t6 VSS nfet_03v3 ad=0.1152p pd=1u as=0.1584p ps=1.6u w=0.36u l=0.28u
X1746 VDD a_9780_7670# a_9914_7860# VDD pfet_03v3 ad=0.1764p pd=1.26u as=0.1584p ps=1.6u w=0.36u l=0.28u
X1747 VSS a_36972_6886# a_37106_7200# VSS nfet_03v3 ad=97.2f pd=0.9u as=0.1584p ps=1.6u w=0.36u l=0.28u
X1748 a_5605_4534# RA8.t16 a_6073_n862.t6 VSS nfet_03v3 ad=0.1152p pd=1u as=0.1584p ps=1.6u w=0.36u l=0.28u
X1749 a_15272_n1738# WEM.t9 VDD VDD pfet_03v3 ad=56.7f pd=0.675u as=0.1584p ps=1.6u w=0.36u l=0.28u
X1750 QB11b.t1 a_28591_n2146.t32 VSS VSS nfet_03v3 ad=0.2052p pd=1.86u as=0.1242p ps=1.05u w=0.36u l=0.28u
X1751 a_661_10806# RA0.t18 a_1129_n862.t17 VSS nfet_03v3 ad=0.1152p pd=1u as=0.1584p ps=1.6u w=0.36u l=0.28u
X1752 VDD a_9780_4534# a_9914_4724# VDD pfet_03v3 ad=0.1764p pd=1.26u as=0.1584p ps=1.6u w=0.36u l=0.28u
X1753 VSS RB13.t14 a_33530_960# VSS nfet_03v3 ad=0.1584p pd=1.6u as=0.1854p ps=1.75u w=0.36u l=0.28u
X1754 VDD RB3.t12 a_31058_8800# VDD pfet_03v3 ad=0.3168p pd=2.32u as=0.3708p ps=2.47u w=0.72u l=0.28u
X1755 a_30325_7670# a_29556_7670# VDD VDD pfet_03v3 ad=0.36p pd=2.44u as=0.1764p ps=1.26u w=0.72u l=0.28u
X1756 VSS RB7.t19 a_36002_5664# VSS nfet_03v3 ad=0.1584p pd=1.6u as=0.1854p ps=1.75u w=0.36u l=0.28u
X1757 a_14724_n954# a_n1204_n954.t12 a_14536_n954# VSS nfet_03v3 ad=0.1278p pd=1.07u as=0.1188p ps=1.02u w=0.36u l=0.28u
X1758 VDD.t1488 RB14.t19 a_38474_n12# VDD.t736 pfet_03v3 ad=0.3168p pd=2.32u as=0.3708p ps=2.47u w=0.72u l=0.28u
X1759 VSS a_24612_n170# a_24746_20# VSS nfet_03v3 ad=97.2f pd=0.9u as=0.1584p ps=1.6u w=0.36u l=0.28u
X1760 VDD a_n1204_6886.t16 a_n884_6886.t0 VDD pfet_03v3 ad=0.5896p pd=3.56u as=0.3886p ps=1.92u w=1.34u l=0.28u
X1761 a_34312_n170# a_34248_n708.t19 VSS VSS nfet_03v3 ad=0.1188p pd=1.02u as=0.1584p ps=1.6u w=0.36u l=0.28u
X1762 a_14724_10806# WE0CLK.t16 a_14536_10806# VSS nfet_03v3 ad=0.1278p pd=1.07u as=0.1188p ps=1.02u w=0.36u l=0.28u
X1763 a_30325_4534# a_29556_4534# VDD VDD pfet_03v3 ad=0.36p pd=2.44u as=0.1764p ps=1.26u w=0.72u l=0.28u
X1764 a_4836_2966# a_n1204_2966.t16 a_4648_2966# VSS nfet_03v3 ad=0.1278p pd=1.07u as=0.1188p ps=1.02u w=0.36u l=0.28u
X1765 VDD a_n1204_3750.t13 a_n884_3750.t0 VDD pfet_03v3 ad=0.5896p pd=3.56u as=0.3886p ps=1.92u w=1.34u l=0.28u
X1766 VDD a_n1204_2966.t17 a_14922_2966# VDD pfet_03v3 ad=0.1584p pd=1.6u as=56.7f ps=0.675u w=0.36u l=0.28u
X1767 a_n108_10806# a_n884_10806.t16 a_n296_10806# VDD pfet_03v3 ad=0.1278p pd=1.07u as=0.2097p ps=1.38u w=0.36u l=0.28u
X1768 a_24612_10806# a_n884_10806.t17 a_24424_10806# VDD pfet_03v3 ad=0.1278p pd=1.07u as=0.2097p ps=1.38u w=0.36u l=0.28u
X1769 a_35573_10114# RA1.t19 VSS VSS nfet_03v3 ad=0.1944p pd=1.8u as=0.1656p ps=1.64u w=0.36u l=0.28u
X1770 a_12450_7670# a_12386_7860# a_12252_7670# VDD pfet_03v3 ad=56.7f pd=0.675u as=0.1278p ps=1.07u w=0.36u l=0.28u
X1771 a_28591_n2146.t0 RB5.t18 a_27853_6886# VSS nfet_03v3 ad=0.1584p pd=1.6u as=0.1152p ps=1u w=0.36u l=0.28u
X1772 VSS a_22140_2966# a_22274_3156# VSS nfet_03v3 ad=97.2f pd=0.9u as=0.1584p ps=1.6u w=0.36u l=0.28u
X1773 a_21952_n170# a_21888_n708.t16 VSS VSS nfet_03v3 ad=0.1188p pd=1.02u as=0.1584p ps=1.6u w=0.36u l=0.28u
X1774 a_11287_n2146.t12 RB14.t20 a_10549_n170# VSS nfet_03v3 ad=0.1584p pd=1.6u as=0.1152p ps=1u w=0.36u l=0.28u
X1775 a_n296_6886# a_n360_n708.t14 VDD VDD pfet_03v3 ad=0.2097p pd=1.38u as=0.3168p ps=2.32u w=0.72u l=0.28u
X1776 a_7308_6102# a_n884_6102.t17 a_7120_6102# VDD pfet_03v3 ad=0.1278p pd=1.07u as=0.2097p ps=1.38u w=0.36u l=0.28u
X1777 a_12450_4534# a_12386_4724# a_12252_4534# VDD pfet_03v3 ad=56.7f pd=0.675u as=0.1278p ps=1.07u w=0.36u l=0.28u
X1778 a_26832_n708.t3 a_26840_n1782# VSS.t2020 VSS nfet_03v3 ad=0.1612p pd=1.14u as=0.2728p ps=2.12u w=0.62u l=0.28u
X1779 VSS a_n884_7670.t9 a_12450_8174# VSS nfet_03v3 ad=0.1584p pd=1.6u as=56.7f ps=0.675u w=0.36u l=0.28u
X1780 a_34698_n450# a_34634_n640# a_34500_n954# VDD.t1997 pfet_03v3 ad=56.7f pd=0.675u as=0.1278p ps=1.07u w=0.36u l=0.28u
X1781 VSS RB1.t15 a_23642_10368# VSS nfet_03v3 ad=0.1584p pd=1.6u as=0.1854p ps=1.75u w=0.36u l=0.28u
X1782 VSS a_n884_4534.t9 a_12450_5038# VSS nfet_03v3 ad=0.1584p pd=1.6u as=56.7f ps=0.675u w=0.36u l=0.28u
X1783 a_7120_2966# a_7056_n708.t11 VSS VSS nfet_03v3 ad=0.1188p pd=1.02u as=0.1584p ps=1.6u w=0.36u l=0.28u
X1784 a_33535_n2146.t16 a_33530_3124# a_32797_2966# VDD pfet_03v3 ad=0.1584p pd=1.6u as=0.1152p ps=1u w=0.36u l=0.28u
X1785 VDD WE0CLK.t17 a_14922_10806# VDD pfet_03v3 ad=0.1584p pd=1.6u as=56.7f ps=0.675u w=0.36u l=0.28u
X1786 a_13021_10022# a_12252_10022# VSS VSS nfet_03v3 ad=0.18p pd=1.72u as=97.2f ps=0.9u w=0.36u l=0.28u
X1787 a_1399_n2146.t17 a_1394_3124# a_661_2966# VDD pfet_03v3 ad=0.1584p pd=1.6u as=0.1152p ps=1u w=0.36u l=0.28u
X1788 VDD.t727 RB15.t16 a_26114_n608# VDD.t726 pfet_03v3 ad=0.3168p pd=2.32u as=0.3708p ps=2.47u w=0.72u l=0.28u
X1789 a_4648_n170# a_4584_n708.t12 VSS VSS nfet_03v3 ad=0.1188p pd=1.02u as=0.1584p ps=1.6u w=0.36u l=0.28u
X1790 VDD RB12.t18 a_18698_1556# VDD pfet_03v3 ad=0.3168p pd=2.32u as=0.3708p ps=2.47u w=0.72u l=0.28u
X1791 VSS RB2.t15 a_3866_9396# VSS nfet_03v3 ad=0.1584p pd=1.6u as=0.1854p ps=1.75u w=0.36u l=0.28u
X1792 a_9780_3750# a_n1204_3750.t14 a_9592_3750# VSS nfet_03v3 ad=0.1278p pd=1.07u as=0.1188p ps=1.02u w=0.36u l=0.28u
X1793 a_14536_9238# a_14472_n708.t17 VDD VDD pfet_03v3 ad=0.2097p pd=1.38u as=0.3168p ps=2.32u w=0.72u l=0.28u
X1794 a_23005_n1738# a_n884_n1738.t10 a_21896_n1782# VDD pfet_03v3 ad=0.2097p pd=1.38u as=0.1278p ps=1.07u w=0.36u l=0.28u
X1795 a_3871_n2146.t2 RB15.t17 a_3133_n954# VSS nfet_03v3 ad=0.1584p pd=1.6u as=0.1152p ps=1u w=0.36u l=0.28u
X1796 VDD a_n1204_1398.t13 a_27282_1398# VDD pfet_03v3 ad=0.1584p pd=1.6u as=56.7f ps=0.675u w=0.36u l=0.28u
X1797 a_23213_8546# RA3.t11 VSS VSS nfet_03v3 ad=0.1944p pd=1.8u as=0.1656p ps=1.64u w=0.36u l=0.28u
X1798 VSS RB6.t18 a_3866_6260# VSS nfet_03v3 ad=0.1584p pd=1.6u as=0.1854p ps=1.75u w=0.36u l=0.28u
X1799 VSS a_n884_3750.t12 a_90_3750# VSS nfet_03v3 ad=0.1584p pd=1.6u as=56.7f ps=0.675u w=0.36u l=0.28u
X1800 a_10328_n1234# a_n884_n1738.t11 VSS.t8 VSS nfet_03v3 ad=56.7f pd=0.675u as=0.1584p ps=1.6u w=0.36u l=0.28u
X1801 a_26896_1398# a_26832_n708.t17 VSS VSS nfet_03v3 ad=0.1188p pd=1.02u as=0.1584p ps=1.6u w=0.36u l=0.28u
X1802 VSS a_17196_9238# a_17330_9428# VSS nfet_03v3 ad=97.2f pd=0.9u as=0.1584p ps=1.6u w=0.36u l=0.28u
X1803 a_22140_7670# a_n884_7670.t10 a_21952_7670# VDD pfet_03v3 ad=0.1278p pd=1.07u as=0.2097p ps=1.38u w=0.36u l=0.28u
X1804 a_1399_n2146.t18 a_1394_10368# a_661_10022# VDD pfet_03v3 ad=0.1584p pd=1.6u as=0.1152p ps=1u w=0.36u l=0.28u
X1805 a_28157_10114# RA1.t20 VDD VDD pfet_03v3 ad=0.3888p pd=2.52u as=0.3312p ps=2.36u w=0.72u l=0.28u
X1806 VSS a_n1652_7670# a_n1204_7670.t2 VSS nfet_03v3 ad=0.1693p pd=1.19u as=0.1651p ps=1.155u w=0.635u l=0.28u
X1807 VSS a_17196_6102# a_17330_6292# VSS nfet_03v3 ad=97.2f pd=0.9u as=0.1584p ps=1.6u w=0.36u l=0.28u
X1808 a_22140_4534# a_n884_4534.t10 a_21952_4534# VDD pfet_03v3 ad=0.1278p pd=1.07u as=0.2097p ps=1.38u w=0.36u l=0.28u
X1809 a_2624_n1738# a_2120_n1782# VDD VDD pfet_03v3 ad=0.1584p pd=1.6u as=0.1584p ps=1.6u w=0.36u l=0.28u
X1810 a_37741_9238# a_36972_9238# VSS VSS nfet_03v3 ad=0.18p pd=1.72u as=97.2f ps=0.9u w=0.36u l=0.28u
X1811 a_30629_5410# RA7.t18 VSS VSS nfet_03v3 ad=0.1944p pd=1.8u as=0.1656p ps=1.64u w=0.36u l=0.28u
X1812 a_965_6102# RA6.t17 VDD VDD pfet_03v3 ad=0.3888p pd=2.52u as=0.3312p ps=2.36u w=0.72u l=0.28u
X1813 a_13759_n2146.t22 a_13754_6260# a_13021_6102# VDD pfet_03v3 ad=0.1584p pd=1.6u as=0.1152p ps=1u w=0.36u l=0.28u
X1814 a_27853_6102# a_28157_6102# a_28321_n862.t14 VDD pfet_03v3 ad=0.1152p pd=1u as=0.1584p ps=1.6u w=0.36u l=0.28u
X1815 a_37741_6102# a_36972_6102# VSS VSS nfet_03v3 ad=0.18p pd=1.72u as=97.2f ps=0.9u w=0.36u l=0.28u
X1816 VSS RB9.t11 a_1394_4096# VSS nfet_03v3 ad=0.1584p pd=1.6u as=0.1854p ps=1.75u w=0.36u l=0.28u
X1817 a_4648_2182# a_4584_n708.t13 VSS VSS nfet_03v3 ad=0.1188p pd=1.02u as=0.1584p ps=1.6u w=0.36u l=0.28u
X1818 a_17008_6886# a_16944_n708.t17 VSS VSS nfet_03v3 ad=0.1188p pd=1.02u as=0.1584p ps=1.6u w=0.36u l=0.28u
X1819 a_29754_3750# a_29690_4064# a_29556_3750# VSS nfet_03v3 ad=56.7f pd=0.675u as=0.1278p ps=1.07u w=0.36u l=0.28u
X1820 a_661_n954# a_965_n862# a_1129_n862.t30 VDD.t2954 pfet_03v3 ad=0.1152p pd=1u as=0.1584p ps=1.6u w=0.36u l=0.28u
X1821 a_12252_n954# a_n1204_n954.t13 a_12064_n954# VSS nfet_03v3 ad=0.1278p pd=1.07u as=0.1188p ps=1.02u w=0.36u l=0.28u
X1822 a_18269_10806# RA0.t19 VSS VSS nfet_03v3 ad=0.1944p pd=1.8u as=0.1656p ps=1.64u w=0.36u l=0.28u
X1823 VDD.t3162 a_29556_n954# a_29690_n640# VDD.t3161 pfet_03v3 ad=0.1764p pd=1.26u as=0.1584p ps=1.6u w=0.36u l=0.28u
X1824 a_2364_1398# a_n884_1398.t17 a_2176_1398# VDD pfet_03v3 ad=0.1278p pd=1.07u as=0.2097p ps=1.38u w=0.36u l=0.28u
X1825 a_32028_6886# a_n884_6886.t17 a_31840_6886# VDD pfet_03v3 ad=0.1278p pd=1.07u as=0.2097p ps=1.38u w=0.36u l=0.28u
X1826 a_13021_2966# RA10.t11 a_13489_n862.t1 VSS nfet_03v3 ad=0.1152p pd=1u as=0.1584p ps=1.6u w=0.36u l=0.28u
X1827 a_32028_3750# a_n884_3750.t13 a_31840_3750# VDD pfet_03v3 ad=0.1278p pd=1.07u as=0.2097p ps=1.38u w=0.36u l=0.28u
X1828 VSS RB2.t16 a_36002_9396# VSS nfet_03v3 ad=0.1584p pd=1.6u as=0.1854p ps=1.75u w=0.36u l=0.28u
X1829 a_29754_334# a_29690_20# a_29556_n170# VSS nfet_03v3 ad=56.7f pd=0.675u as=0.1278p ps=1.07u w=0.36u l=0.28u
X1830 VDD RB1.t16 a_33530_10368# VDD pfet_03v3 ad=0.3168p pd=2.32u as=0.3708p ps=2.47u w=0.72u l=0.28u
X1831 VSS a_n884_7670.t11 a_9978_8174# VSS nfet_03v3 ad=0.1584p pd=1.6u as=56.7f ps=0.675u w=0.36u l=0.28u
X1832 a_965_1398# RA12.t14 VSS VSS nfet_03v3 ad=0.1944p pd=1.8u as=0.1656p ps=1.64u w=0.36u l=0.28u
X1833 a_20741_n862# RA15.t13 VDD.t442 VDD.t395 pfet_03v3 ad=0.3888p pd=2.52u as=0.3312p ps=2.36u w=0.72u l=0.28u
X1834 a_32028_614# a_n884_614.t22 a_31840_614# VDD pfet_03v3 ad=0.1278p pd=1.07u as=0.2097p ps=1.38u w=0.36u l=0.28u
X1835 a_27853_1398# RA12.t15 a_28321_n862.t11 VSS nfet_03v3 ad=0.1152p pd=1u as=0.1584p ps=1.6u w=0.36u l=0.28u
X1836 a_13759_n2146.t5 RB12.t19 a_13021_1398# VSS nfet_03v3 ad=0.1584p pd=1.6u as=0.1152p ps=1u w=0.36u l=0.28u
X1837 VSS RB6.t19 a_36002_6260# VSS nfet_03v3 ad=0.1584p pd=1.6u as=0.1854p ps=1.75u w=0.36u l=0.28u
X1838 a_32226_n450# a_32162_n640# a_32028_n954# VDD.t2185 pfet_03v3 ad=56.7f pd=0.675u as=0.1278p ps=1.07u w=0.36u l=0.28u
X1839 a_24368_n1782# a_24872_n1738# a_25160_n1234# VSS nfet_03v3 ad=0.1278p pd=1.07u as=56.7f ps=0.675u w=0.36u l=0.28u
X1840 a_13325_1398# RA12.t16 VDD VDD pfet_03v3 ad=0.3888p pd=2.52u as=0.3312p ps=2.36u w=0.72u l=0.28u
X1841 VSS a_n884_4534.t11 a_9978_5038# VSS nfet_03v3 ad=0.1584p pd=1.6u as=56.7f ps=0.675u w=0.36u l=0.28u
X1842 a_31063_n2146.t26 a_31058_3124# a_30325_2966# VDD pfet_03v3 ad=0.1584p pd=1.6u as=0.1152p ps=1u w=0.36u l=0.28u
X1843 a_27344_n1738# a_26840_n1782# VSS.t2019 VSS nfet_03v3 ad=0.1584p pd=1.6u as=0.1584p ps=1.6u w=0.36u l=0.28u
X1844 VDD.t1546 a_n1204_n170.t15 a_29754_n170# VDD.t1218 pfet_03v3 ad=0.1584p pd=1.6u as=56.7f ps=0.675u w=0.36u l=0.28u
X1845 a_35573_10806# RA0.t20 VSS VSS nfet_03v3 ad=0.1944p pd=1.8u as=0.1656p ps=1.64u w=0.36u l=0.28u
X1846 a_10549_7670# a_10853_7670# a_11017_n862.t9 VDD pfet_03v3 ad=0.1152p pd=1u as=0.1584p ps=1.6u w=0.36u l=0.28u
X1847 VDD CLK.t0 a_n1652_10454# VDD pfet_03v3 ad=0.3168p pd=2.32u as=0.1872p ps=1.24u w=0.72u l=0.28u
X1848 a_10549_4534# a_10853_4534# a_11017_n862.t17 VDD pfet_03v3 ad=0.1152p pd=1u as=0.1584p ps=1.6u w=0.36u l=0.28u
X1849 a_7308_3750# a_n1204_3750.t15 a_7120_3750# VSS nfet_03v3 ad=0.1278p pd=1.07u as=0.1188p ps=1.02u w=0.36u l=0.28u
X1850 a_36972_7670# a_n884_7670.t12 a_36784_7670# VDD pfet_03v3 ad=0.1278p pd=1.07u as=0.2097p ps=1.38u w=0.36u l=0.28u
X1851 a_9978_6102# a_9914_6292# a_9780_6102# VDD pfet_03v3 ad=56.7f pd=0.675u as=0.1278p ps=1.07u w=0.36u l=0.28u
X1852 QB14b.t0 a_36007_n2146.t33 VDD VDD pfet_03v3 ad=0.4104p pd=2.58u as=0.2484p ps=1.41u w=0.72u l=0.28u
X1853 VSS RB0.t17 a_23642_10964# VSS nfet_03v3 ad=0.1584p pd=1.6u as=0.1854p ps=1.75u w=0.36u l=0.28u
X1854 a_3871_n2146.t8 a_3866_8800# a_3133_8454# VDD pfet_03v3 ad=0.1584p pd=1.6u as=0.1152p ps=1u w=0.36u l=0.28u
X1855 a_27282_5822# a_27218_5632# a_27084_5318# VDD pfet_03v3 ad=56.7f pd=0.675u as=0.1278p ps=1.07u w=0.36u l=0.28u
X1856 VSS a_14724_9238# a_14858_9428# VSS nfet_03v3 ad=97.2f pd=0.9u as=0.1584p ps=1.6u w=0.36u l=0.28u
X1857 a_36972_4534# a_n884_4534.t12 a_36784_4534# VDD pfet_03v3 ad=0.1278p pd=1.07u as=0.2097p ps=1.38u w=0.36u l=0.28u
X1858 a_18703_n2146.t13 RB9.t12 a_17965_3750# VSS nfet_03v3 ad=0.1584p pd=1.6u as=0.1152p ps=1u w=0.36u l=0.28u
X1859 a_n884_6102.t0 a_n1204_6102.t15 VDD VDD pfet_03v3 ad=0.3886p pd=1.92u as=0.3386p ps=1.86u w=1.34u l=0.28u
X1860 a_25381_2182# RA11.t16 a_25849_n862.t6 VSS nfet_03v3 ad=0.1152p pd=1u as=0.1584p ps=1.6u w=0.36u l=0.28u
X1861 VDD.t729 RB15.t18 a_6338_n608# VDD.t728 pfet_03v3 ad=0.3168p pd=2.32u as=0.3708p ps=2.47u w=0.72u l=0.28u
X1862 VDD RB2.t17 a_1394_9396# VDD pfet_03v3 ad=0.3168p pd=2.32u as=0.3708p ps=2.47u w=0.72u l=0.28u
X1863 VSS a_14724_6102# a_14858_6292# VSS nfet_03v3 ad=97.2f pd=0.9u as=0.1584p ps=1.6u w=0.36u l=0.28u
X1864 VSS RB9.t13 a_31058_4096# VSS nfet_03v3 ad=0.1584p pd=1.6u as=0.1854p ps=1.75u w=0.36u l=0.28u
X1865 VDD a_n1204_1398.t14 a_7506_1398# VDD pfet_03v3 ad=0.1584p pd=1.6u as=56.7f ps=0.675u w=0.36u l=0.28u
X1866 a_15797_7670# RA4.t14 VDD VDD pfet_03v3 ad=0.3888p pd=2.52u as=0.3312p ps=2.36u w=0.72u l=0.28u
X1867 a_14536_6886# a_14472_n708.t18 VSS VSS nfet_03v3 ad=0.1188p pd=1.02u as=0.1584p ps=1.6u w=0.36u l=0.28u
X1868 a_15797_4534# RA8.t17 VDD VDD pfet_03v3 ad=0.3888p pd=2.52u as=0.3312p ps=2.36u w=0.72u l=0.28u
X1869 VDD CLK a_n1652_2966# VDD pfet_03v3 ad=0.3168p pd=2.32u as=0.1872p ps=1.24u w=0.72u l=0.28u
X1870 a_27853_n170# a_27084_n170# VSS VSS nfet_03v3 ad=0.18p pd=1.72u as=97.2f ps=0.9u w=0.36u l=0.28u
X1871 a_18269_n170# RA14.t12 VSS VSS nfet_03v3 ad=0.1944p pd=1.8u as=0.1656p ps=1.64u w=0.36u l=0.28u
X1872 a_30629_9238# RA2.t17 VSS VSS nfet_03v3 ad=0.1944p pd=1.8u as=0.1656p ps=1.64u w=0.36u l=0.28u
X1873 a_4648_8454# a_4584_n708.t14 VDD VDD pfet_03v3 ad=0.2097p pd=1.38u as=0.3168p ps=2.32u w=0.72u l=0.28u
X1874 a_30325_3750# a_29556_3750# VDD VDD pfet_03v3 ad=0.36p pd=2.44u as=0.1764p ps=1.26u w=0.72u l=0.28u
X1875 a_440_n1738# WEM.t10 VDD VDD pfet_03v3 ad=56.7f pd=0.675u as=0.1584p ps=1.6u w=0.36u l=0.28u
X1876 a_24810_7670# a_24746_7860# a_24612_7670# VDD pfet_03v3 ad=56.7f pd=0.675u as=0.1278p ps=1.07u w=0.36u l=0.28u
X1877 a_4836_10022# a_n884_10022.t11 a_4648_10022# VDD pfet_03v3 ad=0.1278p pd=1.07u as=0.2097p ps=1.38u w=0.36u l=0.28u
X1878 a_34698_10022# a_34634_10336# a_34500_10022# VSS nfet_03v3 ad=56.7f pd=0.675u as=0.1278p ps=1.07u w=0.36u l=0.28u
X1879 a_30629_6102# RA6.t18 VSS VSS nfet_03v3 ad=0.1944p pd=1.8u as=0.1656p ps=1.64u w=0.36u l=0.28u
X1880 a_11287_n2146.t26 a_11282_5664# a_10549_5318# VDD pfet_03v3 ad=0.1584p pd=1.6u as=0.1152p ps=1u w=0.36u l=0.28u
X1881 a_24810_4534# a_24746_4724# a_24612_4534# VDD pfet_03v3 ad=56.7f pd=0.675u as=0.1278p ps=1.07u w=0.36u l=0.28u
X1882 a_17394_334# a_17330_20# a_17196_n170# VSS nfet_03v3 ad=56.7f pd=0.675u as=0.1278p ps=1.07u w=0.36u l=0.28u
X1883 a_30325_614# a_29556_614# VDD VDD pfet_03v3 ad=0.36p pd=2.44u as=0.1764p ps=1.26u w=0.72u l=0.28u
X1884 a_13021_7670# a_12252_7670# VSS VSS nfet_03v3 ad=0.18p pd=1.72u as=97.2f ps=0.9u w=0.36u l=0.28u
X1885 VSS RB8.t11 a_1394_4692# VSS nfet_03v3 ad=0.1584p pd=1.6u as=0.1854p ps=1.75u w=0.36u l=0.28u
X1886 VSS a_2364_2966# a_2498_3156# VSS nfet_03v3 ad=97.2f pd=0.9u as=0.1584p ps=1.6u w=0.36u l=0.28u
X1887 a_13021_4534# a_12252_4534# VSS VSS nfet_03v3 ad=0.18p pd=1.72u as=97.2f ps=0.9u w=0.36u l=0.28u
X1888 VDD a_n1204_10022.t14 a_12450_10526# VDD pfet_03v3 ad=0.1584p pd=1.6u as=56.7f ps=0.675u w=0.36u l=0.28u
X1889 VSS a_4836_10022# a_4970_10336# VSS nfet_03v3 ad=97.2f pd=0.9u as=0.1584p ps=1.6u w=0.36u l=0.28u
X1890 VDD.t1489 RB14.t21 a_18698_n12# VDD.t738 pfet_03v3 ad=0.3168p pd=2.32u as=0.3708p ps=2.47u w=0.72u l=0.28u
X1891 VSS.t1716 a_14480_n1782# a_14472_n708.t3 VSS nfet_03v3 ad=0.2728p pd=2.12u as=0.1612p ps=1.14u w=0.62u l=0.28u
X1892 a_14922_n954# a_14858_n640# a_14724_n954# VSS nfet_03v3 ad=56.7f pd=0.675u as=0.1278p ps=1.07u w=0.36u l=0.28u
X1893 VDD.t1545 a_n1204_n170.t16 a_27282_n170# VDD.t1220 pfet_03v3 ad=0.1584p pd=1.6u as=56.7f ps=0.675u w=0.36u l=0.28u
X1894 a_26896_9238# a_26832_n708.t18 VDD VDD pfet_03v3 ad=0.2097p pd=1.38u as=0.3168p ps=2.32u w=0.72u l=0.28u
X1895 a_27853_1398# a_27084_1398# VDD VDD pfet_03v3 ad=0.36p pd=2.44u as=0.1764p ps=1.26u w=0.72u l=0.28u
X1896 a_35573_8546# RA3.t12 VSS VSS nfet_03v3 ad=0.1944p pd=1.8u as=0.1656p ps=1.64u w=0.36u l=0.28u
X1897 a_13325_n170# RA14.t13 VSS VSS nfet_03v3 ad=0.1944p pd=1.8u as=0.1656p ps=1.64u w=0.36u l=0.28u
X1898 a_9780_614# a_n1204_614.t18 a_9592_614# VSS nfet_03v3 ad=0.1278p pd=1.07u as=0.1188p ps=1.02u w=0.36u l=0.28u
X1899 a_18703_n2146.t23 a_18698_9396# a_17965_9238# VDD pfet_03v3 ad=0.1584p pd=1.6u as=0.1152p ps=1u w=0.36u l=0.28u
X1900 a_34500_7670# a_n884_7670.t13 a_34312_7670# VDD pfet_03v3 ad=0.1278p pd=1.07u as=0.2097p ps=1.38u w=0.36u l=0.28u
X1901 a_25381_6886# a_24612_6886# VDD VDD pfet_03v3 ad=0.36p pd=2.44u as=0.1764p ps=1.26u w=0.72u l=0.28u
X1902 a_90_9742# a_26_9428# a_n108_9238# VSS nfet_03v3 ad=56.7f pd=0.675u as=0.1278p ps=1.07u w=0.36u l=0.28u
X1903 a_17965_8454# a_17196_8454# VSS VSS nfet_03v3 ad=0.18p pd=1.72u as=97.2f ps=0.9u w=0.36u l=0.28u
X1904 a_7506_6102# a_7442_6292# a_7308_6102# VDD pfet_03v3 ad=56.7f pd=0.675u as=0.1278p ps=1.07u w=0.36u l=0.28u
X1905 VDD RB2.t18 a_31058_9396# VDD pfet_03v3 ad=0.3168p pd=2.32u as=0.3708p ps=2.47u w=0.72u l=0.28u
X1906 a_34500_4534# a_n884_4534.t13 a_34312_4534# VDD pfet_03v3 ad=0.1278p pd=1.07u as=0.2097p ps=1.38u w=0.36u l=0.28u
X1907 a_28591_n2146.t10 RB13.t15 a_27853_614# VSS nfet_03v3 ad=0.1584p pd=1.6u as=0.1152p ps=1u w=0.36u l=0.28u
X1908 a_8077_10806# a_8381_10806# a_8545_n862.t23 VDD pfet_03v3 ad=0.1152p pd=1u as=0.1584p ps=1.6u w=0.36u l=0.28u
X1909 a_90_6606# a_26_6292# a_n108_6102# VSS nfet_03v3 ad=56.7f pd=0.675u as=0.1278p ps=1.07u w=0.36u l=0.28u
X1910 a_17965_5318# a_17196_5318# VSS VSS nfet_03v3 ad=0.18p pd=1.72u as=97.2f ps=0.9u w=0.36u l=0.28u
X1911 a_16231_n2146.t12 RB9.t14 a_15493_3750# VSS nfet_03v3 ad=0.1584p pd=1.6u as=0.1152p ps=1u w=0.36u l=0.28u
X1912 VDD.t731 RB15.t19 a_3866_n608# VDD.t730 pfet_03v3 ad=0.3168p pd=2.32u as=0.3708p ps=2.47u w=0.72u l=0.28u
X1913 a_22909_2182# RA11.t17 a_23377_n862.t0 VSS nfet_03v3 ad=0.1152p pd=1u as=0.1584p ps=1.6u w=0.36u l=0.28u
X1914 a_4584_n708.t2 a_4592_n1782# VDD VDD pfet_03v3 ad=0.3224p pd=1.76u as=0.5456p ps=3.36u w=1.24u l=0.28u
X1915 VDD a_19668_7670# a_19802_7860# VDD pfet_03v3 ad=0.1764p pd=1.26u as=0.1584p ps=1.6u w=0.36u l=0.28u
X1916 a_14724_2182# a_n1204_2182.t11 a_14536_2182# VSS nfet_03v3 ad=0.1278p pd=1.07u as=0.1188p ps=1.02u w=0.36u l=0.28u
X1917 VSS.t3150 a_31784_n1782# a_31776_n708.t3 VSS nfet_03v3 ad=0.2728p pd=2.12u as=0.1612p ps=1.14u w=0.62u l=0.28u
X1918 VDD a_n1204_1398.t15 a_5034_1398# VDD pfet_03v3 ad=0.1584p pd=1.6u as=56.7f ps=0.675u w=0.36u l=0.28u
X1919 VDD a_19668_4534# a_19802_4724# VDD pfet_03v3 ad=0.1764p pd=1.26u as=0.1584p ps=1.6u w=0.36u l=0.28u
X1920 a_4648_1398# a_4584_n708.t15 VSS VSS nfet_03v3 ad=0.1188p pd=1.02u as=0.1584p ps=1.6u w=0.36u l=0.28u
X1921 QB0b.t0 a_1399_n2146.t33 VDD VDD pfet_03v3 ad=0.4104p pd=2.58u as=0.2484p ps=1.41u w=0.72u l=0.28u
X1922 a_24612_n954# a_n1204_n954.t14 a_24424_n954# VSS nfet_03v3 ad=0.1278p pd=1.07u as=0.1188p ps=1.02u w=0.36u l=0.28u
X1923 a_15493_n170# a_14724_n170# VSS VSS nfet_03v3 ad=0.18p pd=1.72u as=97.2f ps=0.9u w=0.36u l=0.28u
X1924 a_2364_n170# a_n884_n170.t10 a_2176_n170# VDD.t1347 pfet_03v3 ad=0.1278p pd=1.07u as=0.2097p ps=1.38u w=0.36u l=0.28u
X1925 VSS a_n884_10806.t18 a_32226_11310# VSS nfet_03v3 ad=0.1584p pd=1.6u as=56.7f ps=0.675u w=0.36u l=0.28u
X1926 a_9978_3750# a_9914_4064# a_9780_3750# VSS nfet_03v3 ad=56.7f pd=0.675u as=0.1278p ps=1.07u w=0.36u l=0.28u
X1927 VDD RB10.t14 a_16226_3124# VDD pfet_03v3 ad=0.3168p pd=2.32u as=0.3708p ps=2.47u w=0.72u l=0.28u
X1928 a_n108_7670# a_n1204_7670.t19 a_n296_7670# VSS nfet_03v3 ad=0.1278p pd=1.07u as=0.1188p ps=1.02u w=0.36u l=0.28u
X1929 a_18703_n2146.t29 RB8.t12 a_17965_4534# VSS nfet_03v3 ad=0.1584p pd=1.6u as=0.1152p ps=1u w=0.36u l=0.28u
X1930 a_25381_2966# RA10.t12 a_25849_n862.t2 VSS nfet_03v3 ad=0.1152p pd=1u as=0.1584p ps=1.6u w=0.36u l=0.28u
X1931 a_90_11310# a_26_10996# a_n108_10806# VSS nfet_03v3 ad=56.7f pd=0.675u as=0.1278p ps=1.07u w=0.36u l=0.28u
X1932 a_22338_7670# a_22274_7860# a_22140_7670# VDD pfet_03v3 ad=56.7f pd=0.675u as=0.1278p ps=1.07u w=0.36u l=0.28u
X1933 a_38479_n2146.t2 RB5.t19 a_37741_6886# VSS nfet_03v3 ad=0.1584p pd=1.6u as=0.1152p ps=1u w=0.36u l=0.28u
X1934 a_n108_4534# a_n1204_4534.t20 a_n296_4534# VSS nfet_03v3 ad=0.1278p pd=1.07u as=0.1188p ps=1.02u w=0.36u l=0.28u
X1935 VSS RB8.t13 a_31058_4692# VSS nfet_03v3 ad=0.1584p pd=1.6u as=0.1854p ps=1.75u w=0.36u l=0.28u
X1936 a_n884_3750.t3 a_n1204_3750.t16 VSS VSS nfet_03v3 ad=0.1943p pd=1.25u as=0.1693p ps=1.19u w=0.67u l=0.28u
X1937 VDD a_n1204_2966.t18 a_24810_2966# VDD pfet_03v3 ad=0.1584p pd=1.6u as=56.7f ps=0.675u w=0.36u l=0.28u
X1938 VSS a_32028_2966# a_32162_3156# VSS nfet_03v3 ad=97.2f pd=0.9u as=0.1584p ps=1.6u w=0.36u l=0.28u
X1939 VSS.t2542 a_9780_n954# a_9914_n640# VSS nfet_03v3 ad=97.2f pd=0.9u as=0.1584p ps=1.6u w=0.36u l=0.28u
X1940 VSS a_n884_n170.t11 a_17394_334# VSS nfet_03v3 ad=0.1584p pd=1.6u as=56.7f ps=0.675u w=0.36u l=0.28u
X1941 a_13325_n170# RA14.t14 VDD.t1080 VDD.t447 pfet_03v3 ad=0.3888p pd=2.52u as=0.3312p ps=2.36u w=0.72u l=0.28u
X1942 a_10549_7670# a_9780_7670# VSS VSS nfet_03v3 ad=0.18p pd=1.72u as=97.2f ps=0.9u w=0.36u l=0.28u
X1943 VSS a_n884_7670.t14 a_22338_8174# VSS nfet_03v3 ad=0.1584p pd=1.6u as=56.7f ps=0.675u w=0.36u l=0.28u
X1944 VDD a_n1204_6886.t17 a_19866_7390# VDD pfet_03v3 ad=0.1584p pd=1.6u as=56.7f ps=0.675u w=0.36u l=0.28u
X1945 a_22338_4534# a_22274_4724# a_22140_4534# VDD pfet_03v3 ad=56.7f pd=0.675u as=0.1278p ps=1.07u w=0.36u l=0.28u
X1946 a_34698_614# a_34634_928# a_34500_614# VSS nfet_03v3 ad=56.7f pd=0.675u as=0.1278p ps=1.07u w=0.36u l=0.28u
X1947 a_25685_1398# RA12.t17 VDD VDD pfet_03v3 ad=0.3888p pd=2.52u as=0.3312p ps=2.36u w=0.72u l=0.28u
X1948 a_29556_10806# WE0CLK.t18 a_29368_10806# VSS nfet_03v3 ad=0.1278p pd=1.07u as=0.1188p ps=1.02u w=0.36u l=0.28u
X1949 a_17965_8454# RA3.t13 a_18433_n862.t23 VSS nfet_03v3 ad=0.1152p pd=1u as=0.1584p ps=1.6u w=0.36u l=0.28u
X1950 VDD a_34500_6102# a_34634_6292# VDD pfet_03v3 ad=0.1764p pd=1.26u as=0.1584p ps=1.6u w=0.36u l=0.28u
X1951 a_10549_4534# a_9780_4534# VSS VSS nfet_03v3 ad=0.18p pd=1.72u as=97.2f ps=0.9u w=0.36u l=0.28u
X1952 VSS a_n884_4534.t14 a_22338_5038# VSS nfet_03v3 ad=0.1584p pd=1.6u as=56.7f ps=0.675u w=0.36u l=0.28u
X1953 VDD a_n1204_3750.t17 a_19866_4254# VDD pfet_03v3 ad=0.1584p pd=1.6u as=56.7f ps=0.675u w=0.36u l=0.28u
X1954 a_30325_n954# a_29556_n954# VSS.t2961 VSS nfet_03v3 ad=0.18p pd=1.72u as=97.2f ps=0.9u w=0.36u l=0.28u
X1955 VDD D8.t0 a_20533_n1738# VDD pfet_03v3 ad=0.3168p pd=2.32u as=0.2097p ps=1.38u w=0.72u l=0.28u
X1956 VSS a_17196_n170# a_17330_20# VSS nfet_03v3 ad=97.2f pd=0.9u as=0.1584p ps=1.6u w=0.36u l=0.28u
X1957 a_13021_10806# a_13325_10806# a_13489_n862.t18 VDD pfet_03v3 ad=0.1152p pd=1u as=0.1584p ps=1.6u w=0.36u l=0.28u
X1958 a_5034_7670# a_4970_7860# a_4836_7670# VDD pfet_03v3 ad=56.7f pd=0.675u as=0.1278p ps=1.07u w=0.36u l=0.28u
X1959 a_n1204_8454.t1 a_n1652_8886# VDD VDD pfet_03v3 ad=0.3302p pd=1.79u as=0.5588p ps=3.42u w=1.27u l=0.28u
X1960 VDD a_n1204_614.t19 a_19866_1118# VDD pfet_03v3 ad=0.1584p pd=1.6u as=56.7f ps=0.675u w=0.36u l=0.28u
X1961 VSS a_9780_10806# a_9914_10996# VSS nfet_03v3 ad=97.2f pd=0.9u as=0.1584p ps=1.6u w=0.36u l=0.28u
X1962 a_5034_4534# a_4970_4724# a_4836_4534# VDD pfet_03v3 ad=56.7f pd=0.675u as=0.1278p ps=1.07u w=0.36u l=0.28u
X1963 VDD.t733 RB15.t20 a_36002_n608# VDD.t732 pfet_03v3 ad=0.3168p pd=2.32u as=0.3708p ps=2.47u w=0.72u l=0.28u
X1964 a_12450_n954# a_12386_n640# a_12252_n954# VSS nfet_03v3 ad=56.7f pd=0.675u as=0.1278p ps=1.07u w=0.36u l=0.28u
X1965 VDD a_19668_10806# a_19802_10996# VDD pfet_03v3 ad=0.1764p pd=1.26u as=0.1584p ps=1.6u w=0.36u l=0.28u
X1966 a_8077_7670# RA4.t15 a_8545_n862.t30 VSS nfet_03v3 ad=0.1152p pd=1u as=0.1584p ps=1.6u w=0.36u l=0.28u
X1967 VDD a_n108_8454# a_26_8768# VDD pfet_03v3 ad=0.1764p pd=1.26u as=0.1584p ps=1.6u w=0.36u l=0.28u
X1968 VDD a_n1652_6102# a_n1204_6102.t0 VDD pfet_03v3 ad=0.3386p pd=1.86u as=0.3302p ps=1.79u w=1.27u l=0.28u
X1969 a_2562_1398# a_2498_1588# a_2364_1398# VDD pfet_03v3 ad=56.7f pd=0.675u as=0.1278p ps=1.07u w=0.36u l=0.28u
X1970 a_13759_n2146.t4 RB1.t17 a_13021_10022# VSS nfet_03v3 ad=0.1584p pd=1.6u as=0.1152p ps=1u w=0.36u l=0.28u
X1971 a_33101_8546# RA3.t14 VSS VSS nfet_03v3 ad=0.1944p pd=1.8u as=0.1656p ps=1.64u w=0.36u l=0.28u
X1972 VDD a_n1204_1398.t16 a_37170_1398# VDD pfet_03v3 ad=0.1584p pd=1.6u as=56.7f ps=0.675u w=0.36u l=0.28u
X1973 a_7120_10022# a_7056_n708.t12 VSS VSS nfet_03v3 ad=0.1188p pd=1.02u as=0.1584p ps=1.6u w=0.36u l=0.28u
X1974 a_16231_n2146.t28 a_16226_9396# a_15493_9238# VDD pfet_03v3 ad=0.1584p pd=1.6u as=0.1152p ps=1u w=0.36u l=0.28u
X1975 VSS a_27084_9238# a_27218_9428# VSS nfet_03v3 ad=97.2f pd=0.9u as=0.1584p ps=1.6u w=0.36u l=0.28u
X1976 a_16231_n2146.t1 RB13.t16 a_15493_614# VSS nfet_03v3 ad=0.1584p pd=1.6u as=0.1152p ps=1u w=0.36u l=0.28u
X1977 a_15493_8454# a_14724_8454# VSS VSS nfet_03v3 ad=0.18p pd=1.72u as=97.2f ps=0.9u w=0.36u l=0.28u
X1978 a_9592_n170# a_9528_n708.t11 VSS VSS nfet_03v3 ad=0.1188p pd=1.02u as=0.1584p ps=1.6u w=0.36u l=0.28u
X1979 VSS a_27084_6102# a_27218_6292# VSS nfet_03v3 ad=97.2f pd=0.9u as=0.1584p ps=1.6u w=0.36u l=0.28u
X1980 a_2112_n708.t3 a_2120_n1782# VSS.t3192 VSS nfet_03v3 ad=0.1612p pd=1.14u as=0.2728p ps=2.12u w=0.62u l=0.28u
X1981 VDD.t1548 a_n1204_n170.t17 a_7506_n170# VDD.t1222 pfet_03v3 ad=0.1584p pd=1.6u as=56.7f ps=0.675u w=0.36u l=0.28u
X1982 VSS a_n884_n170.t12 a_90_334# VSS nfet_03v3 ad=0.1584p pd=1.6u as=56.7f ps=0.675u w=0.36u l=0.28u
X1983 a_10549_10806# a_9780_10806# VSS VSS nfet_03v3 ad=0.18p pd=1.72u as=97.2f ps=0.9u w=0.36u l=0.28u
X1984 a_15493_5318# a_14724_5318# VSS VSS nfet_03v3 ad=0.18p pd=1.72u as=97.2f ps=0.9u w=0.36u l=0.28u
X1985 a_18703_n2146.t6 a_18698_10964# a_17965_10806# VDD pfet_03v3 ad=0.1584p pd=1.6u as=0.1152p ps=1u w=0.36u l=0.28u
X1986 a_20437_10806# a_19668_10806# VDD VDD pfet_03v3 ad=0.36p pd=2.44u as=0.1764p ps=1.26u w=0.72u l=0.28u
X1987 a_10853_2966# RA10.t13 VDD VDD pfet_03v3 ad=0.3888p pd=2.52u as=0.3312p ps=2.36u w=0.72u l=0.28u
X1988 a_26896_6886# a_26832_n708.t19 VSS VSS nfet_03v3 ad=0.1188p pd=1.02u as=0.1584p ps=1.6u w=0.36u l=0.28u
X1989 a_17965_n954# a_17196_n954# VDD.t3196 VDD.t2374 pfet_03v3 ad=0.36p pd=2.44u as=0.1764p ps=1.26u w=0.72u l=0.28u
X1990 VSS a_n108_n170# a_26_20# VSS nfet_03v3 ad=97.2f pd=0.9u as=0.1584p ps=1.6u w=0.36u l=0.28u
X1991 a_5605_6886# a_4836_6886# VDD VDD pfet_03v3 ad=0.36p pd=2.44u as=0.1764p ps=1.26u w=0.72u l=0.28u
X1992 a_12252_2182# a_n1204_2182.t12 a_12064_2182# VSS nfet_03v3 ad=0.1278p pd=1.07u as=0.1188p ps=1.02u w=0.36u l=0.28u
X1993 a_n1652_9238# CLK a_n1652_9678# VSS nfet_03v3 ad=0.3168p pd=2.32u as=0.1872p ps=1.24u w=0.72u l=0.28u
X1994 a_7506_3750# a_7442_4064# a_7308_3750# VSS nfet_03v3 ad=56.7f pd=0.675u as=0.1278p ps=1.07u w=0.36u l=0.28u
X1995 a_15797_3842# RA9.t16 VDD VDD pfet_03v3 ad=0.3888p pd=2.52u as=0.3312p ps=2.36u w=0.72u l=0.28u
X1996 a_22140_n954# a_n1204_n954.t15 a_21952_n954# VSS nfet_03v3 ad=0.1278p pd=1.07u as=0.1188p ps=1.02u w=0.36u l=0.28u
X1997 a_32797_614# a_32028_614# VSS VSS nfet_03v3 ad=0.18p pd=1.72u as=97.2f ps=0.9u w=0.36u l=0.28u
X1998 a_16231_n2146.t26 RB8.t14 a_15493_4534# VSS nfet_03v3 ad=0.1584p pd=1.6u as=0.1152p ps=1u w=0.36u l=0.28u
X1999 VDD RB10.t15 a_13754_3124# VDD pfet_03v3 ad=0.3168p pd=2.32u as=0.3708p ps=2.47u w=0.72u l=0.28u
X2000 a_3133_2182# RA11.t18 a_3601_n862.t14 VSS nfet_03v3 ad=0.1152p pd=1u as=0.1584p ps=1.6u w=0.36u l=0.28u
X2001 a_15797_706# RA13.t14 VDD VDD pfet_03v3 ad=0.3888p pd=2.52u as=0.3312p ps=2.36u w=0.72u l=0.28u
X2002 a_23647_n2146.t19 a_23642_5664# a_22909_5318# VDD pfet_03v3 ad=0.1584p pd=1.6u as=0.1152p ps=1u w=0.36u l=0.28u
X2003 a_22909_2966# RA10.t14 a_23377_n862.t8 VSS nfet_03v3 ad=0.1152p pd=1u as=0.1584p ps=1.6u w=0.36u l=0.28u
X2004 a_35048_n1738# WEM.t11 VDD VDD pfet_03v3 ad=56.7f pd=0.675u as=0.1584p ps=1.6u w=0.36u l=0.28u
X2005 a_11287_n2146.t4 RB13.t17 a_10549_614# VSS nfet_03v3 ad=0.1584p pd=1.6u as=0.1152p ps=1u w=0.36u l=0.28u
X2006 VSS a_n884_614.t23 a_34698_614# VSS nfet_03v3 ad=0.1584p pd=1.6u as=56.7f ps=0.675u w=0.36u l=0.28u
X2007 a_n296_8454# a_n360_n708.t15 VSS VSS nfet_03v3 ad=0.1188p pd=1.02u as=0.1584p ps=1.6u w=0.36u l=0.28u
X2008 VDD a_n1204_6886.t18 a_17394_7390# VDD pfet_03v3 ad=0.1584p pd=1.6u as=56.7f ps=0.675u w=0.36u l=0.28u
X2009 a_30629_n862# RA15.t14 VDD.t444 VDD.t443 pfet_03v3 ad=0.3888p pd=2.52u as=0.3312p ps=2.36u w=0.72u l=0.28u
X2010 a_23213_1398# RA12.t18 VDD VDD pfet_03v3 ad=0.3888p pd=2.52u as=0.3312p ps=2.36u w=0.72u l=0.28u
X2011 a_n296_5318# a_n360_n708.t16 VSS VSS nfet_03v3 ad=0.1188p pd=1.02u as=0.1584p ps=1.6u w=0.36u l=0.28u
X2012 VDD a_n1204_3750.t18 a_17394_4254# VDD pfet_03v3 ad=0.1584p pd=1.6u as=56.7f ps=0.675u w=0.36u l=0.28u
X2013 a_27853_n170# a_27084_n170# VDD.t2989 VDD.t2462 pfet_03v3 ad=0.36p pd=2.44u as=0.1764p ps=1.26u w=0.72u l=0.28u
X2014 a_37741_7670# RA4.t16 a_38209_n862.t30 VSS nfet_03v3 ad=0.1152p pd=1u as=0.1584p ps=1.6u w=0.36u l=0.28u
X2015 QB3b.t1 a_8815_n2146.t32 VSS VSS nfet_03v3 ad=0.2052p pd=1.86u as=0.1242p ps=1.05u w=0.36u l=0.28u
X2016 VDD a_n1204_614.t20 a_17394_1118# VDD pfet_03v3 ad=0.1584p pd=1.6u as=56.7f ps=0.675u w=0.36u l=0.28u
X2017 VSS a_n884_7670.t15 a_2562_8174# VSS nfet_03v3 ad=0.1584p pd=1.6u as=56.7f ps=0.675u w=0.36u l=0.28u
X2018 a_5605_7670# RA4.t17 a_6073_n862.t10 VSS nfet_03v3 ad=0.1152p pd=1u as=0.1584p ps=1.6u w=0.36u l=0.28u
X2019 a_36007_n2146.t2 a_36002_7232# a_35269_6886# VDD pfet_03v3 ad=0.1584p pd=1.6u as=0.1152p ps=1u w=0.36u l=0.28u
X2020 a_24424_5318# a_24360_n708.t18 VDD VDD pfet_03v3 ad=0.2097p pd=1.38u as=0.3168p ps=2.32u w=0.72u l=0.28u
X2021 VSS a_n884_4534.t15 a_2562_5038# VSS nfet_03v3 ad=0.1584p pd=1.6u as=56.7f ps=0.675u w=0.36u l=0.28u
X2022 a_36007_n2146.t15 a_36002_4096# a_35269_3750# VDD pfet_03v3 ad=0.1584p pd=1.6u as=0.1152p ps=1u w=0.36u l=0.28u
X2023 a_22400_n1738# a_21896_n1782# VDD VDD pfet_03v3 ad=0.1584p pd=1.6u as=0.1584p ps=1.6u w=0.36u l=0.28u
X2024 a_37170_5822# a_37106_5632# a_36972_5318# VDD pfet_03v3 ad=56.7f pd=0.675u as=0.1278p ps=1.07u w=0.36u l=0.28u
X2025 a_24424_2182# a_24360_n708.t19 VDD VDD pfet_03v3 ad=0.2097p pd=1.38u as=0.3168p ps=2.32u w=0.72u l=0.28u
X2026 VSS a_34500_3750# a_34634_4064# VSS nfet_03v3 ad=97.2f pd=0.9u as=0.1584p ps=1.6u w=0.36u l=0.28u
X2027 a_36007_n2146.t22 a_36002_960# a_35269_614# VDD pfet_03v3 ad=0.1584p pd=1.6u as=0.1152p ps=1u w=0.36u l=0.28u
X2028 a_12064_10806# a_12000_n708.t16 VSS VSS nfet_03v3 ad=0.1188p pd=1.02u as=0.1584p ps=1.6u w=0.36u l=0.28u
X2029 VSS a_24612_9238# a_24746_9428# VSS nfet_03v3 ad=97.2f pd=0.9u as=0.1584p ps=1.6u w=0.36u l=0.28u
X2030 a_17394_3470# a_17330_3156# a_17196_2966# VSS nfet_03v3 ad=56.7f pd=0.675u as=0.1278p ps=1.07u w=0.36u l=0.28u
X2031 a_35269_2182# RA11.t19 a_35737_n862.t7 VSS nfet_03v3 ad=0.1152p pd=1u as=0.1584p ps=1.6u w=0.36u l=0.28u
X2032 VSS.t2807 D2.t1 a_5701_n1738# VSS nfet_03v3 ad=0.1584p pd=1.6u as=0.1188p ps=1.02u w=0.36u l=0.28u
X2033 VDD.t1503 a_n1204_n170.t18 a_5034_n170# VDD.t1224 pfet_03v3 ad=0.1584p pd=1.6u as=56.7f ps=0.675u w=0.36u l=0.28u
X2034 a_4648_9238# a_4584_n708.t16 VDD VDD pfet_03v3 ad=0.2097p pd=1.38u as=0.3168p ps=2.32u w=0.72u l=0.28u
X2035 VSS a_24612_6102# a_24746_6292# VSS nfet_03v3 ad=97.2f pd=0.9u as=0.1584p ps=1.6u w=0.36u l=0.28u
X2036 a_4648_10806# a_4584_n708.t17 VDD VDD pfet_03v3 ad=0.2097p pd=1.38u as=0.3168p ps=2.32u w=0.72u l=0.28u
X2037 a_13759_n2146.t10 RB0.t18 a_13021_10806# VSS nfet_03v3 ad=0.1584p pd=1.6u as=0.1152p ps=1u w=0.36u l=0.28u
X2038 a_n1652_6542# WE6.t0 VSS VSS nfet_03v3 ad=0.1872p pd=1.24u as=0.3168p ps=2.32u w=0.72u l=0.28u
X2039 VSS a_n1652_4182# a_n1204_3750.t2 VSS nfet_03v3 ad=0.1693p pd=1.19u as=0.1651p ps=1.155u w=0.635u l=0.28u
X2040 a_36972_n954# a_n1204_n954.t16 a_36784_n954# VSS nfet_03v3 ad=0.1278p pd=1.07u as=0.1188p ps=1.02u w=0.36u l=0.28u
X2041 a_15493_n954# a_14724_n954# VDD.t3238 VDD.t3119 pfet_03v3 ad=0.36p pd=2.44u as=0.1764p ps=1.26u w=0.72u l=0.28u
X2042 a_22140_n170# a_n1204_n170.t19 a_21952_n170# VSS nfet_03v3 ad=0.1278p pd=1.07u as=0.1188p ps=1.02u w=0.36u l=0.28u
X2043 VSS a_7308_9238# a_7442_9428# VSS nfet_03v3 ad=97.2f pd=0.9u as=0.1584p ps=1.6u w=0.36u l=0.28u
X2044 a_3133_6886# a_2364_6886# VDD VDD pfet_03v3 ad=0.36p pd=2.44u as=0.1764p ps=1.26u w=0.72u l=0.28u
X2045 a_14724_1398# a_n1204_1398.t17 a_14536_1398# VSS nfet_03v3 ad=0.1278p pd=1.07u as=0.1188p ps=1.02u w=0.36u l=0.28u
X2046 VSS a_7308_6102# a_7442_6292# VSS nfet_03v3 ad=97.2f pd=0.9u as=0.1584p ps=1.6u w=0.36u l=0.28u
X2047 a_n1652_3406# WE10.t1 VSS VSS nfet_03v3 ad=0.1872p pd=1.24u as=0.3168p ps=2.32u w=0.72u l=0.28u
X2048 QB5b.t1 a_13759_n2146.t32 VSS VSS nfet_03v3 ad=0.2052p pd=1.86u as=0.1242p ps=1.05u w=0.36u l=0.28u
X2049 a_15493_10806# a_14724_10806# VDD VDD pfet_03v3 ad=0.36p pd=2.44u as=0.1764p ps=1.26u w=0.72u l=0.28u
X2050 a_34698_7670# a_34634_7860# a_34500_7670# VDD pfet_03v3 ad=56.7f pd=0.675u as=0.1278p ps=1.07u w=0.36u l=0.28u
X2051 a_19480_7670# a_19416_n708.t11 VSS VSS nfet_03v3 ad=0.1188p pd=1.02u as=0.1584p ps=1.6u w=0.36u l=0.28u
X2052 a_13021_6886# RA5.t14 a_13489_n862.t16 VSS nfet_03v3 ad=0.1152p pd=1u as=0.1584p ps=1.6u w=0.36u l=0.28u
X2053 a_3871_n2146.t23 a_3866_6260# a_3133_6102# VDD pfet_03v3 ad=0.1584p pd=1.6u as=0.1152p ps=1u w=0.36u l=0.28u
X2054 a_25685_n170# RA14.t15 VDD.t1081 VDD.t449 pfet_03v3 ad=0.3888p pd=2.52u as=0.3312p ps=2.36u w=0.72u l=0.28u
X2055 a_22909_7670# a_22140_7670# VSS VSS nfet_03v3 ad=0.18p pd=1.72u as=97.2f ps=0.9u w=0.36u l=0.28u
X2056 a_21175_n2146.t30 a_21170_5664# a_20437_5318# VDD pfet_03v3 ad=0.1584p pd=1.6u as=0.1152p ps=1u w=0.36u l=0.28u
X2057 a_34698_4534# a_34634_4724# a_34500_4534# VDD pfet_03v3 ad=56.7f pd=0.675u as=0.1278p ps=1.07u w=0.36u l=0.28u
X2058 VSS a_n884_614.t24 a_22338_614# VSS nfet_03v3 ad=0.1584p pd=1.6u as=56.7f ps=0.675u w=0.36u l=0.28u
X2059 a_17008_10022# a_16944_n708.t18 VSS VSS nfet_03v3 ad=0.1188p pd=1.02u as=0.1584p ps=1.6u w=0.36u l=0.28u
X2060 a_19480_4534# a_19416_n708.t12 VSS VSS nfet_03v3 ad=0.1188p pd=1.02u as=0.1584p ps=1.6u w=0.36u l=0.28u
X2061 a_10549_10022# a_10853_10114# a_11017_n862.t1 VDD pfet_03v3 ad=0.1152p pd=1u as=0.1584p ps=1.6u w=0.36u l=0.28u
X2062 a_22909_4534# a_22140_4534# VSS VSS nfet_03v3 ad=0.18p pd=1.72u as=97.2f ps=0.9u w=0.36u l=0.28u
X2063 a_20437_3750# RA9.t17 a_20905_n862.t17 VSS nfet_03v3 ad=0.1152p pd=1u as=0.1584p ps=1.6u w=0.36u l=0.28u
X2064 a_27084_2966# a_n1204_2966.t19 a_26896_2966# VSS nfet_03v3 ad=0.1278p pd=1.07u as=0.1188p ps=1.02u w=0.36u l=0.28u
X2065 a_14922_2182# a_14858_2496# a_14724_2182# VSS nfet_03v3 ad=56.7f pd=0.675u as=0.1278p ps=1.07u w=0.36u l=0.28u
X2066 VSS.t2945 D4.t1 a_10645_n1738# VSS nfet_03v3 ad=0.1584p pd=1.6u as=0.1188p ps=1.02u w=0.36u l=0.28u
X2067 a_3133_2966# RA10.t15 a_3601_n862.t5 VSS nfet_03v3 ad=0.1152p pd=1u as=0.1584p ps=1.6u w=0.36u l=0.28u
X2068 VSS a_20905_n862.t32 QA8b.t1 VSS nfet_03v3 ad=0.1242p pd=1.05u as=0.2052p ps=1.86u w=0.36u l=0.28u
X2069 a_24810_n954# a_24746_n640# a_24612_n954# VSS nfet_03v3 ad=56.7f pd=0.675u as=0.1278p ps=1.07u w=0.36u l=0.28u
X2070 a_2562_n170# a_2498_20# a_2364_n170# VDD.t2032 pfet_03v3 ad=56.7f pd=0.675u as=0.1278p ps=1.07u w=0.36u l=0.28u
X2071 VDD a_17196_1398# a_17330_1588# VDD pfet_03v3 ad=0.1764p pd=1.26u as=0.1584p ps=1.6u w=0.36u l=0.28u
X2072 VSS a_n884_7670.t16 a_32226_8174# VSS nfet_03v3 ad=0.1584p pd=1.6u as=56.7f ps=0.675u w=0.36u l=0.28u
X2073 a_n296_n954# a_n360_n708.t17 VDD.t244 VDD.t234 pfet_03v3 ad=0.2097p pd=1.38u as=0.3168p ps=2.32u w=0.72u l=0.28u
X2074 VDD.t1558 a_n1204_n170.t20 a_37170_n170# VDD.t1226 pfet_03v3 ad=0.1584p pd=1.6u as=56.7f ps=0.675u w=0.36u l=0.28u
X2075 a_32226_11310# a_32162_10996# a_32028_10806# VSS nfet_03v3 ad=56.7f pd=0.675u as=0.1278p ps=1.07u w=0.36u l=0.28u
X2076 VSS a_n884_4534.t16 a_32226_5038# VSS nfet_03v3 ad=0.1584p pd=1.6u as=56.7f ps=0.675u w=0.36u l=0.28u
X2077 a_3871_n2146.t5 RB12.t20 a_3133_1398# VSS nfet_03v3 ad=0.1584p pd=1.6u as=0.1152p ps=1u w=0.36u l=0.28u
X2078 a_37741_1398# a_36972_1398# VDD VDD pfet_03v3 ad=0.36p pd=2.44u as=0.1764p ps=1.26u w=0.72u l=0.28u
X2079 a_35269_6886# a_34500_6886# VDD VDD pfet_03v3 ad=0.36p pd=2.44u as=0.1764p ps=1.26u w=0.72u l=0.28u
X2080 a_661_7670# a_965_7670# a_1129_n862.t13 VDD pfet_03v3 ad=0.1152p pd=1u as=0.1584p ps=1.6u w=0.36u l=0.28u
X2081 a_26119_n2146.t16 RB9.t15 a_25381_3750# VSS nfet_03v3 ad=0.1584p pd=1.6u as=0.1152p ps=1u w=0.36u l=0.28u
X2082 VSS a_29556_614# a_29690_928# VSS nfet_03v3 ad=97.2f pd=0.9u as=0.1584p ps=1.6u w=0.36u l=0.28u
X2083 a_661_4534# a_965_4534# a_1129_n862.t8 VDD pfet_03v3 ad=0.1152p pd=1u as=0.1584p ps=1.6u w=0.36u l=0.28u
X2084 a_32797_2182# RA11.t20 a_33265_n862.t9 VSS nfet_03v3 ad=0.1152p pd=1u as=0.1584p ps=1.6u w=0.36u l=0.28u
X2085 a_20437_10022# a_19668_10022# VDD VDD pfet_03v3 ad=0.36p pd=2.44u as=0.1764p ps=1.26u w=0.72u l=0.28u
X2086 VDD a_29556_7670# a_29690_7860# VDD pfet_03v3 ad=0.1764p pd=1.26u as=0.1584p ps=1.6u w=0.36u l=0.28u
X2087 a_24612_2182# a_n1204_2182.t13 a_24424_2182# VSS nfet_03v3 ad=0.1278p pd=1.07u as=0.1188p ps=1.02u w=0.36u l=0.28u
X2088 VDD a_29556_4534# a_29690_4724# VDD pfet_03v3 ad=0.1764p pd=1.26u as=0.1584p ps=1.6u w=0.36u l=0.28u
X2089 a_n1204_10022.t1 a_n1652_10454# VDD VDD pfet_03v3 ad=0.3302p pd=1.79u as=0.5588p ps=3.42u w=1.27u l=0.28u
X2090 VSS a_4836_9238# a_4970_9428# VSS nfet_03v3 ad=97.2f pd=0.9u as=0.1584p ps=1.6u w=0.36u l=0.28u
X2091 a_8815_n2146.t11 RB9.t16 a_8077_3750# VSS nfet_03v3 ad=0.1584p pd=1.6u as=0.1152p ps=1u w=0.36u l=0.28u
X2092 a_34500_n954# a_n1204_n954.t17 a_34312_n954# VSS nfet_03v3 ad=0.1278p pd=1.07u as=0.1188p ps=1.02u w=0.36u l=0.28u
X2093 a_12252_1398# a_n1204_1398.t18 a_12064_1398# VSS nfet_03v3 ad=0.1278p pd=1.07u as=0.1188p ps=1.02u w=0.36u l=0.28u
X2094 VDD RB10.t16 a_26114_3124# VDD pfet_03v3 ad=0.3168p pd=2.32u as=0.3708p ps=2.47u w=0.72u l=0.28u
X2095 a_7568_n1738# a_7064_n1782# VSS.t2129 VSS nfet_03v3 ad=0.1584p pd=1.6u as=0.1584p ps=1.6u w=0.36u l=0.28u
X2096 a_38045_7670# RA4.t18 VDD VDD pfet_03v3 ad=0.3888p pd=2.52u as=0.3312p ps=2.36u w=0.72u l=0.28u
X2097 VSS a_4836_6102# a_4970_6292# VSS nfet_03v3 ad=97.2f pd=0.9u as=0.1584p ps=1.6u w=0.36u l=0.28u
X2098 VSS a_9780_2182# a_9914_2496# VSS nfet_03v3 ad=97.2f pd=0.9u as=0.1584p ps=1.6u w=0.36u l=0.28u
X2099 a_18269_706# RA13.t15 VSS VSS nfet_03v3 ad=0.1944p pd=1.8u as=0.1656p ps=1.64u w=0.36u l=0.28u
X2100 a_32226_7670# a_32162_7860# a_32028_7670# VDD pfet_03v3 ad=56.7f pd=0.675u as=0.1278p ps=1.07u w=0.36u l=0.28u
X2101 a_35269_2966# RA10.t16 a_35737_n862.t1 VSS nfet_03v3 ad=0.1152p pd=1u as=0.1584p ps=1.6u w=0.36u l=0.28u
X2102 VDD a_n1204_2966.t20 a_34698_2966# VDD pfet_03v3 ad=0.1584p pd=1.6u as=56.7f ps=0.675u w=0.36u l=0.28u
X2103 VSS.t747 RB15.t21 a_28586_n608# VSS nfet_03v3 ad=0.1584p pd=1.6u as=0.1854p ps=1.75u w=0.36u l=0.28u
X2104 VSS a_24612_10022# a_24746_10336# VSS nfet_03v3 ad=97.2f pd=0.9u as=0.1584p ps=1.6u w=0.36u l=0.28u
X2105 a_38045_4534# RA8.t18 VDD VDD pfet_03v3 ad=0.3888p pd=2.52u as=0.3312p ps=2.36u w=0.72u l=0.28u
X2106 VSS.t2183 a_19668_n954# a_19802_n640# VSS nfet_03v3 ad=97.2f pd=0.9u as=0.1584p ps=1.6u w=0.36u l=0.28u
X2107 a_23213_n170# RA14.t16 VDD.t1082 VDD.t451 pfet_03v3 ad=0.3888p pd=2.52u as=0.3312p ps=2.36u w=0.72u l=0.28u
X2108 a_5909_7670# RA4.t19 VDD VDD pfet_03v3 ad=0.3888p pd=2.52u as=0.3312p ps=2.36u w=0.72u l=0.28u
X2109 a_20437_7670# a_19668_7670# VSS VSS nfet_03v3 ad=0.18p pd=1.72u as=97.2f ps=0.9u w=0.36u l=0.28u
X2110 a_4648_6886# a_4584_n708.t18 VSS VSS nfet_03v3 ad=0.1188p pd=1.02u as=0.1584p ps=1.6u w=0.36u l=0.28u
X2111 a_32226_4534# a_32162_4724# a_32028_4534# VDD pfet_03v3 ad=56.7f pd=0.675u as=0.1278p ps=1.07u w=0.36u l=0.28u
X2112 a_30325_2182# a_29556_2182# VSS VSS nfet_03v3 ad=0.18p pd=1.72u as=97.2f ps=0.9u w=0.36u l=0.28u
X2113 a_20437_9238# a_20741_9238# a_20905_n862.t25 VDD pfet_03v3 ad=0.1152p pd=1u as=0.1584p ps=1.6u w=0.36u l=0.28u
X2114 VDD a_n1204_6886.t19 a_29754_7390# VDD pfet_03v3 ad=0.1584p pd=1.6u as=56.7f ps=0.675u w=0.36u l=0.28u
X2115 a_5909_4534# RA8.t19 VDD VDD pfet_03v3 ad=0.3888p pd=2.52u as=0.3312p ps=2.36u w=0.72u l=0.28u
X2116 a_35573_1398# RA12.t19 VDD VDD pfet_03v3 ad=0.3888p pd=2.52u as=0.3312p ps=2.36u w=0.72u l=0.28u
X2117 a_20437_4534# a_19668_4534# VSS VSS nfet_03v3 ad=0.18p pd=1.72u as=97.2f ps=0.9u w=0.36u l=0.28u
X2118 VDD a_n1204_3750.t19 a_29754_4254# VDD pfet_03v3 ad=0.1584p pd=1.6u as=56.7f ps=0.675u w=0.36u l=0.28u
X2119 a_19668_8454# a_n1204_8454.t11 a_19480_8454# VSS nfet_03v3 ad=0.1278p pd=1.07u as=0.1188p ps=1.02u w=0.36u l=0.28u
X2120 a_12450_2182# a_12386_2496# a_12252_2182# VSS nfet_03v3 ad=56.7f pd=0.675u as=0.1278p ps=1.07u w=0.36u l=0.28u
X2121 VDD RB4.t11 a_8810_7828# VDD pfet_03v3 ad=0.3168p pd=2.32u as=0.3708p ps=2.47u w=0.72u l=0.28u
X2122 VDD a_n1204_614.t21 a_29754_1118# VDD pfet_03v3 ad=0.1584p pd=1.6u as=56.7f ps=0.675u w=0.36u l=0.28u
X2123 a_19668_5318# a_n1204_5318.t12 a_19480_5318# VSS nfet_03v3 ad=0.1278p pd=1.07u as=0.1188p ps=1.02u w=0.36u l=0.28u
X2124 a_22338_n954# a_22274_n640# a_22140_n954# VSS nfet_03v3 ad=56.7f pd=0.675u as=0.1278p ps=1.07u w=0.36u l=0.28u
X2125 VDD a_14724_1398# a_14858_1588# VDD pfet_03v3 ad=0.1764p pd=1.26u as=0.1584p ps=1.6u w=0.36u l=0.28u
X2126 a_36784_5318# a_36720_n708.t18 VDD VDD pfet_03v3 ad=0.2097p pd=1.38u as=0.3168p ps=2.32u w=0.72u l=0.28u
X2127 VDD RB8.t15 a_8810_4692# VDD pfet_03v3 ad=0.3168p pd=2.32u as=0.3708p ps=2.47u w=0.72u l=0.28u
X2128 a_32028_8454# a_n884_8454.t17 a_31840_8454# VDD pfet_03v3 ad=0.1278p pd=1.07u as=0.2097p ps=1.38u w=0.36u l=0.28u
X2129 a_36784_2182# a_36720_n708.t19 VDD VDD pfet_03v3 ad=0.2097p pd=1.38u as=0.3168p ps=2.32u w=0.72u l=0.28u
X2130 a_12512_n1738# a_12008_n1782# VSS.t2658 VSS nfet_03v3 ad=0.1584p pd=1.6u as=0.1584p ps=1.6u w=0.36u l=0.28u
X2131 a_26119_n2146.t11 a_26114_9396# a_25381_9238# VDD pfet_03v3 ad=0.1584p pd=1.6u as=0.1152p ps=1u w=0.36u l=0.28u
X2132 VSS a_36972_9238# a_37106_9428# VSS nfet_03v3 ad=97.2f pd=0.9u as=0.1584p ps=1.6u w=0.36u l=0.28u
X2133 a_20437_4534# RA8.t20 a_20905_n862.t10 VSS nfet_03v3 ad=0.1152p pd=1u as=0.1584p ps=1.6u w=0.36u l=0.28u
X2134 a_5034_n954# a_4970_n640# a_4836_n954# VSS nfet_03v3 ad=56.7f pd=0.675u as=0.1278p ps=1.07u w=0.36u l=0.28u
X2135 a_13325_706# RA13.t16 VSS VSS nfet_03v3 ad=0.1944p pd=1.8u as=0.1656p ps=1.64u w=0.36u l=0.28u
X2136 a_25381_8454# a_24612_8454# VSS VSS nfet_03v3 ad=0.18p pd=1.72u as=97.2f ps=0.9u w=0.36u l=0.28u
X2137 VSS a_36972_6102# a_37106_6292# VSS nfet_03v3 ad=97.2f pd=0.9u as=0.1584p ps=1.6u w=0.36u l=0.28u
X2138 a_25381_5318# a_24612_5318# VSS VSS nfet_03v3 ad=0.18p pd=1.72u as=97.2f ps=0.9u w=0.36u l=0.28u
X2139 VDD D0.t0 a_757_n1738# VDD pfet_03v3 ad=0.3168p pd=2.32u as=0.2097p ps=1.38u w=0.72u l=0.28u
X2140 VDD a_11017_n862.t33 QA4b.t0 VDD pfet_03v3 ad=0.2484p pd=1.41u as=0.4104p ps=2.58u w=0.72u l=0.28u
X2141 a_27282_11310# a_27218_10996# a_27084_10806# VSS nfet_03v3 ad=56.7f pd=0.675u as=0.1278p ps=1.07u w=0.36u l=0.28u
X2142 a_14724_9238# a_n884_9238.t16 a_14536_9238# VDD pfet_03v3 ad=0.1278p pd=1.07u as=0.2097p ps=1.38u w=0.36u l=0.28u
X2143 a_37170_10806# a_37106_10996# a_36972_10806# VDD pfet_03v3 ad=56.7f pd=0.675u as=0.1278p ps=1.07u w=0.36u l=0.28u
X2144 a_4648_10022# a_4584_n708.t19 VDD VDD pfet_03v3 ad=0.2097p pd=1.38u as=0.3168p ps=2.32u w=0.72u l=0.28u
X2145 a_8815_n2146.t19 a_8810_9396# a_8077_9238# VDD pfet_03v3 ad=0.1584p pd=1.6u as=0.1152p ps=1u w=0.36u l=0.28u
X2146 VSS RB4.t12 a_1394_7828# VSS nfet_03v3 ad=0.1584p pd=1.6u as=0.1854p ps=1.75u w=0.36u l=0.28u
X2147 a_20741_2966# RA10.t17 VDD VDD pfet_03v3 ad=0.3888p pd=2.52u as=0.3312p ps=2.36u w=0.72u l=0.28u
X2148 a_9978_614# a_9914_928# a_9780_614# VSS nfet_03v3 ad=56.7f pd=0.675u as=0.1278p ps=1.07u w=0.36u l=0.28u
X2149 VDD a_n1204_5318.t13 a_14922_5822# VDD pfet_03v3 ad=0.1584p pd=1.6u as=56.7f ps=0.675u w=0.36u l=0.28u
X2150 a_22140_2182# a_n1204_2182.t14 a_21952_2182# VSS nfet_03v3 ad=0.1278p pd=1.07u as=0.1188p ps=1.02u w=0.36u l=0.28u
X2151 a_6343_n2146.t16 RB9.t17 a_5605_3750# VSS nfet_03v3 ad=0.1584p pd=1.6u as=0.1152p ps=1u w=0.36u l=0.28u
X2152 VDD a_n1204_2182.t15 a_12450_2686# VDD pfet_03v3 ad=0.1584p pd=1.6u as=56.7f ps=0.675u w=0.36u l=0.28u
X2153 VSS a_n1652_1046# a_n1204_614.t3 VSS nfet_03v3 ad=0.1693p pd=1.19u as=0.1651p ps=1.155u w=0.635u l=0.28u
X2154 a_17965_1398# a_18269_1398# a_18433_n862.t28 VDD pfet_03v3 ad=0.1152p pd=1u as=0.1584p ps=1.6u w=0.36u l=0.28u
X2155 VDD a_n108_6102# a_26_6292# VDD pfet_03v3 ad=0.1764p pd=1.26u as=0.1584p ps=1.6u w=0.36u l=0.28u
X2156 a_15493_10022# a_14724_10022# VDD VDD pfet_03v3 ad=0.36p pd=2.44u as=0.1764p ps=1.26u w=0.72u l=0.28u
X2157 a_25381_6886# RA5.t15 a_25849_n862.t12 VSS nfet_03v3 ad=0.1152p pd=1u as=0.1584p ps=1.6u w=0.36u l=0.28u
X2158 a_26119_n2146.t1 RB8.t16 a_25381_4534# VSS nfet_03v3 ad=0.1584p pd=1.6u as=0.1152p ps=1u w=0.36u l=0.28u
X2159 a_33535_n2146.t27 a_33530_5664# a_32797_5318# VDD pfet_03v3 ad=0.1584p pd=1.6u as=0.1152p ps=1u w=0.36u l=0.28u
X2160 a_21952_2966# a_21888_n708.t17 VSS VSS nfet_03v3 ad=0.1188p pd=1.02u as=0.1584p ps=1.6u w=0.36u l=0.28u
X2161 a_32797_2966# RA10.t18 a_33265_n862.t1 VSS nfet_03v3 ad=0.1152p pd=1u as=0.1584p ps=1.6u w=0.36u l=0.28u
X2162 a_19668_10022# a_n884_10022.t12 a_19480_10022# VDD pfet_03v3 ad=0.1278p pd=1.07u as=0.2097p ps=1.38u w=0.36u l=0.28u
X2163 a_3437_7670# RA4.t20 VDD VDD pfet_03v3 ad=0.3888p pd=2.52u as=0.3312p ps=2.36u w=0.72u l=0.28u
X2164 a_1399_n2146.t22 a_1394_5664# a_661_5318# VDD pfet_03v3 ad=0.1584p pd=1.6u as=0.1152p ps=1u w=0.36u l=0.28u
X2165 VDD a_n1204_6886.t20 a_27282_7390# VDD pfet_03v3 ad=0.1584p pd=1.6u as=56.7f ps=0.675u w=0.36u l=0.28u
X2166 a_8815_n2146.t27 RB8.t17 a_8077_4534# VSS nfet_03v3 ad=0.1584p pd=1.6u as=0.1152p ps=1u w=0.36u l=0.28u
X2167 VDD RB10.t17 a_6338_3124# VDD pfet_03v3 ad=0.3168p pd=2.32u as=0.3708p ps=2.47u w=0.72u l=0.28u
X2168 VDD.t2373 a_17196_n170# a_17330_20# VDD.t2372 pfet_03v3 ad=0.1764p pd=1.26u as=0.1584p ps=1.6u w=0.36u l=0.28u
X2169 a_24424_6102# a_24360_n708.t20 VDD VDD pfet_03v3 ad=0.2097p pd=1.38u as=0.3168p ps=2.32u w=0.72u l=0.28u
X2170 a_3437_4534# RA8.t21 VDD VDD pfet_03v3 ad=0.3888p pd=2.52u as=0.3312p ps=2.36u w=0.72u l=0.28u
X2171 a_33101_1398# RA12.t20 VDD VDD pfet_03v3 ad=0.3888p pd=2.52u as=0.3312p ps=2.36u w=0.72u l=0.28u
X2172 VDD a_n1204_3750.t20 a_27282_4254# VDD pfet_03v3 ad=0.1584p pd=1.6u as=56.7f ps=0.675u w=0.36u l=0.28u
X2173 a_17196_8454# a_n1204_8454.t12 a_17008_8454# VSS nfet_03v3 ad=0.1278p pd=1.07u as=0.1188p ps=1.02u w=0.36u l=0.28u
X2174 a_30325_8454# a_29556_8454# VDD VDD pfet_03v3 ad=0.36p pd=2.44u as=0.1764p ps=1.26u w=0.72u l=0.28u
X2175 a_90_1398# a_26_1588# a_n108_1398# VDD pfet_03v3 ad=56.7f pd=0.675u as=0.1278p ps=1.07u w=0.36u l=0.28u
X2176 a_37741_n170# a_36972_n170# VDD.t2634 VDD.t2552 pfet_03v3 ad=0.36p pd=2.44u as=0.1764p ps=1.26u w=0.72u l=0.28u
X2177 a_90_614# a_26_928# a_n108_614# VSS nfet_03v3 ad=56.7f pd=0.675u as=0.1278p ps=1.07u w=0.36u l=0.28u
X2178 a_14922_1902# a_14858_1588# a_14724_1398# VSS nfet_03v3 ad=56.7f pd=0.675u as=0.1278p ps=1.07u w=0.36u l=0.28u
X2179 a_36007_n2146.t5 RB1.t18 a_35269_10022# VSS nfet_03v3 ad=0.1584p pd=1.6u as=0.1152p ps=1u w=0.36u l=0.28u
X2180 a_17196_5318# a_n1204_5318.t14 a_17008_5318# VSS nfet_03v3 ad=0.1278p pd=1.07u as=0.1188p ps=1.02u w=0.36u l=0.28u
X2181 VDD a_n1204_614.t22 a_27282_1118# VDD pfet_03v3 ad=0.1584p pd=1.6u as=56.7f ps=0.675u w=0.36u l=0.28u
X2182 a_5034_614# a_4970_928# a_4836_614# VSS nfet_03v3 ad=56.7f pd=0.675u as=0.1278p ps=1.07u w=0.36u l=0.28u
X2183 a_17965_10022# RA1.t21 a_18433_n862.t1 VSS nfet_03v3 ad=0.1152p pd=1u as=0.1584p ps=1.6u w=0.36u l=0.28u
X2184 a_8077_8454# RA3.t15 a_8545_n862.t21 VSS nfet_03v3 ad=0.1152p pd=1u as=0.1584p ps=1.6u w=0.36u l=0.28u
X2185 a_34312_5318# a_34248_n708.t20 VDD VDD pfet_03v3 ad=0.2097p pd=1.38u as=0.3168p ps=2.32u w=0.72u l=0.28u
X2186 a_34312_2182# a_34248_n708.t21 VDD VDD pfet_03v3 ad=0.2097p pd=1.38u as=0.3168p ps=2.32u w=0.72u l=0.28u
X2187 a_36972_10022# a_n884_10022.t13 a_36784_10022# VDD pfet_03v3 ad=0.1278p pd=1.07u as=0.2097p ps=1.38u w=0.36u l=0.28u
X2188 a_17008_9238# a_16944_n708.t19 VSS VSS nfet_03v3 ad=0.1188p pd=1.02u as=0.1584p ps=1.6u w=0.36u l=0.28u
X2189 a_2176_5318# a_2112_n708.t22 VDD VDD pfet_03v3 ad=0.2097p pd=1.38u as=0.3168p ps=2.32u w=0.72u l=0.28u
X2190 a_19668_n170# a_n1204_n170.t21 a_19480_n170# VSS nfet_03v3 ad=0.1278p pd=1.07u as=0.1188p ps=1.02u w=0.36u l=0.28u
X2191 a_18703_n2146.t15 RB4.t13 a_17965_7670# VSS nfet_03v3 ad=0.1584p pd=1.6u as=0.1152p ps=1u w=0.36u l=0.28u
X2192 VDD WE0CLK.t19 a_9978_10806# VDD pfet_03v3 ad=0.1584p pd=1.6u as=56.7f ps=0.675u w=0.36u l=0.28u
X2193 a_17008_6102# a_16944_n708.t20 VSS VSS nfet_03v3 ad=0.1188p pd=1.02u as=0.1584p ps=1.6u w=0.36u l=0.28u
X2194 a_2176_2182# a_2112_n708.t23 VDD VDD pfet_03v3 ad=0.2097p pd=1.38u as=0.3168p ps=2.32u w=0.72u l=0.28u
X2195 a_2364_6886# a_n884_6886.t18 a_2176_6886# VDD pfet_03v3 ad=0.1278p pd=1.07u as=0.2097p ps=1.38u w=0.36u l=0.28u
X2196 a_27282_3470# a_27218_3156# a_27084_2966# VSS nfet_03v3 ad=56.7f pd=0.675u as=0.1278p ps=1.07u w=0.36u l=0.28u
X2197 VSS RB4.t14 a_31058_7828# VSS nfet_03v3 ad=0.1584p pd=1.6u as=0.1854p ps=1.75u w=0.36u l=0.28u
X2198 a_2364_3750# a_n884_3750.t14 a_2176_3750# VDD pfet_03v3 ad=0.1278p pd=1.07u as=0.2097p ps=1.38u w=0.36u l=0.28u
X2199 a_36972_2182# a_n1204_2182.t16 a_36784_2182# VSS nfet_03v3 ad=0.1278p pd=1.07u as=0.1188p ps=1.02u w=0.36u l=0.28u
X2200 a_12252_9238# a_n884_9238.t17 a_12064_9238# VDD pfet_03v3 ad=0.1278p pd=1.07u as=0.2097p ps=1.38u w=0.36u l=0.28u
X2201 VDD RB7.t20 a_28586_5664# VDD pfet_03v3 ad=0.3168p pd=2.32u as=0.3708p ps=2.47u w=0.72u l=0.28u
X2202 a_19416_n708.t1 a_19424_n1782# VDD VDD pfet_03v3 ad=0.3224p pd=1.76u as=0.5456p ps=3.36u w=1.24u l=0.28u
X2203 a_25381_n954# a_24612_n954# VDD.t2790 VDD.t2789 pfet_03v3 ad=0.36p pd=2.44u as=0.1764p ps=1.26u w=0.72u l=0.28u
X2204 a_6343_n2146.t20 a_6338_9396# a_5605_9238# VDD pfet_03v3 ad=0.1584p pd=1.6u as=0.1152p ps=1u w=0.36u l=0.28u
X2205 a_n352_n1782# a_152_n1738# a_440_n1738# VDD pfet_03v3 ad=0.1278p pd=1.07u as=56.7f ps=0.675u w=0.36u l=0.28u
X2206 a_2364_614# a_n884_614.t25 a_2176_614# VDD pfet_03v3 ad=0.1278p pd=1.07u as=0.2097p ps=1.38u w=0.36u l=0.28u
X2207 a_24612_1398# a_n1204_1398.t19 a_24424_1398# VSS nfet_03v3 ad=0.1278p pd=1.07u as=0.1188p ps=1.02u w=0.36u l=0.28u
X2208 a_5605_8454# a_4836_8454# VSS VSS nfet_03v3 ad=0.18p pd=1.72u as=97.2f ps=0.9u w=0.36u l=0.28u
X2209 VDD RB11.t16 a_28586_2528# VDD pfet_03v3 ad=0.3168p pd=2.32u as=0.3708p ps=2.47u w=0.72u l=0.28u
X2210 a_35269_10022# RA1.t22 a_35737_n862.t2 VSS nfet_03v3 ad=0.1152p pd=1u as=0.1584p ps=1.6u w=0.36u l=0.28u
X2211 VDD a_n1204_2182.t17 a_9978_2686# VDD pfet_03v3 ad=0.1584p pd=1.6u as=56.7f ps=0.675u w=0.36u l=0.28u
X2212 VSS a_12252_7670# a_12386_7860# VSS nfet_03v3 ad=97.2f pd=0.9u as=0.1584p ps=1.6u w=0.36u l=0.28u
X2213 a_5605_5318# a_4836_5318# VSS VSS nfet_03v3 ad=0.18p pd=1.72u as=97.2f ps=0.9u w=0.36u l=0.28u
X2214 a_29368_7670# a_29304_n708.t12 VSS VSS nfet_03v3 ad=0.1188p pd=1.02u as=0.1584p ps=1.6u w=0.36u l=0.28u
X2215 a_22909_6886# RA5.t16 a_23377_n862.t24 VSS nfet_03v3 ad=0.1152p pd=1u as=0.1584p ps=1.6u w=0.36u l=0.28u
X2216 a_15493_5318# RA7.t19 a_15961_n862.t8 VSS nfet_03v3 ad=0.1152p pd=1u as=0.1584p ps=1.6u w=0.36u l=0.28u
X2217 VSS a_12252_4534# a_12386_4724# VSS nfet_03v3 ad=97.2f pd=0.9u as=0.1584p ps=1.6u w=0.36u l=0.28u
X2218 a_35573_n170# RA14.t17 VDD.t1083 VDD.t453 pfet_03v3 ad=0.3888p pd=2.52u as=0.3312p ps=2.36u w=0.72u l=0.28u
X2219 a_27084_n170# a_n1204_n170.t22 a_26896_n170# VSS nfet_03v3 ad=0.1278p pd=1.07u as=0.1188p ps=1.02u w=0.36u l=0.28u
X2220 a_37741_10022# a_36972_10022# VSS VSS nfet_03v3 ad=0.18p pd=1.72u as=97.2f ps=0.9u w=0.36u l=0.28u
X2221 a_32797_7670# a_32028_7670# VSS VSS nfet_03v3 ad=0.18p pd=1.72u as=97.2f ps=0.9u w=0.36u l=0.28u
X2222 a_31063_n2146.t31 a_31058_5664# a_30325_5318# VDD pfet_03v3 ad=0.1584p pd=1.6u as=0.1152p ps=1u w=0.36u l=0.28u
X2223 a_38045_3842# RA9.t18 VDD VDD pfet_03v3 ad=0.3888p pd=2.52u as=0.3312p ps=2.36u w=0.72u l=0.28u
X2224 VSS a_9780_1398# a_9914_1588# VSS nfet_03v3 ad=97.2f pd=0.9u as=0.1584p ps=1.6u w=0.36u l=0.28u
X2225 a_2562_10806# a_2498_10996# a_2364_10806# VDD pfet_03v3 ad=56.7f pd=0.675u as=0.1278p ps=1.07u w=0.36u l=0.28u
X2226 a_14724_6886# a_n1204_6886.t21 a_14536_6886# VSS nfet_03v3 ad=0.1278p pd=1.07u as=0.1188p ps=1.02u w=0.36u l=0.28u
X2227 a_29368_4534# a_29304_n708.t13 VSS VSS nfet_03v3 ad=0.1188p pd=1.02u as=0.1584p ps=1.6u w=0.36u l=0.28u
X2228 a_965_6978# RA5.t17 VDD VDD pfet_03v3 ad=0.3888p pd=2.52u as=0.3312p ps=2.36u w=0.72u l=0.28u
X2229 a_32797_4534# a_32028_4534# VSS VSS nfet_03v3 ad=0.18p pd=1.72u as=97.2f ps=0.9u w=0.36u l=0.28u
X2230 a_5909_3842# RA9.t19 VDD VDD pfet_03v3 ad=0.3888p pd=2.52u as=0.3312p ps=2.36u w=0.72u l=0.28u
X2231 a_14724_n170# a_n1204_n170.t23 a_14536_n170# VSS nfet_03v3 ad=0.1278p pd=1.07u as=0.1188p ps=1.02u w=0.36u l=0.28u
X2232 a_38045_706# RA13.t17 VDD VDD pfet_03v3 ad=0.3888p pd=2.52u as=0.3312p ps=2.36u w=0.72u l=0.28u
X2233 VSS a_n884_10022.t14 a_7506_10022# VSS nfet_03v3 ad=0.1584p pd=1.6u as=56.7f ps=0.675u w=0.36u l=0.28u
X2234 VDD RB10.t18 a_3866_3124# VDD pfet_03v3 ad=0.3168p pd=2.32u as=0.3708p ps=2.47u w=0.72u l=0.28u
X2235 a_24810_2182# a_24746_2496# a_24612_2182# VSS nfet_03v3 ad=56.7f pd=0.675u as=0.1278p ps=1.07u w=0.36u l=0.28u
X2236 a_36720_n708.t3 a_36728_n1782# VDD VDD pfet_03v3 ad=0.3224p pd=1.76u as=0.5456p ps=3.36u w=1.24u l=0.28u
X2237 VDD.t3118 a_14724_n170# a_14858_20# VDD.t3117 pfet_03v3 ad=0.1764p pd=1.26u as=0.1584p ps=1.6u w=0.36u l=0.28u
X2238 a_30325_1398# a_29556_1398# VSS VSS nfet_03v3 ad=0.18p pd=1.72u as=97.2f ps=0.9u w=0.36u l=0.28u
X2239 a_6343_n2146.t28 RB8.t18 a_5605_4534# VSS nfet_03v3 ad=0.1584p pd=1.6u as=0.1152p ps=1u w=0.36u l=0.28u
X2240 a_30325_3750# RA9.t20 a_30793_n862.t12 VSS nfet_03v3 ad=0.1152p pd=1u as=0.1584p ps=1.6u w=0.36u l=0.28u
X2241 a_5909_706# RA13.t18 VDD VDD pfet_03v3 ad=0.3888p pd=2.52u as=0.3312p ps=2.36u w=0.72u l=0.28u
X2242 a_32028_10022# a_n1204_10022.t15 a_31840_10022# VSS nfet_03v3 ad=0.1278p pd=1.07u as=0.1188p ps=1.02u w=0.36u l=0.28u
X2243 a_661_2966# a_n108_2966# VSS VSS nfet_03v3 ad=0.18p pd=1.72u as=97.2f ps=0.9u w=0.36u l=0.28u
X2244 a_34698_n954# a_34634_n640# a_34500_n954# VSS nfet_03v3 ad=56.7f pd=0.675u as=0.1278p ps=1.07u w=0.36u l=0.28u
X2245 VDD a_27084_1398# a_27218_1588# VDD pfet_03v3 ad=0.1764p pd=1.26u as=0.1584p ps=1.6u w=0.36u l=0.28u
X2246 a_23213_10806# RA0.t21 VDD VDD pfet_03v3 ad=0.3888p pd=2.52u as=0.3312p ps=2.36u w=0.72u l=0.28u
X2247 VSS a_n108_3750# a_26_4064# VSS nfet_03v3 ad=97.2f pd=0.9u as=0.1584p ps=1.6u w=0.36u l=0.28u
X2248 a_12450_1902# a_12386_1588# a_12252_1398# VSS nfet_03v3 ad=56.7f pd=0.675u as=0.1278p ps=1.07u w=0.36u l=0.28u
X2249 VDD RB9.t18 a_8810_4096# VDD pfet_03v3 ad=0.3168p pd=2.32u as=0.3708p ps=2.47u w=0.72u l=0.28u
X2250 a_37741_8454# RA3.t16 a_38209_n862.t25 VSS nfet_03v3 ad=0.1152p pd=1u as=0.1584p ps=1.6u w=0.36u l=0.28u
X2251 VDD a_n1204_6886.t22 a_7506_7390# VDD pfet_03v3 ad=0.1584p pd=1.6u as=56.7f ps=0.675u w=0.36u l=0.28u
X2252 VDD RB0.t19 a_11282_10964# VDD pfet_03v3 ad=0.3168p pd=2.32u as=0.3708p ps=2.47u w=0.72u l=0.28u
X2253 VDD RB13.t18 a_8810_960# VDD pfet_03v3 ad=0.3168p pd=2.32u as=0.3708p ps=2.47u w=0.72u l=0.28u
X2254 a_14536_10806# a_14472_n708.t19 VSS VSS nfet_03v3 ad=0.1188p pd=1.02u as=0.1584p ps=1.6u w=0.36u l=0.28u
X2255 a_5605_8454# RA3.t17 a_6073_n862.t25 VSS nfet_03v3 ad=0.1152p pd=1u as=0.1584p ps=1.6u w=0.36u l=0.28u
X2256 VDD a_n1204_8454.t13 a_19866_8958# VDD pfet_03v3 ad=0.1584p pd=1.6u as=56.7f ps=0.675u w=0.36u l=0.28u
X2257 VDD a_n1204_3750.t21 a_7506_4254# VDD pfet_03v3 ad=0.1584p pd=1.6u as=56.7f ps=0.675u w=0.36u l=0.28u
X2258 VDD a_17196_10806# a_17330_10996# VDD pfet_03v3 ad=0.1764p pd=1.26u as=0.1584p ps=1.6u w=0.36u l=0.28u
X2259 a_24424_3750# a_24360_n708.t21 VSS VSS nfet_03v3 ad=0.1188p pd=1.02u as=0.1584p ps=1.6u w=0.36u l=0.28u
X2260 a_18269_2274# RA11.t21 VSS VSS nfet_03v3 ad=0.1944p pd=1.8u as=0.1656p ps=1.64u w=0.36u l=0.28u
X2261 VSS a_35737_n862.t32 QA14b.t1 VSS nfet_03v3 ad=0.1242p pd=1.05u as=0.2052p ps=1.86u w=0.36u l=0.28u
X2262 a_14536_9238# a_14472_n708.t20 VSS VSS nfet_03v3 ad=0.1188p pd=1.02u as=0.1584p ps=1.6u w=0.36u l=0.28u
X2263 VDD a_n1204_614.t23 a_7506_1118# VDD pfet_03v3 ad=0.1584p pd=1.6u as=56.7f ps=0.675u w=0.36u l=0.28u
X2264 a_965_10114# RA1.t23 VSS VSS nfet_03v3 ad=0.1944p pd=1.8u as=0.1656p ps=1.64u w=0.36u l=0.28u
X2265 a_16231_n2146.t13 RB4.t15 a_15493_7670# VSS nfet_03v3 ad=0.1584p pd=1.6u as=0.1152p ps=1u w=0.36u l=0.28u
X2266 a_14536_6102# a_14472_n708.t21 VSS VSS nfet_03v3 ad=0.1188p pd=1.02u as=0.1584p ps=1.6u w=0.36u l=0.28u
X2267 a_36007_n2146.t20 RB0.t20 a_35269_10806# VSS nfet_03v3 ad=0.1584p pd=1.6u as=0.1152p ps=1u w=0.36u l=0.28u
X2268 a_19866_8454# a_19802_8768# a_19668_8454# VSS nfet_03v3 ad=56.7f pd=0.675u as=0.1278p ps=1.07u w=0.36u l=0.28u
X2269 a_8381_10114# RA1.t24 VSS VSS nfet_03v3 ad=0.1944p pd=1.8u as=0.1656p ps=1.64u w=0.36u l=0.28u
X2270 a_34500_2182# a_n1204_2182.t18 a_34312_2182# VSS nfet_03v3 ad=0.1278p pd=1.07u as=0.1188p ps=1.02u w=0.36u l=0.28u
X2271 a_36007_n2146.t1 RB15.t22 a_35269_n954# VSS nfet_03v3 ad=0.1584p pd=1.6u as=0.1152p ps=1u w=0.36u l=0.28u
X2272 a_38479_n2146.t8 RB14.t22 a_37741_n170# VSS nfet_03v3 ad=0.1584p pd=1.6u as=0.1152p ps=1u w=0.36u l=0.28u
X2273 a_17965_n170# a_18269_n170# a_18433_n862.t27 VDD.t2018 pfet_03v3 ad=0.1152p pd=1u as=0.1584p ps=1.6u w=0.36u l=0.28u
X2274 a_17965_10806# RA0.t22 a_18433_n862.t16 VSS nfet_03v3 ad=0.1152p pd=1u as=0.1584p ps=1.6u w=0.36u l=0.28u
X2275 a_19866_5318# a_19802_5632# a_19668_5318# VSS nfet_03v3 ad=56.7f pd=0.675u as=0.1278p ps=1.07u w=0.36u l=0.28u
X2276 a_3133_8454# a_2364_8454# VSS VSS nfet_03v3 ad=0.18p pd=1.72u as=97.2f ps=0.9u w=0.36u l=0.28u
X2277 VDD RB10.t19 a_36002_3124# VDD pfet_03v3 ad=0.3168p pd=2.32u as=0.3708p ps=2.47u w=0.72u l=0.28u
X2278 a_29312_n1782# a_29816_n1738# a_30104_n1738# VDD pfet_03v3 ad=0.1278p pd=1.07u as=56.7f ps=0.675u w=0.36u l=0.28u
X2279 a_22140_1398# a_n1204_1398.t20 a_21952_1398# VSS nfet_03v3 ad=0.1278p pd=1.07u as=0.1188p ps=1.02u w=0.36u l=0.28u
X2280 a_31840_10806# a_31776_n708.t16 VSS VSS nfet_03v3 ad=0.1188p pd=1.02u as=0.1584p ps=1.6u w=0.36u l=0.28u
X2281 a_5384_n1738# WEM.t12 VDD VDD pfet_03v3 ad=56.7f pd=0.675u as=0.1584p ps=1.6u w=0.36u l=0.28u
X2282 a_31063_n2146.t29 a_31058_10368# a_30325_10022# VDD pfet_03v3 ad=0.1584p pd=1.6u as=0.1152p ps=1u w=0.36u l=0.28u
X2283 a_3133_5318# a_2364_5318# VSS VSS nfet_03v3 ad=0.18p pd=1.72u as=97.2f ps=0.9u w=0.36u l=0.28u
X2284 VSS a_19668_2182# a_19802_2496# VSS nfet_03v3 ad=97.2f pd=0.9u as=0.1584p ps=1.6u w=0.36u l=0.28u
X2285 VSS.t748 RB15.t23 a_38474_n608# VSS nfet_03v3 ad=0.1584p pd=1.6u as=0.1854p ps=1.75u w=0.36u l=0.28u
X2286 VSS.t2960 a_29556_n954# a_29690_n640# VSS nfet_03v3 ad=97.2f pd=0.9u as=0.1584p ps=1.6u w=0.36u l=0.28u
X2287 a_5605_n954# a_4836_n954# VDD.t2523 VDD.t2522 pfet_03v3 ad=0.36p pd=2.44u as=0.1764p ps=1.26u w=0.72u l=0.28u
X2288 a_33101_n170# RA14.t18 VDD.t1084 VDD.t455 pfet_03v3 ad=0.3888p pd=2.52u as=0.3312p ps=2.36u w=0.72u l=0.28u
X2289 a_22338_334# a_22274_20# a_22140_n170# VSS nfet_03v3 ad=56.7f pd=0.675u as=0.1278p ps=1.07u w=0.36u l=0.28u
X2290 a_30325_9238# a_30629_9238# a_30793_n862.t5 VDD pfet_03v3 ad=0.1152p pd=1u as=0.1584p ps=1.6u w=0.36u l=0.28u
X2291 a_12252_6886# a_n1204_6886.t23 a_12064_6886# VSS nfet_03v3 ad=0.1278p pd=1.07u as=0.1188p ps=1.02u w=0.36u l=0.28u
X2292 a_n884_614.t1 a_n1204_614.t24 VDD VDD pfet_03v3 ad=0.3886p pd=1.92u as=0.3386p ps=1.86u w=1.34u l=0.28u
X2293 a_14922_9238# a_14858_9428# a_14724_9238# VDD pfet_03v3 ad=56.7f pd=0.675u as=0.1278p ps=1.07u w=0.36u l=0.28u
X2294 a_36784_6102# a_36720_n708.t20 VDD VDD pfet_03v3 ad=0.2097p pd=1.38u as=0.3168p ps=2.32u w=0.72u l=0.28u
X2295 a_90_n170# a_26_20# a_n108_n170# VDD.t2002 pfet_03v3 ad=56.7f pd=0.675u as=0.1278p ps=1.07u w=0.36u l=0.28u
X2296 a_35269_10806# RA0.t23 a_35737_n862.t13 VSS nfet_03v3 ad=0.1152p pd=1u as=0.1584p ps=1.6u w=0.36u l=0.28u
X2297 a_15797_8546# RA3.t18 VDD VDD pfet_03v3 ad=0.3888p pd=2.52u as=0.3312p ps=2.36u w=0.72u l=0.28u
X2298 a_3437_3842# RA9.t21 VDD VDD pfet_03v3 ad=0.3888p pd=2.52u as=0.3312p ps=2.36u w=0.72u l=0.28u
X2299 a_11287_n2146.t17 RB11.t17 a_10549_2182# VSS nfet_03v3 ad=0.1584p pd=1.6u as=0.1152p ps=1u w=0.36u l=0.28u
X2300 a_32028_614# a_n1204_614.t25 a_31840_614# VSS nfet_03v3 ad=0.1278p pd=1.07u as=0.1188p ps=1.02u w=0.36u l=0.28u
X2301 a_15493_9238# RA2.t18 a_15961_n862.t4 VSS nfet_03v3 ad=0.1152p pd=1u as=0.1584p ps=1.6u w=0.36u l=0.28u
X2302 a_29556_8454# a_n1204_8454.t14 a_29368_8454# VSS nfet_03v3 ad=0.1278p pd=1.07u as=0.1188p ps=1.02u w=0.36u l=0.28u
X2303 a_9592_7670# a_9528_n708.t12 VSS VSS nfet_03v3 ad=0.1188p pd=1.02u as=0.1584p ps=1.6u w=0.36u l=0.28u
X2304 a_22338_2182# a_22274_2496# a_22140_2182# VSS nfet_03v3 ad=56.7f pd=0.675u as=0.1278p ps=1.07u w=0.36u l=0.28u
X2305 a_3437_706# RA13.t19 VDD VDD pfet_03v3 ad=0.3888p pd=2.52u as=0.3312p ps=2.36u w=0.72u l=0.28u
X2306 a_13325_10114# RA1.t25 VSS VSS nfet_03v3 ad=0.1944p pd=1.8u as=0.1656p ps=1.64u w=0.36u l=0.28u
X2307 a_22338_10526# a_22274_10336# a_22140_10022# VDD pfet_03v3 ad=56.7f pd=0.675u as=0.1278p ps=1.07u w=0.36u l=0.28u
X2308 a_3133_6886# RA5.t18 a_3601_n862.t23 VSS nfet_03v3 ad=0.1152p pd=1u as=0.1584p ps=1.6u w=0.36u l=0.28u
X2309 a_15493_6102# RA6.t19 a_15961_n862.t16 VSS nfet_03v3 ad=0.1152p pd=1u as=0.1584p ps=1.6u w=0.36u l=0.28u
X2310 a_29556_5318# a_n1204_5318.t15 a_29368_5318# VSS nfet_03v3 ad=0.1278p pd=1.07u as=0.1188p ps=1.02u w=0.36u l=0.28u
X2311 a_17965_2966# a_17196_2966# VDD VDD pfet_03v3 ad=0.36p pd=2.44u as=0.1764p ps=1.26u w=0.72u l=0.28u
X2312 a_9592_4534# a_9528_n708.t13 VSS VSS nfet_03v3 ad=0.1188p pd=1.02u as=0.1584p ps=1.6u w=0.36u l=0.28u
X2313 a_32226_n954# a_32162_n640# a_32028_n954# VSS nfet_03v3 ad=56.7f pd=0.675u as=0.1278p ps=1.07u w=0.36u l=0.28u
X2314 VDD a_24612_1398# a_24746_1588# VDD pfet_03v3 ad=0.1764p pd=1.26u as=0.1584p ps=1.6u w=0.36u l=0.28u
X2315 a_5034_2182# a_4970_2496# a_4836_2182# VSS nfet_03v3 ad=56.7f pd=0.675u as=0.1278p ps=1.07u w=0.36u l=0.28u
X2316 a_30325_10022# a_30629_10114# a_30793_n862.t31 VDD pfet_03v3 ad=0.1152p pd=1u as=0.1584p ps=1.6u w=0.36u l=0.28u
X2317 VDD a_n1204_6886.t24 a_5034_7390# VDD pfet_03v3 ad=0.1584p pd=1.6u as=56.7f ps=0.675u w=0.36u l=0.28u
X2318 a_30325_4534# RA8.t22 a_30793_n862.t4 VSS nfet_03v3 ad=0.1152p pd=1u as=0.1584p ps=1.6u w=0.36u l=0.28u
X2319 VDD a_n1204_3750.t22 a_5034_4254# VDD pfet_03v3 ad=0.1584p pd=1.6u as=56.7f ps=0.675u w=0.36u l=0.28u
X2320 VDD a_7308_1398# a_7442_1588# VDD pfet_03v3 ad=0.1764p pd=1.26u as=0.1584p ps=1.6u w=0.36u l=0.28u
X2321 VDD a_n1204_8454.t15 a_17394_8958# VDD pfet_03v3 ad=0.1584p pd=1.6u as=56.7f ps=0.675u w=0.36u l=0.28u
X2322 a_35269_8454# a_34500_8454# VSS VSS nfet_03v3 ad=0.18p pd=1.72u as=97.2f ps=0.9u w=0.36u l=0.28u
X2323 a_n884_1398.t3 a_n1204_1398.t21 VSS VSS nfet_03v3 ad=0.1943p pd=1.25u as=0.1693p ps=1.19u w=0.67u l=0.28u
X2324 a_19928_n1738# a_19424_n1782# VDD VDD pfet_03v3 ad=0.1584p pd=1.6u as=0.1584p ps=1.6u w=0.36u l=0.28u
X2325 VDD a_n1204_614.t26 a_5034_1118# VDD pfet_03v3 ad=0.1584p pd=1.6u as=56.7f ps=0.675u w=0.36u l=0.28u
X2326 a_35269_5318# a_34500_5318# VSS VSS nfet_03v3 ad=0.18p pd=1.72u as=97.2f ps=0.9u w=0.36u l=0.28u
X2327 a_n108_2182# a_n884_2182.t17 a_n296_2182# VDD pfet_03v3 ad=0.1278p pd=1.07u as=0.2097p ps=1.38u w=0.36u l=0.28u
X2328 a_26119_n2146.t14 RB14.t23 a_25381_n170# VSS nfet_03v3 ad=0.1584p pd=1.6u as=0.1152p ps=1u w=0.36u l=0.28u
X2329 a_24612_9238# a_n884_9238.t18 a_24424_9238# VDD pfet_03v3 ad=0.1278p pd=1.07u as=0.2097p ps=1.38u w=0.36u l=0.28u
X2330 a_30629_2966# RA10.t19 VDD VDD pfet_03v3 ad=0.3888p pd=2.52u as=0.3312p ps=2.36u w=0.72u l=0.28u
X2331 VDD a_n1204_5318.t16 a_24810_5822# VDD pfet_03v3 ad=0.1584p pd=1.6u as=56.7f ps=0.675u w=0.36u l=0.28u
X2332 a_36972_1398# a_n1204_1398.t22 a_36784_1398# VSS nfet_03v3 ad=0.1278p pd=1.07u as=0.1188p ps=1.02u w=0.36u l=0.28u
X2333 a_19480_10806# a_19416_n708.t13 VDD VDD pfet_03v3 ad=0.2097p pd=1.38u as=0.3168p ps=2.32u w=0.72u l=0.28u
X2334 a_36007_n2146.t14 a_36002_8800# a_35269_8454# VDD pfet_03v3 ad=0.1584p pd=1.6u as=0.1152p ps=1u w=0.36u l=0.28u
X2335 a_21888_n708.t2 a_21896_n1782# VSS.t2313 VSS nfet_03v3 ad=0.1612p pd=1.14u as=0.2728p ps=2.12u w=0.62u l=0.28u
X2336 a_13759_n2146.t15 RB14.t24 a_13021_n170# VSS nfet_03v3 ad=0.1584p pd=1.6u as=0.1152p ps=1u w=0.36u l=0.28u
X2337 a_18269_2966# RA10.t20 VSS VSS nfet_03v3 ad=0.1944p pd=1.8u as=0.1656p ps=1.64u w=0.36u l=0.28u
X2338 VDD a_n1204_2182.t19 a_22338_2686# VDD pfet_03v3 ad=0.1584p pd=1.6u as=56.7f ps=0.675u w=0.36u l=0.28u
X2339 a_20437_n170# a_19668_n170# VSS VSS nfet_03v3 ad=0.18p pd=1.72u as=97.2f ps=0.9u w=0.36u l=0.28u
X2340 VSS a_n1652_10454# a_n1204_10022.t2 VSS nfet_03v3 ad=0.1693p pd=1.19u as=0.1651p ps=1.155u w=0.635u l=0.28u
X2341 VDD a_9780_9238# a_9914_9428# VDD pfet_03v3 ad=0.1764p pd=1.26u as=0.1584p ps=1.6u w=0.36u l=0.28u
X2342 a_32028_6102# a_n884_6102.t18 a_31840_6102# VDD pfet_03v3 ad=0.1278p pd=1.07u as=0.2097p ps=1.38u w=0.36u l=0.28u
X2343 a_965_5410# RA7.t20 VSS VSS nfet_03v3 ad=0.1944p pd=1.8u as=0.1656p ps=1.64u w=0.36u l=0.28u
X2344 a_13759_n2146.t9 RB7.t21 a_13021_5318# VSS nfet_03v3 ad=0.1584p pd=1.6u as=0.1152p ps=1u w=0.36u l=0.28u
X2345 a_35269_6886# RA5.t19 a_35737_n862.t16 VSS nfet_03v3 ad=0.1152p pd=1u as=0.1584p ps=1.6u w=0.36u l=0.28u
X2346 a_27853_5318# RA7.t21 a_28321_n862.t7 VSS nfet_03v3 ad=0.1152p pd=1u as=0.1584p ps=1.6u w=0.36u l=0.28u
X2347 a_965_10806# RA0.t24 VSS VSS nfet_03v3 ad=0.1944p pd=1.8u as=0.1656p ps=1.64u w=0.36u l=0.28u
X2348 VDD a_n1204_10022.t16 a_37170_10526# VDD pfet_03v3 ad=0.1584p pd=1.6u as=56.7f ps=0.675u w=0.36u l=0.28u
X2349 a_30325_9238# a_29556_9238# VDD VDD pfet_03v3 ad=0.36p pd=2.44u as=0.1764p ps=1.26u w=0.72u l=0.28u
X2350 a_4836_7670# a_n1204_7670.t20 a_4648_7670# VSS nfet_03v3 ad=0.1278p pd=1.07u as=0.1188p ps=1.02u w=0.36u l=0.28u
X2351 a_31840_2966# a_31776_n708.t17 VSS VSS nfet_03v3 ad=0.1188p pd=1.02u as=0.1584p ps=1.6u w=0.36u l=0.28u
X2352 a_8381_10806# RA0.t25 VSS VSS nfet_03v3 ad=0.1944p pd=1.8u as=0.1656p ps=1.64u w=0.36u l=0.28u
X2353 a_2562_7390# a_2498_7200# a_2364_6886# VDD pfet_03v3 ad=56.7f pd=0.675u as=0.1278p ps=1.07u w=0.36u l=0.28u
X2354 a_4836_4534# a_n1204_4534.t21 a_4648_4534# VSS nfet_03v3 ad=0.1278p pd=1.07u as=0.1188p ps=1.02u w=0.36u l=0.28u
X2355 a_3133_n954# a_2364_n954# VDD.t2325 VDD.t2324 pfet_03v3 ad=0.36p pd=2.44u as=0.1764p ps=1.26u w=0.72u l=0.28u
X2356 VSS a_22140_7670# a_22274_7860# VSS nfet_03v3 ad=97.2f pd=0.9u as=0.1584p ps=1.6u w=0.36u l=0.28u
X2357 VDD a_n1204_6886.t25 a_37170_7390# VDD pfet_03v3 ad=0.1584p pd=1.6u as=56.7f ps=0.675u w=0.36u l=0.28u
X2358 VDD.t2988 a_27084_n170# a_27218_20# VDD.t2464 pfet_03v3 ad=0.1764p pd=1.26u as=0.1584p ps=1.6u w=0.36u l=0.28u
X2359 a_12450_9238# a_12386_9428# a_12252_9238# VDD pfet_03v3 ad=56.7f pd=0.675u as=0.1278p ps=1.07u w=0.36u l=0.28u
X2360 a_34312_6102# a_34248_n708.t22 VDD VDD pfet_03v3 ad=0.2097p pd=1.38u as=0.3168p ps=2.32u w=0.72u l=0.28u
X2361 a_2562_4254# a_2498_4064# a_2364_3750# VDD pfet_03v3 ad=56.7f pd=0.675u as=0.1278p ps=1.07u w=0.36u l=0.28u
X2362 a_36784_10806# a_36720_n708.t21 VDD VDD pfet_03v3 ad=0.2097p pd=1.38u as=0.3168p ps=2.32u w=0.72u l=0.28u
X2363 VSS a_22140_4534# a_22274_4724# VSS nfet_03v3 ad=97.2f pd=0.9u as=0.1584p ps=1.6u w=0.36u l=0.28u
X2364 VDD a_n1204_3750.t23 a_37170_4254# VDD pfet_03v3 ad=0.1584p pd=1.6u as=56.7f ps=0.675u w=0.36u l=0.28u
X2365 a_2176_6102# a_2112_n708.t24 VDD VDD pfet_03v3 ad=0.2097p pd=1.38u as=0.3168p ps=2.32u w=0.72u l=0.28u
X2366 a_31840_n170# a_31776_n708.t18 VSS VSS nfet_03v3 ad=0.1188p pd=1.02u as=0.1584p ps=1.6u w=0.36u l=0.28u
X2367 a_21175_n2146.t16 RB14.t25 a_20437_n170# VSS nfet_03v3 ad=0.1584p pd=1.6u as=0.1152p ps=1u w=0.36u l=0.28u
X2368 a_2562_1118# a_2498_928# a_2364_614# VDD pfet_03v3 ad=56.7f pd=0.675u as=0.1278p ps=1.07u w=0.36u l=0.28u
X2369 a_24810_1902# a_24746_1588# a_24612_1398# VSS nfet_03v3 ad=56.7f pd=0.675u as=0.1278p ps=1.07u w=0.36u l=0.28u
X2370 a_23213_10114# RA1.t26 VDD VDD pfet_03v3 ad=0.3888p pd=2.52u as=0.3312p ps=2.36u w=0.72u l=0.28u
X2371 a_7120_7670# a_7056_n708.t13 VSS VSS nfet_03v3 ad=0.1188p pd=1.02u as=0.1584p ps=1.6u w=0.36u l=0.28u
X2372 a_15493_2966# a_14724_2966# VDD VDD pfet_03v3 ad=0.36p pd=2.44u as=0.1764p ps=1.26u w=0.72u l=0.28u
X2373 VDD a_n1204_614.t27 a_37170_1118# VDD pfet_03v3 ad=0.1584p pd=1.6u as=56.7f ps=0.675u w=0.36u l=0.28u
X2374 a_7120_4534# a_7056_n708.t14 VSS VSS nfet_03v3 ad=0.1188p pd=1.02u as=0.1584p ps=1.6u w=0.36u l=0.28u
X2375 VDD a_24368_n1782# a_24360_n708.t3 VDD pfet_03v3 ad=0.5456p pd=3.36u as=0.3224p ps=1.76u w=1.24u l=0.28u
X2376 VDD RB1.t19 a_11282_10368# VDD pfet_03v3 ad=0.3168p pd=2.32u as=0.3708p ps=2.47u w=0.72u l=0.28u
X2377 a_26896_9238# a_26832_n708.t20 VSS VSS nfet_03v3 ad=0.1188p pd=1.02u as=0.1584p ps=1.6u w=0.36u l=0.28u
X2378 a_9780_8454# a_n1204_8454.t16 a_9592_8454# VSS nfet_03v3 ad=0.1278p pd=1.07u as=0.1188p ps=1.02u w=0.36u l=0.28u
X2379 a_14922_6886# a_14858_7200# a_14724_6886# VSS nfet_03v3 ad=56.7f pd=0.675u as=0.1278p ps=1.07u w=0.36u l=0.28u
X2380 a_36784_3750# a_36720_n708.t22 VSS VSS nfet_03v3 ad=0.1188p pd=1.02u as=0.1584p ps=1.6u w=0.36u l=0.28u
X2381 a_28591_n2146.t23 a_28586_2528# a_27853_2182# VDD pfet_03v3 ad=0.1584p pd=1.6u as=0.1152p ps=1u w=0.36u l=0.28u
X2382 a_17394_10526# a_17330_10336# a_17196_10022# VDD pfet_03v3 ad=56.7f pd=0.675u as=0.1278p ps=1.07u w=0.36u l=0.28u
X2383 VDD RB6.t20 a_28586_6260# VDD pfet_03v3 ad=0.3168p pd=2.32u as=0.3708p ps=2.47u w=0.72u l=0.28u
X2384 a_11287_n2146.t3 RB10.t20 a_10549_2966# VSS nfet_03v3 ad=0.1584p pd=1.6u as=0.1152p ps=1u w=0.36u l=0.28u
X2385 VDD D11.t0 a_27949_n1738# VDD pfet_03v3 ad=0.3168p pd=2.32u as=0.2097p ps=1.38u w=0.72u l=0.28u
X2386 VSS a_n884_8454.t18 a_90_8454# VSS nfet_03v3 ad=0.1584p pd=1.6u as=56.7f ps=0.675u w=0.36u l=0.28u
X2387 a_26896_6102# a_26832_n708.t21 VSS VSS nfet_03v3 ad=0.1188p pd=1.02u as=0.1584p ps=1.6u w=0.36u l=0.28u
X2388 a_9780_5318# a_n1204_5318.t17 a_9592_5318# VSS nfet_03v3 ad=0.1278p pd=1.07u as=0.1188p ps=1.02u w=0.36u l=0.28u
X2389 a_10549_3750# RA9.t22 a_11017_n862.t12 VSS nfet_03v3 ad=0.1152p pd=1u as=0.1584p ps=1.6u w=0.36u l=0.28u
X2390 VDD a_4836_1398# a_4970_1588# VDD pfet_03v3 ad=0.1764p pd=1.26u as=0.1584p ps=1.6u w=0.36u l=0.28u
X2391 a_13325_10806# RA0.t26 VSS VSS nfet_03v3 ad=0.1944p pd=1.8u as=0.1656p ps=1.64u w=0.36u l=0.28u
X2392 a_37170_3470# a_37106_3156# a_36972_2966# VSS nfet_03v3 ad=56.7f pd=0.675u as=0.1278p ps=1.07u w=0.36u l=0.28u
X2393 VSS a_n884_5318.t15 a_90_5318# VSS nfet_03v3 ad=0.1584p pd=1.6u as=56.7f ps=0.675u w=0.36u l=0.28u
X2394 a_7506_10022# a_7442_10336# a_7308_10022# VSS nfet_03v3 ad=56.7f pd=0.675u as=0.1278p ps=1.07u w=0.36u l=0.28u
X2395 a_25381_10022# a_25685_10114# a_25849_n862.t27 VDD pfet_03v3 ad=0.1152p pd=1u as=0.1584p ps=1.6u w=0.36u l=0.28u
X2396 a_22140_9238# a_n884_9238.t19 a_21952_9238# VDD pfet_03v3 ad=0.1278p pd=1.07u as=0.2097p ps=1.38u w=0.36u l=0.28u
X2397 VDD RB7.t22 a_38474_5664# VDD pfet_03v3 ad=0.3168p pd=2.32u as=0.3708p ps=2.47u w=0.72u l=0.28u
X2398 a_35269_n954# a_34500_n954# VDD.t2453 VDD.t2452 pfet_03v3 ad=0.36p pd=2.44u as=0.1764p ps=1.26u w=0.72u l=0.28u
X2399 VDD.t1229 a_n1204_n954.t18 a_12450_n450# VDD.t1228 pfet_03v3 ad=0.1584p pd=1.6u as=56.7f ps=0.675u w=0.36u l=0.28u
X2400 VSS RB3.t13 a_1394_8800# VSS nfet_03v3 ad=0.1584p pd=1.6u as=0.1854p ps=1.75u w=0.36u l=0.28u
X2401 a_34500_1398# a_n1204_1398.t23 a_34312_1398# VSS nfet_03v3 ad=0.1278p pd=1.07u as=0.1188p ps=1.02u w=0.36u l=0.28u
X2402 a_29754_8454# a_29690_8768# a_29556_8454# VSS nfet_03v3 ad=56.7f pd=0.675u as=0.1278p ps=1.07u w=0.36u l=0.28u
X2403 a_n296_2966# a_n360_n708.t18 VDD VDD pfet_03v3 ad=0.2097p pd=1.38u as=0.3168p ps=2.32u w=0.72u l=0.28u
X2404 VDD RB11.t18 a_38474_2528# VDD pfet_03v3 ad=0.3168p pd=2.32u as=0.3708p ps=2.47u w=0.72u l=0.28u
X2405 a_19424_n1782# a_19928_n1738# a_20216_n1234# VSS nfet_03v3 ad=0.1278p pd=1.07u as=56.7f ps=0.675u w=0.36u l=0.28u
X2406 a_29754_5318# a_29690_5632# a_29556_5318# VSS nfet_03v3 ad=56.7f pd=0.675u as=0.1278p ps=1.07u w=0.36u l=0.28u
X2407 VSS a_n884_n170.t13 a_9978_334# VSS nfet_03v3 ad=0.1584p pd=1.6u as=56.7f ps=0.675u w=0.36u l=0.28u
X2408 VSS RB12.t21 a_28586_1556# VSS nfet_03v3 ad=0.1584p pd=1.6u as=0.1854p ps=1.75u w=0.36u l=0.28u
X2409 a_37741_10806# a_38045_10806# a_38209_n862.t27 VDD pfet_03v3 ad=0.1152p pd=1u as=0.1584p ps=1.6u w=0.36u l=0.28u
X2410 a_32797_6886# RA5.t20 a_33265_n862.t18 VSS nfet_03v3 ad=0.1152p pd=1u as=0.1584p ps=1.6u w=0.36u l=0.28u
X2411 a_24612_6886# a_n1204_6886.t26 a_24424_6886# VSS nfet_03v3 ad=0.1278p pd=1.07u as=0.1188p ps=1.02u w=0.36u l=0.28u
X2412 a_15797_3842# RA9.t23 VSS VSS nfet_03v3 ad=0.1944p pd=1.8u as=0.1656p ps=1.64u w=0.36u l=0.28u
X2413 VSS RB14.t26 a_1394_n12# VSS nfet_03v3 ad=0.1584p pd=1.6u as=0.1854p ps=1.75u w=0.36u l=0.28u
X2414 VSS a_19668_1398# a_19802_1588# VSS nfet_03v3 ad=97.2f pd=0.9u as=0.1584p ps=1.6u w=0.36u l=0.28u
X2415 VSS a_34500_10806# a_34634_10996# VSS nfet_03v3 ad=97.2f pd=0.9u as=0.1584p ps=1.6u w=0.36u l=0.28u
X2416 VDD a_n1204_2182.t20 a_2562_2686# VDD pfet_03v3 ad=0.1584p pd=1.6u as=56.7f ps=0.675u w=0.36u l=0.28u
X2417 a_965_9238# RA2.t19 VSS VSS nfet_03v3 ad=0.1944p pd=1.8u as=0.1656p ps=1.64u w=0.36u l=0.28u
X2418 a_13759_n2146.t8 RB2.t19 a_13021_9238# VSS nfet_03v3 ad=0.1584p pd=1.6u as=0.1152p ps=1u w=0.36u l=0.28u
X2419 VDD RB4.t16 a_11282_7828# VDD pfet_03v3 ad=0.3168p pd=2.32u as=0.3708p ps=2.47u w=0.72u l=0.28u
X2420 VDD a_n1204_6102.t16 a_n884_6102.t1 VDD pfet_03v3 ad=0.5896p pd=3.56u as=0.3886p ps=1.92u w=1.34u l=0.28u
X2421 a_23647_n2146.t12 RB11.t19 a_22909_2182# VSS nfet_03v3 ad=0.1584p pd=1.6u as=0.1152p ps=1u w=0.36u l=0.28u
X2422 a_8077_1398# a_8381_1398# a_8545_n862.t31 VDD pfet_03v3 ad=0.1152p pd=1u as=0.1584p ps=1.6u w=0.36u l=0.28u
X2423 a_27853_9238# RA2.t20 a_28321_n862.t2 VSS nfet_03v3 ad=0.1152p pd=1u as=0.1584p ps=1.6u w=0.36u l=0.28u
X2424 VDD RB8.t19 a_11282_4692# VDD pfet_03v3 ad=0.3168p pd=2.32u as=0.3708p ps=2.47u w=0.72u l=0.28u
X2425 a_34698_2182# a_34634_2496# a_34500_2182# VSS nfet_03v3 ad=56.7f pd=0.675u as=0.1278p ps=1.07u w=0.36u l=0.28u
X2426 VDD.t2842 a_24612_n170# a_24746_20# VDD.t2791 pfet_03v3 ad=0.1764p pd=1.26u as=0.1584p ps=1.6u w=0.36u l=0.28u
X2427 a_38479_n2146.t4 RB1.t20 a_37741_10022# VSS nfet_03v3 ad=0.1584p pd=1.6u as=0.1152p ps=1u w=0.36u l=0.28u
X2428 a_20437_7670# RA4.t21 a_20905_n862.t16 VSS nfet_03v3 ad=0.1152p pd=1u as=0.1584p ps=1.6u w=0.36u l=0.28u
X2429 a_965_6102# RA6.t20 VSS VSS nfet_03v3 ad=0.1944p pd=1.8u as=0.1656p ps=1.64u w=0.36u l=0.28u
X2430 a_13759_n2146.t7 RB6.t21 a_13021_6102# VSS nfet_03v3 ad=0.1584p pd=1.6u as=0.1152p ps=1u w=0.36u l=0.28u
X2431 a_27853_6102# RA6.t21 a_28321_n862.t18 VSS nfet_03v3 ad=0.1152p pd=1u as=0.1584p ps=1.6u w=0.36u l=0.28u
X2432 a_32028_3750# a_n1204_3750.t24 a_31840_3750# VSS nfet_03v3 ad=0.1278p pd=1.07u as=0.1188p ps=1.02u w=0.36u l=0.28u
X2433 a_12450_10022# a_12386_10336# a_12252_10022# VSS nfet_03v3 ad=56.7f pd=0.675u as=0.1278p ps=1.07u w=0.36u l=0.28u
X2434 VSS a_9780_6886# a_9914_7200# VSS nfet_03v3 ad=97.2f pd=0.9u as=0.1584p ps=1.6u w=0.36u l=0.28u
X2435 VDD a_36972_1398# a_37106_1588# VDD pfet_03v3 ad=0.1764p pd=1.26u as=0.1584p ps=1.6u w=0.36u l=0.28u
X2436 a_22338_1902# a_22274_1588# a_22140_1398# VSS nfet_03v3 ad=56.7f pd=0.675u as=0.1278p ps=1.07u w=0.36u l=0.28u
X2437 VDD a_n1204_10022.t17 a_2562_10526# VDD pfet_03v3 ad=0.1584p pd=1.6u as=56.7f ps=0.675u w=0.36u l=0.28u
X2438 VSS.t749 RB15.t24 a_18698_n608# VSS nfet_03v3 ad=0.1584p pd=1.6u as=0.1854p ps=1.75u w=0.36u l=0.28u
X2439 VDD.t2863 a_7308_n170# a_7442_20# VDD.t2862 pfet_03v3 ad=0.1764p pd=1.26u as=0.1584p ps=1.6u w=0.36u l=0.28u
X2440 a_30325_6886# a_29556_6886# VSS VSS nfet_03v3 ad=0.18p pd=1.72u as=97.2f ps=0.9u w=0.36u l=0.28u
X2441 VSS.t2785 a_4592_n1782# a_4584_n708.t1 VSS nfet_03v3 ad=0.2728p pd=2.12u as=0.1612p ps=1.14u w=0.62u l=0.28u
X2442 a_2176_n170# a_2112_n708.t25 VSS VSS nfet_03v3 ad=0.1188p pd=1.02u as=0.1584p ps=1.6u w=0.36u l=0.28u
X2443 a_10549_9238# a_10853_9238# a_11017_n862.t31 VDD pfet_03v3 ad=0.1152p pd=1u as=0.1584p ps=1.6u w=0.36u l=0.28u
X2444 a_7308_8454# a_n1204_8454.t17 a_7120_8454# VSS nfet_03v3 ad=0.1278p pd=1.07u as=0.1188p ps=1.02u w=0.36u l=0.28u
X2445 VDD a_n1204_8454.t18 a_29754_8958# VDD pfet_03v3 ad=0.1584p pd=1.6u as=56.7f ps=0.675u w=0.36u l=0.28u
X2446 a_28157_2274# RA11.t22 VSS VSS nfet_03v3 ad=0.1944p pd=1.8u as=0.1656p ps=1.64u w=0.36u l=0.28u
X2447 a_5034_1902# a_4970_1588# a_4836_1398# VSS nfet_03v3 ad=56.7f pd=0.675u as=0.1278p ps=1.07u w=0.36u l=0.28u
X2448 VSS a_n884_10806.t19 a_5034_11310# VSS nfet_03v3 ad=0.1584p pd=1.6u as=56.7f ps=0.675u w=0.36u l=0.28u
X2449 a_12450_6886# a_12386_7200# a_12252_6886# VSS nfet_03v3 ad=56.7f pd=0.675u as=0.1278p ps=1.07u w=0.36u l=0.28u
X2450 a_34312_3750# a_34248_n708.t23 VSS VSS nfet_03v3 ad=0.1188p pd=1.02u as=0.1584p ps=1.6u w=0.36u l=0.28u
X2451 a_36972_9238# a_n884_9238.t20 a_36784_9238# VDD pfet_03v3 ad=0.1278p pd=1.07u as=0.2097p ps=1.38u w=0.36u l=0.28u
X2452 a_26119_n2146.t2 RB4.t17 a_25381_7670# VSS nfet_03v3 ad=0.1584p pd=1.6u as=0.1152p ps=1u w=0.36u l=0.28u
X2453 a_7308_5318# a_n1204_5318.t18 a_7120_5318# VSS nfet_03v3 ad=0.1278p pd=1.07u as=0.1188p ps=1.02u w=0.36u l=0.28u
X2454 a_18703_n2146.t12 RB3.t14 a_17965_8454# VSS nfet_03v3 ad=0.1584p pd=1.6u as=0.1152p ps=1u w=0.36u l=0.28u
X2455 a_2176_3750# a_2112_n708.t26 VSS VSS nfet_03v3 ad=0.1188p pd=1.02u as=0.1584p ps=1.6u w=0.36u l=0.28u
X2456 VSS RB3.t15 a_31058_8800# VSS nfet_03v3 ad=0.1584p pd=1.6u as=0.1854p ps=1.75u w=0.36u l=0.28u
X2457 a_19480_10022# a_19416_n708.t14 VDD VDD pfet_03v3 ad=0.2097p pd=1.38u as=0.3168p ps=2.32u w=0.72u l=0.28u
X2458 QB7b.t0 a_18703_n2146.t33 VDD VDD pfet_03v3 ad=0.4104p pd=2.58u as=0.2484p ps=1.41u w=0.72u l=0.28u
X2459 VDD.t1231 a_n1204_n954.t19 a_9978_n450# VDD.t1230 pfet_03v3 ad=0.1584p pd=1.6u as=56.7f ps=0.675u w=0.36u l=0.28u
X2460 a_19866_334# a_19802_20# a_19668_n170# VSS nfet_03v3 ad=56.7f pd=0.675u as=0.1278p ps=1.07u w=0.36u l=0.28u
X2461 a_8815_n2146.t12 RB4.t18 a_8077_7670# VSS nfet_03v3 ad=0.1584p pd=1.6u as=0.1152p ps=1u w=0.36u l=0.28u
X2462 a_15797_9238# RA2.t21 VDD VDD pfet_03v3 ad=0.3888p pd=2.52u as=0.3312p ps=2.36u w=0.72u l=0.28u
X2463 VDD a_17196_6886# a_17330_7200# VDD pfet_03v3 ad=0.1764p pd=1.26u as=0.1584p ps=1.6u w=0.36u l=0.28u
X2464 a_10549_4534# RA8.t23 a_11017_n862.t4 VSS nfet_03v3 ad=0.1152p pd=1u as=0.1584p ps=1.6u w=0.36u l=0.28u
X2465 VSS a_29556_2182# a_29690_2496# VSS nfet_03v3 ad=97.2f pd=0.9u as=0.1584p ps=1.6u w=0.36u l=0.28u
X2466 VSS a_n884_10022.t15 a_27282_10022# VSS nfet_03v3 ad=0.1584p pd=1.6u as=56.7f ps=0.675u w=0.36u l=0.28u
X2467 VDD a_n1204_6102.t17 a_19866_6102# VDD pfet_03v3 ad=0.1584p pd=1.6u as=56.7f ps=0.675u w=0.36u l=0.28u
X2468 VDD a_17196_3750# a_17330_4064# VDD pfet_03v3 ad=0.1764p pd=1.26u as=0.1584p ps=1.6u w=0.36u l=0.28u
X2469 VDD a_n1204_2182.t21 a_32226_2686# VDD pfet_03v3 ad=0.1584p pd=1.6u as=56.7f ps=0.675u w=0.36u l=0.28u
X2470 a_37741_1398# a_38045_1398# a_38209_n862.t6 VDD pfet_03v3 ad=0.1152p pd=1u as=0.1584p ps=1.6u w=0.36u l=0.28u
X2471 a_24810_9238# a_24746_9428# a_24612_9238# VDD pfet_03v3 ad=56.7f pd=0.675u as=0.1278p ps=1.07u w=0.36u l=0.28u
X2472 a_22140_6886# a_n1204_6886.t27 a_21952_6886# VSS nfet_03v3 ad=0.1278p pd=1.07u as=0.1188p ps=1.02u w=0.36u l=0.28u
X2473 a_37741_n170# a_36972_n170# VSS VSS nfet_03v3 ad=0.18p pd=1.72u as=97.2f ps=0.9u w=0.36u l=0.28u
X2474 a_28157_n170# RA14.t19 VSS VSS nfet_03v3 ad=0.1944p pd=1.8u as=0.1656p ps=1.64u w=0.36u l=0.28u
X2475 VDD a_17196_614# a_17330_928# VDD pfet_03v3 ad=0.1764p pd=1.26u as=0.1584p ps=1.6u w=0.36u l=0.28u
X2476 VSS a_2364_7670# a_2498_7860# VSS nfet_03v3 ad=97.2f pd=0.9u as=0.1584p ps=1.6u w=0.36u l=0.28u
X2477 a_13325_n862# RA15.t15 VSS.t491 VSS nfet_03v3 ad=0.1944p pd=1.8u as=0.1656p ps=1.64u w=0.36u l=0.28u
X2478 a_5605_1398# a_5909_1398# a_6073_n862.t17 VDD pfet_03v3 ad=0.1152p pd=1u as=0.1584p ps=1.6u w=0.36u l=0.28u
X2479 a_36784_10022# a_36720_n708.t23 VDD VDD pfet_03v3 ad=0.2097p pd=1.38u as=0.3168p ps=2.32u w=0.72u l=0.28u
X2480 a_21175_n2146.t4 RB11.t20 a_20437_2182# VSS nfet_03v3 ad=0.1584p pd=1.6u as=0.1152p ps=1u w=0.36u l=0.28u
X2481 a_32226_2182# a_32162_2496# a_32028_2182# VSS nfet_03v3 ad=56.7f pd=0.675u as=0.1278p ps=1.07u w=0.36u l=0.28u
X2482 VDD a_25849_n862.t33 QA10b.t0 VDD pfet_03v3 ad=0.2484p pd=1.41u as=0.4104p ps=2.58u w=0.72u l=0.28u
X2483 a_15797_n170# RA14.t20 VSS VSS nfet_03v3 ad=0.1944p pd=1.8u as=0.1656p ps=1.64u w=0.36u l=0.28u
X2484 a_n296_10022# a_n360_n708.t19 VSS VSS nfet_03v3 ad=0.1188p pd=1.02u as=0.1584p ps=1.6u w=0.36u l=0.28u
X2485 VSS a_2364_4534# a_2498_4724# VSS nfet_03v3 ad=97.2f pd=0.9u as=0.1584p ps=1.6u w=0.36u l=0.28u
X2486 a_27282_334# a_27218_20# a_27084_n170# VSS nfet_03v3 ad=56.7f pd=0.675u as=0.1278p ps=1.07u w=0.36u l=0.28u
X2487 a_17008_1398# a_16944_n708.t21 VDD VDD pfet_03v3 ad=0.2097p pd=1.38u as=0.3168p ps=2.32u w=0.72u l=0.28u
X2488 a_3133_10806# a_3437_10806# a_3601_n862.t26 VDD pfet_03v3 ad=0.1152p pd=1u as=0.1584p ps=1.6u w=0.36u l=0.28u
X2489 a_14922_334# a_14858_20# a_14724_n170# VSS nfet_03v3 ad=56.7f pd=0.675u as=0.1278p ps=1.07u w=0.36u l=0.28u
X2490 a_15797_4534# RA8.t24 VSS VSS nfet_03v3 ad=0.1944p pd=1.8u as=0.1656p ps=1.64u w=0.36u l=0.28u
X2491 a_12064_2966# a_12000_n708.t17 VSS VSS nfet_03v3 ad=0.1188p pd=1.02u as=0.1584p ps=1.6u w=0.36u l=0.28u
X2492 a_36972_614# a_n1204_614.t28 a_36784_614# VSS nfet_03v3 ad=0.1278p pd=1.07u as=0.1188p ps=1.02u w=0.36u l=0.28u
X2493 VDD.t3194 a_4836_n170# a_4970_20# VDD.t2524 pfet_03v3 ad=0.1764p pd=1.26u as=0.1584p ps=1.6u w=0.36u l=0.28u
X2494 a_17196_10806# a_n884_10806.t20 a_17008_10806# VDD pfet_03v3 ad=0.1278p pd=1.07u as=0.2097p ps=1.38u w=0.36u l=0.28u
X2495 VSS a_n1204_3750.t25 a_n884_3750.t2 VSS nfet_03v3 ad=0.2948p pd=2.22u as=0.1943p ps=1.25u w=0.67u l=0.28u
X2496 a_23647_n2146.t6 RB10.t21 a_22909_2966# VSS nfet_03v3 ad=0.1584p pd=1.6u as=0.1152p ps=1u w=0.36u l=0.28u
X2497 a_28157_10114# RA1.t27 VSS VSS nfet_03v3 ad=0.1944p pd=1.8u as=0.1656p ps=1.64u w=0.36u l=0.28u
X2498 VDD a_n1204_8454.t19 a_27282_8958# VDD pfet_03v3 ad=0.1584p pd=1.6u as=56.7f ps=0.675u w=0.36u l=0.28u
X2499 VSS.t2808 D7.t1 a_18061_n1738# VSS nfet_03v3 ad=0.1584p pd=1.6u as=0.1188p ps=1.02u w=0.36u l=0.28u
X2500 a_38479_n2146.t22 RB0.t21 a_37741_10806# VSS nfet_03v3 ad=0.1584p pd=1.6u as=0.1152p ps=1u w=0.36u l=0.28u
X2501 a_3871_n2146.t6 RB1.t21 a_3133_10022# VSS nfet_03v3 ad=0.1584p pd=1.6u as=0.1152p ps=1u w=0.36u l=0.28u
X2502 VDD a_n108_10022# a_26_10336# VDD pfet_03v3 ad=0.1764p pd=1.26u as=0.1584p ps=1.6u w=0.36u l=0.28u
X2503 a_34500_9238# a_n884_9238.t21 a_34312_9238# VDD pfet_03v3 ad=0.1278p pd=1.07u as=0.2097p ps=1.38u w=0.36u l=0.28u
X2504 a_16231_n2146.t11 RB3.t16 a_15493_8454# VSS nfet_03v3 ad=0.1584p pd=1.6u as=0.1152p ps=1u w=0.36u l=0.28u
X2505 a_25160_n1738# WEM.t13 VDD VDD pfet_03v3 ad=56.7f pd=0.675u as=0.1584p ps=1.6u w=0.36u l=0.28u
X2506 QB15b.t1 a_38479_n2146.t32 VSS VSS nfet_03v3 ad=0.2052p pd=1.86u as=0.1242p ps=1.05u w=0.36u l=0.28u
X2507 a_23213_n170# RA14.t21 VSS VSS nfet_03v3 ad=0.1944p pd=1.8u as=0.1656p ps=1.64u w=0.36u l=0.28u
X2508 a_n1652_7670# WE4.t0 VDD VDD pfet_03v3 ad=0.1872p pd=1.24u as=0.3168p ps=2.32u w=0.72u l=0.28u
X2509 VDD a_n1204_5318.t19 a_34698_5822# VDD pfet_03v3 ad=0.1584p pd=1.6u as=56.7f ps=0.675u w=0.36u l=0.28u
X2510 a_8381_2274# RA11.t23 VSS VSS nfet_03v3 ad=0.1944p pd=1.8u as=0.1656p ps=1.64u w=0.36u l=0.28u
X2511 a_4648_9238# a_4584_n708.t20 VSS VSS nfet_03v3 ad=0.1188p pd=1.02u as=0.1584p ps=1.6u w=0.36u l=0.28u
X2512 a_10853_n170# RA14.t22 VSS VSS nfet_03v3 ad=0.1944p pd=1.8u as=0.1656p ps=1.64u w=0.36u l=0.28u
X2513 a_38479_n2146.t29 RB13.t19 a_37741_614# VSS nfet_03v3 ad=0.1584p pd=1.6u as=0.1152p ps=1u w=0.36u l=0.28u
X2514 a_8815_n2146.t26 a_8810_10964# a_8077_10806# VDD pfet_03v3 ad=0.1584p pd=1.6u as=0.1152p ps=1u w=0.36u l=0.28u
X2515 a_n1652_4534# WE8.t0 VDD VDD pfet_03v3 ad=0.1872p pd=1.24u as=0.3168p ps=2.32u w=0.72u l=0.28u
X2516 a_28157_2966# RA10.t21 VSS VSS nfet_03v3 ad=0.1944p pd=1.8u as=0.1656p ps=1.64u w=0.36u l=0.28u
X2517 a_n108_10806# WE0CLK.t20 a_n296_10806# VSS nfet_03v3 ad=0.1278p pd=1.07u as=0.1188p ps=1.02u w=0.36u l=0.28u
X2518 a_24612_10806# WE0CLK.t21 a_24424_10806# VSS nfet_03v3 ad=0.1278p pd=1.07u as=0.1188p ps=1.02u w=0.36u l=0.28u
X2519 VDD a_19668_9238# a_19802_9428# VDD pfet_03v3 ad=0.1764p pd=1.26u as=0.1584p ps=1.6u w=0.36u l=0.28u
X2520 a_9978_8454# a_9914_8768# a_9780_8454# VSS nfet_03v3 ad=56.7f pd=0.675u as=0.1278p ps=1.07u w=0.36u l=0.28u
X2521 a_6343_n2146.t17 RB4.t19 a_5605_7670# VSS nfet_03v3 ad=0.1584p pd=1.6u as=0.1152p ps=1u w=0.36u l=0.28u
X2522 a_4648_6102# a_4584_n708.t21 VSS VSS nfet_03v3 ad=0.1188p pd=1.02u as=0.1584p ps=1.6u w=0.36u l=0.28u
X2523 VSS a_n884_2966.t12 a_14922_3470# VSS nfet_03v3 ad=0.1584p pd=1.6u as=56.7f ps=0.675u w=0.36u l=0.28u
X2524 a_34500_10806# a_n884_10806.t21 a_34312_10806# VDD pfet_03v3 ad=0.1278p pd=1.07u as=0.2097p ps=1.38u w=0.36u l=0.28u
X2525 a_19668_2966# a_n884_2966.t13 a_19480_2966# VDD pfet_03v3 ad=0.1278p pd=1.07u as=0.2097p ps=1.38u w=0.36u l=0.28u
X2526 a_15589_n1738# a_n884_n1738.t12 a_14480_n1782# VDD pfet_03v3 ad=0.2097p pd=1.38u as=0.1278p ps=1.07u w=0.36u l=0.28u
X2527 VSS.t3237 D14.t1 a_35365_n1738# VSS nfet_03v3 ad=0.1584p pd=1.6u as=0.1188p ps=1.02u w=0.36u l=0.28u
X2528 VDD a_14724_6886# a_14858_7200# VDD pfet_03v3 ad=0.1764p pd=1.26u as=0.1584p ps=1.6u w=0.36u l=0.28u
X2529 a_36972_6886# a_n1204_6886.t28 a_36784_6886# VSS nfet_03v3 ad=0.1278p pd=1.07u as=0.1188p ps=1.02u w=0.36u l=0.28u
X2530 a_9978_5318# a_9914_5632# a_9780_5318# VSS nfet_03v3 ad=56.7f pd=0.675u as=0.1278p ps=1.07u w=0.36u l=0.28u
X2531 a_18703_n2146.t10 RB14.t27 a_17965_n170# VSS nfet_03v3 ad=0.1584p pd=1.6u as=0.1152p ps=1u w=0.36u l=0.28u
X2532 a_8077_n170# a_8381_n170# a_8545_n862.t15 VDD.t2309 pfet_03v3 ad=0.1152p pd=1u as=0.1584p ps=1.6u w=0.36u l=0.28u
X2533 a_2364_10022# a_n1204_10022.t18 a_2176_10022# VSS nfet_03v3 ad=0.1278p pd=1.07u as=0.1188p ps=1.02u w=0.36u l=0.28u
X2534 a_n884_8454.t0 a_n1204_8454.t20 VSS VSS nfet_03v3 ad=0.1943p pd=1.25u as=0.1693p ps=1.19u w=0.67u l=0.28u
X2535 a_2364_8454# a_n884_8454.t19 a_2176_8454# VDD pfet_03v3 ad=0.1278p pd=1.07u as=0.2097p ps=1.38u w=0.36u l=0.28u
X2536 VDD a_n1204_6102.t18 a_17394_6102# VDD pfet_03v3 ad=0.1584p pd=1.6u as=56.7f ps=0.675u w=0.36u l=0.28u
X2537 a_25381_n170# a_24612_n170# VSS VSS nfet_03v3 ad=0.18p pd=1.72u as=97.2f ps=0.9u w=0.36u l=0.28u
X2538 VSS RB1.t22 a_33530_10368# VSS nfet_03v3 ad=0.1584p pd=1.6u as=0.1854p ps=1.75u w=0.36u l=0.28u
X2539 VDD RB4.t20 a_23642_7828# VDD pfet_03v3 ad=0.3168p pd=2.32u as=0.3708p ps=2.47u w=0.72u l=0.28u
X2540 VDD a_14724_3750# a_14858_4064# VDD pfet_03v3 ad=0.1764p pd=1.26u as=0.1584p ps=1.6u w=0.36u l=0.28u
X2541 VSS a_32028_7670# a_32162_7860# VSS nfet_03v3 ad=97.2f pd=0.9u as=0.1584p ps=1.6u w=0.36u l=0.28u
X2542 a_n884_5318.t0 a_n1204_5318.t20 VSS VSS nfet_03v3 ad=0.1943p pd=1.25u as=0.1693p ps=1.19u w=0.67u l=0.28u
X2543 VDD RB7.t23 a_18698_5664# VDD pfet_03v3 ad=0.3168p pd=2.32u as=0.3708p ps=2.47u w=0.72u l=0.28u
X2544 VDD RB8.t20 a_23642_4692# VDD pfet_03v3 ad=0.3168p pd=2.32u as=0.3708p ps=2.47u w=0.72u l=0.28u
X2545 VDD.t2633 a_36972_n170# a_37106_20# VDD.t2554 pfet_03v3 ad=0.1764p pd=1.26u as=0.1584p ps=1.6u w=0.36u l=0.28u
X2546 VDD a_14724_614# a_14858_928# VDD pfet_03v3 ad=0.1764p pd=1.26u as=0.1584p ps=1.6u w=0.36u l=0.28u
X2547 VSS a_n884_10806.t22 a_14922_11310# VSS nfet_03v3 ad=0.1584p pd=1.6u as=56.7f ps=0.675u w=0.36u l=0.28u
X2548 a_22909_10022# a_22140_10022# VSS VSS nfet_03v3 ad=0.18p pd=1.72u as=97.2f ps=0.9u w=0.36u l=0.28u
X2549 a_22338_9238# a_22274_9428# a_22140_9238# VDD pfet_03v3 ad=56.7f pd=0.675u as=0.1278p ps=1.07u w=0.36u l=0.28u
X2550 VSS a_32028_4534# a_32162_4724# VSS nfet_03v3 ad=97.2f pd=0.9u as=0.1584p ps=1.6u w=0.36u l=0.28u
X2551 VDD RB9.t19 a_11282_4096# VDD pfet_03v3 ad=0.3168p pd=2.32u as=0.3708p ps=2.47u w=0.72u l=0.28u
X2552 a_13021_n170# a_12252_n170# VSS VSS nfet_03v3 ad=0.18p pd=1.72u as=97.2f ps=0.9u w=0.36u l=0.28u
X2553 VDD WE0CLK.t22 a_24810_10806# VDD pfet_03v3 ad=0.1584p pd=1.6u as=56.7f ps=0.675u w=0.36u l=0.28u
X2554 VDD RB11.t21 a_18698_2528# VDD pfet_03v3 ad=0.3168p pd=2.32u as=0.3708p ps=2.47u w=0.72u l=0.28u
X2555 a_34698_1902# a_34634_1588# a_34500_1398# VSS nfet_03v3 ad=56.7f pd=0.675u as=0.1278p ps=1.07u w=0.36u l=0.28u
X2556 a_36007_n2146.t30 a_36002_6260# a_35269_6102# VDD pfet_03v3 ad=0.1584p pd=1.6u as=0.1152p ps=1u w=0.36u l=0.28u
X2557 VSS a_n884_n170.t14 a_27282_334# VSS nfet_03v3 ad=0.1584p pd=1.6u as=56.7f ps=0.675u w=0.36u l=0.28u
X2558 VDD RB13.t20 a_11282_960# VDD pfet_03v3 ad=0.3168p pd=2.32u as=0.3708p ps=2.47u w=0.72u l=0.28u
X2559 a_14536_1398# a_14472_n708.t22 VDD VDD pfet_03v3 ad=0.2097p pd=1.38u as=0.3168p ps=2.32u w=0.72u l=0.28u
X2560 a_38045_8546# RA3.t19 VDD VDD pfet_03v3 ad=0.3888p pd=2.52u as=0.3312p ps=2.36u w=0.72u l=0.28u
X2561 a_25381_2966# a_24612_2966# VDD VDD pfet_03v3 ad=0.36p pd=2.44u as=0.1764p ps=1.26u w=0.72u l=0.28u
X2562 a_8077_n170# a_7308_n170# VSS VSS nfet_03v3 ad=0.18p pd=1.72u as=97.2f ps=0.9u w=0.36u l=0.28u
X2563 a_5034_9238# a_4970_9428# a_4836_9238# VDD pfet_03v3 ad=56.7f pd=0.675u as=0.1278p ps=1.07u w=0.36u l=0.28u
X2564 VSS a_n884_3750.t15 a_19866_3750# VSS nfet_03v3 ad=0.1584p pd=1.6u as=56.7f ps=0.675u w=0.36u l=0.28u
X2565 a_965_n862# RA15.t16 VDD.t446 VDD.t445 pfet_03v3 ad=0.3888p pd=2.52u as=0.3312p ps=2.36u w=0.72u l=0.28u
X2566 VSS a_n884_n170.t15 a_14922_334# VSS nfet_03v3 ad=0.1584p pd=1.6u as=56.7f ps=0.675u w=0.36u l=0.28u
X2567 a_20216_n1234# a_n884_n1738.t13 VSS.t9 VSS nfet_03v3 ad=56.7f pd=0.675u as=0.1584p ps=1.6u w=0.36u l=0.28u
X2568 a_32893_n1738# a_n884_n1738.t14 a_31784_n1782# VDD pfet_03v3 ad=0.2097p pd=1.38u as=0.1278p ps=1.07u w=0.36u l=0.28u
X2569 VSS a_27084_n170# a_27218_20# VSS nfet_03v3 ad=97.2f pd=0.9u as=0.1584p ps=1.6u w=0.36u l=0.28u
X2570 a_5909_8546# RA3.t20 VDD VDD pfet_03v3 ad=0.3888p pd=2.52u as=0.3312p ps=2.36u w=0.72u l=0.28u
X2571 a_38479_n2146.t17 a_38474_2528# a_37741_2182# VDD pfet_03v3 ad=0.1584p pd=1.6u as=0.1152p ps=1u w=0.36u l=0.28u
X2572 a_36784_n170# a_36720_n708.t24 VSS VSS nfet_03v3 ad=0.1188p pd=1.02u as=0.1584p ps=1.6u w=0.36u l=0.28u
X2573 a_24810_6886# a_24746_7200# a_24612_6886# VSS nfet_03v3 ad=56.7f pd=0.675u as=0.1278p ps=1.07u w=0.36u l=0.28u
X2574 VDD RB6.t22 a_38474_6260# VDD pfet_03v3 ad=0.3168p pd=2.32u as=0.3708p ps=2.47u w=0.72u l=0.28u
X2575 a_17965_6886# a_18269_6978# a_18433_n862.t24 VDD pfet_03v3 ad=0.1152p pd=1u as=0.1584p ps=1.6u w=0.36u l=0.28u
X2576 a_21175_n2146.t12 RB10.t22 a_20437_2966# VSS nfet_03v3 ad=0.1584p pd=1.6u as=0.1152p ps=1u w=0.36u l=0.28u
X2577 a_n108_n954# a_n884_n954.t18 a_n296_n954# VDD.t1354 pfet_03v3 ad=0.1278p pd=1.07u as=0.2097p ps=1.38u w=0.36u l=0.28u
X2578 VDD RB3.t17 a_8810_8800# VDD pfet_03v3 ad=0.3168p pd=2.32u as=0.3708p ps=2.47u w=0.72u l=0.28u
X2579 a_17965_3750# a_18269_3842# a_18433_n862.t19 VDD pfet_03v3 ad=0.1152p pd=1u as=0.1584p ps=1.6u w=0.36u l=0.28u
X2580 a_8077_7670# a_7308_7670# VDD VDD pfet_03v3 ad=0.36p pd=2.44u as=0.1764p ps=1.26u w=0.72u l=0.28u
X2581 a_17965_614# a_18269_706# a_18433_n862.t10 VDD pfet_03v3 ad=0.1152p pd=1u as=0.1584p ps=1.6u w=0.36u l=0.28u
X2582 a_36007_n2146.t4 RB12.t22 a_35269_1398# VSS nfet_03v3 ad=0.1584p pd=1.6u as=0.1152p ps=1u w=0.36u l=0.28u
X2583 VDD.t1233 a_n1204_n954.t20 a_22338_n450# VDD.t1232 pfet_03v3 ad=0.1584p pd=1.6u as=56.7f ps=0.675u w=0.36u l=0.28u
X2584 a_26119_n2146.t10 RB13.t21 a_25381_614# VSS nfet_03v3 ad=0.1584p pd=1.6u as=0.1152p ps=1u w=0.36u l=0.28u
X2585 VDD a_n1204_8454.t21 a_7506_8958# VDD pfet_03v3 ad=0.1584p pd=1.6u as=56.7f ps=0.675u w=0.36u l=0.28u
X2586 a_8077_4534# a_7308_4534# VDD VDD pfet_03v3 ad=0.36p pd=2.44u as=0.1764p ps=1.26u w=0.72u l=0.28u
X2587 a_28157_10806# RA0.t27 VSS VSS nfet_03v3 ad=0.1944p pd=1.8u as=0.1656p ps=1.64u w=0.36u l=0.28u
X2588 a_18269_6978# RA5.t21 VSS VSS nfet_03v3 ad=0.1944p pd=1.8u as=0.1656p ps=1.64u w=0.36u l=0.28u
X2589 VSS a_34500_n170# a_34634_20# VSS nfet_03v3 ad=97.2f pd=0.9u as=0.1584p ps=1.6u w=0.36u l=0.28u
X2590 a_13759_n2146.t12 RB13.t22 a_13021_614# VSS nfet_03v3 ad=0.1584p pd=1.6u as=0.1152p ps=1u w=0.36u l=0.28u
X2591 a_38045_10806# RA0.t28 VDD VDD pfet_03v3 ad=0.3888p pd=2.52u as=0.3312p ps=2.36u w=0.72u l=0.28u
X2592 a_3871_n2146.t21 RB0.t22 a_3133_10806# VSS nfet_03v3 ad=0.1584p pd=1.6u as=0.1152p ps=1u w=0.36u l=0.28u
X2593 a_37741_n170# a_38045_n170# a_38209_n862.t8 VDD.t2206 pfet_03v3 ad=0.1152p pd=1u as=0.1584p ps=1.6u w=0.36u l=0.28u
X2594 a_3133_n170# a_2364_n170# VSS VSS nfet_03v3 ad=0.18p pd=1.72u as=97.2f ps=0.9u w=0.36u l=0.28u
X2595 VSS RB12.t23 a_38474_1556# VSS nfet_03v3 ad=0.1584p pd=1.6u as=0.1854p ps=1.75u w=0.36u l=0.28u
X2596 a_7506_8454# a_7442_8768# a_7308_8454# VSS nfet_03v3 ad=56.7f pd=0.675u as=0.1278p ps=1.07u w=0.36u l=0.28u
X2597 a_90_7390# a_26_7200# a_n108_6886# VDD pfet_03v3 ad=56.7f pd=0.675u as=0.1278p ps=1.07u w=0.36u l=0.28u
X2598 a_13325_5410# RA7.t22 VDD VDD pfet_03v3 ad=0.3888p pd=2.52u as=0.3312p ps=2.36u w=0.72u l=0.28u
X2599 VSS a_22140_n170# a_22274_20# VSS nfet_03v3 ad=97.2f pd=0.9u as=0.1584p ps=1.6u w=0.36u l=0.28u
X2600 a_17196_2966# a_n884_2966.t14 a_17008_2966# VDD pfet_03v3 ad=0.1278p pd=1.07u as=0.2097p ps=1.38u w=0.36u l=0.28u
X2601 a_26840_n1782# a_27344_n1738# a_27632_n1738# VDD pfet_03v3 ad=0.1278p pd=1.07u as=56.7f ps=0.675u w=0.36u l=0.28u
X2602 QB1b.t1 a_3871_n2146.t32 VSS VSS nfet_03v3 ad=0.2052p pd=1.86u as=0.1242p ps=1.05u w=0.36u l=0.28u
X2603 a_5605_n170# a_5909_n170# a_6073_n862.t15 VDD.t2467 pfet_03v3 ad=0.1152p pd=1u as=0.1584p ps=1.6u w=0.36u l=0.28u
X2604 VSS a_29556_1398# a_29690_1588# VSS nfet_03v3 ad=97.2f pd=0.9u as=0.1584p ps=1.6u w=0.36u l=0.28u
X2605 a_5605_10806# a_4836_10806# VDD VDD pfet_03v3 ad=0.36p pd=2.44u as=0.1764p ps=1.26u w=0.72u l=0.28u
X2606 a_28591_n2146.t31 a_28586_10368# a_27853_10022# VDD pfet_03v3 ad=0.1584p pd=1.6u as=0.1152p ps=1u w=0.36u l=0.28u
X2607 a_34500_6886# a_n1204_6886.t29 a_34312_6886# VSS nfet_03v3 ad=0.1278p pd=1.07u as=0.1188p ps=1.02u w=0.36u l=0.28u
X2608 a_7506_5318# a_7442_5632# a_7308_5318# VSS nfet_03v3 ad=56.7f pd=0.675u as=0.1278p ps=1.07u w=0.36u l=0.28u
X2609 a_90_4254# a_26_4064# a_n108_3750# VDD pfet_03v3 ad=56.7f pd=0.675u as=0.1278p ps=1.07u w=0.36u l=0.28u
X2610 a_13325_2274# RA11.t24 VDD VDD pfet_03v3 ad=0.3888p pd=2.52u as=0.3312p ps=2.36u w=0.72u l=0.28u
X2611 a_n296_n170# a_n360_n708.t20 VSS VSS nfet_03v3 ad=0.1188p pd=1.02u as=0.1584p ps=1.6u w=0.36u l=0.28u
X2612 VDD RB4.t21 a_21170_7828# VDD pfet_03v3 ad=0.3168p pd=2.32u as=0.3708p ps=2.47u w=0.72u l=0.28u
X2613 a_8381_2966# RA10.t22 VSS VSS nfet_03v3 ad=0.1944p pd=1.8u as=0.1656p ps=1.64u w=0.36u l=0.28u
X2614 a_34256_n1782# a_34760_n1738# a_35048_n1234# VSS nfet_03v3 ad=0.1278p pd=1.07u as=56.7f ps=0.675u w=0.36u l=0.28u
X2615 a_25685_n862# RA15.t17 VSS.t492 VSS nfet_03v3 ad=0.1944p pd=1.8u as=0.1656p ps=1.64u w=0.36u l=0.28u
X2616 a_17008_n170# a_16944_n708.t22 VDD.t976 VDD.t975 pfet_03v3 ad=0.2097p pd=1.38u as=0.3168p ps=2.32u w=0.72u l=0.28u
X2617 a_90_1118# a_26_928# a_n108_614# VDD pfet_03v3 ad=56.7f pd=0.675u as=0.1278p ps=1.07u w=0.36u l=0.28u
X2618 a_3871_n2146.t17 RB7.t24 a_3133_5318# VSS nfet_03v3 ad=0.1584p pd=1.6u as=0.1152p ps=1u w=0.36u l=0.28u
X2619 a_33535_n2146.t19 RB11.t22 a_32797_2182# VSS nfet_03v3 ad=0.1584p pd=1.6u as=0.1152p ps=1u w=0.36u l=0.28u
X2620 VSS a_n884_n170.t16 a_5034_334# VSS nfet_03v3 ad=0.1584p pd=1.6u as=56.7f ps=0.675u w=0.36u l=0.28u
X2621 a_2364_614# a_n1204_614.t29 a_2176_614# VSS nfet_03v3 ad=0.1278p pd=1.07u as=0.1188p ps=1.02u w=0.36u l=0.28u
X2622 a_30325_7670# RA4.t22 a_30793_n862.t11 VSS nfet_03v3 ad=0.1152p pd=1u as=0.1584p ps=1.6u w=0.36u l=0.28u
X2623 VDD RB8.t21 a_21170_4692# VDD pfet_03v3 ad=0.3168p pd=2.32u as=0.3708p ps=2.47u w=0.72u l=0.28u
X2624 a_37232_n1738# a_36728_n1782# VSS.t1978 VSS nfet_03v3 ad=0.1584p pd=1.6u as=0.1584p ps=1.6u w=0.36u l=0.28u
X2625 a_661_10022# a_965_10114# a_1129_n862.t1 VDD pfet_03v3 ad=0.1152p pd=1u as=0.1584p ps=1.6u w=0.36u l=0.28u
X2626 VSS a_19668_6886# a_19802_7200# VSS nfet_03v3 ad=97.2f pd=0.9u as=0.1584p ps=1.6u w=0.36u l=0.28u
X2627 a_1399_n2146.t4 RB11.t23 a_661_2182# VSS nfet_03v3 ad=0.1584p pd=1.6u as=0.1152p ps=1u w=0.36u l=0.28u
X2628 VSS.t2710 a_n352_n1782# a_n360_n708.t2 VSS nfet_03v3 ad=0.2728p pd=2.12u as=0.1612p ps=1.14u w=0.62u l=0.28u
X2629 VSS a_4836_n170# a_4970_20# VSS nfet_03v3 ad=97.2f pd=0.9u as=0.1584p ps=1.6u w=0.36u l=0.28u
X2630 a_21175_n2146.t13 RB13.t23 a_20437_614# VSS nfet_03v3 ad=0.1584p pd=1.6u as=0.1152p ps=1u w=0.36u l=0.28u
X2631 a_32226_1902# a_32162_1588# a_32028_1398# VSS nfet_03v3 ad=56.7f pd=0.675u as=0.1278p ps=1.07u w=0.36u l=0.28u
X2632 VSS a_n884_3750.t16 a_17394_3750# VSS nfet_03v3 ad=0.1584p pd=1.6u as=56.7f ps=0.675u w=0.36u l=0.28u
X2633 a_28591_n2146.t27 a_28586_n608# a_27853_n954# VDD.t2137 pfet_03v3 ad=0.1584p pd=1.6u as=0.1152p ps=1u w=0.36u l=0.28u
X2634 VSS RB0.t23 a_33530_10964# VSS nfet_03v3 ad=0.1584p pd=1.6u as=0.1854p ps=1.75u w=0.36u l=0.28u
X2635 a_17965_10022# a_17196_10022# VSS VSS nfet_03v3 ad=0.18p pd=1.72u as=97.2f ps=0.9u w=0.36u l=0.28u
X2636 VDD WE0CLK.t23 a_19866_10806# VDD pfet_03v3 ad=0.1584p pd=1.6u as=56.7f ps=0.675u w=0.36u l=0.28u
X2637 a_3437_8546# RA3.t21 VDD VDD pfet_03v3 ad=0.3888p pd=2.52u as=0.3312p ps=2.36u w=0.72u l=0.28u
X2638 a_11287_n2146.t9 RB5.t20 a_10549_6886# VSS nfet_03v3 ad=0.1584p pd=1.6u as=0.1152p ps=1u w=0.36u l=0.28u
X2639 a_22338_6886# a_22274_7200# a_22140_6886# VSS nfet_03v3 ad=56.7f pd=0.675u as=0.1278p ps=1.07u w=0.36u l=0.28u
X2640 VDD RB12.t24 a_1394_1556# VDD pfet_03v3 ad=0.3168p pd=2.32u as=0.3708p ps=2.47u w=0.72u l=0.28u
X2641 a_24424_6886# a_24360_n708.t22 VDD VDD pfet_03v3 ad=0.2097p pd=1.38u as=0.3168p ps=2.32u w=0.72u l=0.28u
X2642 a_5605_2966# a_4836_2966# VDD VDD pfet_03v3 ad=0.36p pd=2.44u as=0.1764p ps=1.26u w=0.72u l=0.28u
X2643 VSS a_34500_8454# a_34634_8768# VSS nfet_03v3 ad=97.2f pd=0.9u as=0.1584p ps=1.6u w=0.36u l=0.28u
X2644 VDD a_12252_2182# a_12386_2496# VDD pfet_03v3 ad=0.1764p pd=1.26u as=0.1584p ps=1.6u w=0.36u l=0.28u
X2645 a_15272_n1234# a_n884_n1738.t15 VSS.t10 VSS nfet_03v3 ad=56.7f pd=0.675u as=0.1584p ps=1.6u w=0.36u l=0.28u
X2646 a_17394_8174# a_17330_7860# a_17196_7670# VSS nfet_03v3 ad=56.7f pd=0.675u as=0.1278p ps=1.07u w=0.36u l=0.28u
X2647 VSS a_34500_5318# a_34634_5632# VSS nfet_03v3 ad=97.2f pd=0.9u as=0.1584p ps=1.6u w=0.36u l=0.28u
X2648 a_5034_6886# a_4970_7200# a_4836_6886# VSS nfet_03v3 ad=56.7f pd=0.675u as=0.1278p ps=1.07u w=0.36u l=0.28u
X2649 a_14724_9238# a_n1204_9238.t21 a_14536_9238# VSS nfet_03v3 ad=0.1278p pd=1.07u as=0.1188p ps=1.02u w=0.36u l=0.28u
X2650 a_17394_5038# a_17330_4724# a_17196_4534# VSS nfet_03v3 ad=56.7f pd=0.675u as=0.1278p ps=1.07u w=0.36u l=0.28u
X2651 VSS a_n1652_8886# a_n1204_8454.t2 VSS nfet_03v3 ad=0.1693p pd=1.19u as=0.1651p ps=1.155u w=0.635u l=0.28u
X2652 VDD a_n1204_8454.t22 a_5034_8958# VDD pfet_03v3 ad=0.1584p pd=1.6u as=56.7f ps=0.675u w=0.36u l=0.28u
X2653 a_n1652_4182# WE9.t0 VDD VDD pfet_03v3 ad=0.1872p pd=1.24u as=0.3168p ps=2.32u w=0.72u l=0.28u
X2654 a_661_3750# RA9.t24 a_1129_n862.t14 VSS nfet_03v3 ad=0.1152p pd=1u as=0.1584p ps=1.6u w=0.36u l=0.28u
X2655 a_14724_6102# a_n1204_6102.t19 a_14536_6102# VSS nfet_03v3 ad=0.1278p pd=1.07u as=0.1188p ps=1.02u w=0.36u l=0.28u
X2656 VSS a_9780_n170# a_9914_20# VSS nfet_03v3 ad=97.2f pd=0.9u as=0.1584p ps=1.6u w=0.36u l=0.28u
X2657 a_n1652_1046# WE13.t1 VDD VDD pfet_03v3 ad=0.1872p pd=1.24u as=0.3168p ps=2.32u w=0.72u l=0.28u
X2658 VDD a_27084_6886# a_27218_7200# VDD pfet_03v3 ad=0.1764p pd=1.26u as=0.1584p ps=1.6u w=0.36u l=0.28u
X2659 VSS a_n1652_5750# a_n1204_5318.t2 VSS nfet_03v3 ad=0.1693p pd=1.19u as=0.1651p ps=1.155u w=0.635u l=0.28u
X2660 VDD a_n1204_6102.t20 a_29754_6102# VDD pfet_03v3 ad=0.1584p pd=1.6u as=56.7f ps=0.675u w=0.36u l=0.28u
X2661 VDD.t1235 a_n1204_n954.t21 a_2562_n450# VDD.t1234 pfet_03v3 ad=0.1584p pd=1.6u as=56.7f ps=0.675u w=0.36u l=0.28u
X2662 VDD a_27084_3750# a_27218_4064# VDD pfet_03v3 ad=0.1764p pd=1.26u as=0.1584p ps=1.6u w=0.36u l=0.28u
X2663 VDD a_27084_614# a_27218_928# VDD pfet_03v3 ad=0.1764p pd=1.26u as=0.1584p ps=1.6u w=0.36u l=0.28u
X2664 VDD a_n1204_10022.t19 a_22338_10526# VDD pfet_03v3 ad=0.1584p pd=1.6u as=56.7f ps=0.675u w=0.36u l=0.28u
X2665 a_34698_9238# a_34634_9428# a_34500_9238# VDD pfet_03v3 ad=56.7f pd=0.675u as=0.1278p ps=1.07u w=0.36u l=0.28u
X2666 VDD RB9.t20 a_23642_4096# VDD pfet_03v3 ad=0.3168p pd=2.32u as=0.3708p ps=2.47u w=0.72u l=0.28u
X2667 a_14536_n170# a_14472_n708.t23 VDD.t947 VDD.t946 pfet_03v3 ad=0.2097p pd=1.38u as=0.3168p ps=2.32u w=0.72u l=0.28u
X2668 VSS RB13.t24 a_1394_960# VSS nfet_03v3 ad=0.1584p pd=1.6u as=0.1854p ps=1.75u w=0.36u l=0.28u
X2669 a_27853_5318# a_27084_5318# VDD VDD pfet_03v3 ad=0.36p pd=2.44u as=0.1764p ps=1.26u w=0.72u l=0.28u
X2670 a_38045_3842# RA9.t25 VSS VSS nfet_03v3 ad=0.1944p pd=1.8u as=0.1656p ps=1.64u w=0.36u l=0.28u
X2671 a_31063_n2146.t4 RB11.t24 a_30325_2182# VSS nfet_03v3 ad=0.1584p pd=1.6u as=0.1152p ps=1u w=0.36u l=0.28u
X2672 a_23213_n862# RA15.t18 VSS.t493 VSS nfet_03v3 ad=0.1944p pd=1.8u as=0.1656p ps=1.64u w=0.36u l=0.28u
X2673 VDD RB13.t25 a_23642_960# VDD pfet_03v3 ad=0.3168p pd=2.32u as=0.3708p ps=2.47u w=0.72u l=0.28u
X2674 a_26896_1398# a_26832_n708.t22 VDD VDD pfet_03v3 ad=0.2097p pd=1.38u as=0.3168p ps=2.32u w=0.72u l=0.28u
X2675 a_20437_8454# RA3.t22 a_20905_n862.t4 VSS nfet_03v3 ad=0.1152p pd=1u as=0.1584p ps=1.6u w=0.36u l=0.28u
X2676 a_27084_7670# a_n1204_7670.t21 a_26896_7670# VSS nfet_03v3 ad=0.1278p pd=1.07u as=0.1188p ps=1.02u w=0.36u l=0.28u
X2677 a_5909_3842# RA9.t26 VSS VSS nfet_03v3 ad=0.1944p pd=1.8u as=0.1656p ps=1.64u w=0.36u l=0.28u
X2678 a_27853_2182# a_27084_2182# VDD VDD pfet_03v3 ad=0.36p pd=2.44u as=0.1764p ps=1.26u w=0.72u l=0.28u
X2679 a_27084_4534# a_n1204_4534.t22 a_26896_4534# VSS nfet_03v3 ad=0.1278p pd=1.07u as=0.1188p ps=1.02u w=0.36u l=0.28u
X2680 a_18703_n2146.t22 a_18698_1556# a_17965_1398# VDD pfet_03v3 ad=0.1584p pd=1.6u as=0.1152p ps=1u w=0.36u l=0.28u
X2681 a_3871_n2146.t1 RB2.t20 a_3133_9238# VSS nfet_03v3 ad=0.1584p pd=1.6u as=0.1152p ps=1u w=0.36u l=0.28u
X2682 a_19866_2966# a_19802_3156# a_19668_2966# VDD pfet_03v3 ad=56.7f pd=0.675u as=0.1278p ps=1.07u w=0.36u l=0.28u
X2683 a_23005_n1738# WEM.t14 a_21896_n1782# VSS nfet_03v3 ad=0.1188p pd=1.02u as=0.1278p ps=1.07u w=0.36u l=0.28u
X2684 a_2562_8958# a_2498_8768# a_2364_8454# VDD pfet_03v3 ad=56.7f pd=0.675u as=0.1278p ps=1.07u w=0.36u l=0.28u
X2685 a_33535_n2146.t11 RB10.t23 a_32797_2966# VSS nfet_03v3 ad=0.1584p pd=1.6u as=0.1152p ps=1u w=0.36u l=0.28u
X2686 a_13021_2182# a_13325_2274# a_13489_n862.t31 VDD pfet_03v3 ad=0.1152p pd=1u as=0.1584p ps=1.6u w=0.36u l=0.28u
X2687 VDD RB12.t25 a_31058_1556# VDD pfet_03v3 ad=0.3168p pd=2.32u as=0.3708p ps=2.47u w=0.72u l=0.28u
X2688 a_3871_n2146.t7 RB6.t23 a_3133_6102# VSS nfet_03v3 ad=0.1584p pd=1.6u as=0.1152p ps=1u w=0.36u l=0.28u
X2689 VSS RB9.t21 a_8810_4096# VSS nfet_03v3 ad=0.1584p pd=1.6u as=0.1854p ps=1.75u w=0.36u l=0.28u
X2690 VSS a_n1652_n170# a_n1204_n170.t3 VSS nfet_03v3 ad=0.1693p pd=1.19u as=0.1651p ps=1.155u w=0.635u l=0.28u
X2691 VDD a_n1204_8454.t23 a_37170_8958# VDD pfet_03v3 ad=0.1584p pd=1.6u as=56.7f ps=0.675u w=0.36u l=0.28u
X2692 VDD a_n1204_7670.t22 a_12450_7670# VDD pfet_03v3 ad=0.1584p pd=1.6u as=56.7f ps=0.675u w=0.36u l=0.28u
X2693 a_2624_n1738# a_2120_n1782# VSS.t3191 VSS nfet_03v3 ad=0.1584p pd=1.6u as=0.1584p ps=1.6u w=0.36u l=0.28u
X2694 a_1399_n2146.t12 RB10.t24 a_661_2966# VSS nfet_03v3 ad=0.1584p pd=1.6u as=0.1152p ps=1u w=0.36u l=0.28u
X2695 a_3133_2966# a_2364_2966# VDD VDD pfet_03v3 ad=0.36p pd=2.44u as=0.1764p ps=1.26u w=0.72u l=0.28u
X2696 VDD a_n1204_4534.t23 a_12450_4534# VDD pfet_03v3 ad=0.1584p pd=1.6u as=56.7f ps=0.675u w=0.36u l=0.28u
X2697 a_26119_n2146.t15 RB3.t18 a_25381_8454# VSS nfet_03v3 ad=0.1584p pd=1.6u as=0.1152p ps=1u w=0.36u l=0.28u
X2698 a_661_9238# a_965_9238# a_1129_n862.t26 VDD pfet_03v3 ad=0.1152p pd=1u as=0.1584p ps=1.6u w=0.36u l=0.28u
X2699 VDD a_1129_n862.t33 QA0b.t0 VDD pfet_03v3 ad=0.2484p pd=1.41u as=0.4104p ps=2.58u w=0.72u l=0.28u
X2700 a_8077_3750# a_7308_3750# VDD VDD pfet_03v3 ad=0.36p pd=2.44u as=0.1764p ps=1.26u w=0.72u l=0.28u
X2701 a_n884_n1738.t0 WEM.t15 VSS.t534 VSS nfet_03v3 ad=0.1827p pd=1.21u as=0.2772p ps=2.14u w=0.63u l=0.28u
X2702 a_12252_9238# a_n1204_9238.t22 a_12064_9238# VSS nfet_03v3 ad=0.1278p pd=1.07u as=0.1188p ps=1.02u w=0.36u l=0.28u
X2703 a_38045_10114# RA1.t28 VDD VDD pfet_03v3 ad=0.3888p pd=2.52u as=0.3312p ps=2.36u w=0.72u l=0.28u
X2704 VDD a_29556_9238# a_29690_9428# VDD pfet_03v3 ad=0.1764p pd=1.26u as=0.1584p ps=1.6u w=0.36u l=0.28u
X2705 VSS a_n884_2966.t15 a_24810_3470# VSS nfet_03v3 ad=0.1584p pd=1.6u as=56.7f ps=0.675u w=0.36u l=0.28u
X2706 a_8077_614# a_7308_614# VDD VDD pfet_03v3 ad=0.36p pd=2.44u as=0.1764p ps=1.26u w=0.72u l=0.28u
X2707 a_8815_n2146.t10 RB3.t19 a_8077_8454# VSS nfet_03v3 ad=0.1584p pd=1.6u as=0.1152p ps=1u w=0.36u l=0.28u
X2708 a_12252_6102# a_n1204_6102.t21 a_12064_6102# VSS nfet_03v3 ad=0.1278p pd=1.07u as=0.1188p ps=1.02u w=0.36u l=0.28u
X2709 VDD RB6.t24 a_18698_6260# VDD pfet_03v3 ad=0.3168p pd=2.32u as=0.3708p ps=2.47u w=0.72u l=0.28u
X2710 a_25685_5410# RA7.t23 VDD VDD pfet_03v3 ad=0.3888p pd=2.52u as=0.3312p ps=2.36u w=0.72u l=0.28u
X2711 VDD a_24612_6886# a_24746_7200# VDD pfet_03v3 ad=0.1764p pd=1.26u as=0.1584p ps=1.6u w=0.36u l=0.28u
X2712 a_29556_2966# a_n884_2966.t16 a_29368_2966# VDD pfet_03v3 ad=0.1278p pd=1.07u as=0.2097p ps=1.38u w=0.36u l=0.28u
X2713 VDD.t1237 a_n1204_n954.t22 a_32226_n450# VDD.t1236 pfet_03v3 ad=0.1584p pd=1.6u as=56.7f ps=0.675u w=0.36u l=0.28u
X2714 VSS a_n1204_n170.t24 a_n884_n170.t2 VSS nfet_03v3 ad=0.2948p pd=2.22u as=0.1943p ps=1.25u w=0.67u l=0.28u
X2715 VDD a_n1204_6102.t22 a_27282_6102# VDD pfet_03v3 ad=0.1584p pd=1.6u as=56.7f ps=0.675u w=0.36u l=0.28u
X2716 a_25685_2274# RA11.t25 VDD VDD pfet_03v3 ad=0.3888p pd=2.52u as=0.3312p ps=2.36u w=0.72u l=0.28u
X2717 a_5605_10022# a_4836_10022# VDD VDD pfet_03v3 ad=0.36p pd=2.44u as=0.1764p ps=1.26u w=0.72u l=0.28u
X2718 VDD RB4.t22 a_33530_7828# VDD pfet_03v3 ad=0.3168p pd=2.32u as=0.3708p ps=2.47u w=0.72u l=0.28u
X2719 VDD a_24612_3750# a_24746_4064# VDD pfet_03v3 ad=0.1764p pd=1.26u as=0.1584p ps=1.6u w=0.36u l=0.28u
X2720 a_38045_9238# RA2.t22 VDD VDD pfet_03v3 ad=0.3888p pd=2.52u as=0.3312p ps=2.36u w=0.72u l=0.28u
X2721 VDD D12.t0 a_30421_n1738# VDD pfet_03v3 ad=0.3168p pd=2.32u as=0.2097p ps=1.38u w=0.72u l=0.28u
X2722 a_22909_10806# a_23213_10806# a_23377_n862.t18 VDD pfet_03v3 ad=0.1152p pd=1u as=0.1584p ps=1.6u w=0.36u l=0.28u
X2723 a_32226_9238# a_32162_9428# a_32028_9238# VDD pfet_03v3 ad=56.7f pd=0.675u as=0.1278p ps=1.07u w=0.36u l=0.28u
X2724 a_661_4534# RA8.t25 a_1129_n862.t4 VSS nfet_03v3 ad=0.1152p pd=1u as=0.1584p ps=1.6u w=0.36u l=0.28u
X2725 VDD RB8.t22 a_33530_4692# VDD pfet_03v3 ad=0.3168p pd=2.32u as=0.3708p ps=2.47u w=0.72u l=0.28u
X2726 a_28157_706# RA13.t20 VSS VSS nfet_03v3 ad=0.1944p pd=1.8u as=0.1656p ps=1.64u w=0.36u l=0.28u
X2727 VDD a_24612_614# a_24746_928# VDD pfet_03v3 ad=0.1764p pd=1.26u as=0.1584p ps=1.6u w=0.36u l=0.28u
X2728 a_9780_10022# a_n884_10022.t16 a_9592_10022# VDD pfet_03v3 ad=0.1278p pd=1.07u as=0.2097p ps=1.38u w=0.36u l=0.28u
X2729 a_5909_9238# RA2.t23 VDD VDD pfet_03v3 ad=0.3888p pd=2.52u as=0.3312p ps=2.36u w=0.72u l=0.28u
X2730 VDD a_7308_6886# a_7442_7200# VDD pfet_03v3 ad=0.1764p pd=1.26u as=0.1584p ps=1.6u w=0.36u l=0.28u
X2731 VDD RB9.t22 a_21170_4096# VDD pfet_03v3 ad=0.3168p pd=2.32u as=0.3708p ps=2.47u w=0.72u l=0.28u
X2732 VSS a_19668_10806# a_19802_10996# VSS nfet_03v3 ad=97.2f pd=0.9u as=0.1584p ps=1.6u w=0.36u l=0.28u
X2733 VDD RB13.t26 a_21170_960# VDD pfet_03v3 ad=0.3168p pd=2.32u as=0.3708p ps=2.47u w=0.72u l=0.28u
X2734 VDD a_29556_10806# a_29690_10996# VDD pfet_03v3 ad=0.1764p pd=1.26u as=0.1584p ps=1.6u w=0.36u l=0.28u
X2735 VDD a_7308_3750# a_7442_4064# VDD pfet_03v3 ad=0.1764p pd=1.26u as=0.1584p ps=1.6u w=0.36u l=0.28u
X2736 a_35269_2966# a_34500_2966# VDD VDD pfet_03v3 ad=0.36p pd=2.44u as=0.1764p ps=1.26u w=0.72u l=0.28u
X2737 a_15797_706# RA13.t21 VSS VSS nfet_03v3 ad=0.1944p pd=1.8u as=0.1656p ps=1.64u w=0.36u l=0.28u
X2738 a_3437_3842# RA9.t27 VSS VSS nfet_03v3 ad=0.1944p pd=1.8u as=0.1656p ps=1.64u w=0.36u l=0.28u
X2739 VSS a_n884_3750.t17 a_29754_3750# VSS nfet_03v3 ad=0.1584p pd=1.6u as=56.7f ps=0.675u w=0.36u l=0.28u
X2740 QB11b.t0 a_28591_n2146.t33 VDD VDD pfet_03v3 ad=0.4104p pd=2.58u as=0.2484p ps=1.41u w=0.72u l=0.28u
X2741 VSS RB12.t26 a_18698_1556# VSS nfet_03v3 ad=0.1584p pd=1.6u as=0.1854p ps=1.75u w=0.36u l=0.28u
X2742 a_17965_n170# a_17196_n170# VSS VSS nfet_03v3 ad=0.18p pd=1.72u as=97.2f ps=0.9u w=0.36u l=0.28u
X2743 VDD.t1490 RB14.t28 a_1394_n12# VDD.t740 pfet_03v3 ad=0.3168p pd=2.32u as=0.3708p ps=2.47u w=0.72u l=0.28u
X2744 VDD a_7308_614# a_7442_928# VDD pfet_03v3 ad=0.1764p pd=1.26u as=0.1584p ps=1.6u w=0.36u l=0.28u
X2745 a_16231_n2146.t27 a_16226_1556# a_15493_1398# VDD pfet_03v3 ad=0.1584p pd=1.6u as=0.1152p ps=1u w=0.36u l=0.28u
X2746 VDD RB2.t21 a_8810_9396# VDD pfet_03v3 ad=0.3168p pd=2.32u as=0.3708p ps=2.47u w=0.72u l=0.28u
X2747 a_23647_n2146.t2 RB5.t21 a_22909_6886# VSS nfet_03v3 ad=0.1584p pd=1.6u as=0.1152p ps=1u w=0.36u l=0.28u
X2748 a_34698_6886# a_34634_7200# a_34500_6886# VSS nfet_03v3 ad=56.7f pd=0.675u as=0.1278p ps=1.07u w=0.36u l=0.28u
X2749 a_36784_6886# a_36720_n708.t25 VDD VDD pfet_03v3 ad=0.2097p pd=1.38u as=0.3168p ps=2.32u w=0.72u l=0.28u
X2750 a_2364_6102# a_n884_6102.t19 a_2176_6102# VDD pfet_03v3 ad=0.1278p pd=1.07u as=0.2097p ps=1.38u w=0.36u l=0.28u
X2751 a_38045_4534# RA8.t26 VSS VSS nfet_03v3 ad=0.1944p pd=1.8u as=0.1656p ps=1.64u w=0.36u l=0.28u
X2752 a_31063_n2146.t12 RB10.t25 a_30325_2966# VSS nfet_03v3 ad=0.1584p pd=1.6u as=0.1152p ps=1u w=0.36u l=0.28u
X2753 a_20437_10806# a_19668_10806# VSS VSS nfet_03v3 ad=0.18p pd=1.72u as=97.2f ps=0.9u w=0.36u l=0.28u
X2754 a_8077_10022# RA1.t29 a_8545_n862.t0 VSS nfet_03v3 ad=0.1152p pd=1u as=0.1584p ps=1.6u w=0.36u l=0.28u
X2755 a_10549_7670# RA4.t23 a_11017_n862.t11 VSS nfet_03v3 ad=0.1152p pd=1u as=0.1584p ps=1.6u w=0.36u l=0.28u
X2756 VSS a_n884_n170.t17 a_19866_334# VSS nfet_03v3 ad=0.1584p pd=1.6u as=56.7f ps=0.675u w=0.36u l=0.28u
X2757 VDD a_n1204_7670.t23 a_9978_7670# VDD pfet_03v3 ad=0.1584p pd=1.6u as=56.7f ps=0.675u w=0.36u l=0.28u
X2758 a_5909_4534# RA8.t27 VSS VSS nfet_03v3 ad=0.1944p pd=1.8u as=0.1656p ps=1.64u w=0.36u l=0.28u
X2759 VDD a_n1204_4534.t24 a_9978_4534# VDD pfet_03v3 ad=0.1584p pd=1.6u as=56.7f ps=0.675u w=0.36u l=0.28u
X2760 a_4836_2182# a_n884_2182.t18 a_4648_2182# VDD pfet_03v3 ad=0.1278p pd=1.07u as=0.2097p ps=1.38u w=0.36u l=0.28u
X2761 a_14724_10022# a_n884_10022.t17 a_14536_10022# VDD pfet_03v3 ad=0.1278p pd=1.07u as=0.2097p ps=1.38u w=0.36u l=0.28u
X2762 a_13325_6102# RA6.t22 VDD VDD pfet_03v3 ad=0.3888p pd=2.52u as=0.3312p ps=2.36u w=0.72u l=0.28u
X2763 a_23213_706# RA13.t22 VSS VSS nfet_03v3 ad=0.1944p pd=1.8u as=0.1656p ps=1.64u w=0.36u l=0.28u
X2764 a_28157_6978# RA5.t22 VSS VSS nfet_03v3 ad=0.1944p pd=1.8u as=0.1656p ps=1.64u w=0.36u l=0.28u
X2765 VSS RB11.t25 a_16226_2528# VSS nfet_03v3 ad=0.1584p pd=1.6u as=0.1854p ps=1.75u w=0.36u l=0.28u
X2766 VSS RB8.t23 a_8810_4692# VSS nfet_03v3 ad=0.1584p pd=1.6u as=0.1854p ps=1.75u w=0.36u l=0.28u
X2767 VDD a_22140_2182# a_22274_2496# VDD pfet_03v3 ad=0.1764p pd=1.26u as=0.1584p ps=1.6u w=0.36u l=0.28u
X2768 a_9528_n708.t1 a_9536_n1782# VDD VDD pfet_03v3 ad=0.3224p pd=1.76u as=0.5456p ps=3.36u w=1.24u l=0.28u
X2769 a_440_n1234# a_n884_n1738.t16 VSS.t11 VSS nfet_03v3 ad=56.7f pd=0.675u as=0.1584p ps=1.6u w=0.36u l=0.28u
X2770 a_661_n170# a_n108_n170# VSS VSS nfet_03v3 ad=0.18p pd=1.72u as=97.2f ps=0.9u w=0.36u l=0.28u
X2771 a_10853_706# RA13.t23 VSS VSS nfet_03v3 ad=0.1944p pd=1.8u as=0.1656p ps=1.64u w=0.36u l=0.28u
X2772 a_4836_10022# a_n1204_10022.t20 a_4648_10022# VSS nfet_03v3 ad=0.1278p pd=1.07u as=0.1188p ps=1.02u w=0.36u l=0.28u
X2773 a_6343_n2146.t15 RB3.t20 a_5605_8454# VSS nfet_03v3 ad=0.1584p pd=1.6u as=0.1152p ps=1u w=0.36u l=0.28u
X2774 a_19866_10806# a_19802_10996# a_19668_10806# VDD pfet_03v3 ad=56.7f pd=0.675u as=0.1278p ps=1.07u w=0.36u l=0.28u
X2775 a_23213_5410# RA7.t24 VDD VDD pfet_03v3 ad=0.3888p pd=2.52u as=0.3312p ps=2.36u w=0.72u l=0.28u
X2776 a_15493_2966# a_15797_2966# a_15961_n862.t29 VDD pfet_03v3 ad=0.1152p pd=1u as=0.1584p ps=1.6u w=0.36u l=0.28u
X2777 a_8077_n954# a_7308_n954# VSS.t2713 VSS nfet_03v3 ad=0.18p pd=1.72u as=97.2f ps=0.9u w=0.36u l=0.28u
X2778 a_15797_7670# RA4.t24 VSS VSS nfet_03v3 ad=0.1944p pd=1.8u as=0.1656p ps=1.64u w=0.36u l=0.28u
X2779 a_23213_2274# RA11.t26 VDD VDD pfet_03v3 ad=0.3888p pd=2.52u as=0.3312p ps=2.36u w=0.72u l=0.28u
X2780 a_18703_n2146.t1 RB13.t27 a_17965_614# VSS nfet_03v3 ad=0.1584p pd=1.6u as=0.1152p ps=1u w=0.36u l=0.28u
X2781 a_21952_7670# a_21888_n708.t18 VSS VSS nfet_03v3 ad=0.1188p pd=1.02u as=0.1584p ps=1.6u w=0.36u l=0.28u
X2782 a_26896_n170# a_26832_n708.t23 VDD.t151 VDD.t150 pfet_03v3 ad=0.2097p pd=1.38u as=0.3168p ps=2.32u w=0.72u l=0.28u
X2783 a_13021_10022# RA1.t30 a_13489_n862.t0 VSS nfet_03v3 ad=0.1152p pd=1u as=0.1584p ps=1.6u w=0.36u l=0.28u
X2784 VSS a_n884_10022.t18 a_12450_10022# VSS nfet_03v3 ad=0.1584p pd=1.6u as=56.7f ps=0.675u w=0.36u l=0.28u
X2785 a_35573_n862# RA15.t19 VSS.t494 VSS nfet_03v3 ad=0.1944p pd=1.8u as=0.1656p ps=1.64u w=0.36u l=0.28u
X2786 a_21952_4534# a_21888_n708.t19 VSS VSS nfet_03v3 ad=0.1188p pd=1.02u as=0.1584p ps=1.6u w=0.36u l=0.28u
X2787 a_13325_1398# RA12.t21 VSS VSS nfet_03v3 ad=0.1944p pd=1.8u as=0.1656p ps=1.64u w=0.36u l=0.28u
X2788 VDD a_4836_6886# a_4970_7200# VDD pfet_03v3 ad=0.1764p pd=1.26u as=0.1584p ps=1.6u w=0.36u l=0.28u
X2789 a_9780_2966# a_n884_2966.t17 a_9592_2966# VDD pfet_03v3 ad=0.1278p pd=1.07u as=0.2097p ps=1.38u w=0.36u l=0.28u
X2790 a_18703_n2146.t28 a_18698_n12# a_17965_n170# VDD.t2971 pfet_03v3 ad=0.1584p pd=1.6u as=0.1152p ps=1u w=0.36u l=0.28u
X2791 a_3437_9238# RA2.t24 VDD VDD pfet_03v3 ad=0.3888p pd=2.52u as=0.3312p ps=2.36u w=0.72u l=0.28u
X2792 a_14922_9742# a_14858_9428# a_14724_9238# VSS nfet_03v3 ad=56.7f pd=0.675u as=0.1278p ps=1.07u w=0.36u l=0.28u
X2793 VSS a_29556_6886# a_29690_7200# VSS nfet_03v3 ad=97.2f pd=0.9u as=0.1584p ps=1.6u w=0.36u l=0.28u
X2794 VDD a_n1204_6102.t23 a_7506_6102# VDD pfet_03v3 ad=0.1584p pd=1.6u as=56.7f ps=0.675u w=0.36u l=0.28u
X2795 a_14922_6606# a_14858_6292# a_14724_6102# VSS nfet_03v3 ad=56.7f pd=0.675u as=0.1278p ps=1.07u w=0.36u l=0.28u
X2796 VDD a_4836_3750# a_4970_4064# VDD pfet_03v3 ad=0.1764p pd=1.26u as=0.1584p ps=1.6u w=0.36u l=0.28u
X2797 VDD a_n1204_2966.t21 a_90_2966# VDD pfet_03v3 ad=0.1584p pd=1.6u as=56.7f ps=0.675u w=0.36u l=0.28u
X2798 VDD.t1491 RB14.t29 a_31058_n12# VDD.t742 pfet_03v3 ad=0.3168p pd=2.32u as=0.3708p ps=2.47u w=0.72u l=0.28u
X2799 VDD a_17196_8454# a_17330_8768# VDD pfet_03v3 ad=0.1764p pd=1.26u as=0.1584p ps=1.6u w=0.36u l=0.28u
X2800 VDD D10.t0 a_25477_n1738# VDD pfet_03v3 ad=0.3168p pd=2.32u as=0.2097p ps=1.38u w=0.72u l=0.28u
X2801 a_32288_n1738# a_31784_n1782# VDD VDD pfet_03v3 ad=0.1584p pd=1.6u as=0.1584p ps=1.6u w=0.36u l=0.28u
X2802 VSS a_n884_3750.t18 a_27282_3750# VSS nfet_03v3 ad=0.1584p pd=1.6u as=56.7f ps=0.675u w=0.36u l=0.28u
X2803 a_25381_2182# a_25685_2274# a_25849_n862.t28 VDD pfet_03v3 ad=0.1152p pd=1u as=0.1584p ps=1.6u w=0.36u l=0.28u
X2804 a_38479_n2146.t21 a_38474_n608# a_37741_n954# VDD.t2810 pfet_03v3 ad=0.1584p pd=1.6u as=0.1152p ps=1u w=0.36u l=0.28u
X2805 a_n1652_n962# WE15.t0 VSS.t3046 VSS nfet_03v3 ad=0.1872p pd=1.24u as=0.3168p ps=2.32u w=0.72u l=0.28u
X2806 VDD a_4836_614# a_4970_928# VDD pfet_03v3 ad=0.1764p pd=1.26u as=0.1584p ps=1.6u w=0.36u l=0.28u
X2807 a_13021_7670# a_12252_7670# VDD VDD pfet_03v3 ad=0.36p pd=2.44u as=0.1764p ps=1.26u w=0.72u l=0.28u
X2808 a_21175_n2146.t1 RB5.t22 a_20437_6886# VSS nfet_03v3 ad=0.1584p pd=1.6u as=0.1152p ps=1u w=0.36u l=0.28u
X2809 a_34312_6886# a_34248_n708.t24 VDD VDD pfet_03v3 ad=0.2097p pd=1.38u as=0.3168p ps=2.32u w=0.72u l=0.28u
X2810 a_32226_6886# a_32162_7200# a_32028_6886# VSS nfet_03v3 ad=56.7f pd=0.675u as=0.1278p ps=1.07u w=0.36u l=0.28u
X2811 a_4648_1398# a_4584_n708.t22 VDD VDD pfet_03v3 ad=0.2097p pd=1.38u as=0.3168p ps=2.32u w=0.72u l=0.28u
X2812 a_4648_10806# a_4584_n708.t23 VSS VSS nfet_03v3 ad=0.1188p pd=1.02u as=0.1584p ps=1.6u w=0.36u l=0.28u
X2813 a_13021_4534# a_12252_4534# VDD VDD pfet_03v3 ad=0.36p pd=2.44u as=0.1764p ps=1.26u w=0.72u l=0.28u
X2814 a_29754_2966# a_29690_3156# a_29556_2966# VDD pfet_03v3 ad=56.7f pd=0.675u as=0.1278p ps=1.07u w=0.36u l=0.28u
X2815 a_n884_n1738.t1 WEM.t16 VDD VDD pfet_03v3 ad=0.3654p pd=1.84u as=0.5544p ps=3.4u w=1.26u l=0.28u
X2816 VDD a_7308_10806# a_7442_10996# VDD pfet_03v3 ad=0.1764p pd=1.26u as=0.1584p ps=1.6u w=0.36u l=0.28u
X2817 a_18703_n2146.t0 RB1.t23 a_17965_10022# VSS nfet_03v3 ad=0.1584p pd=1.6u as=0.1152p ps=1u w=0.36u l=0.28u
X2818 a_2176_6886# a_2112_n708.t27 VDD VDD pfet_03v3 ad=0.2097p pd=1.38u as=0.3168p ps=2.32u w=0.72u l=0.28u
X2819 a_n1652_2174# WE11.t0 VSS VSS nfet_03v3 ad=0.1872p pd=1.24u as=0.3168p ps=2.32u w=0.72u l=0.28u
X2820 a_10853_2274# RA11.t27 VSS VSS nfet_03v3 ad=0.1944p pd=1.8u as=0.1656p ps=1.64u w=0.36u l=0.28u
X2821 a_3437_4534# RA8.t28 VSS VSS nfet_03v3 ad=0.1944p pd=1.8u as=0.1656p ps=1.64u w=0.36u l=0.28u
X2822 a_27282_8174# a_27218_7860# a_27084_7670# VSS nfet_03v3 ad=56.7f pd=0.675u as=0.1278p ps=1.07u w=0.36u l=0.28u
X2823 a_29556_n170# a_n1204_n170.t25 a_29368_n170# VSS nfet_03v3 ad=0.1278p pd=1.07u as=0.1188p ps=1.02u w=0.36u l=0.28u
X2824 a_24612_9238# a_n1204_9238.t23 a_24424_9238# VSS nfet_03v3 ad=0.1278p pd=1.07u as=0.1188p ps=1.02u w=0.36u l=0.28u
X2825 a_8077_6886# a_8381_6978# a_8545_n862.t29 VDD pfet_03v3 ad=0.1152p pd=1u as=0.1584p ps=1.6u w=0.36u l=0.28u
X2826 VSS a_13489_n862.t32 QA5b.t1 VSS nfet_03v3 ad=0.1242p pd=1.05u as=0.2052p ps=1.86u w=0.36u l=0.28u
X2827 a_15493_10806# a_14724_10806# VSS VSS nfet_03v3 ad=0.18p pd=1.72u as=97.2f ps=0.9u w=0.36u l=0.28u
X2828 a_27282_5038# a_27218_4724# a_27084_4534# VSS nfet_03v3 ad=56.7f pd=0.675u as=0.1278p ps=1.07u w=0.36u l=0.28u
X2829 VSS RB11.t26 a_13754_2528# VSS nfet_03v3 ad=0.1584p pd=1.6u as=0.1854p ps=1.75u w=0.36u l=0.28u
X2830 VDD a_2120_n1782# a_2112_n708.t0 VDD pfet_03v3 ad=0.5456p pd=3.36u as=0.3224p ps=1.76u w=1.24u l=0.28u
X2831 QB9b.t1 a_23647_n2146.t32 VSS VSS nfet_03v3 ad=0.2052p pd=1.86u as=0.1242p ps=1.05u w=0.36u l=0.28u
X2832 a_25381_10806# a_24612_10806# VDD VDD pfet_03v3 ad=0.36p pd=2.44u as=0.1764p ps=1.26u w=0.72u l=0.28u
X2833 a_24612_6102# a_n1204_6102.t24 a_24424_6102# VSS nfet_03v3 ad=0.1278p pd=1.07u as=0.1188p ps=1.02u w=0.36u l=0.28u
X2834 a_2364_3750# a_n1204_3750.t26 a_2176_3750# VSS nfet_03v3 ad=0.1278p pd=1.07u as=0.1188p ps=1.02u w=0.36u l=0.28u
X2835 a_8077_3750# a_8381_3842# a_8545_n862.t16 VDD pfet_03v3 ad=0.1152p pd=1u as=0.1584p ps=1.6u w=0.36u l=0.28u
X2836 a_17965_n954# RA15.t20 a_18433_n862.t9 VSS nfet_03v3 ad=0.1152p pd=1u as=0.1584p ps=1.6u w=0.36u l=0.28u
X2837 a_8077_10806# RA0.t29 a_8545_n862.t13 VSS nfet_03v3 ad=0.1152p pd=1u as=0.1584p ps=1.6u w=0.36u l=0.28u
X2838 VDD RB5.t23 a_28586_7232# VDD pfet_03v3 ad=0.3168p pd=2.32u as=0.3708p ps=2.47u w=0.72u l=0.28u
X2839 VDD a_36972_6886# a_37106_7200# VDD pfet_03v3 ad=0.1764p pd=1.26u as=0.1584p ps=1.6u w=0.36u l=0.28u
X2840 a_27853_6102# a_27084_6102# VDD VDD pfet_03v3 ad=0.36p pd=2.44u as=0.1764p ps=1.26u w=0.72u l=0.28u
X2841 a_8077_614# a_8381_706# a_8545_n862.t26 VDD pfet_03v3 ad=0.1152p pd=1u as=0.1584p ps=1.6u w=0.36u l=0.28u
X2842 a_26896_10022# a_26832_n708.t24 VSS VSS nfet_03v3 ad=0.1188p pd=1.02u as=0.1584p ps=1.6u w=0.36u l=0.28u
X2843 VSS a_9780_9238# a_9914_9428# VSS nfet_03v3 ad=97.2f pd=0.9u as=0.1584p ps=1.6u w=0.36u l=0.28u
X2844 VDD a_36972_3750# a_37106_4064# VDD pfet_03v3 ad=0.1764p pd=1.26u as=0.1584p ps=1.6u w=0.36u l=0.28u
X2845 a_8381_6978# RA5.t23 VSS VSS nfet_03v3 ad=0.1944p pd=1.8u as=0.1656p ps=1.64u w=0.36u l=0.28u
X2846 VSS a_9780_6102# a_9914_6292# VSS nfet_03v3 ad=97.2f pd=0.9u as=0.1584p ps=1.6u w=0.36u l=0.28u
X2847 VSS RB10.t26 a_16226_3124# VSS nfet_03v3 ad=0.1584p pd=1.6u as=0.1854p ps=1.75u w=0.36u l=0.28u
X2848 VSS.t3233 D8.t1 a_20533_n1738# VSS nfet_03v3 ad=0.1584p pd=1.6u as=0.1188p ps=1.02u w=0.36u l=0.28u
X2849 VDD a_36972_614# a_37106_928# VDD pfet_03v3 ad=0.1764p pd=1.26u as=0.1584p ps=1.6u w=0.36u l=0.28u
X2850 a_30325_9238# a_29556_9238# VSS VSS nfet_03v3 ad=0.18p pd=1.72u as=97.2f ps=0.9u w=0.36u l=0.28u
X2851 VDD RB9.t23 a_33530_4096# VDD pfet_03v3 ad=0.3168p pd=2.32u as=0.3708p ps=2.47u w=0.72u l=0.28u
X2852 a_33101_n862# RA15.t21 VSS.t495 VSS nfet_03v3 ad=0.1944p pd=1.8u as=0.1656p ps=1.64u w=0.36u l=0.28u
X2853 a_37741_5318# a_36972_5318# VDD VDD pfet_03v3 ad=0.36p pd=2.44u as=0.1764p ps=1.26u w=0.72u l=0.28u
X2854 VDD RB13.t28 a_33530_960# VDD pfet_03v3 ad=0.3168p pd=2.32u as=0.3708p ps=2.47u w=0.72u l=0.28u
X2855 a_30325_6102# a_29556_6102# VSS VSS nfet_03v3 ad=0.18p pd=1.72u as=97.2f ps=0.9u w=0.36u l=0.28u
X2856 a_7308_2966# a_n884_2966.t18 a_7120_2966# VDD pfet_03v3 ad=0.1278p pd=1.07u as=0.2097p ps=1.38u w=0.36u l=0.28u
X2857 VSS a_30793_n862.t32 QA12b.t1 VSS nfet_03v3 ad=0.1242p pd=1.05u as=0.2052p ps=1.86u w=0.36u l=0.28u
X2858 a_16231_n2146.t7 a_16226_n12# a_15493_n170# VDD.t2051 pfet_03v3 ad=0.1584p pd=1.6u as=0.1152p ps=1u w=0.36u l=0.28u
X2859 a_12450_9742# a_12386_9428# a_12252_9238# VSS nfet_03v3 ad=56.7f pd=0.675u as=0.1278p ps=1.07u w=0.36u l=0.28u
X2860 a_30325_8454# RA3.t23 a_30793_n862.t25 VSS nfet_03v3 ad=0.1152p pd=1u as=0.1584p ps=1.6u w=0.36u l=0.28u
X2861 a_37741_2182# a_36972_2182# VDD VDD pfet_03v3 ad=0.36p pd=2.44u as=0.1764p ps=1.26u w=0.72u l=0.28u
X2862 a_24612_n170# a_n1204_n170.t26 a_24424_n170# VSS nfet_03v3 ad=0.1278p pd=1.07u as=0.1188p ps=1.02u w=0.36u l=0.28u
X2863 a_661_7670# a_n108_7670# VSS VSS nfet_03v3 ad=0.18p pd=1.72u as=97.2f ps=0.9u w=0.36u l=0.28u
X2864 VDD a_n1204_6102.t25 a_5034_6102# VDD pfet_03v3 ad=0.1584p pd=1.6u as=56.7f ps=0.675u w=0.36u l=0.28u
X2865 VSS a_n108_8454# a_26_8768# VSS nfet_03v3 ad=97.2f pd=0.9u as=0.1584p ps=1.6u w=0.36u l=0.28u
X2866 VDD a_14724_8454# a_14858_8768# VDD pfet_03v3 ad=0.1764p pd=1.26u as=0.1584p ps=1.6u w=0.36u l=0.28u
X2867 a_n108_7670# a_n884_7670.t17 a_n296_7670# VDD pfet_03v3 ad=0.1278p pd=1.07u as=0.2097p ps=1.38u w=0.36u l=0.28u
X2868 a_12450_6606# a_12386_6292# a_12252_6102# VSS nfet_03v3 ad=56.7f pd=0.675u as=0.1278p ps=1.07u w=0.36u l=0.28u
X2869 a_661_4534# a_n108_4534# VSS VSS nfet_03v3 ad=0.18p pd=1.72u as=97.2f ps=0.9u w=0.36u l=0.28u
X2870 a_12000_n708.t3 a_12008_n1782# VSS.t2657 VSS nfet_03v3 ad=0.1612p pd=1.14u as=0.2728p ps=2.12u w=0.62u l=0.28u
X2871 VSS a_n108_5318# a_26_5632# VSS nfet_03v3 ad=97.2f pd=0.9u as=0.1584p ps=1.6u w=0.36u l=0.28u
X2872 a_n108_4534# a_n884_4534.t17 a_n296_4534# VDD pfet_03v3 ad=0.1278p pd=1.07u as=0.2097p ps=1.38u w=0.36u l=0.28u
X2873 a_22909_2182# a_23213_2274# a_23377_n862.t20 VDD pfet_03v3 ad=0.1152p pd=1u as=0.1584p ps=1.6u w=0.36u l=0.28u
X2874 a_2562_614# a_2498_928# a_2364_614# VSS nfet_03v3 ad=56.7f pd=0.675u as=0.1278p ps=1.07u w=0.36u l=0.28u
X2875 a_13021_10806# RA0.t30 a_13489_n862.t13 VSS nfet_03v3 ad=0.1152p pd=1u as=0.1584p ps=1.6u w=0.36u l=0.28u
X2876 VDD RB3.t21 a_11282_8800# VDD pfet_03v3 ad=0.3168p pd=2.32u as=0.3708p ps=2.47u w=0.72u l=0.28u
X2877 a_10549_7670# a_9780_7670# VDD VDD pfet_03v3 ad=0.36p pd=2.44u as=0.1764p ps=1.26u w=0.72u l=0.28u
X2878 VDD a_n1204_7670.t24 a_22338_7670# VDD pfet_03v3 ad=0.1584p pd=1.6u as=56.7f ps=0.675u w=0.36u l=0.28u
X2879 VDD.t3324 a_12252_n954# a_12386_n640# VDD.t3323 pfet_03v3 ad=0.1764p pd=1.26u as=0.1584p ps=1.6u w=0.36u l=0.28u
X2880 a_24424_8454# a_24360_n708.t23 VSS VSS nfet_03v3 ad=0.1188p pd=1.02u as=0.1584p ps=1.6u w=0.36u l=0.28u
X2881 a_10549_4534# a_9780_4534# VDD VDD pfet_03v3 ad=0.36p pd=2.44u as=0.1764p ps=1.26u w=0.72u l=0.28u
X2882 a_7308_n170# a_n1204_n170.t27 a_7120_n170# VSS nfet_03v3 ad=0.1278p pd=1.07u as=0.1188p ps=1.02u w=0.36u l=0.28u
X2883 a_25685_6102# RA6.t23 VDD VDD pfet_03v3 ad=0.3888p pd=2.52u as=0.3312p ps=2.36u w=0.72u l=0.28u
X2884 VDD a_n1204_4534.t25 a_22338_4534# VDD pfet_03v3 ad=0.1584p pd=1.6u as=56.7f ps=0.675u w=0.36u l=0.28u
X2885 VSS a_n884_3750.t19 a_7506_3750# VSS nfet_03v3 ad=0.1584p pd=1.6u as=56.7f ps=0.675u w=0.36u l=0.28u
X2886 a_24424_5318# a_24360_n708.t24 VSS VSS nfet_03v3 ad=0.1188p pd=1.02u as=0.1584p ps=1.6u w=0.36u l=0.28u
X2887 a_10040_n1738# a_9536_n1782# VDD VDD pfet_03v3 ad=0.1584p pd=1.6u as=0.1584p ps=1.6u w=0.36u l=0.28u
X2888 a_37741_6886# a_38045_6978# a_38209_n862.t24 VDD pfet_03v3 ad=0.1152p pd=1u as=0.1584p ps=1.6u w=0.36u l=0.28u
X2889 a_37741_3750# a_38045_3842# a_38209_n862.t31 VDD pfet_03v3 ad=0.1152p pd=1u as=0.1584p ps=1.6u w=0.36u l=0.28u
X2890 a_22140_9238# a_n1204_9238.t24 a_21952_9238# VSS nfet_03v3 ad=0.1278p pd=1.07u as=0.1188p ps=1.02u w=0.36u l=0.28u
X2891 a_5605_6886# a_5909_6978# a_6073_n862.t23 VDD pfet_03v3 ad=0.1152p pd=1u as=0.1584p ps=1.6u w=0.36u l=0.28u
X2892 VSS a_n884_2966.t19 a_34698_3470# VSS nfet_03v3 ad=0.1584p pd=1.6u as=56.7f ps=0.675u w=0.36u l=0.28u
X2893 a_9592_10806# a_9528_n708.t14 VDD VDD pfet_03v3 ad=0.2097p pd=1.38u as=0.3168p ps=2.32u w=0.72u l=0.28u
X2894 a_35573_5410# RA7.t25 VDD VDD pfet_03v3 ad=0.3888p pd=2.52u as=0.3312p ps=2.36u w=0.72u l=0.28u
X2895 a_13759_n2146.t21 a_13754_3124# a_13021_2966# VDD pfet_03v3 ad=0.1584p pd=1.6u as=0.1152p ps=1u w=0.36u l=0.28u
X2896 VDD a_2364_2182# a_2498_2496# VDD pfet_03v3 ad=0.1764p pd=1.26u as=0.1584p ps=1.6u w=0.36u l=0.28u
X2897 VSS.t1255 a_n884_n954.t19 a_12450_n954# VSS nfet_03v3 ad=0.1584p pd=1.6u as=56.7f ps=0.675u w=0.36u l=0.28u
X2898 a_37741_614# a_38045_706# a_38209_n862.t29 VDD pfet_03v3 ad=0.1152p pd=1u as=0.1584p ps=1.6u w=0.36u l=0.28u
X2899 a_17965_8454# a_18269_8546# a_18433_n862.t18 VDD pfet_03v3 ad=0.1152p pd=1u as=0.1584p ps=1.6u w=0.36u l=0.28u
X2900 a_2562_6102# a_2498_6292# a_2364_6102# VDD pfet_03v3 ad=56.7f pd=0.675u as=0.1278p ps=1.07u w=0.36u l=0.28u
X2901 a_22140_6102# a_n1204_6102.t26 a_21952_6102# VSS nfet_03v3 ad=0.1278p pd=1.07u as=0.1188p ps=1.02u w=0.36u l=0.28u
X2902 a_5605_3750# a_5909_3842# a_6073_n862.t31 VDD pfet_03v3 ad=0.1152p pd=1u as=0.1584p ps=1.6u w=0.36u l=0.28u
X2903 a_965_2966# RA10.t23 VDD VDD pfet_03v3 ad=0.3888p pd=2.52u as=0.3312p ps=2.36u w=0.72u l=0.28u
X2904 a_10853_2966# RA10.t24 VSS VSS nfet_03v3 ad=0.1944p pd=1.8u as=0.1656p ps=1.64u w=0.36u l=0.28u
X2905 a_27853_2966# a_28157_2966# a_28321_n862.t13 VDD pfet_03v3 ad=0.1152p pd=1u as=0.1584p ps=1.6u w=0.36u l=0.28u
X2906 a_18703_n2146.t24 RB0.t24 a_17965_10806# VSS nfet_03v3 ad=0.1584p pd=1.6u as=0.1152p ps=1u w=0.36u l=0.28u
X2907 a_35573_2274# RA11.t28 VDD VDD pfet_03v3 ad=0.3888p pd=2.52u as=0.3312p ps=2.36u w=0.72u l=0.28u
X2908 a_5605_614# a_5909_706# a_6073_n862.t16 VDD pfet_03v3 ad=0.1152p pd=1u as=0.1584p ps=1.6u w=0.36u l=0.28u
X2909 a_20437_1398# a_20741_1398# a_20905_n862.t15 VDD pfet_03v3 ad=0.1152p pd=1u as=0.1584p ps=1.6u w=0.36u l=0.28u
X2910 VDD a_n1204_6102.t27 a_37170_6102# VDD pfet_03v3 ad=0.1584p pd=1.6u as=56.7f ps=0.675u w=0.36u l=0.28u
X2911 a_35048_n1234# a_n884_n1738.t17 VSS.t12 VSS nfet_03v3 ad=56.7f pd=0.675u as=0.1584p ps=1.6u w=0.36u l=0.28u
X2912 a_25685_1398# RA12.t22 VSS VSS nfet_03v3 ad=0.1944p pd=1.8u as=0.1656p ps=1.64u w=0.36u l=0.28u
X2913 VSS a_n1204_1398.t24 a_n884_1398.t2 VSS nfet_03v3 ad=0.2948p pd=2.22u as=0.1943p ps=1.25u w=0.67u l=0.28u
X2914 VSS RB10.t27 a_13754_3124# VSS nfet_03v3 ad=0.1584p pd=1.6u as=0.1854p ps=1.75u w=0.36u l=0.28u
X2915 a_12008_n1782# a_12512_n1738# a_12800_n1738# VDD pfet_03v3 ad=0.1278p pd=1.07u as=56.7f ps=0.675u w=0.36u l=0.28u
X2916 a_13759_n2146.t31 a_13754_10368# a_13021_10022# VDD pfet_03v3 ad=0.1584p pd=1.6u as=0.1152p ps=1u w=0.36u l=0.28u
X2917 a_28591_n2146.t18 a_28586_7828# a_27853_7670# VDD pfet_03v3 ad=0.1584p pd=1.6u as=0.1152p ps=1u w=0.36u l=0.28u
X2918 a_32226_334# a_32162_20# a_32028_n170# VSS nfet_03v3 ad=56.7f pd=0.675u as=0.1278p ps=1.07u w=0.36u l=0.28u
X2919 a_28591_n2146.t11 a_28586_4692# a_27853_4534# VDD pfet_03v3 ad=0.1584p pd=1.6u as=0.1152p ps=1u w=0.36u l=0.28u
X2920 a_27853_3750# a_27084_3750# VSS VSS nfet_03v3 ad=0.18p pd=1.72u as=97.2f ps=0.9u w=0.36u l=0.28u
X2921 a_90_8958# a_26_8768# a_n108_8454# VDD pfet_03v3 ad=56.7f pd=0.675u as=0.1278p ps=1.07u w=0.36u l=0.28u
X2922 a_22400_n1738# a_21896_n1782# VSS.t2312 VSS nfet_03v3 ad=0.1584p pd=1.6u as=0.1584p ps=1.6u w=0.36u l=0.28u
X2923 a_13021_n954# a_13325_n862# a_13489_n862.t14 VDD.t2065 pfet_03v3 ad=0.1152p pd=1u as=0.1584p ps=1.6u w=0.36u l=0.28u
X2924 a_26119_n2146.t12 a_26114_1556# a_25381_1398# VDD pfet_03v3 ad=0.1584p pd=1.6u as=0.1152p ps=1u w=0.36u l=0.28u
X2925 a_4648_n170# a_4584_n708.t24 VDD.t1588 VDD.t1587 pfet_03v3 ad=0.2097p pd=1.38u as=0.3168p ps=2.32u w=0.72u l=0.28u
X2926 a_33535_n2146.t7 RB5.t24 a_32797_6886# VSS nfet_03v3 ad=0.1584p pd=1.6u as=0.1152p ps=1u w=0.36u l=0.28u
X2927 VSS a_n884_614.t26 a_2562_614# VSS nfet_03v3 ad=0.1584p pd=1.6u as=56.7f ps=0.675u w=0.36u l=0.28u
X2928 a_1399_n2146.t1 RB5.t25 a_661_6886# VSS nfet_03v3 ad=0.1584p pd=1.6u as=0.1152p ps=1u w=0.36u l=0.28u
X2929 a_14724_1398# a_n884_1398.t18 a_14536_1398# VDD pfet_03v3 ad=0.1278p pd=1.07u as=0.2097p ps=1.38u w=0.36u l=0.28u
X2930 a_37170_11310# a_37106_10996# a_36972_10806# VSS nfet_03v3 ad=56.7f pd=0.675u as=0.1278p ps=1.07u w=0.36u l=0.28u
X2931 a_n884_9238.t2 a_n1204_9238.t25 VSS VSS nfet_03v3 ad=0.1943p pd=1.25u as=0.1693p ps=1.19u w=0.67u l=0.28u
X2932 a_13021_3750# a_12252_3750# VDD VDD pfet_03v3 ad=0.36p pd=2.44u as=0.1764p ps=1.26u w=0.72u l=0.28u
X2933 VSS a_2364_614# a_2498_928# VSS nfet_03v3 ad=97.2f pd=0.9u as=0.1584p ps=1.6u w=0.36u l=0.28u
X2934 a_8815_n2146.t17 a_8810_1556# a_8077_1398# VDD pfet_03v3 ad=0.1584p pd=1.6u as=0.1152p ps=1u w=0.36u l=0.28u
X2935 a_n884_10806.t0 WE0CLK.t24 VDD VDD pfet_03v3 ad=0.3886p pd=1.92u as=0.3386p ps=1.86u w=1.34u l=0.28u
X2936 a_n1204_4534.t3 a_n1652_4534# VSS VSS nfet_03v3 ad=0.1651p pd=1.155u as=0.2794p ps=2.15u w=0.635u l=0.28u
X2937 a_9978_2966# a_9914_3156# a_9780_2966# VDD pfet_03v3 ad=56.7f pd=0.675u as=0.1278p ps=1.07u w=0.36u l=0.28u
X2938 a_13021_614# a_12252_614# VDD VDD pfet_03v3 ad=0.36p pd=2.44u as=0.1764p ps=1.26u w=0.72u l=0.28u
X2939 VDD a_n1204_10022.t21 a_32226_10526# VDD pfet_03v3 ad=0.1584p pd=1.6u as=56.7f ps=0.675u w=0.36u l=0.28u
X2940 a_n884_6102.t2 a_n1204_6102.t28 VSS VSS nfet_03v3 ad=0.1943p pd=1.25u as=0.1693p ps=1.19u w=0.67u l=0.28u
X2941 a_19668_5318# a_n884_5318.t16 a_19480_5318# VDD pfet_03v3 ad=0.1278p pd=1.07u as=0.2097p ps=1.38u w=0.36u l=0.28u
X2942 VSS RB7.t25 a_28586_5664# VSS nfet_03v3 ad=0.1584p pd=1.6u as=0.1854p ps=1.75u w=0.36u l=0.28u
X2943 VSS a_n884_3750.t20 a_5034_3750# VSS nfet_03v3 ad=0.1584p pd=1.6u as=56.7f ps=0.675u w=0.36u l=0.28u
X2944 a_36972_9238# a_n1204_9238.t26 a_36784_9238# VSS nfet_03v3 ad=0.1278p pd=1.07u as=0.1188p ps=1.02u w=0.36u l=0.28u
X2945 a_23213_6102# RA6.t24 VDD VDD pfet_03v3 ad=0.3888p pd=2.52u as=0.3312p ps=2.36u w=0.72u l=0.28u
X2946 a_n884_2966.t3 a_n1204_2966.t22 VSS VSS nfet_03v3 ad=0.1943p pd=1.25u as=0.1693p ps=1.19u w=0.67u l=0.28u
X2947 a_3133_2182# a_3437_2274# a_3601_n862.t25 VDD pfet_03v3 ad=0.1152p pd=1u as=0.1584p ps=1.6u w=0.36u l=0.28u
X2948 a_n1204_1398.t3 a_n1652_1398# VSS VSS nfet_03v3 ad=0.1651p pd=1.155u as=0.2794p ps=2.15u w=0.635u l=0.28u
X2949 a_n884_2966.t1 a_n1204_2966.t23 VDD VDD pfet_03v3 ad=0.3886p pd=1.92u as=0.3386p ps=1.86u w=1.34u l=0.28u
X2950 VSS RB11.t27 a_26114_2528# VSS nfet_03v3 ad=0.1584p pd=1.6u as=0.1854p ps=1.75u w=0.36u l=0.28u
X2951 a_90_10526# a_26_10336# a_n108_10022# VDD pfet_03v3 ad=56.7f pd=0.675u as=0.1278p ps=1.07u w=0.36u l=0.28u
X2952 VDD a_n1204_7670.t25 a_2562_7670# VDD pfet_03v3 ad=0.1584p pd=1.6u as=56.7f ps=0.675u w=0.36u l=0.28u
X2953 a_36972_6102# a_n1204_6102.t29 a_36784_6102# VSS nfet_03v3 ad=0.1278p pd=1.07u as=0.1188p ps=1.02u w=0.36u l=0.28u
X2954 VDD a_32028_2182# a_32162_2496# VDD pfet_03v3 ad=0.1764p pd=1.26u as=0.1584p ps=1.6u w=0.36u l=0.28u
X2955 a_24424_n954# a_24360_n708.t25 VDD.t1738 VDD.t1730 pfet_03v3 ad=0.2097p pd=1.38u as=0.3168p ps=2.32u w=0.72u l=0.28u
X2956 a_25381_10022# a_24612_10022# VDD VDD pfet_03v3 ad=0.36p pd=2.44u as=0.1764p ps=1.26u w=0.72u l=0.28u
X2957 VDD a_n1204_4534.t26 a_2562_4534# VDD pfet_03v3 ad=0.1584p pd=1.6u as=56.7f ps=0.675u w=0.36u l=0.28u
X2958 a_8077_2182# a_7308_2182# VSS VSS nfet_03v3 ad=0.18p pd=1.72u as=97.2f ps=0.9u w=0.36u l=0.28u
X2959 VSS.t1256 a_n884_n954.t20 a_9978_n954# VSS nfet_03v3 ad=0.1584p pd=1.6u as=56.7f ps=0.675u w=0.36u l=0.28u
X2960 a_33101_5410# RA7.t26 VDD VDD pfet_03v3 ad=0.3888p pd=2.52u as=0.3312p ps=2.36u w=0.72u l=0.28u
X2961 a_29556_10022# a_n884_10022.t19 a_29368_10022# VDD pfet_03v3 ad=0.1278p pd=1.07u as=0.2097p ps=1.38u w=0.36u l=0.28u
X2962 a_33101_2274# RA11.t29 VDD VDD pfet_03v3 ad=0.3888p pd=2.52u as=0.3312p ps=2.36u w=0.72u l=0.28u
X2963 a_31840_7670# a_31776_n708.t19 VSS VSS nfet_03v3 ad=0.1188p pd=1.02u as=0.1584p ps=1.6u w=0.36u l=0.28u
X2964 VDD a_9780_10022# a_9914_10336# VDD pfet_03v3 ad=0.1764p pd=1.26u as=0.1584p ps=1.6u w=0.36u l=0.28u
X2965 a_n1652_8886# WE3.t0 VDD VDD pfet_03v3 ad=0.1872p pd=1.24u as=0.3168p ps=2.32u w=0.72u l=0.28u
X2966 a_31840_4534# a_31776_n708.t20 VSS VSS nfet_03v3 ad=0.1188p pd=1.02u as=0.1584p ps=1.6u w=0.36u l=0.28u
X2967 a_23213_1398# RA12.t23 VSS VSS nfet_03v3 ad=0.1944p pd=1.8u as=0.1656p ps=1.64u w=0.36u l=0.28u
X2968 a_24810_9742# a_24746_9428# a_24612_9238# VSS nfet_03v3 ad=56.7f pd=0.675u as=0.1278p ps=1.07u w=0.36u l=0.28u
X2969 VDD a_27084_8454# a_27218_8768# VDD pfet_03v3 ad=0.1764p pd=1.26u as=0.1584p ps=1.6u w=0.36u l=0.28u
X2970 a_24810_6606# a_24746_6292# a_24612_6102# VSS nfet_03v3 ad=56.7f pd=0.675u as=0.1278p ps=1.07u w=0.36u l=0.28u
X2971 a_2562_3750# a_2498_4064# a_2364_3750# VSS nfet_03v3 ad=56.7f pd=0.675u as=0.1278p ps=1.07u w=0.36u l=0.28u
X2972 VSS RB9.t24 a_11282_4096# VSS nfet_03v3 ad=0.1584p pd=1.6u as=0.1854p ps=1.75u w=0.36u l=0.28u
X2973 VSS a_n884_3750.t21 a_37170_3750# VSS nfet_03v3 ad=0.1584p pd=1.6u as=56.7f ps=0.675u w=0.36u l=0.28u
X2974 a_35269_2182# a_35573_2274# a_35737_n862.t15 VDD pfet_03v3 ad=0.1152p pd=1u as=0.1584p ps=1.6u w=0.36u l=0.28u
X2975 a_19480_7670# a_19416_n708.t15 VDD VDD pfet_03v3 ad=0.2097p pd=1.38u as=0.3168p ps=2.32u w=0.72u l=0.28u
X2976 a_31063_n2146.t13 RB14.t30 a_30325_n170# VSS nfet_03v3 ad=0.1584p pd=1.6u as=0.1152p ps=1u w=0.36u l=0.28u
X2977 VDD RB3.t22 a_23642_8800# VDD pfet_03v3 ad=0.3168p pd=2.32u as=0.3708p ps=2.47u w=0.72u l=0.28u
X2978 a_22909_7670# a_22140_7670# VDD VDD pfet_03v3 ad=0.36p pd=2.44u as=0.1764p ps=1.26u w=0.72u l=0.28u
X2979 VSS a_n884_10806.t23 a_9978_11310# VSS nfet_03v3 ad=0.1584p pd=1.6u as=56.7f ps=0.675u w=0.36u l=0.28u
X2980 a_31063_n2146.t1 RB5.t26 a_30325_6886# VSS nfet_03v3 ad=0.1584p pd=1.6u as=0.1152p ps=1u w=0.36u l=0.28u
X2981 a_19480_4534# a_19416_n708.t16 VDD VDD pfet_03v3 ad=0.2097p pd=1.38u as=0.3168p ps=2.32u w=0.72u l=0.28u
X2982 a_36784_8454# a_36720_n708.t26 VSS VSS nfet_03v3 ad=0.1188p pd=1.02u as=0.1584p ps=1.6u w=0.36u l=0.28u
X2983 a_22909_4534# a_22140_4534# VDD VDD pfet_03v3 ad=0.36p pd=2.44u as=0.1764p ps=1.26u w=0.72u l=0.28u
X2984 a_12252_1398# a_n884_1398.t19 a_12064_1398# VDD pfet_03v3 ad=0.1278p pd=1.07u as=0.2097p ps=1.38u w=0.36u l=0.28u
X2985 a_10549_3750# a_9780_3750# VDD VDD pfet_03v3 ad=0.36p pd=2.44u as=0.1764p ps=1.26u w=0.72u l=0.28u
X2986 a_20741_2274# RA11.t30 VSS VSS nfet_03v3 ad=0.1944p pd=1.8u as=0.1656p ps=1.64u w=0.36u l=0.28u
X2987 a_10549_8454# RA3.t24 a_11017_n862.t29 VSS nfet_03v3 ad=0.1152p pd=1u as=0.1584p ps=1.6u w=0.36u l=0.28u
X2988 a_36784_5318# a_36720_n708.t27 VSS VSS nfet_03v3 ad=0.1188p pd=1.02u as=0.1584p ps=1.6u w=0.36u l=0.28u
X2989 VSS.t535 WEM.t17 a_n884_n1738.t2 VSS nfet_03v3 ad=0.2772p pd=2.14u as=0.1827p ps=1.21u w=0.63u l=0.28u
X2990 a_29304_n708.t1 a_29312_n1782# VDD VDD pfet_03v3 ad=0.3224p pd=1.76u as=0.5456p ps=3.36u w=1.24u l=0.28u
X2991 a_4836_n954# a_n884_n954.t21 a_4648_n954# VDD.t1355 pfet_03v3 ad=0.1278p pd=1.07u as=0.2097p ps=1.38u w=0.36u l=0.28u
X2992 a_6343_n2146.t12 a_6338_1556# a_5605_1398# VDD pfet_03v3 ad=0.1584p pd=1.6u as=0.1152p ps=1u w=0.36u l=0.28u
X2993 a_37170_8174# a_37106_7860# a_36972_7670# VSS nfet_03v3 ad=56.7f pd=0.675u as=0.1278p ps=1.07u w=0.36u l=0.28u
X2994 a_7506_2966# a_7442_3156# a_7308_2966# VDD pfet_03v3 ad=56.7f pd=0.675u as=0.1278p ps=1.07u w=0.36u l=0.28u
X2995 a_10549_614# a_9780_614# VDD VDD pfet_03v3 ad=0.36p pd=2.44u as=0.1764p ps=1.26u w=0.72u l=0.28u
X2996 VDD a_n1204_7670.t26 a_32226_7670# VDD pfet_03v3 ad=0.1584p pd=1.6u as=56.7f ps=0.675u w=0.36u l=0.28u
X2997 a_17196_5318# a_n884_5318.t17 a_17008_5318# VDD pfet_03v3 ad=0.1278p pd=1.07u as=0.2097p ps=1.38u w=0.36u l=0.28u
X2998 VDD.t2381 a_22140_n954# a_22274_n640# VDD.t2380 pfet_03v3 ad=0.1764p pd=1.26u as=0.1584p ps=1.6u w=0.36u l=0.28u
X2999 a_34500_9238# a_n1204_9238.t27 a_34312_9238# VSS nfet_03v3 ad=0.1278p pd=1.07u as=0.1188p ps=1.02u w=0.36u l=0.28u
X3000 a_37170_5038# a_37106_4724# a_36972_4534# VSS nfet_03v3 ad=56.7f pd=0.675u as=0.1278p ps=1.07u w=0.36u l=0.28u
X3001 a_13021_n954# a_12252_n954# VSS.t3155 VSS nfet_03v3 ad=0.18p pd=1.72u as=97.2f ps=0.9u w=0.36u l=0.28u
X3002 a_661_7670# RA4.t25 a_1129_n862.t12 VSS nfet_03v3 ad=0.1152p pd=1u as=0.1584p ps=1.6u w=0.36u l=0.28u
X3003 VDD a_17196_6102# a_17330_6292# VDD pfet_03v3 ad=0.1764p pd=1.26u as=0.1584p ps=1.6u w=0.36u l=0.28u
X3004 VDD a_n1204_4534.t27 a_32226_4534# VDD pfet_03v3 ad=0.1584p pd=1.6u as=56.7f ps=0.675u w=0.36u l=0.28u
X3005 a_20437_n170# a_20741_n170# a_20905_n862.t29 VDD.t3177 pfet_03v3 ad=0.1152p pd=1u as=0.1584p ps=1.6u w=0.36u l=0.28u
X3006 a_9592_10022# a_9528_n708.t15 VDD VDD pfet_03v3 ad=0.2097p pd=1.38u as=0.3168p ps=2.32u w=0.72u l=0.28u
X3007 VDD RB5.t27 a_38474_7232# VDD pfet_03v3 ad=0.3168p pd=2.32u as=0.3708p ps=2.47u w=0.72u l=0.28u
X3008 a_34500_6102# a_n1204_6102.t30 a_34312_6102# VSS nfet_03v3 ad=0.1278p pd=1.07u as=0.1188p ps=1.02u w=0.36u l=0.28u
X3009 QB3b.t0 a_8815_n2146.t33 VDD VDD pfet_03v3 ad=0.4104p pd=2.58u as=0.2484p ps=1.41u w=0.72u l=0.28u
X3010 a_2562_11310# a_2498_10996# a_2364_10806# VSS nfet_03v3 ad=56.7f pd=0.675u as=0.1278p ps=1.07u w=0.36u l=0.28u
X3011 VSS RB2.t22 a_28586_9396# VSS nfet_03v3 ad=0.1584p pd=1.6u as=0.1854p ps=1.75u w=0.36u l=0.28u
X3012 a_37741_6102# a_36972_6102# VDD VDD pfet_03v3 ad=0.36p pd=2.44u as=0.1764p ps=1.26u w=0.72u l=0.28u
X3013 VSS a_19668_9238# a_19802_9428# VSS nfet_03v3 ad=97.2f pd=0.9u as=0.1584p ps=1.6u w=0.36u l=0.28u
X3014 VSS RB6.t25 a_28586_6260# VSS nfet_03v3 ad=0.1584p pd=1.6u as=0.1854p ps=1.75u w=0.36u l=0.28u
X3015 VSS RB11.t28 a_6338_2528# VSS nfet_03v3 ad=0.1584p pd=1.6u as=0.1854p ps=1.75u w=0.36u l=0.28u
X3016 a_8077_8454# a_7308_8454# VDD VDD pfet_03v3 ad=0.36p pd=2.44u as=0.1764p ps=1.26u w=0.72u l=0.28u
X3017 VSS a_19668_6102# a_19802_6292# VSS nfet_03v3 ad=97.2f pd=0.9u as=0.1584p ps=1.6u w=0.36u l=0.28u
X3018 a_15797_8546# RA3.t25 VSS VSS nfet_03v3 ad=0.1944p pd=1.8u as=0.1656p ps=1.64u w=0.36u l=0.28u
X3019 VSS RB10.t28 a_26114_3124# VSS nfet_03v3 ad=0.1584p pd=1.6u as=0.1854p ps=1.75u w=0.36u l=0.28u
X3020 a_33101_10806# RA0.t31 VDD VDD pfet_03v3 ad=0.3888p pd=2.52u as=0.3312p ps=2.36u w=0.72u l=0.28u
X3021 a_38045_7670# RA4.t26 VSS VSS nfet_03v3 ad=0.1944p pd=1.8u as=0.1656p ps=1.64u w=0.36u l=0.28u
X3022 VDD RB2.t23 a_11282_9396# VDD pfet_03v3 ad=0.3168p pd=2.32u as=0.3708p ps=2.47u w=0.72u l=0.28u
X3023 a_26119_n2146.t28 a_26114_n12# a_25381_n170# VDD.t2405 pfet_03v3 ad=0.1584p pd=1.6u as=0.1152p ps=1u w=0.36u l=0.28u
X3024 a_22338_9742# a_22274_9428# a_22140_9238# VSS nfet_03v3 ad=56.7f pd=0.675u as=0.1278p ps=1.07u w=0.36u l=0.28u
X3025 a_32028_8454# a_n1204_8454.t24 a_31840_8454# VSS nfet_03v3 ad=0.1278p pd=1.07u as=0.1188p ps=1.02u w=0.36u l=0.28u
X3026 a_5909_7670# RA4.t27 VSS VSS nfet_03v3 ad=0.1944p pd=1.8u as=0.1656p ps=1.64u w=0.36u l=0.28u
X3027 a_25381_n954# a_25685_n862# a_25849_n862.t31 VDD.t2628 pfet_03v3 ad=0.1152p pd=1u as=0.1584p ps=1.6u w=0.36u l=0.28u
X3028 VDD RB0.t25 a_21170_10964# VDD pfet_03v3 ad=0.3168p pd=2.32u as=0.3708p ps=2.47u w=0.72u l=0.28u
X3029 a_22338_6606# a_22274_6292# a_22140_6102# VSS nfet_03v3 ad=56.7f pd=0.675u as=0.1278p ps=1.07u w=0.36u l=0.28u
X3030 VDD a_34500_2966# a_34634_3156# VDD pfet_03v3 ad=0.1764p pd=1.26u as=0.1584p ps=1.6u w=0.36u l=0.28u
X3031 VSS a_17196_10806# a_17330_10996# VSS nfet_03v3 ad=97.2f pd=0.9u as=0.1584p ps=1.6u w=0.36u l=0.28u
X3032 VDD a_24612_8454# a_24746_8768# VDD pfet_03v3 ad=0.1764p pd=1.26u as=0.1584p ps=1.6u w=0.36u l=0.28u
X3033 a_32028_5318# a_n1204_5318.t21 a_31840_5318# VSS nfet_03v3 ad=0.1278p pd=1.07u as=0.1188p ps=1.02u w=0.36u l=0.28u
X3034 a_14724_n170# a_n884_n170.t18 a_14536_n170# VDD.t1348 pfet_03v3 ad=0.1278p pd=1.07u as=0.2097p ps=1.38u w=0.36u l=0.28u
X3035 VDD a_27084_10806# a_27218_10996# VDD pfet_03v3 ad=0.1764p pd=1.26u as=0.1584p ps=1.6u w=0.36u l=0.28u
X3036 a_17394_2686# a_17330_2496# a_17196_2182# VDD pfet_03v3 ad=56.7f pd=0.675u as=0.1278p ps=1.07u w=0.36u l=0.28u
X3037 a_32797_2182# a_33101_2274# a_33265_n862.t31 VDD pfet_03v3 ad=0.1152p pd=1u as=0.1584p ps=1.6u w=0.36u l=0.28u
X3038 a_8815_n2146.t31 a_8810_n12# a_8077_n170# VDD.t2490 pfet_03v3 ad=0.1584p pd=1.6u as=0.1152p ps=1u w=0.36u l=0.28u
X3039 a_5034_9742# a_4970_9428# a_4836_9238# VSS nfet_03v3 ad=56.7f pd=0.675u as=0.1278p ps=1.07u w=0.36u l=0.28u
X3040 VDD RB3.t23 a_21170_8800# VDD pfet_03v3 ad=0.3168p pd=2.32u as=0.3708p ps=2.47u w=0.72u l=0.28u
X3041 VSS RB4.t23 a_8810_7828# VSS nfet_03v3 ad=0.1584p pd=1.6u as=0.1854p ps=1.75u w=0.36u l=0.28u
X3042 QB5b.t0 a_13759_n2146.t33 VDD VDD pfet_03v3 ad=0.4104p pd=2.58u as=0.2484p ps=1.41u w=0.72u l=0.28u
X3043 a_29754_10806# a_29690_10996# a_29556_10806# VDD pfet_03v3 ad=56.7f pd=0.675u as=0.1278p ps=1.07u w=0.36u l=0.28u
X3044 a_20437_7670# a_19668_7670# VDD VDD pfet_03v3 ad=0.36p pd=2.44u as=0.1764p ps=1.26u w=0.72u l=0.28u
X3045 VSS.t2667 D0.t1 a_757_n1738# VSS nfet_03v3 ad=0.1584p pd=1.6u as=0.1188p ps=1.02u w=0.36u l=0.28u
X3046 a_2176_10022# a_2112_n708.t28 VSS VSS nfet_03v3 ad=0.1188p pd=1.02u as=0.1584p ps=1.6u w=0.36u l=0.28u
X3047 VDD a_7308_8454# a_7442_8768# VDD pfet_03v3 ad=0.1764p pd=1.26u as=0.1584p ps=1.6u w=0.36u l=0.28u
X3048 a_34312_8454# a_34248_n708.t25 VSS VSS nfet_03v3 ad=0.1188p pd=1.02u as=0.1584p ps=1.6u w=0.36u l=0.28u
X3049 a_5034_6606# a_4970_6292# a_4836_6102# VSS nfet_03v3 ad=56.7f pd=0.675u as=0.1278p ps=1.07u w=0.36u l=0.28u
X3050 VDD a_n1652_2966# a_n1204_2966.t0 VDD pfet_03v3 ad=0.3386p pd=1.86u as=0.3302p ps=1.79u w=1.27u l=0.28u
X3051 a_7308_10806# a_n884_10806.t24 a_7120_10806# VDD pfet_03v3 ad=0.1278p pd=1.07u as=0.2097p ps=1.38u w=0.36u l=0.28u
X3052 a_20437_4534# a_19668_4534# VDD VDD pfet_03v3 ad=0.36p pd=2.44u as=0.1764p ps=1.26u w=0.72u l=0.28u
X3053 a_35573_6102# RA6.t25 VDD VDD pfet_03v3 ad=0.3888p pd=2.52u as=0.3312p ps=2.36u w=0.72u l=0.28u
X3054 a_34312_5318# a_34248_n708.t26 VSS VSS nfet_03v3 ad=0.1188p pd=1.02u as=0.1584p ps=1.6u w=0.36u l=0.28u
X3055 VSS RB8.t24 a_11282_4692# VSS nfet_03v3 ad=0.1584p pd=1.6u as=0.1854p ps=1.75u w=0.36u l=0.28u
X3056 a_n108_n954# a_n1204_n954.t23 a_n296_n954# VSS nfet_03v3 ad=0.1278p pd=1.07u as=0.1188p ps=1.02u w=0.36u l=0.28u
X3057 a_2176_8454# a_2112_n708.t29 VSS VSS nfet_03v3 ad=0.1188p pd=1.02u as=0.1584p ps=1.6u w=0.36u l=0.28u
X3058 a_2176_5318# a_2112_n708.t30 VSS VSS nfet_03v3 ad=0.1188p pd=1.02u as=0.1584p ps=1.6u w=0.36u l=0.28u
X3059 VSS a_n884_2182.t19 a_12450_2182# VSS nfet_03v3 ad=0.1584p pd=1.6u as=56.7f ps=0.675u w=0.36u l=0.28u
X3060 a_36784_n954# a_36720_n708.t28 VDD.t1779 VDD.t1763 pfet_03v3 ad=0.2097p pd=1.38u as=0.3168p ps=2.32u w=0.72u l=0.28u
X3061 VDD a_14724_6102# a_14858_6292# VDD pfet_03v3 ad=0.1764p pd=1.26u as=0.1584p ps=1.6u w=0.36u l=0.28u
X3062 VSS.t1257 a_n884_n954.t22 a_22338_n954# VSS nfet_03v3 ad=0.1584p pd=1.6u as=56.7f ps=0.675u w=0.36u l=0.28u
X3063 a_10549_n954# a_9780_n954# VSS.t2541 VSS nfet_03v3 ad=0.18p pd=1.72u as=97.2f ps=0.9u w=0.36u l=0.28u
X3064 VDD a_20905_n862.t33 QA8b.t0 VDD pfet_03v3 ad=0.2484p pd=1.41u as=0.4104p ps=2.58u w=0.72u l=0.28u
X3065 a_20741_2966# RA10.t25 VSS VSS nfet_03v3 ad=0.1944p pd=1.8u as=0.1656p ps=1.64u w=0.36u l=0.28u
X3066 a_8077_1398# a_7308_1398# VSS VSS nfet_03v3 ad=0.18p pd=1.72u as=97.2f ps=0.9u w=0.36u l=0.28u
X3067 a_30325_1398# a_30629_1398# a_30793_n862.t1 VDD pfet_03v3 ad=0.1152p pd=1u as=0.1584p ps=1.6u w=0.36u l=0.28u
X3068 a_19668_10022# a_n1204_10022.t22 a_19480_10022# VSS nfet_03v3 ad=0.1278p pd=1.07u as=0.1188p ps=1.02u w=0.36u l=0.28u
X3069 a_18703_n2146.t21 a_18698_7232# a_17965_6886# VDD pfet_03v3 ad=0.1584p pd=1.6u as=0.1152p ps=1u w=0.36u l=0.28u
X3070 a_27084_2182# a_n884_2182.t20 a_26896_2182# VDD pfet_03v3 ad=0.1278p pd=1.07u as=0.2097p ps=1.38u w=0.36u l=0.28u
X3071 a_14922_1398# a_14858_1588# a_14724_1398# VDD pfet_03v3 ad=56.7f pd=0.675u as=0.1278p ps=1.07u w=0.36u l=0.28u
X3072 VSS RB5.t28 a_16226_7232# VSS nfet_03v3 ad=0.1584p pd=1.6u as=0.1854p ps=1.75u w=0.36u l=0.28u
X3073 a_18703_n2146.t8 a_18698_4096# a_17965_3750# VDD pfet_03v3 ad=0.1584p pd=1.6u as=0.1152p ps=1u w=0.36u l=0.28u
X3074 VSS RB11.t29 a_3866_2528# VSS nfet_03v3 ad=0.1584p pd=1.6u as=0.1854p ps=1.75u w=0.36u l=0.28u
X3075 a_5701_n1738# a_n884_n1738.t18 a_4592_n1782# VDD pfet_03v3 ad=0.2097p pd=1.38u as=0.1278p ps=1.07u w=0.36u l=0.28u
X3076 a_35573_1398# RA12.t24 VSS VSS nfet_03v3 ad=0.1944p pd=1.8u as=0.1656p ps=1.64u w=0.36u l=0.28u
X3077 a_19866_5822# a_19802_5632# a_19668_5318# VDD pfet_03v3 ad=56.7f pd=0.675u as=0.1278p ps=1.07u w=0.36u l=0.28u
X3078 a_17965_2966# a_17196_2966# VSS VSS nfet_03v3 ad=0.18p pd=1.72u as=97.2f ps=0.9u w=0.36u l=0.28u
X3079 a_8077_n954# RA15.t22 a_8545_n862.t7 VSS nfet_03v3 ad=0.1152p pd=1u as=0.1584p ps=1.6u w=0.36u l=0.28u
X3080 a_12252_10806# a_n884_10806.t25 a_12064_10806# VDD pfet_03v3 ad=0.1278p pd=1.07u as=0.2097p ps=1.38u w=0.36u l=0.28u
X3081 a_23213_10114# RA1.t31 VSS VSS nfet_03v3 ad=0.1944p pd=1.8u as=0.1656p ps=1.64u w=0.36u l=0.28u
X3082 a_38479_n2146.t28 a_38474_7828# a_37741_7670# VDD pfet_03v3 ad=0.1584p pd=1.6u as=0.1152p ps=1u w=0.36u l=0.28u
X3083 a_n1652_5750# CLK a_n1652_5310# VSS nfet_03v3 ad=0.3168p pd=2.32u as=0.1872p ps=1.24u w=0.72u l=0.28u
X3084 VSS a_17196_3750# a_17330_4064# VSS nfet_03v3 ad=97.2f pd=0.9u as=0.1584p ps=1.6u w=0.36u l=0.28u
X3085 a_18703_n2146.t18 a_18698_960# a_17965_614# VDD pfet_03v3 ad=0.1584p pd=1.6u as=0.1152p ps=1u w=0.36u l=0.28u
X3086 a_32226_10526# a_32162_10336# a_32028_10022# VDD pfet_03v3 ad=56.7f pd=0.675u as=0.1278p ps=1.07u w=0.36u l=0.28u
X3087 a_14472_n708.t2 a_14480_n1782# VSS.t1715 VSS nfet_03v3 ad=0.1612p pd=1.14u as=0.2728p ps=2.12u w=0.62u l=0.28u
X3088 a_38479_n2146.t13 a_38474_4692# a_37741_4534# VDD pfet_03v3 ad=0.1584p pd=1.6u as=0.1152p ps=1u w=0.36u l=0.28u
X3089 VSS RB9.t25 a_23642_4096# VSS nfet_03v3 ad=0.1584p pd=1.6u as=0.1854p ps=1.75u w=0.36u l=0.28u
X3090 VSS RB1.t24 a_11282_10368# VSS nfet_03v3 ad=0.1584p pd=1.6u as=0.1854p ps=1.75u w=0.36u l=0.28u
X3091 a_3437_7670# RA4.t28 VSS VSS nfet_03v3 ad=0.1944p pd=1.8u as=0.1656p ps=1.64u w=0.36u l=0.28u
X3092 a_37741_3750# a_36972_3750# VSS VSS nfet_03v3 ad=0.18p pd=1.72u as=97.2f ps=0.9u w=0.36u l=0.28u
X3093 VSS RB10.t29 a_6338_3124# VSS nfet_03v3 ad=0.1584p pd=1.6u as=0.1854p ps=1.75u w=0.36u l=0.28u
X3094 a_22909_n954# a_23213_n862# a_23377_n862.t22 VDD.t2603 pfet_03v3 ad=0.1152p pd=1u as=0.1584p ps=1.6u w=0.36u l=0.28u
X3095 a_36972_10022# a_n1204_10022.t23 a_36784_10022# VSS nfet_03v3 ad=0.1278p pd=1.07u as=0.1188p ps=1.02u w=0.36u l=0.28u
X3096 a_17965_6102# a_18269_6102# a_18433_n862.t17 VDD pfet_03v3 ad=0.1152p pd=1u as=0.1584p ps=1.6u w=0.36u l=0.28u
X3097 a_36007_n2146.t13 RB7.t26 a_35269_5318# VSS nfet_03v3 ad=0.1584p pd=1.6u as=0.1152p ps=1u w=0.36u l=0.28u
X3098 a_37170_334# a_37106_20# a_36972_n170# VSS nfet_03v3 ad=56.7f pd=0.675u as=0.1278p ps=1.07u w=0.36u l=0.28u
X3099 a_12252_n170# a_n884_n170.t19 a_12064_n170# VDD.t1349 pfet_03v3 ad=0.1278p pd=1.07u as=0.2097p ps=1.38u w=0.36u l=0.28u
X3100 a_12064_7670# a_12000_n708.t18 VSS VSS nfet_03v3 ad=0.1188p pd=1.02u as=0.1584p ps=1.6u w=0.36u l=0.28u
X3101 VDD WEM.t18 a_n884_n1738.t3 VDD pfet_03v3 ad=0.5544p pd=3.4u as=0.3654p ps=1.84u w=1.26u l=0.28u
X3102 a_19480_3750# a_19416_n708.t17 VDD VDD pfet_03v3 ad=0.2097p pd=1.38u as=0.3168p ps=2.32u w=0.72u l=0.28u
X3103 a_29816_n1738# a_29312_n1782# VDD VDD pfet_03v3 ad=0.1584p pd=1.6u as=0.1584p ps=1.6u w=0.36u l=0.28u
X3104 a_6343_n2146.t30 a_6338_n12# a_5605_n170# VDD.t3049 pfet_03v3 ad=0.1584p pd=1.6u as=0.1152p ps=1u w=0.36u l=0.28u
X3105 a_24612_1398# a_n884_1398.t20 a_24424_1398# VDD pfet_03v3 ad=0.1278p pd=1.07u as=0.2097p ps=1.38u w=0.36u l=0.28u
X3106 VSS a_n1204_8454.t25 a_n884_8454.t1 VSS nfet_03v3 ad=0.2948p pd=2.22u as=0.1943p ps=1.25u w=0.67u l=0.28u
X3107 a_12064_4534# a_12000_n708.t19 VSS VSS nfet_03v3 ad=0.1188p pd=1.02u as=0.1584p ps=1.6u w=0.36u l=0.28u
X3108 a_22909_3750# a_22140_3750# VDD VDD pfet_03v3 ad=0.36p pd=2.44u as=0.1764p ps=1.26u w=0.72u l=0.28u
X3109 a_24810_334# a_24746_20# a_24612_n170# VSS nfet_03v3 ad=56.7f pd=0.675u as=0.1278p ps=1.07u w=0.36u l=0.28u
X3110 VDD RB0.t26 a_16226_10964# VDD pfet_03v3 ad=0.3168p pd=2.32u as=0.3708p ps=2.47u w=0.72u l=0.28u
X3111 a_19480_614# a_19416_n708.t18 VDD VDD pfet_03v3 ad=0.2097p pd=1.38u as=0.3168p ps=2.32u w=0.72u l=0.28u
X3112 a_19480_10806# a_19416_n708.t19 VSS VSS nfet_03v3 ad=0.1188p pd=1.02u as=0.1584p ps=1.6u w=0.36u l=0.28u
X3113 VDD a_4836_8454# a_4970_8768# VDD pfet_03v3 ad=0.1764p pd=1.26u as=0.1584p ps=1.6u w=0.36u l=0.28u
X3114 VSS a_n1204_5318.t22 a_n884_5318.t1 VSS nfet_03v3 ad=0.2948p pd=2.22u as=0.1943p ps=1.25u w=0.67u l=0.28u
X3115 VSS RB7.t27 a_38474_5664# VSS nfet_03v3 ad=0.1584p pd=1.6u as=0.1854p ps=1.75u w=0.36u l=0.28u
X3116 a_10645_n1738# a_n884_n1738.t19 a_9536_n1782# VDD pfet_03v3 ad=0.2097p pd=1.38u as=0.1278p ps=1.07u w=0.36u l=0.28u
X3117 a_22909_614# a_22140_614# VDD VDD pfet_03v3 ad=0.36p pd=2.44u as=0.1764p ps=1.26u w=0.72u l=0.28u
X3118 a_29368_10806# a_29304_n708.t14 VDD VDD pfet_03v3 ad=0.2097p pd=1.38u as=0.3168p ps=2.32u w=0.72u l=0.28u
X3119 a_n1652_10014# WE1.t1 VSS VSS nfet_03v3 ad=0.1872p pd=1.24u as=0.3168p ps=2.32u w=0.72u l=0.28u
X3120 a_33101_6102# RA6.t26 VDD VDD pfet_03v3 ad=0.3888p pd=2.52u as=0.3312p ps=2.36u w=0.72u l=0.28u
X3121 a_29556_5318# a_n884_5318.t18 a_29368_5318# VDD pfet_03v3 ad=0.1278p pd=1.07u as=0.2097p ps=1.38u w=0.36u l=0.28u
X3122 a_n352_n1782# a_152_n1738# a_440_n1234# VSS nfet_03v3 ad=0.1278p pd=1.07u as=56.7f ps=0.675u w=0.36u l=0.28u
X3123 a_31776_n708.t2 a_31784_n1782# VSS.t3149 VSS nfet_03v3 ad=0.1612p pd=1.14u as=0.2728p ps=2.12u w=0.62u l=0.28u
X3124 VDD a_9780_1398# a_9914_1588# VDD pfet_03v3 ad=0.1764p pd=1.26u as=0.1584p ps=1.6u w=0.36u l=0.28u
X3125 VSS RB11.t30 a_36002_2528# VSS nfet_03v3 ad=0.1584p pd=1.6u as=0.1854p ps=1.75u w=0.36u l=0.28u
X3126 a_34312_n954# a_34248_n708.t27 VDD.t1278 VDD.t1268 pfet_03v3 ad=0.2097p pd=1.38u as=0.3168p ps=2.32u w=0.72u l=0.28u
X3127 VDD.t2323 a_2364_n954# a_2498_n640# VDD.t2322 pfet_03v3 ad=0.1764p pd=1.26u as=0.1584p ps=1.6u w=0.36u l=0.28u
X3128 VDD a_n1652_1046# a_n1204_614.t1 VDD pfet_03v3 ad=0.3386p pd=1.86u as=0.3302p ps=1.79u w=1.27u l=0.28u
X3129 a_90_6102# a_26_6292# a_n108_6102# VDD pfet_03v3 ad=56.7f pd=0.675u as=0.1278p ps=1.07u w=0.36u l=0.28u
X3130 VSS a_n884_2182.t21 a_9978_2182# VSS nfet_03v3 ad=0.1584p pd=1.6u as=56.7f ps=0.675u w=0.36u l=0.28u
X3131 a_17965_1398# RA12.t25 a_18433_n862.t5 VSS nfet_03v3 ad=0.1152p pd=1u as=0.1584p ps=1.6u w=0.36u l=0.28u
X3132 VDD a_16952_n1782# a_16944_n708.t1 VDD pfet_03v3 ad=0.5456p pd=3.36u as=0.3224p ps=1.76u w=1.24u l=0.28u
X3133 a_2176_n954# a_2112_n708.t31 VDD.t1211 VDD.t1201 pfet_03v3 ad=0.2097p pd=1.38u as=0.3168p ps=2.32u w=0.72u l=0.28u
X3134 a_33101_n170# RA14.t23 VSS VSS nfet_03v3 ad=0.1944p pd=1.8u as=0.1656p ps=1.64u w=0.36u l=0.28u
X3135 a_7506_334# a_7442_20# a_7308_n170# VSS nfet_03v3 ad=56.7f pd=0.675u as=0.1278p ps=1.07u w=0.36u l=0.28u
X3136 a_30325_1398# a_29556_1398# VDD VDD pfet_03v3 ad=0.36p pd=2.44u as=0.1764p ps=1.26u w=0.72u l=0.28u
X3137 a_n1652_9238# WE2.t1 VDD VDD pfet_03v3 ad=0.1872p pd=1.24u as=0.3168p ps=2.32u w=0.72u l=0.28u
X3138 VSS a_n884_7670.t18 a_14922_8174# VSS nfet_03v3 ad=0.1584p pd=1.6u as=56.7f ps=0.675u w=0.36u l=0.28u
X3139 a_n1652_6878# WE5.t0 VSS VSS nfet_03v3 ad=0.1872p pd=1.24u as=0.3168p ps=2.32u w=0.72u l=0.28u
X3140 a_10853_6978# RA5.t24 VSS VSS nfet_03v3 ad=0.1944p pd=1.8u as=0.1656p ps=1.64u w=0.36u l=0.28u
X3141 VSS a_n884_4534.t18 a_14922_5038# VSS nfet_03v3 ad=0.1584p pd=1.6u as=56.7f ps=0.675u w=0.36u l=0.28u
X3142 a_20741_n170# RA14.t24 VSS VSS nfet_03v3 ad=0.1944p pd=1.8u as=0.1656p ps=1.64u w=0.36u l=0.28u
X3143 a_12450_1398# a_12386_1588# a_12252_1398# VDD pfet_03v3 ad=56.7f pd=0.675u as=0.1278p ps=1.07u w=0.36u l=0.28u
X3144 a_16231_n2146.t24 a_16226_7232# a_15493_6886# VDD pfet_03v3 ad=0.1584p pd=1.6u as=0.1152p ps=1u w=0.36u l=0.28u
X3145 a_37741_n954# RA15.t23 a_38209_n862.t9 VSS nfet_03v3 ad=0.1152p pd=1u as=0.1584p ps=1.6u w=0.36u l=0.28u
X3146 a_36784_10806# a_36720_n708.t29 VSS VSS nfet_03v3 ad=0.1188p pd=1.02u as=0.1584p ps=1.6u w=0.36u l=0.28u
X3147 a_36007_n2146.t28 a_36002_10368# a_35269_10022# VDD pfet_03v3 ad=0.1584p pd=1.6u as=0.1152p ps=1u w=0.36u l=0.28u
X3148 a_16231_n2146.t30 a_16226_4096# a_15493_3750# VDD pfet_03v3 ad=0.1584p pd=1.6u as=0.1152p ps=1u w=0.36u l=0.28u
X3149 VSS.t1258 a_n884_n954.t23 a_2562_n954# VSS nfet_03v3 ad=0.1584p pd=1.6u as=56.7f ps=0.675u w=0.36u l=0.28u
X3150 a_33101_1398# RA12.t26 VSS VSS nfet_03v3 ad=0.1944p pd=1.8u as=0.1656p ps=1.64u w=0.36u l=0.28u
X3151 VSS RB5.t29 a_13754_7232# VSS nfet_03v3 ad=0.1584p pd=1.6u as=0.1854p ps=1.75u w=0.36u l=0.28u
X3152 a_3871_n2146.t20 a_3866_3124# a_3133_2966# VDD pfet_03v3 ad=0.1584p pd=1.6u as=0.1152p ps=1u w=0.36u l=0.28u
X3153 a_15493_2966# a_14724_2966# VSS VSS nfet_03v3 ad=0.18p pd=1.72u as=97.2f ps=0.9u w=0.36u l=0.28u
X3154 VDD.t735 RB15.t25 a_28586_n608# VDD.t734 pfet_03v3 ad=0.3168p pd=2.32u as=0.3708p ps=2.47u w=0.72u l=0.28u
X3155 a_5605_n954# RA15.t24 a_6073_n862.t9 VSS nfet_03v3 ad=0.1152p pd=1u as=0.1584p ps=1.6u w=0.36u l=0.28u
X3156 a_17965_10022# a_18269_10114# a_18433_n862.t30 VDD pfet_03v3 ad=0.1152p pd=1u as=0.1584p ps=1.6u w=0.36u l=0.28u
X3157 a_33101_10114# RA1.t32 VDD VDD pfet_03v3 ad=0.3888p pd=2.52u as=0.3312p ps=2.36u w=0.72u l=0.28u
X3158 VDD RB2.t24 a_23642_9396# VDD pfet_03v3 ad=0.3168p pd=2.32u as=0.3708p ps=2.47u w=0.72u l=0.28u
X3159 a_34698_9742# a_34634_9428# a_34500_9238# VSS nfet_03v3 ad=56.7f pd=0.675u as=0.1278p ps=1.07u w=0.36u l=0.28u
X3160 a_8077_8454# a_8381_8546# a_8545_n862.t28 VDD pfet_03v3 ad=0.1152p pd=1u as=0.1584p ps=1.6u w=0.36u l=0.28u
X3161 a_16231_n2146.t31 a_16226_960# a_15493_614# VDD pfet_03v3 ad=0.1584p pd=1.6u as=0.1152p ps=1u w=0.36u l=0.28u
X3162 VSS a_14724_3750# a_14858_4064# VSS nfet_03v3 ad=97.2f pd=0.9u as=0.1584p ps=1.6u w=0.36u l=0.28u
X3163 a_35269_n170# a_34500_n170# VSS VSS nfet_03v3 ad=0.18p pd=1.72u as=97.2f ps=0.9u w=0.36u l=0.28u
X3164 VDD RB5.t30 a_18698_7232# VDD pfet_03v3 ad=0.3168p pd=2.32u as=0.3708p ps=2.47u w=0.72u l=0.28u
X3165 a_34698_6606# a_34634_6292# a_34500_6102# VSS nfet_03v3 ad=56.7f pd=0.675u as=0.1278p ps=1.07u w=0.36u l=0.28u
X3166 VDD a_34256_n1782# a_34248_n708.t1 VDD pfet_03v3 ad=0.5456p pd=3.36u as=0.3224p ps=1.76u w=1.24u l=0.28u
X3167 a_3437_n170# RA14.t25 VSS VSS nfet_03v3 ad=0.1944p pd=1.8u as=0.1656p ps=1.64u w=0.36u l=0.28u
X3168 VDD RB1.t25 a_21170_10368# VDD pfet_03v3 ad=0.3168p pd=2.32u as=0.3708p ps=2.47u w=0.72u l=0.28u
X3169 VDD a_36972_8454# a_37106_8768# VDD pfet_03v3 ad=0.1764p pd=1.26u as=0.1584p ps=1.6u w=0.36u l=0.28u
X3170 VDD a_12252_7670# a_12386_7860# VDD pfet_03v3 ad=0.1764p pd=1.26u as=0.1584p ps=1.6u w=0.36u l=0.28u
X3171 VSS RB9.t26 a_21170_4096# VSS nfet_03v3 ad=0.1584p pd=1.6u as=0.1854p ps=1.75u w=0.36u l=0.28u
X3172 a_22909_n170# a_22140_n170# VSS VSS nfet_03v3 ad=0.18p pd=1.72u as=97.2f ps=0.9u w=0.36u l=0.28u
X3173 VSS a_n884_8454.t20 a_19866_8454# VSS nfet_03v3 ad=0.1584p pd=1.6u as=56.7f ps=0.675u w=0.36u l=0.28u
X3174 VDD RB3.t24 a_33530_8800# VDD pfet_03v3 ad=0.3168p pd=2.32u as=0.3708p ps=2.47u w=0.72u l=0.28u
X3175 a_29368_7670# a_29304_n708.t15 VDD VDD pfet_03v3 ad=0.2097p pd=1.38u as=0.3168p ps=2.32u w=0.72u l=0.28u
X3176 VDD a_12252_4534# a_12386_4724# VDD pfet_03v3 ad=0.1764p pd=1.26u as=0.1584p ps=1.6u w=0.36u l=0.28u
X3177 VSS RB10.t30 a_3866_3124# VSS nfet_03v3 ad=0.1584p pd=1.6u as=0.1854p ps=1.75u w=0.36u l=0.28u
X3178 VSS a_n884_n170.t20 a_37170_334# VSS nfet_03v3 ad=0.1584p pd=1.6u as=56.7f ps=0.675u w=0.36u l=0.28u
X3179 a_27282_10526# a_27218_10336# a_27084_10022# VDD pfet_03v3 ad=56.7f pd=0.675u as=0.1278p ps=1.07u w=0.36u l=0.28u
X3180 a_32797_7670# a_32028_7670# VDD VDD pfet_03v3 ad=0.36p pd=2.44u as=0.1764p ps=1.26u w=0.72u l=0.28u
X3181 VSS a_n884_5318.t19 a_19866_5318# VSS nfet_03v3 ad=0.1584p pd=1.6u as=56.7f ps=0.675u w=0.36u l=0.28u
X3182 a_29368_4534# a_29304_n708.t16 VDD VDD pfet_03v3 ad=0.2097p pd=1.38u as=0.3168p ps=2.32u w=0.72u l=0.28u
X3183 a_23213_10806# RA0.t32 VSS VSS nfet_03v3 ad=0.1944p pd=1.8u as=0.1656p ps=1.64u w=0.36u l=0.28u
X3184 a_32797_4534# a_32028_4534# VDD VDD pfet_03v3 ad=0.36p pd=2.44u as=0.1764p ps=1.26u w=0.72u l=0.28u
X3185 a_30629_2274# RA11.t31 VSS VSS nfet_03v3 ad=0.1944p pd=1.8u as=0.1656p ps=1.64u w=0.36u l=0.28u
X3186 VSS a_36972_n170# a_37106_20# VSS nfet_03v3 ad=97.2f pd=0.9u as=0.1584p ps=1.6u w=0.36u l=0.28u
X3187 VSS a_n884_n170.t21 a_24810_334# VSS nfet_03v3 ad=0.1584p pd=1.6u as=56.7f ps=0.675u w=0.36u l=0.28u
X3188 a_22140_1398# a_n884_1398.t21 a_21952_1398# VDD pfet_03v3 ad=0.1278p pd=1.07u as=0.2097p ps=1.38u w=0.36u l=0.28u
X3189 a_35269_10022# a_35573_10114# a_35737_n862.t25 VDD pfet_03v3 ad=0.1152p pd=1u as=0.1584p ps=1.6u w=0.36u l=0.28u
X3190 VSS RB8.t25 a_23642_4692# VSS nfet_03v3 ad=0.1584p pd=1.6u as=0.1854p ps=1.75u w=0.36u l=0.28u
X3191 a_20437_3750# a_19668_3750# VDD VDD pfet_03v3 ad=0.36p pd=2.44u as=0.1764p ps=1.26u w=0.72u l=0.28u
X3192 a_3133_n954# a_3437_n862# a_3601_n862.t31 VDD.t3360 pfet_03v3 ad=0.1152p pd=1u as=0.1584p ps=1.6u w=0.36u l=0.28u
X3193 a_36007_n2146.t8 RB14.t31 a_35269_n170# VSS nfet_03v3 ad=0.1584p pd=1.6u as=0.1152p ps=1u w=0.36u l=0.28u
X3194 VSS RB0.t27 a_11282_10964# VSS nfet_03v3 ad=0.1584p pd=1.6u as=0.1854p ps=1.75u w=0.36u l=0.28u
X3195 a_36007_n2146.t0 RB2.t25 a_35269_9238# VSS nfet_03v3 ad=0.1584p pd=1.6u as=0.1152p ps=1u w=0.36u l=0.28u
X3196 a_20437_614# a_19668_614# VDD VDD pfet_03v3 ad=0.36p pd=2.44u as=0.1764p ps=1.26u w=0.72u l=0.28u
X3197 a_15493_5318# a_15797_5410# a_15961_n862.t31 VDD pfet_03v3 ad=0.1152p pd=1u as=0.1584p ps=1.6u w=0.36u l=0.28u
X3198 a_13021_2182# a_12252_2182# VSS VSS nfet_03v3 ad=0.18p pd=1.72u as=97.2f ps=0.9u w=0.36u l=0.28u
X3199 a_36007_n2146.t6 RB6.t26 a_35269_6102# VSS nfet_03v3 ad=0.1584p pd=1.6u as=0.1152p ps=1u w=0.36u l=0.28u
X3200 a_n296_2966# a_n360_n708.t21 VSS VSS nfet_03v3 ad=0.1188p pd=1.02u as=0.1584p ps=1.6u w=0.36u l=0.28u
X3201 VDD.t2760 a_32028_n954# a_32162_n640# VDD.t2759 pfet_03v3 ad=0.1764p pd=1.26u as=0.1584p ps=1.6u w=0.36u l=0.28u
X3202 a_19480_n954# a_19416_n708.t20 VSS.t1566 VSS nfet_03v3 ad=0.1188p pd=1.02u as=0.1584p ps=1.6u w=0.36u l=0.28u
X3203 a_23647_n2146.t7 RB14.t32 a_22909_n170# VSS nfet_03v3 ad=0.1584p pd=1.6u as=0.1152p ps=1u w=0.36u l=0.28u
X3204 VDD a_27084_6102# a_27218_6292# VDD pfet_03v3 ad=0.1764p pd=1.26u as=0.1584p ps=1.6u w=0.36u l=0.28u
X3205 a_5384_n1234# a_n884_n1738.t20 VSS.t13 VSS nfet_03v3 ad=56.7f pd=0.675u as=0.1584p ps=1.6u w=0.36u l=0.28u
X3206 a_29312_n1782# a_29816_n1738# a_30104_n1234# VSS nfet_03v3 ad=0.1278p pd=1.07u as=56.7f ps=0.675u w=0.36u l=0.28u
X3207 a_22909_n954# a_22140_n954# VSS.t2193 VSS nfet_03v3 ad=0.18p pd=1.72u as=97.2f ps=0.9u w=0.36u l=0.28u
X3208 a_30325_n170# a_30629_n170# a_30793_n862.t27 VDD.t3062 pfet_03v3 ad=0.1152p pd=1u as=0.1584p ps=1.6u w=0.36u l=0.28u
X3209 a_30325_n170# a_29556_n170# VSS VSS nfet_03v3 ad=0.18p pd=1.72u as=97.2f ps=0.9u w=0.36u l=0.28u
X3210 a_8077_9238# a_7308_9238# VDD VDD pfet_03v3 ad=0.36p pd=2.44u as=0.1764p ps=1.26u w=0.72u l=0.28u
X3211 a_14922_n170# a_14858_20# a_14724_n170# VDD.t2803 pfet_03v3 ad=56.7f pd=0.675u as=0.1278p ps=1.07u w=0.36u l=0.28u
X3212 VSS a_n884_1398.t22 a_12450_1902# VSS nfet_03v3 ad=0.1584p pd=1.6u as=56.7f ps=0.675u w=0.36u l=0.28u
X3213 VSS RB2.t26 a_38474_9396# VSS nfet_03v3 ad=0.1584p pd=1.6u as=0.1854p ps=1.75u w=0.36u l=0.28u
X3214 a_9780_5318# a_n884_5318.t20 a_9592_5318# VDD pfet_03v3 ad=0.1278p pd=1.07u as=0.2097p ps=1.38u w=0.36u l=0.28u
X3215 VDD WE0CLK.t25 a_90_10806# VDD pfet_03v3 ad=0.1584p pd=1.6u as=56.7f ps=0.675u w=0.36u l=0.28u
X3216 VSS a_29556_9238# a_29690_9428# VSS nfet_03v3 ad=97.2f pd=0.9u as=0.1584p ps=1.6u w=0.36u l=0.28u
X3217 VSS RB6.t27 a_38474_6260# VSS nfet_03v3 ad=0.1584p pd=1.6u as=0.1854p ps=1.75u w=0.36u l=0.28u
X3218 VDD a_n1204_5318.t23 a_90_5822# VDD pfet_03v3 ad=0.1584p pd=1.6u as=56.7f ps=0.675u w=0.36u l=0.28u
X3219 VSS a_n884_n170.t22 a_32226_334# VSS nfet_03v3 ad=0.1584p pd=1.6u as=56.7f ps=0.675u w=0.36u l=0.28u
X3220 a_n884_8454.t2 a_n1204_8454.t26 VDD VDD pfet_03v3 ad=0.3886p pd=1.92u as=0.3386p ps=1.86u w=1.34u l=0.28u
X3221 VSS a_29556_6102# a_29690_6292# VSS nfet_03v3 ad=97.2f pd=0.9u as=0.1584p ps=1.6u w=0.36u l=0.28u
X3222 VSS RB10.t31 a_36002_3124# VSS nfet_03v3 ad=0.1584p pd=1.6u as=0.1854p ps=1.75u w=0.36u l=0.28u
X3223 VSS.t1259 a_n884_n954.t24 a_32226_n954# VSS nfet_03v3 ad=0.1584p pd=1.6u as=56.7f ps=0.675u w=0.36u l=0.28u
X3224 a_6343_n2146.t14 RB14.t33 a_5605_n170# VSS nfet_03v3 ad=0.1584p pd=1.6u as=0.1152p ps=1u w=0.36u l=0.28u
X3225 a_37741_8454# a_38045_8546# a_38209_n862.t16 VDD pfet_03v3 ad=0.1152p pd=1u as=0.1584p ps=1.6u w=0.36u l=0.28u
X3226 a_13325_6978# RA5.t25 VDD VDD pfet_03v3 ad=0.3888p pd=2.52u as=0.3312p ps=2.36u w=0.72u l=0.28u
X3227 a_13021_7670# a_13325_7670# a_13489_n862.t11 VDD pfet_03v3 ad=0.1152p pd=1u as=0.1584p ps=1.6u w=0.36u l=0.28u
X3228 a_n884_5318.t2 a_n1204_5318.t24 VDD VDD pfet_03v3 ad=0.3886p pd=1.92u as=0.3386p ps=1.86u w=1.34u l=0.28u
X3229 a_90_3750# a_26_4064# a_n108_3750# VSS nfet_03v3 ad=56.7f pd=0.675u as=0.1278p ps=1.07u w=0.36u l=0.28u
X3230 VSS a_32028_n170# a_32162_20# VSS nfet_03v3 ad=97.2f pd=0.9u as=0.1584p ps=1.6u w=0.36u l=0.28u
X3231 a_22338_10022# a_22274_10336# a_22140_10022# VSS nfet_03v3 ad=56.7f pd=0.675u as=0.1278p ps=1.07u w=0.36u l=0.28u
X3232 a_5605_8454# a_5909_8546# a_6073_n862.t20 VDD pfet_03v3 ad=0.1152p pd=1u as=0.1584p ps=1.6u w=0.36u l=0.28u
X3233 a_13021_4534# a_13325_4534# a_13489_n862.t24 VDD pfet_03v3 ad=0.1152p pd=1u as=0.1584p ps=1.6u w=0.36u l=0.28u
X3234 VDD RB2.t27 a_21170_9396# VDD pfet_03v3 ad=0.3168p pd=2.32u as=0.3708p ps=2.47u w=0.72u l=0.28u
X3235 a_32226_9742# a_32162_9428# a_32028_9238# VSS nfet_03v3 ad=56.7f pd=0.675u as=0.1278p ps=1.07u w=0.36u l=0.28u
X3236 a_35269_n954# a_35573_n862# a_35737_n862.t30 VDD.t3437 pfet_03v3 ad=0.1152p pd=1u as=0.1584p ps=1.6u w=0.36u l=0.28u
X3237 a_10549_1398# a_10853_1398# a_11017_n862.t22 VDD pfet_03v3 ad=0.1152p pd=1u as=0.1584p ps=1.6u w=0.36u l=0.28u
X3238 a_32226_6606# a_32162_6292# a_32028_6102# VSS nfet_03v3 ad=56.7f pd=0.675u as=0.1278p ps=1.07u w=0.36u l=0.28u
X3239 a_29754_5822# a_29690_5632# a_29556_5318# VDD pfet_03v3 ad=56.7f pd=0.675u as=0.1278p ps=1.07u w=0.36u l=0.28u
X3240 a_24612_n170# a_n884_n170.t23 a_24424_n170# VDD.t1350 pfet_03v3 ad=0.1278p pd=1.07u as=0.2097p ps=1.38u w=0.36u l=0.28u
X3241 VSS a_n884_8454.t21 a_17394_8454# VSS nfet_03v3 ad=0.1584p pd=1.6u as=56.7f ps=0.675u w=0.36u l=0.28u
X3242 a_27282_2686# a_27218_2496# a_27084_2182# VDD pfet_03v3 ad=56.7f pd=0.675u as=0.1278p ps=1.07u w=0.36u l=0.28u
X3243 a_36972_1398# a_n884_1398.t23 a_36784_1398# VDD pfet_03v3 ad=0.1278p pd=1.07u as=0.2097p ps=1.38u w=0.36u l=0.28u
X3244 VDD WE0CLK.t26 a_n884_10806.t1 VDD pfet_03v3 ad=0.5896p pd=3.56u as=0.3886p ps=1.92u w=1.34u l=0.28u
X3245 a_19928_n1738# a_19424_n1782# VSS.t2810 VSS nfet_03v3 ad=0.1584p pd=1.6u as=0.1584p ps=1.6u w=0.36u l=0.28u
X3246 VSS a_n884_n170.t24 a_12450_334# VSS nfet_03v3 ad=0.1584p pd=1.6u as=56.7f ps=0.675u w=0.36u l=0.28u
X3247 a_31063_n2146.t15 RB13.t29 a_30325_614# VSS nfet_03v3 ad=0.1584p pd=1.6u as=0.1152p ps=1u w=0.36u l=0.28u
X3248 VSS a_n884_5318.t21 a_17394_5318# VSS nfet_03v3 ad=0.1584p pd=1.6u as=56.7f ps=0.675u w=0.36u l=0.28u
X3249 a_n108_2182# a_n1204_2182.t22 a_n296_2182# VSS nfet_03v3 ad=0.1278p pd=1.07u as=0.1188p ps=1.02u w=0.36u l=0.28u
X3250 VDD RB1.t26 a_16226_10368# VDD pfet_03v3 ad=0.3168p pd=2.32u as=0.3708p ps=2.47u w=0.72u l=0.28u
X3251 VDD.t3076 a_9780_n170# a_9914_20# VDD.t2771 pfet_03v3 ad=0.1764p pd=1.26u as=0.1584p ps=1.6u w=0.36u l=0.28u
X3252 VSS a_12252_n170# a_12386_20# VSS nfet_03v3 ad=97.2f pd=0.9u as=0.1584p ps=1.6u w=0.36u l=0.28u
X3253 a_29368_10022# a_29304_n708.t17 VDD VDD pfet_03v3 ad=0.2097p pd=1.38u as=0.3168p ps=2.32u w=0.72u l=0.28u
X3254 a_9592_7670# a_9528_n708.t16 VDD VDD pfet_03v3 ad=0.2097p pd=1.38u as=0.3168p ps=2.32u w=0.72u l=0.28u
X3255 VSS RB8.t26 a_21170_4692# VSS nfet_03v3 ad=0.1584p pd=1.6u as=0.1854p ps=1.75u w=0.36u l=0.28u
X3256 a_10549_2182# a_9780_2182# VSS VSS nfet_03v3 ad=0.18p pd=1.72u as=97.2f ps=0.9u w=0.36u l=0.28u
X3257 VSS a_n884_2182.t22 a_22338_2182# VSS nfet_03v3 ad=0.1584p pd=1.6u as=56.7f ps=0.675u w=0.36u l=0.28u
X3258 a_30325_n170# a_29556_n170# VDD.t3332 VDD.t3159 pfet_03v3 ad=0.36p pd=2.44u as=0.1764p ps=1.26u w=0.72u l=0.28u
X3259 a_9592_4534# a_9528_n708.t17 VDD VDD pfet_03v3 ad=0.2097p pd=1.38u as=0.3168p ps=2.32u w=0.72u l=0.28u
X3260 VDD D1.t0 a_3229_n1738# VDD pfet_03v3 ad=0.3168p pd=2.32u as=0.2097p ps=1.38u w=0.72u l=0.28u
X3261 a_15797_1398# RA12.t27 VDD VDD pfet_03v3 ad=0.3888p pd=2.52u as=0.3312p ps=2.36u w=0.72u l=0.28u
X3262 VDD a_24612_6102# a_24746_6292# VDD pfet_03v3 ad=0.1764p pd=1.26u as=0.1584p ps=1.6u w=0.36u l=0.28u
X3263 a_20437_n954# a_19668_n954# VSS.t2182 VSS nfet_03v3 ad=0.18p pd=1.72u as=97.2f ps=0.9u w=0.36u l=0.28u
X3264 VSS a_n884_10022.t20 a_37170_10022# VSS nfet_03v3 ad=0.1584p pd=1.6u as=56.7f ps=0.675u w=0.36u l=0.28u
X3265 a_661_8454# RA3.t26 a_1129_n862.t22 VSS nfet_03v3 ad=0.1152p pd=1u as=0.1584p ps=1.6u w=0.36u l=0.28u
X3266 a_13021_8454# a_12252_8454# VDD VDD pfet_03v3 ad=0.36p pd=2.44u as=0.1764p ps=1.26u w=0.72u l=0.28u
X3267 VSS a_n884_1398.t24 a_9978_1902# VSS nfet_03v3 ad=0.1584p pd=1.6u as=56.7f ps=0.675u w=0.36u l=0.28u
X3268 a_12450_n170# a_12386_20# a_12252_n170# VDD.t2804 pfet_03v3 ad=56.7f pd=0.675u as=0.1278p ps=1.07u w=0.36u l=0.28u
X3269 a_37741_10022# RA1.t33 a_38209_n862.t0 VSS nfet_03v3 ad=0.1152p pd=1u as=0.1584p ps=1.6u w=0.36u l=0.28u
X3270 a_30629_2966# RA10.t26 VSS VSS nfet_03v3 ad=0.1944p pd=1.8u as=0.1656p ps=1.64u w=0.36u l=0.28u
X3271 a_11287_n2146.t21 a_11282_2528# a_10549_2182# VDD pfet_03v3 ad=0.1584p pd=1.6u as=0.1152p ps=1u w=0.36u l=0.28u
X3272 a_24810_1398# a_24746_1588# a_24612_1398# VDD pfet_03v3 ad=56.7f pd=0.675u as=0.1278p ps=1.07u w=0.36u l=0.28u
X3273 a_7308_5318# a_n884_5318.t22 a_7120_5318# VDD pfet_03v3 ad=0.1278p pd=1.07u as=0.2097p ps=1.38u w=0.36u l=0.28u
X3274 a_17008_5318# a_16944_n708.t23 VDD VDD pfet_03v3 ad=0.2097p pd=1.38u as=0.3168p ps=2.32u w=0.72u l=0.28u
X3275 VDD a_7308_6102# a_7442_6292# VDD pfet_03v3 ad=0.1764p pd=1.26u as=0.1584p ps=1.6u w=0.36u l=0.28u
X3276 VSS RB7.t28 a_18698_5664# VSS nfet_03v3 ad=0.1584p pd=1.6u as=0.1854p ps=1.75u w=0.36u l=0.28u
X3277 VSS RB5.t31 a_26114_7232# VSS nfet_03v3 ad=0.1584p pd=1.6u as=0.1854p ps=1.75u w=0.36u l=0.28u
X3278 VDD a_n108_2966# a_26_3156# VDD pfet_03v3 ad=0.1764p pd=1.26u as=0.1584p ps=1.6u w=0.36u l=0.28u
X3279 a_17008_2182# a_16944_n708.t24 VDD VDD pfet_03v3 ad=0.2097p pd=1.38u as=0.3168p ps=2.32u w=0.72u l=0.28u
X3280 VDD a_35737_n862.t33 QA14b.t0 VDD pfet_03v3 ad=0.2484p pd=1.41u as=0.4104p ps=2.58u w=0.72u l=0.28u
X3281 a_n1204_n954.t1 a_n1652_n522# VDD.t1368 VDD.t1367 pfet_03v3 ad=0.3302p pd=1.79u as=0.5588p ps=3.42u w=1.27u l=0.28u
X3282 VSS a_19668_n170# a_19802_20# VSS nfet_03v3 ad=97.2f pd=0.9u as=0.1584p ps=1.6u w=0.36u l=0.28u
X3283 a_8077_6886# a_7308_6886# VSS VSS nfet_03v3 ad=0.18p pd=1.72u as=97.2f ps=0.9u w=0.36u l=0.28u
X3284 VSS a_27084_3750# a_27218_4064# VSS nfet_03v3 ad=97.2f pd=0.9u as=0.1584p ps=1.6u w=0.36u l=0.28u
X3285 a_38045_8546# RA3.t27 VSS VSS nfet_03v3 ad=0.1944p pd=1.8u as=0.1656p ps=1.64u w=0.36u l=0.28u
X3286 VSS RB9.t27 a_33530_4096# VSS nfet_03v3 ad=0.1584p pd=1.6u as=0.1854p ps=1.75u w=0.36u l=0.28u
X3287 a_38045_n170# RA14.t26 VSS VSS nfet_03v3 ad=0.1944p pd=1.8u as=0.1656p ps=1.64u w=0.36u l=0.28u
X3288 a_5909_8546# RA3.t28 VSS VSS nfet_03v3 ad=0.1944p pd=1.8u as=0.1656p ps=1.64u w=0.36u l=0.28u
X3289 a_27853_6886# a_27084_6886# VDD VDD pfet_03v3 ad=0.36p pd=2.44u as=0.1764p ps=1.26u w=0.72u l=0.28u
X3290 a_24424_2966# a_24360_n708.t26 VDD VDD pfet_03v3 ad=0.2097p pd=1.38u as=0.3168p ps=2.32u w=0.72u l=0.28u
X3291 a_32797_n954# a_33101_n862# a_33265_n862.t5 VDD.t2042 pfet_03v3 ad=0.1152p pd=1u as=0.1584p ps=1.6u w=0.36u l=0.28u
X3292 a_17394_n450# a_17330_n640# a_17196_n954# VDD.t2056 pfet_03v3 ad=56.7f pd=0.675u as=0.1278p ps=1.07u w=0.36u l=0.28u
X3293 a_17196_10806# WE0CLK.t27 a_17008_10806# VSS nfet_03v3 ad=0.1278p pd=1.07u as=0.1188p ps=1.02u w=0.36u l=0.28u
X3294 a_4836_7670# a_n884_7670.t19 a_4648_7670# VDD pfet_03v3 ad=0.1278p pd=1.07u as=0.2097p ps=1.38u w=0.36u l=0.28u
X3295 VSS.t3153 D11.t1 a_27949_n1738# VSS nfet_03v3 ad=0.1584p pd=1.6u as=0.1188p ps=1.02u w=0.36u l=0.28u
X3296 a_22140_n170# a_n884_n170.t25 a_21952_n170# VDD.t1351 pfet_03v3 ad=0.1278p pd=1.07u as=0.2097p ps=1.38u w=0.36u l=0.28u
X3297 a_17394_10022# a_17330_10336# a_17196_10022# VSS nfet_03v3 ad=56.7f pd=0.675u as=0.1278p ps=1.07u w=0.36u l=0.28u
X3298 VDD a_n1652_4182# a_n1204_3750.t0 VDD pfet_03v3 ad=0.3386p pd=1.86u as=0.3302p ps=1.79u w=1.27u l=0.28u
X3299 a_29368_3750# a_29304_n708.t18 VDD VDD pfet_03v3 ad=0.2097p pd=1.38u as=0.3168p ps=2.32u w=0.72u l=0.28u
X3300 VSS.t750 RB15.t26 a_1394_n608# VSS nfet_03v3 ad=0.1584p pd=1.6u as=0.1854p ps=1.75u w=0.36u l=0.28u
X3301 a_4836_4534# a_n884_4534.t19 a_4648_4534# VDD pfet_03v3 ad=0.1278p pd=1.07u as=0.2097p ps=1.38u w=0.36u l=0.28u
X3302 a_34500_1398# a_n884_1398.t25 a_34312_1398# VDD pfet_03v3 ad=0.1278p pd=1.07u as=0.2097p ps=1.38u w=0.36u l=0.28u
X3303 VSS RB3.t25 a_8810_8800# VSS nfet_03v3 ad=0.1584p pd=1.6u as=0.1854p ps=1.75u w=0.36u l=0.28u
X3304 VDD a_22140_7670# a_22274_7860# VDD pfet_03v3 ad=0.1764p pd=1.26u as=0.1584p ps=1.6u w=0.36u l=0.28u
X3305 a_32797_3750# a_32028_3750# VDD VDD pfet_03v3 ad=0.36p pd=2.44u as=0.1764p ps=1.26u w=0.72u l=0.28u
X3306 VSS a_38209_n862.t32 QA15b.t1 VSS nfet_03v3 ad=0.1242p pd=1.05u as=0.2052p ps=1.86u w=0.36u l=0.28u
X3307 a_29368_614# a_29304_n708.t19 VDD VDD pfet_03v3 ad=0.2097p pd=1.38u as=0.3168p ps=2.32u w=0.72u l=0.28u
X3308 a_20437_6886# a_20741_6978# a_20905_n862.t26 VDD pfet_03v3 ad=0.1152p pd=1u as=0.1584p ps=1.6u w=0.36u l=0.28u
X3309 VDD a_22140_4534# a_22274_4724# VDD pfet_03v3 ad=0.1764p pd=1.26u as=0.1584p ps=1.6u w=0.36u l=0.28u
X3310 a_32797_614# a_32028_614# VDD VDD pfet_03v3 ad=0.36p pd=2.44u as=0.1764p ps=1.26u w=0.72u l=0.28u
X3311 a_13759_n2146.t27 a_13754_5664# a_13021_5318# VDD pfet_03v3 ad=0.1584p pd=1.6u as=0.1152p ps=1u w=0.36u l=0.28u
X3312 a_27853_5318# a_28157_5410# a_28321_n862.t31 VDD pfet_03v3 ad=0.1152p pd=1u as=0.1584p ps=1.6u w=0.36u l=0.28u
X3313 VDD a_n1204_9238.t28 a_12450_9238# VDD pfet_03v3 ad=0.1584p pd=1.6u as=56.7f ps=0.675u w=0.36u l=0.28u
X3314 a_7120_7670# a_7056_n708.t15 VDD VDD pfet_03v3 ad=0.2097p pd=1.38u as=0.3168p ps=2.32u w=0.72u l=0.28u
X3315 a_20437_3750# a_20741_3842# a_20905_n862.t22 VDD pfet_03v3 ad=0.1152p pd=1u as=0.1584p ps=1.6u w=0.36u l=0.28u
X3316 VDD a_19668_1398# a_19802_1588# VDD pfet_03v3 ad=0.1764p pd=1.26u as=0.1584p ps=1.6u w=0.36u l=0.28u
X3317 a_13021_1398# a_12252_1398# VSS VSS nfet_03v3 ad=0.18p pd=1.72u as=97.2f ps=0.9u w=0.36u l=0.28u
X3318 a_34500_10806# WE0CLK.t28 a_34312_10806# VSS nfet_03v3 ad=0.1278p pd=1.07u as=0.1188p ps=1.02u w=0.36u l=0.28u
X3319 VDD a_n1652_10454# a_n1204_10022.t0 VDD pfet_03v3 ad=0.3386p pd=1.86u as=0.3302p ps=1.79u w=1.27u l=0.28u
X3320 a_7120_4534# a_7056_n708.t16 VDD VDD pfet_03v3 ad=0.2097p pd=1.38u as=0.3168p ps=2.32u w=0.72u l=0.28u
X3321 a_19668_2966# a_n1204_2966.t24 a_19480_2966# VSS nfet_03v3 ad=0.1278p pd=1.07u as=0.1188p ps=1.02u w=0.36u l=0.28u
X3322 a_20437_614# a_20741_706# a_20905_n862.t20 VDD pfet_03v3 ad=0.1152p pd=1u as=0.1584p ps=1.6u w=0.36u l=0.28u
X3323 a_25477_n1738# a_n884_n1738.t21 a_24368_n1782# VDD pfet_03v3 ad=0.2097p pd=1.38u as=0.1278p ps=1.07u w=0.36u l=0.28u
X3324 a_13325_5410# RA7.t27 VSS VSS nfet_03v3 ad=0.1944p pd=1.8u as=0.1656p ps=1.64u w=0.36u l=0.28u
X3325 a_27084_n954# a_n884_n954.t25 a_26896_n954# VDD.t1356 pfet_03v3 ad=0.1278p pd=1.07u as=0.2097p ps=1.38u w=0.36u l=0.28u
X3326 a_10549_8454# a_9780_8454# VDD VDD pfet_03v3 ad=0.36p pd=2.44u as=0.1764p ps=1.26u w=0.72u l=0.28u
X3327 VSS a_n884_7670.t20 a_24810_8174# VSS nfet_03v3 ad=0.1584p pd=1.6u as=56.7f ps=0.675u w=0.36u l=0.28u
X3328 a_20741_6978# RA5.t26 VSS VSS nfet_03v3 ad=0.1944p pd=1.8u as=0.1656p ps=1.64u w=0.36u l=0.28u
X3329 a_22338_1398# a_22274_1588# a_22140_1398# VDD pfet_03v3 ad=56.7f pd=0.675u as=0.1278p ps=1.07u w=0.36u l=0.28u
X3330 a_26119_n2146.t27 a_26114_7232# a_25381_6886# VDD pfet_03v3 ad=0.1584p pd=1.6u as=0.1152p ps=1u w=0.36u l=0.28u
X3331 VSS a_n884_4534.t20 a_24810_5038# VSS nfet_03v3 ad=0.1584p pd=1.6u as=56.7f ps=0.675u w=0.36u l=0.28u
X3332 VSS a_n884_2182.t23 a_2562_2182# VSS nfet_03v3 ad=0.1584p pd=1.6u as=56.7f ps=0.675u w=0.36u l=0.28u
X3333 a_5096_n1738# a_4592_n1782# VDD VDD pfet_03v3 ad=0.1584p pd=1.6u as=0.1584p ps=1.6u w=0.36u l=0.28u
X3334 VSS a_n884_10806.t26 a_24810_11310# VSS nfet_03v3 ad=0.1584p pd=1.6u as=56.7f ps=0.675u w=0.36u l=0.28u
X3335 a_32797_10022# a_32028_10022# VSS VSS nfet_03v3 ad=0.18p pd=1.72u as=97.2f ps=0.9u w=0.36u l=0.28u
X3336 a_25685_6978# RA5.t27 VDD VDD pfet_03v3 ad=0.3888p pd=2.52u as=0.3312p ps=2.36u w=0.72u l=0.28u
X3337 a_14536_5318# a_14472_n708.t24 VDD VDD pfet_03v3 ad=0.2097p pd=1.38u as=0.3168p ps=2.32u w=0.72u l=0.28u
X3338 a_9978_10806# a_9914_10996# a_9780_10806# VDD pfet_03v3 ad=56.7f pd=0.675u as=0.1278p ps=1.07u w=0.36u l=0.28u
X3339 VDD WE0CLK.t29 a_34698_10806# VDD pfet_03v3 ad=0.1584p pd=1.6u as=56.7f ps=0.675u w=0.36u l=0.28u
X3340 a_25381_7670# a_25685_7670# a_25849_n862.t24 VDD pfet_03v3 ad=0.1152p pd=1u as=0.1584p ps=1.6u w=0.36u l=0.28u
X3341 VDD a_4836_6102# a_4970_6292# VDD pfet_03v3 ad=0.1764p pd=1.26u as=0.1584p ps=1.6u w=0.36u l=0.28u
X3342 a_26119_n2146.t22 a_26114_4096# a_25381_3750# VDD pfet_03v3 ad=0.1584p pd=1.6u as=0.1152p ps=1u w=0.36u l=0.28u
X3343 a_14536_2182# a_14472_n708.t25 VDD VDD pfet_03v3 ad=0.2097p pd=1.38u as=0.3168p ps=2.32u w=0.72u l=0.28u
X3344 VDD.t737 RB15.t27 a_38474_n608# VDD.t736 pfet_03v3 ad=0.3168p pd=2.32u as=0.3708p ps=2.47u w=0.72u l=0.28u
X3345 a_14724_6886# a_n884_6886.t19 a_14536_6886# VDD pfet_03v3 ad=0.1278p pd=1.07u as=0.2097p ps=1.38u w=0.36u l=0.28u
X3346 a_25381_4534# a_25685_4534# a_25849_n862.t13 VDD pfet_03v3 ad=0.1152p pd=1u as=0.1584p ps=1.6u w=0.36u l=0.28u
X3347 a_25381_2966# a_24612_2966# VSS VSS nfet_03v3 ad=0.18p pd=1.72u as=97.2f ps=0.9u w=0.36u l=0.28u
X3348 a_37741_10806# RA0.t33 a_38209_n862.t14 VSS nfet_03v3 ad=0.1152p pd=1u as=0.1584p ps=1.6u w=0.36u l=0.28u
X3349 VSS a_n884_10022.t21 a_2562_10022# VSS nfet_03v3 ad=0.1584p pd=1.6u as=56.7f ps=0.675u w=0.36u l=0.28u
X3350 VDD RB2.t28 a_33530_9396# VDD pfet_03v3 ad=0.3168p pd=2.32u as=0.3708p ps=2.47u w=0.72u l=0.28u
X3351 VSS a_24612_3750# a_24746_4064# VSS nfet_03v3 ad=97.2f pd=0.9u as=0.1584p ps=1.6u w=0.36u l=0.28u
X3352 a_5034_1398# a_4970_1588# a_4836_1398# VDD pfet_03v3 ad=56.7f pd=0.675u as=0.1278p ps=1.07u w=0.36u l=0.28u
X3353 a_25685_n170# RA14.t27 VSS VSS nfet_03v3 ad=0.1944p pd=1.8u as=0.1656p ps=1.64u w=0.36u l=0.28u
X3354 a_10549_n170# a_10853_n170# a_11017_n862.t21 VDD.t2560 pfet_03v3 ad=0.1152p pd=1u as=0.1584p ps=1.6u w=0.36u l=0.28u
X3355 a_26119_n2146.t17 a_26114_960# a_25381_614# VDD pfet_03v3 ad=0.1584p pd=1.6u as=0.1152p ps=1u w=0.36u l=0.28u
X3356 a_3133_10022# RA1.t34 a_3601_n862.t7 VSS nfet_03v3 ad=0.1152p pd=1u as=0.1584p ps=1.6u w=0.36u l=0.28u
X3357 a_8815_n2146.t22 a_8810_7232# a_8077_6886# VDD pfet_03v3 ad=0.1584p pd=1.6u as=0.1152p ps=1u w=0.36u l=0.28u
X3358 a_14724_3750# a_n884_3750.t22 a_14536_3750# VDD pfet_03v3 ad=0.1278p pd=1.07u as=0.2097p ps=1.38u w=0.36u l=0.28u
X3359 a_23647_n2146.t23 a_23642_10964# a_22909_10806# VDD pfet_03v3 ad=0.1584p pd=1.6u as=0.1152p ps=1u w=0.36u l=0.28u
X3360 VSS RB2.t29 a_18698_9396# VSS nfet_03v3 ad=0.1584p pd=1.6u as=0.1854p ps=1.75u w=0.36u l=0.28u
X3361 a_18703_n2146.t3 RB15.t28 a_17965_n954# VSS nfet_03v3 ad=0.1584p pd=1.6u as=0.1152p ps=1u w=0.36u l=0.28u
X3362 a_36972_n170# a_n884_n170.t26 a_36784_n170# VDD.t1352 pfet_03v3 ad=0.1278p pd=1.07u as=0.2097p ps=1.38u w=0.36u l=0.28u
X3363 VSS RB4.t24 a_11282_7828# VSS nfet_03v3 ad=0.1584p pd=1.6u as=0.1854p ps=1.75u w=0.36u l=0.28u
X3364 VSS RB5.t32 a_6338_7232# VSS nfet_03v3 ad=0.1584p pd=1.6u as=0.1854p ps=1.75u w=0.36u l=0.28u
X3365 VSS RB6.t28 a_18698_6260# VSS nfet_03v3 ad=0.1584p pd=1.6u as=0.1854p ps=1.75u w=0.36u l=0.28u
X3366 a_8815_n2146.t25 a_8810_4096# a_8077_3750# VDD pfet_03v3 ad=0.1584p pd=1.6u as=0.1152p ps=1u w=0.36u l=0.28u
X3367 a_14724_614# a_n884_614.t27 a_14536_614# VDD pfet_03v3 ad=0.1278p pd=1.07u as=0.2097p ps=1.38u w=0.36u l=0.28u
X3368 a_3437_8546# RA3.t29 VSS VSS nfet_03v3 ad=0.1944p pd=1.8u as=0.1656p ps=1.64u w=0.36u l=0.28u
X3369 VSS a_n884_8454.t22 a_29754_8454# VSS nfet_03v3 ad=0.1584p pd=1.6u as=56.7f ps=0.675u w=0.36u l=0.28u
X3370 a_9978_5822# a_9914_5632# a_9780_5318# VDD pfet_03v3 ad=56.7f pd=0.675u as=0.1278p ps=1.07u w=0.36u l=0.28u
X3371 a_8815_n2146.t8 a_8810_960# a_8077_614# VDD pfet_03v3 ad=0.1584p pd=1.6u as=0.1152p ps=1u w=0.36u l=0.28u
X3372 VSS a_7308_3750# a_7442_4064# VSS nfet_03v3 ad=97.2f pd=0.9u as=0.1584p ps=1.6u w=0.36u l=0.28u
X3373 VSS.t751 RB15.t29 a_31058_n608# VSS nfet_03v3 ad=0.1584p pd=1.6u as=0.1854p ps=1.75u w=0.36u l=0.28u
X3374 VSS a_n884_5318.t23 a_29754_5318# VSS nfet_03v3 ad=0.1584p pd=1.6u as=56.7f ps=0.675u w=0.36u l=0.28u
X3375 a_8381_n170# RA14.t28 VSS VSS nfet_03v3 ad=0.1944p pd=1.8u as=0.1656p ps=1.64u w=0.36u l=0.28u
X3376 VDD a_12252_10806# a_12386_10996# VDD pfet_03v3 ad=0.1764p pd=1.26u as=0.1584p ps=1.6u w=0.36u l=0.28u
X3377 VSS RB8.t27 a_33530_4692# VSS nfet_03v3 ad=0.1584p pd=1.6u as=0.1854p ps=1.75u w=0.36u l=0.28u
X3378 a_19480_2182# a_19416_n708.t21 VSS VSS nfet_03v3 ad=0.1188p pd=1.02u as=0.1584p ps=1.6u w=0.36u l=0.28u
X3379 a_n108_1398# a_n1204_1398.t25 a_n296_1398# VSS nfet_03v3 ad=0.1278p pd=1.07u as=0.1188p ps=1.02u w=0.36u l=0.28u
X3380 VSS.t3154 a_12252_n954# a_12386_n640# VSS nfet_03v3 ad=97.2f pd=0.9u as=0.1584p ps=1.6u w=0.36u l=0.28u
X3381 a_15797_n170# RA14.t29 VDD.t1085 VDD.t457 pfet_03v3 ad=0.3888p pd=2.52u as=0.3312p ps=2.36u w=0.72u l=0.28u
X3382 a_14922_10806# a_14858_10996# a_14724_10806# VDD pfet_03v3 ad=56.7f pd=0.675u as=0.1278p ps=1.07u w=0.36u l=0.28u
X3383 a_8077_6102# a_8381_6102# a_8545_n862.t22 VDD pfet_03v3 ad=0.1152p pd=1u as=0.1584p ps=1.6u w=0.36u l=0.28u
X3384 a_22909_2182# a_22140_2182# VSS VSS nfet_03v3 ad=0.18p pd=1.72u as=97.2f ps=0.9u w=0.36u l=0.28u
X3385 VDD a_n1204_9238.t29 a_9978_9238# VDD pfet_03v3 ad=0.1584p pd=1.6u as=56.7f ps=0.675u w=0.36u l=0.28u
X3386 a_29368_n954# a_29304_n708.t20 VSS.t724 VSS nfet_03v3 ad=0.1188p pd=1.02u as=0.1584p ps=1.6u w=0.36u l=0.28u
X3387 a_8815_n2146.t1 RB1.t27 a_8077_10022# VSS nfet_03v3 ad=0.1584p pd=1.6u as=0.1152p ps=1u w=0.36u l=0.28u
X3388 VDD a_36972_6102# a_37106_6292# VDD pfet_03v3 ad=0.1764p pd=1.26u as=0.1584p ps=1.6u w=0.36u l=0.28u
X3389 a_9592_3750# a_9528_n708.t18 VDD VDD pfet_03v3 ad=0.2097p pd=1.38u as=0.3168p ps=2.32u w=0.72u l=0.28u
X3390 a_32797_n954# a_32028_n954# VSS.t2532 VSS nfet_03v3 ad=0.18p pd=1.72u as=97.2f ps=0.9u w=0.36u l=0.28u
X3391 VSS a_n884_n170.t27 a_29754_334# VSS nfet_03v3 ad=0.1584p pd=1.6u as=56.7f ps=0.675u w=0.36u l=0.28u
X3392 a_10549_1398# a_9780_1398# VSS VSS nfet_03v3 ad=0.18p pd=1.72u as=97.2f ps=0.9u w=0.36u l=0.28u
X3393 a_24810_n170# a_24746_20# a_24612_n170# VDD.t2595 pfet_03v3 ad=56.7f pd=0.675u as=0.1278p ps=1.07u w=0.36u l=0.28u
X3394 a_9592_614# a_9528_n708.t19 VDD VDD pfet_03v3 ad=0.2097p pd=1.38u as=0.3168p ps=2.32u w=0.72u l=0.28u
X3395 VSS a_n884_1398.t26 a_22338_1902# VSS nfet_03v3 ad=0.1584p pd=1.6u as=56.7f ps=0.675u w=0.36u l=0.28u
X3396 a_17196_2966# a_n1204_2966.t25 a_17008_2966# VSS nfet_03v3 ad=0.1278p pd=1.07u as=0.1188p ps=1.02u w=0.36u l=0.28u
X3397 a_5605_10806# a_4836_10806# VSS VSS nfet_03v3 ad=0.18p pd=1.72u as=97.2f ps=0.9u w=0.36u l=0.28u
X3398 a_23647_n2146.t24 a_23642_2528# a_22909_2182# VDD pfet_03v3 ad=0.1584p pd=1.6u as=0.1152p ps=1u w=0.36u l=0.28u
X3399 VSS a_3601_n862.t32 QA1b.t1 VSS nfet_03v3 ad=0.1242p pd=1.05u as=0.2052p ps=1.86u w=0.36u l=0.28u
X3400 a_33101_706# RA13.t24 VSS VSS nfet_03v3 ad=0.1944p pd=1.8u as=0.1656p ps=1.64u w=0.36u l=0.28u
X3401 VSS a_n884_2182.t24 a_32226_2182# VSS nfet_03v3 ad=0.1584p pd=1.6u as=56.7f ps=0.675u w=0.36u l=0.28u
X3402 a_36728_n1782# a_37232_n1738# a_37520_n1738# VDD pfet_03v3 ad=0.1278p pd=1.07u as=56.7f ps=0.675u w=0.36u l=0.28u
X3403 a_38479_n2146.t18 a_38474_10368# a_37741_10022# VDD pfet_03v3 ad=0.1584p pd=1.6u as=0.1152p ps=1u w=0.36u l=0.28u
X3404 a_20741_706# RA13.t25 VSS VSS nfet_03v3 ad=0.1944p pd=1.8u as=0.1656p ps=1.64u w=0.36u l=0.28u
X3405 VSS a_n884_6886.t20 a_12450_6886# VSS nfet_03v3 ad=0.1584p pd=1.6u as=56.7f ps=0.675u w=0.36u l=0.28u
X3406 a_23213_6978# RA5.t28 VDD VDD pfet_03v3 ad=0.3888p pd=2.52u as=0.3312p ps=2.36u w=0.72u l=0.28u
X3407 a_8077_1398# RA12.t28 a_8545_n862.t2 VSS nfet_03v3 ad=0.1152p pd=1u as=0.1584p ps=1.6u w=0.36u l=0.28u
X3408 a_13325_9238# RA2.t25 VSS VSS nfet_03v3 ad=0.1944p pd=1.8u as=0.1656p ps=1.64u w=0.36u l=0.28u
X3409 a_22909_7670# a_23213_7670# a_23377_n862.t31 VDD pfet_03v3 ad=0.1152p pd=1u as=0.1584p ps=1.6u w=0.36u l=0.28u
X3410 a_13325_6102# RA6.t27 VSS VSS nfet_03v3 ad=0.1944p pd=1.8u as=0.1656p ps=1.64u w=0.36u l=0.28u
X3411 a_12252_6886# a_n884_6886.t21 a_12064_6886# VDD pfet_03v3 ad=0.1278p pd=1.07u as=0.2097p ps=1.38u w=0.36u l=0.28u
X3412 a_22909_4534# a_23213_4534# a_23377_n862.t30 VDD pfet_03v3 ad=0.1152p pd=1u as=0.1584p ps=1.6u w=0.36u l=0.28u
X3413 a_6343_n2146.t4 a_6338_7232# a_5605_6886# VDD pfet_03v3 ad=0.1584p pd=1.6u as=0.1152p ps=1u w=0.36u l=0.28u
X3414 VDD RB7.t29 a_1394_5664# VDD pfet_03v3 ad=0.3168p pd=2.32u as=0.3708p ps=2.47u w=0.72u l=0.28u
X3415 a_36784_2966# a_36720_n708.t30 VDD VDD pfet_03v3 ad=0.2097p pd=1.38u as=0.3168p ps=2.32u w=0.72u l=0.28u
X3416 VSS a_n884_10806.t27 a_19866_11310# VSS nfet_03v3 ad=0.1584p pd=1.6u as=56.7f ps=0.675u w=0.36u l=0.28u
X3417 a_12252_3750# a_n884_3750.t23 a_12064_3750# VDD pfet_03v3 ad=0.1278p pd=1.07u as=0.2097p ps=1.38u w=0.36u l=0.28u
X3418 VDD WE0CLK.t30 a_29754_10806# VDD pfet_03v3 ad=0.1584p pd=1.6u as=56.7f ps=0.675u w=0.36u l=0.28u
X3419 a_18703_n2146.t25 a_18698_8800# a_17965_8454# VDD pfet_03v3 ad=0.1584p pd=1.6u as=0.1152p ps=1u w=0.36u l=0.28u
X3420 VSS RB5.t33 a_3866_7232# VSS nfet_03v3 ad=0.1584p pd=1.6u as=0.1854p ps=1.75u w=0.36u l=0.28u
X3421 a_6343_n2146.t7 a_6338_4096# a_5605_3750# VDD pfet_03v3 ad=0.1584p pd=1.6u as=0.1152p ps=1u w=0.36u l=0.28u
X3422 VDD RB11.t31 a_1394_2528# VDD pfet_03v3 ad=0.3168p pd=2.32u as=0.3708p ps=2.47u w=0.72u l=0.28u
X3423 a_16231_n2146.t3 RB15.t30 a_15493_n954# VSS nfet_03v3 ad=0.1584p pd=1.6u as=0.1152p ps=1u w=0.36u l=0.28u
X3424 a_34500_n170# a_n884_n170.t28 a_34312_n170# VDD.t1353 pfet_03v3 ad=0.1278p pd=1.07u as=0.2097p ps=1.38u w=0.36u l=0.28u
X3425 a_12252_614# a_n884_614.t28 a_12064_614# VDD pfet_03v3 ad=0.1278p pd=1.07u as=0.2097p ps=1.38u w=0.36u l=0.28u
X3426 a_3437_706# RA13.t26 VSS VSS nfet_03v3 ad=0.1944p pd=1.8u as=0.1656p ps=1.64u w=0.36u l=0.28u
X3427 a_7506_5822# a_7442_5632# a_7308_5318# VDD pfet_03v3 ad=56.7f pd=0.675u as=0.1278p ps=1.07u w=0.36u l=0.28u
X3428 a_5605_2966# a_4836_2966# VSS VSS nfet_03v3 ad=0.18p pd=1.72u as=97.2f ps=0.9u w=0.36u l=0.28u
X3429 a_37170_2686# a_37106_2496# a_36972_2182# VDD pfet_03v3 ad=56.7f pd=0.675u as=0.1278p ps=1.07u w=0.36u l=0.28u
X3430 a_5605_n170# a_4836_n170# VSS VSS nfet_03v3 ad=0.18p pd=1.72u as=97.2f ps=0.9u w=0.36u l=0.28u
X3431 VSS a_n884_8454.t23 a_27282_8454# VSS nfet_03v3 ad=0.1584p pd=1.6u as=56.7f ps=0.675u w=0.36u l=0.28u
X3432 VSS a_4836_3750# a_4970_4064# VSS nfet_03v3 ad=97.2f pd=0.9u as=0.1584p ps=1.6u w=0.36u l=0.28u
X3433 a_6343_n2146.t24 a_6338_960# a_5605_614# VDD pfet_03v3 ad=0.1584p pd=1.6u as=0.1152p ps=1u w=0.36u l=0.28u
X3434 VSS a_n108_10022# a_26_10336# VSS nfet_03v3 ad=97.2f pd=0.9u as=0.1584p ps=1.6u w=0.36u l=0.28u
X3435 VSS a_n884_5318.t24 a_27282_5318# VSS nfet_03v3 ad=0.1584p pd=1.6u as=56.7f ps=0.675u w=0.36u l=0.28u
X3436 a_17744_n1738# WEM.t19 VDD VDD pfet_03v3 ad=56.7f pd=0.675u as=0.1584p ps=1.6u w=0.36u l=0.28u
X3437 a_3133_10806# RA0.t34 a_3601_n862.t1 VSS nfet_03v3 ad=0.1152p pd=1u as=0.1584p ps=1.6u w=0.36u l=0.28u
X3438 VDD a_2364_7670# a_2498_7860# VDD pfet_03v3 ad=0.1764p pd=1.26u as=0.1584p ps=1.6u w=0.36u l=0.28u
X3439 a_37741_6102# a_38045_6102# a_38209_n862.t1 VDD pfet_03v3 ad=0.1152p pd=1u as=0.1584p ps=1.6u w=0.36u l=0.28u
X3440 a_25160_n1234# a_n884_n1738.t22 VSS.t14 VSS nfet_03v3 ad=56.7f pd=0.675u as=0.1584p ps=1.6u w=0.36u l=0.28u
X3441 VDD.t2802 a_19668_n170# a_19802_20# VDD.t2368 pfet_03v3 ad=0.1764p pd=1.26u as=0.1584p ps=1.6u w=0.36u l=0.28u
X3442 a_13021_9238# a_12252_9238# VDD VDD pfet_03v3 ad=0.36p pd=2.44u as=0.1764p ps=1.26u w=0.72u l=0.28u
X3443 VSS a_n884_n170.t29 a_7506_334# VSS nfet_03v3 ad=0.1584p pd=1.6u as=56.7f ps=0.675u w=0.36u l=0.28u
X3444 a_21952_10022# a_21888_n708.t20 VSS VSS nfet_03v3 ad=0.1188p pd=1.02u as=0.1584p ps=1.6u w=0.36u l=0.28u
X3445 a_5605_6102# a_5909_6102# a_6073_n862.t4 VDD pfet_03v3 ad=0.1152p pd=1u as=0.1584p ps=1.6u w=0.36u l=0.28u
X3446 VDD a_2364_4534# a_2498_4724# VDD pfet_03v3 ad=0.1764p pd=1.26u as=0.1584p ps=1.6u w=0.36u l=0.28u
X3447 a_36007_n2146.t27 RB13.t30 a_35269_614# VSS nfet_03v3 ad=0.1584p pd=1.6u as=0.1152p ps=1u w=0.36u l=0.28u
X3448 a_20437_2182# a_19668_2182# VSS VSS nfet_03v3 ad=0.18p pd=1.72u as=97.2f ps=0.9u w=0.36u l=0.28u
X3449 a_38045_10114# RA1.t35 VSS VSS nfet_03v3 ad=0.1944p pd=1.8u as=0.1656p ps=1.64u w=0.36u l=0.28u
X3450 a_19480_8454# a_19416_n708.t22 VDD VDD pfet_03v3 ad=0.2097p pd=1.38u as=0.3168p ps=2.32u w=0.72u l=0.28u
X3451 a_17008_6102# a_16944_n708.t25 VDD VDD pfet_03v3 ad=0.2097p pd=1.38u as=0.3168p ps=2.32u w=0.72u l=0.28u
X3452 a_7120_3750# a_7056_n708.t17 VDD VDD pfet_03v3 ad=0.2097p pd=1.38u as=0.3168p ps=2.32u w=0.72u l=0.28u
X3453 VSS a_7308_n170# a_7442_20# VSS nfet_03v3 ad=97.2f pd=0.9u as=0.1584p ps=1.6u w=0.36u l=0.28u
X3454 a_25685_5410# RA7.t28 VSS VSS nfet_03v3 ad=0.1944p pd=1.8u as=0.1656p ps=1.64u w=0.36u l=0.28u
X3455 a_15589_n1738# WEM.t20 a_14480_n1782# VSS nfet_03v3 ad=0.1188p pd=1.02u as=0.1278p ps=1.07u w=0.36u l=0.28u
X3456 a_22338_n170# a_22274_20# a_22140_n170# VDD.t2598 pfet_03v3 ad=56.7f pd=0.675u as=0.1278p ps=1.07u w=0.36u l=0.28u
X3457 a_23647_n2146.t30 RB13.t31 a_22909_614# VSS nfet_03v3 ad=0.1584p pd=1.6u as=0.1152p ps=1u w=0.36u l=0.28u
X3458 VDD a_34500_10022# a_34634_10336# VDD pfet_03v3 ad=0.1764p pd=1.26u as=0.1584p ps=1.6u w=0.36u l=0.28u
X3459 a_22909_8454# a_22140_8454# VDD VDD pfet_03v3 ad=0.36p pd=2.44u as=0.1764p ps=1.26u w=0.72u l=0.28u
X3460 a_7120_614# a_7056_n708.t18 VDD VDD pfet_03v3 ad=0.2097p pd=1.38u as=0.3168p ps=2.32u w=0.72u l=0.28u
X3461 a_2364_8454# a_n1204_8454.t27 a_2176_8454# VSS nfet_03v3 ad=0.1278p pd=1.07u as=0.1188p ps=1.02u w=0.36u l=0.28u
X3462 a_21175_n2146.t23 a_21170_2528# a_20437_2182# VDD pfet_03v3 ad=0.1584p pd=1.6u as=0.1152p ps=1u w=0.36u l=0.28u
X3463 a_34698_1398# a_34634_1588# a_34500_1398# VDD pfet_03v3 ad=56.7f pd=0.675u as=0.1278p ps=1.07u w=0.36u l=0.28u
X3464 a_9592_n954# a_9528_n708.t20 VSS.t201 VSS nfet_03v3 ad=0.1188p pd=1.02u as=0.1584p ps=1.6u w=0.36u l=0.28u
X3465 a_2364_5318# a_n1204_5318.t25 a_2176_5318# VSS nfet_03v3 ad=0.1278p pd=1.07u as=0.1188p ps=1.02u w=0.36u l=0.28u
X3466 a_26896_5318# a_26832_n708.t25 VDD VDD pfet_03v3 ad=0.2097p pd=1.38u as=0.3168p ps=2.32u w=0.72u l=0.28u
X3467 a_32028_2966# a_n884_2966.t20 a_31840_2966# VDD pfet_03v3 ad=0.1278p pd=1.07u as=0.2097p ps=1.38u w=0.36u l=0.28u
X3468 a_37741_1398# RA12.t29 a_38209_n862.t3 VSS nfet_03v3 ad=0.1152p pd=1u as=0.1584p ps=1.6u w=0.36u l=0.28u
X3469 a_8815_n2146.t21 RB0.t28 a_8077_10806# VSS nfet_03v3 ad=0.1584p pd=1.6u as=0.1152p ps=1u w=0.36u l=0.28u
X3470 VSS RB5.t34 a_36002_7232# VSS nfet_03v3 ad=0.1584p pd=1.6u as=0.1854p ps=1.75u w=0.36u l=0.28u
X3471 a_26896_2182# a_26832_n708.t26 VDD VDD pfet_03v3 ad=0.2097p pd=1.38u as=0.3168p ps=2.32u w=0.72u l=0.28u
X3472 VSS a_n884_1398.t27 a_2562_1902# VSS nfet_03v3 ad=0.1584p pd=1.6u as=56.7f ps=0.675u w=0.36u l=0.28u
X3473 a_5034_n170# a_4970_20# a_4836_n170# VDD.t2526 pfet_03v3 ad=56.7f pd=0.675u as=0.1278p ps=1.07u w=0.36u l=0.28u
X3474 VSS a_n884_6886.t22 a_9978_6886# VSS nfet_03v3 ad=0.1584p pd=1.6u as=56.7f ps=0.675u w=0.36u l=0.28u
X3475 VDD a_34500_5318# a_34634_5632# VDD pfet_03v3 ad=0.1764p pd=1.26u as=0.1584p ps=1.6u w=0.36u l=0.28u
X3476 a_5605_1398# RA12.t30 a_6073_n862.t5 VSS nfet_03v3 ad=0.1152p pd=1u as=0.1584p ps=1.6u w=0.36u l=0.28u
X3477 a_6343_n2146.t1 RB13.t32 a_5605_614# VSS nfet_03v3 ad=0.1584p pd=1.6u as=0.1152p ps=1u w=0.36u l=0.28u
X3478 VSS a_36972_3750# a_37106_4064# VSS nfet_03v3 ad=97.2f pd=0.9u as=0.1584p ps=1.6u w=0.36u l=0.28u
X3479 VDD RB7.t30 a_31058_5664# VDD pfet_03v3 ad=0.3168p pd=2.32u as=0.3708p ps=2.47u w=0.72u l=0.28u
X3480 a_19866_3470# a_19802_3156# a_19668_2966# VSS nfet_03v3 ad=56.7f pd=0.675u as=0.1278p ps=1.07u w=0.36u l=0.28u
X3481 VSS RB4.t25 a_23642_7828# VSS nfet_03v3 ad=0.1584p pd=1.6u as=0.1854p ps=1.75u w=0.36u l=0.28u
X3482 a_37741_6886# a_36972_6886# VDD VDD pfet_03v3 ad=0.36p pd=2.44u as=0.1764p ps=1.26u w=0.72u l=0.28u
X3483 a_34312_2966# a_34248_n708.t28 VDD VDD pfet_03v3 ad=0.2097p pd=1.38u as=0.3168p ps=2.32u w=0.72u l=0.28u
X3484 VDD RB11.t32 a_31058_2528# VDD pfet_03v3 ad=0.3168p pd=2.32u as=0.3708p ps=2.47u w=0.72u l=0.28u
X3485 a_2120_n1782# a_2624_n1738# a_2912_n1738# VDD pfet_03v3 ad=0.1278p pd=1.07u as=56.7f ps=0.675u w=0.36u l=0.28u
X3486 a_32893_n1738# WEM.t21 a_31784_n1782# VSS nfet_03v3 ad=0.1188p pd=1.02u as=0.1278p ps=1.07u w=0.36u l=0.28u
X3487 a_3871_n2146.t3 a_3866_10368# a_3133_10022# VDD pfet_03v3 ad=0.1584p pd=1.6u as=0.1152p ps=1u w=0.36u l=0.28u
X3488 VDD a_n1204_10022.t24 a_5034_10526# VDD pfet_03v3 ad=0.1584p pd=1.6u as=56.7f ps=0.675u w=0.36u l=0.28u
X3489 a_27282_n450# a_27218_n640# a_27084_n954# VDD.t2466 pfet_03v3 ad=56.7f pd=0.675u as=0.1278p ps=1.07u w=0.36u l=0.28u
X3490 a_3133_7670# a_3437_7670# a_3601_n862.t22 VDD pfet_03v3 ad=0.1152p pd=1u as=0.1584p ps=1.6u w=0.36u l=0.28u
X3491 a_16231_n2146.t22 a_16226_8800# a_15493_8454# VDD pfet_03v3 ad=0.1584p pd=1.6u as=0.1152p ps=1u w=0.36u l=0.28u
X3492 a_28591_n2146.t15 RB9.t28 a_27853_3750# VSS nfet_03v3 ad=0.1584p pd=1.6u as=0.1152p ps=1u w=0.36u l=0.28u
X3493 a_3133_2966# a_2364_2966# VSS VSS nfet_03v3 ad=0.18p pd=1.72u as=97.2f ps=0.9u w=0.36u l=0.28u
X3494 a_2176_2966# a_2112_n708.t32 VDD VDD pfet_03v3 ad=0.2097p pd=1.38u as=0.3168p ps=2.32u w=0.72u l=0.28u
X3495 a_n108_9238# a_n884_9238.t22 a_n296_9238# VDD pfet_03v3 ad=0.1278p pd=1.07u as=0.2097p ps=1.38u w=0.36u l=0.28u
X3496 a_3133_4534# a_3437_4534# a_3601_n862.t16 VDD pfet_03v3 ad=0.1152p pd=1u as=0.1584p ps=1.6u w=0.36u l=0.28u
X3497 a_34500_n170# a_n1204_n170.t28 a_34312_n170# VSS nfet_03v3 ad=0.1278p pd=1.07u as=0.1188p ps=1.02u w=0.36u l=0.28u
X3498 VDD a_32028_7670# a_32162_7860# VDD pfet_03v3 ad=0.1764p pd=1.26u as=0.1584p ps=1.6u w=0.36u l=0.28u
X3499 VDD.t739 RB15.t31 a_18698_n608# VDD.t738 pfet_03v3 ad=0.3168p pd=2.32u as=0.3708p ps=2.47u w=0.72u l=0.28u
X3500 a_661_1398# a_965_1398# a_1129_n862.t19 VDD pfet_03v3 ad=0.1152p pd=1u as=0.1584p ps=1.6u w=0.36u l=0.28u
X3501 a_14922_7390# a_14858_7200# a_14724_6886# VDD pfet_03v3 ad=56.7f pd=0.675u as=0.1278p ps=1.07u w=0.36u l=0.28u
X3502 a_30325_6886# a_30629_6978# a_30793_n862.t19 VDD pfet_03v3 ad=0.1152p pd=1u as=0.1584p ps=1.6u w=0.36u l=0.28u
X3503 VDD a_32028_4534# a_32162_4724# VDD pfet_03v3 ad=0.1764p pd=1.26u as=0.1584p ps=1.6u w=0.36u l=0.28u
X3504 a_10549_9238# a_9780_9238# VDD VDD pfet_03v3 ad=0.36p pd=2.44u as=0.1764p ps=1.26u w=0.72u l=0.28u
X3505 VDD a_n1204_9238.t30 a_22338_9238# VDD pfet_03v3 ad=0.1584p pd=1.6u as=56.7f ps=0.675u w=0.36u l=0.28u
X3506 VDD RB10.t32 a_28586_3124# VDD pfet_03v3 ad=0.3168p pd=2.32u as=0.3708p ps=2.47u w=0.72u l=0.28u
X3507 VSS a_n884_8454.t24 a_7506_8454# VSS nfet_03v3 ad=0.1584p pd=1.6u as=56.7f ps=0.675u w=0.36u l=0.28u
X3508 a_14922_4254# a_14858_4064# a_14724_3750# VDD pfet_03v3 ad=56.7f pd=0.675u as=0.1278p ps=1.07u w=0.36u l=0.28u
X3509 a_30325_3750# a_30629_3842# a_30793_n862.t29 VDD pfet_03v3 ad=0.1152p pd=1u as=0.1584p ps=1.6u w=0.36u l=0.28u
X3510 a_4836_n954# a_n1204_n954.t24 a_4648_n954# VSS nfet_03v3 ad=0.1278p pd=1.07u as=0.1188p ps=1.02u w=0.36u l=0.28u
X3511 VDD a_29556_1398# a_29690_1588# VDD pfet_03v3 ad=0.1764p pd=1.26u as=0.1584p ps=1.6u w=0.36u l=0.28u
X3512 a_19480_1398# a_19416_n708.t23 VSS VSS nfet_03v3 ad=0.1188p pd=1.02u as=0.1584p ps=1.6u w=0.36u l=0.28u
X3513 a_30325_614# a_30629_706# a_30793_n862.t28 VDD pfet_03v3 ad=0.1152p pd=1u as=0.1584p ps=1.6u w=0.36u l=0.28u
X3514 a_22909_1398# a_22140_1398# VSS VSS nfet_03v3 ad=0.18p pd=1.72u as=97.2f ps=0.9u w=0.36u l=0.28u
X3515 a_14536_6102# a_14472_n708.t26 VDD VDD pfet_03v3 ad=0.2097p pd=1.38u as=0.3168p ps=2.32u w=0.72u l=0.28u
X3516 VSS a_n884_5318.t25 a_7506_5318# VSS nfet_03v3 ad=0.1584p pd=1.6u as=56.7f ps=0.675u w=0.36u l=0.28u
X3517 a_29556_2966# a_n1204_2966.t26 a_29368_2966# VSS nfet_03v3 ad=0.1278p pd=1.07u as=0.1188p ps=1.02u w=0.36u l=0.28u
X3518 a_14922_1118# a_14858_928# a_14724_614# VDD pfet_03v3 ad=56.7f pd=0.675u as=0.1278p ps=1.07u w=0.36u l=0.28u
X3519 a_23213_5410# RA7.t29 VSS VSS nfet_03v3 ad=0.1944p pd=1.8u as=0.1656p ps=1.64u w=0.36u l=0.28u
X3520 VSS.t2192 a_22140_n954# a_22274_n640# VSS nfet_03v3 ad=97.2f pd=0.9u as=0.1584p ps=1.6u w=0.36u l=0.28u
X3521 a_11287_n2146.t11 a_11282_n608# a_10549_n954# VDD.t2041 pfet_03v3 ad=0.1584p pd=1.6u as=0.1152p ps=1u w=0.36u l=0.28u
X3522 a_20437_8454# a_19668_8454# VDD VDD pfet_03v3 ad=0.36p pd=2.44u as=0.1764p ps=1.26u w=0.72u l=0.28u
X3523 VSS a_n884_7670.t21 a_34698_8174# VSS nfet_03v3 ad=0.1584p pd=1.6u as=56.7f ps=0.675u w=0.36u l=0.28u
X3524 a_30629_6978# RA5.t29 VSS VSS nfet_03v3 ad=0.1944p pd=1.8u as=0.1656p ps=1.64u w=0.36u l=0.28u
X3525 a_4836_n170# a_n1204_n170.t29 a_4648_n170# VSS nfet_03v3 ad=0.1278p pd=1.07u as=0.1188p ps=1.02u w=0.36u l=0.28u
X3526 a_26840_n1782# a_27344_n1738# a_27632_n1234# VSS nfet_03v3 ad=0.1278p pd=1.07u as=56.7f ps=0.675u w=0.36u l=0.28u
X3527 a_38045_1398# RA12.t31 VDD VDD pfet_03v3 ad=0.3888p pd=2.52u as=0.3312p ps=2.36u w=0.72u l=0.28u
X3528 a_13021_6886# a_12252_6886# VSS VSS nfet_03v3 ad=0.18p pd=1.72u as=97.2f ps=0.9u w=0.36u l=0.28u
X3529 VSS a_n884_4534.t21 a_34698_5038# VSS nfet_03v3 ad=0.1584p pd=1.6u as=56.7f ps=0.675u w=0.36u l=0.28u
X3530 a_32226_1398# a_32162_1588# a_32028_1398# VDD pfet_03v3 ad=56.7f pd=0.675u as=0.1278p ps=1.07u w=0.36u l=0.28u
X3531 a_32797_10806# a_33101_10806# a_33265_n862.t30 VDD pfet_03v3 ad=0.1152p pd=1u as=0.1584p ps=1.6u w=0.36u l=0.28u
X3532 a_35573_6978# RA5.t30 VDD VDD pfet_03v3 ad=0.3888p pd=2.52u as=0.3312p ps=2.36u w=0.72u l=0.28u
X3533 a_5909_1398# RA12.t32 VDD VDD pfet_03v3 ad=0.3888p pd=2.52u as=0.3312p ps=2.36u w=0.72u l=0.28u
X3534 a_7120_n954# a_7056_n708.t19 VSS.t1041 VSS nfet_03v3 ad=0.1188p pd=1.02u as=0.1584p ps=1.6u w=0.36u l=0.28u
X3535 VSS a_n884_1398.t28 a_32226_1902# VSS nfet_03v3 ad=0.1584p pd=1.6u as=56.7f ps=0.675u w=0.36u l=0.28u
X3536 a_38045_10806# RA0.t35 VSS VSS nfet_03v3 ad=0.1944p pd=1.8u as=0.1656p ps=1.64u w=0.36u l=0.28u
X3537 VSS a_n1204_9238.t31 a_n884_9238.t3 VSS nfet_03v3 ad=0.2948p pd=2.22u as=0.1943p ps=1.25u w=0.67u l=0.28u
X3538 a_25685_9238# RA2.t26 VSS VSS nfet_03v3 ad=0.1944p pd=1.8u as=0.1656p ps=1.64u w=0.36u l=0.28u
X3539 a_35269_7670# a_35573_7670# a_35737_n862.t19 VDD pfet_03v3 ad=0.1152p pd=1u as=0.1584p ps=1.6u w=0.36u l=0.28u
X3540 VSS a_29556_10806# a_29690_10996# VSS nfet_03v3 ad=97.2f pd=0.9u as=0.1584p ps=1.6u w=0.36u l=0.28u
X3541 a_25685_6102# RA6.t28 VSS VSS nfet_03v3 ad=0.1944p pd=1.8u as=0.1656p ps=1.64u w=0.36u l=0.28u
X3542 a_17008_3750# a_16944_n708.t26 VSS VSS nfet_03v3 ad=0.1188p pd=1.02u as=0.1584p ps=1.6u w=0.36u l=0.28u
X3543 a_35269_2966# a_34500_2966# VSS VSS nfet_03v3 ad=0.18p pd=1.72u as=97.2f ps=0.9u w=0.36u l=0.28u
X3544 a_24612_6886# a_n884_6886.t23 a_24424_6886# VDD pfet_03v3 ad=0.1278p pd=1.07u as=0.2097p ps=1.38u w=0.36u l=0.28u
X3545 VSS a_n1204_6102.t31 a_n884_6102.t3 VSS nfet_03v3 ad=0.2948p pd=2.22u as=0.1943p ps=1.25u w=0.67u l=0.28u
X3546 a_35269_4534# a_35573_4534# a_35737_n862.t26 VDD pfet_03v3 ad=0.1152p pd=1u as=0.1584p ps=1.6u w=0.36u l=0.28u
X3547 VSS a_n1204_2966.t27 a_n884_2966.t2 VSS nfet_03v3 ad=0.2948p pd=2.22u as=0.1943p ps=1.25u w=0.67u l=0.28u
X3548 QB15b.t0 a_38479_n2146.t33 VDD VDD pfet_03v3 ad=0.4104p pd=2.58u as=0.2484p ps=1.41u w=0.72u l=0.28u
X3549 a_24612_3750# a_n884_3750.t24 a_24424_3750# VDD pfet_03v3 ad=0.1278p pd=1.07u as=0.2097p ps=1.38u w=0.36u l=0.28u
X3550 VDD a_n1204_2966.t28 a_n884_2966.t0 VDD pfet_03v3 ad=0.5896p pd=3.56u as=0.3886p ps=1.92u w=1.34u l=0.28u
X3551 VDD RB12.t27 a_8810_1556# VDD pfet_03v3 ad=0.3168p pd=2.32u as=0.3708p ps=2.47u w=0.72u l=0.28u
X3552 a_28591_n2146.t22 a_28586_9396# a_27853_9238# VDD pfet_03v3 ad=0.1584p pd=1.6u as=0.1152p ps=1u w=0.36u l=0.28u
X3553 VSS RB4.t26 a_21170_7828# VSS nfet_03v3 ad=0.1584p pd=1.6u as=0.1854p ps=1.75u w=0.36u l=0.28u
X3554 a_24612_614# a_n884_614.t29 a_24424_614# VDD pfet_03v3 ad=0.1278p pd=1.07u as=0.2097p ps=1.38u w=0.36u l=0.28u
X3555 a_27853_8454# a_27084_8454# VSS VSS nfet_03v3 ad=0.18p pd=1.72u as=97.2f ps=0.9u w=0.36u l=0.28u
X3556 a_13325_n862# RA15.t25 VDD.t448 VDD.t447 pfet_03v3 ad=0.3888p pd=2.52u as=0.3312p ps=2.36u w=0.72u l=0.28u
X3557 a_38045_706# RA13.t27 VSS VSS nfet_03v3 ad=0.1944p pd=1.8u as=0.1656p ps=1.64u w=0.36u l=0.28u
X3558 VDD a_9780_6886# a_9914_7200# VDD pfet_03v3 ad=0.1764p pd=1.26u as=0.1584p ps=1.6u w=0.36u l=0.28u
X3559 a_27853_5318# a_27084_5318# VSS VSS nfet_03v3 ad=0.18p pd=1.72u as=97.2f ps=0.9u w=0.36u l=0.28u
X3560 VDD a_9780_3750# a_9914_4064# VDD pfet_03v3 ad=0.1764p pd=1.26u as=0.1584p ps=1.6u w=0.36u l=0.28u
X3561 VSS a_12252_2182# a_12386_2496# VSS nfet_03v3 ad=97.2f pd=0.9u as=0.1584p ps=1.6u w=0.36u l=0.28u
X3562 VDD a_9780_614# a_9914_928# VDD pfet_03v3 ad=0.1764p pd=1.26u as=0.1584p ps=1.6u w=0.36u l=0.28u
X3563 a_29368_2182# a_29304_n708.t21 VSS VSS nfet_03v3 ad=0.1188p pd=1.02u as=0.1584p ps=1.6u w=0.36u l=0.28u
X3564 a_24612_10022# a_n884_10022.t22 a_24424_10022# VDD pfet_03v3 ad=0.1278p pd=1.07u as=0.2097p ps=1.38u w=0.36u l=0.28u
X3565 VDD a_n1204_2182.t23 a_14922_2686# VDD pfet_03v3 ad=0.1584p pd=1.6u as=56.7f ps=0.675u w=0.36u l=0.28u
X3566 a_n108_10022# a_n884_10022.t23 a_n296_10022# VDD pfet_03v3 ad=0.1278p pd=1.07u as=0.2097p ps=1.38u w=0.36u l=0.28u
X3567 a_n1204_9238.t3 a_n1652_9238# VSS VSS nfet_03v3 ad=0.1651p pd=1.155u as=0.2794p ps=2.15u w=0.635u l=0.28u
X3568 a_12450_7390# a_12386_7200# a_12252_6886# VDD pfet_03v3 ad=56.7f pd=0.675u as=0.1278p ps=1.07u w=0.36u l=0.28u
X3569 a_32797_2182# a_32028_2182# VSS VSS nfet_03v3 ad=0.18p pd=1.72u as=97.2f ps=0.9u w=0.36u l=0.28u
X3570 VSS a_n884_8454.t25 a_5034_8454# VSS nfet_03v3 ad=0.1584p pd=1.6u as=56.7f ps=0.675u w=0.36u l=0.28u
X3571 a_28591_n2146.t1 RB8.t28 a_27853_4534# VSS nfet_03v3 ad=0.1584p pd=1.6u as=0.1152p ps=1u w=0.36u l=0.28u
X3572 a_12450_4254# a_12386_4064# a_12252_3750# VDD pfet_03v3 ad=56.7f pd=0.675u as=0.1278p ps=1.07u w=0.36u l=0.28u
X3573 a_34698_n170# a_34634_20# a_34500_n170# VDD.t1997 pfet_03v3 ad=56.7f pd=0.675u as=0.1278p ps=1.07u w=0.36u l=0.28u
X3574 a_20437_1398# a_19668_1398# VSS VSS nfet_03v3 ad=0.18p pd=1.72u as=97.2f ps=0.9u w=0.36u l=0.28u
X3575 VSS a_n884_5318.t26 a_5034_5318# VSS nfet_03v3 ad=0.1584p pd=1.6u as=56.7f ps=0.675u w=0.36u l=0.28u
X3576 a_12450_1118# a_12386_928# a_12252_614# VDD pfet_03v3 ad=56.7f pd=0.675u as=0.1278p ps=1.07u w=0.36u l=0.28u
X3577 a_19866_11310# a_19802_10996# a_19668_10806# VSS nfet_03v3 ad=56.7f pd=0.675u as=0.1278p ps=1.07u w=0.36u l=0.28u
X3578 a_n108_6886# a_n1204_6886.t30 a_n296_6886# VSS nfet_03v3 ad=0.1278p pd=1.07u as=0.1188p ps=1.02u w=0.36u l=0.28u
X3579 a_3871_n2146.t22 a_3866_5664# a_3133_5318# VDD pfet_03v3 ad=0.1584p pd=1.6u as=0.1152p ps=1u w=0.36u l=0.28u
X3580 a_33535_n2146.t23 a_33530_2528# a_32797_2182# VDD pfet_03v3 ad=0.1584p pd=1.6u as=0.1152p ps=1u w=0.36u l=0.28u
X3581 VDD a_n1204_10022.t25 a_14922_10526# VDD pfet_03v3 ad=0.1584p pd=1.6u as=56.7f ps=0.675u w=0.36u l=0.28u
X3582 a_20437_n954# RA15.t26 a_20905_n862.t3 VSS nfet_03v3 ad=0.1152p pd=1u as=0.1584p ps=1.6u w=0.36u l=0.28u
X3583 VDD a_n1204_9238.t32 a_2562_9238# VDD pfet_03v3 ad=0.1584p pd=1.6u as=56.7f ps=0.675u w=0.36u l=0.28u
X3584 a_1399_n2146.t19 a_1394_2528# a_661_2182# VDD pfet_03v3 ad=0.1584p pd=1.6u as=0.1152p ps=1u w=0.36u l=0.28u
X3585 a_22909_10022# RA1.t36 a_23377_n862.t11 VSS nfet_03v3 ad=0.1152p pd=1u as=0.1584p ps=1.6u w=0.36u l=0.28u
X3586 VSS a_n884_10022.t24 a_22338_10022# VSS nfet_03v3 ad=0.1584p pd=1.6u as=56.7f ps=0.675u w=0.36u l=0.28u
X3587 VDD RB6.t29 a_1394_6260# VDD pfet_03v3 ad=0.3168p pd=2.32u as=0.3708p ps=2.47u w=0.72u l=0.28u
X3588 a_10549_6886# a_9780_6886# VSS VSS nfet_03v3 ad=0.18p pd=1.72u as=97.2f ps=0.9u w=0.36u l=0.28u
X3589 VSS a_n884_6886.t24 a_22338_6886# VSS nfet_03v3 ad=0.1584p pd=1.6u as=56.7f ps=0.675u w=0.36u l=0.28u
X3590 a_9780_2966# a_n1204_2966.t29 a_9592_2966# VSS nfet_03v3 ad=0.1278p pd=1.07u as=0.1188p ps=1.02u w=0.36u l=0.28u
X3591 a_3437_1398# RA12.t33 VDD VDD pfet_03v3 ad=0.3888p pd=2.52u as=0.3312p ps=2.36u w=0.72u l=0.28u
X3592 a_965_n170# RA14.t30 VSS VSS nfet_03v3 ad=0.1944p pd=1.8u as=0.1656p ps=1.64u w=0.36u l=0.28u
X3593 a_23213_9238# RA2.t27 VSS VSS nfet_03v3 ad=0.1944p pd=1.8u as=0.1656p ps=1.64u w=0.36u l=0.28u
X3594 a_33101_6978# RA5.t31 VDD VDD pfet_03v3 ad=0.3888p pd=2.52u as=0.3312p ps=2.36u w=0.72u l=0.28u
X3595 a_17394_7670# a_17330_7860# a_17196_7670# VDD pfet_03v3 ad=56.7f pd=0.675u as=0.1278p ps=1.07u w=0.36u l=0.28u
X3596 a_32797_7670# a_33101_7670# a_33265_n862.t22 VDD pfet_03v3 ad=0.1152p pd=1u as=0.1584p ps=1.6u w=0.36u l=0.28u
X3597 VSS a_n884_2966.t21 a_90_3470# VSS nfet_03v3 ad=0.1584p pd=1.6u as=56.7f ps=0.675u w=0.36u l=0.28u
X3598 VDD a_n1204_2966.t30 a_19866_2966# VDD pfet_03v3 ad=0.1584p pd=1.6u as=56.7f ps=0.675u w=0.36u l=0.28u
X3599 a_22140_6886# a_n884_6886.t25 a_21952_6886# VDD pfet_03v3 ad=0.1278p pd=1.07u as=0.2097p ps=1.38u w=0.36u l=0.28u
X3600 a_23213_6102# RA6.t29 VSS VSS nfet_03v3 ad=0.1944p pd=1.8u as=0.1656p ps=1.64u w=0.36u l=0.28u
X3601 a_32797_4534# a_33101_4534# a_33265_n862.t23 VDD pfet_03v3 ad=0.1152p pd=1u as=0.1584p ps=1.6u w=0.36u l=0.28u
X3602 a_14536_3750# a_14472_n708.t27 VSS VSS nfet_03v3 ad=0.1188p pd=1.02u as=0.1584p ps=1.6u w=0.36u l=0.28u
X3603 a_17394_4534# a_17330_4724# a_17196_4534# VDD pfet_03v3 ad=56.7f pd=0.675u as=0.1278p ps=1.07u w=0.36u l=0.28u
X3604 a_25685_706# RA13.t28 VSS VSS nfet_03v3 ad=0.1944p pd=1.8u as=0.1656p ps=1.64u w=0.36u l=0.28u
X3605 a_27853_10806# a_28157_10806# a_28321_n862.t22 VDD pfet_03v3 ad=0.1152p pd=1u as=0.1584p ps=1.6u w=0.36u l=0.28u
X3606 a_4648_5318# a_4584_n708.t25 VDD VDD pfet_03v3 ad=0.2097p pd=1.38u as=0.3168p ps=2.32u w=0.72u l=0.28u
X3607 a_22140_3750# a_n884_3750.t25 a_21952_3750# VDD pfet_03v3 ad=0.1278p pd=1.07u as=0.2097p ps=1.38u w=0.36u l=0.28u
X3608 a_24360_n708.t2 a_24368_n1782# VDD VDD pfet_03v3 ad=0.3224p pd=1.76u as=0.5456p ps=3.36u w=1.24u l=0.28u
X3609 a_26119_n2146.t6 RB15.t32 a_25381_n954# VSS nfet_03v3 ad=0.1584p pd=1.6u as=0.1152p ps=1u w=0.36u l=0.28u
X3610 a_2562_8454# a_2498_8768# a_2364_8454# VSS nfet_03v3 ad=56.7f pd=0.675u as=0.1278p ps=1.07u w=0.36u l=0.28u
X3611 VSS RB3.t26 a_11282_8800# VSS nfet_03v3 ad=0.1584p pd=1.6u as=0.1854p ps=1.75u w=0.36u l=0.28u
X3612 a_4648_2182# a_4584_n708.t26 VDD VDD pfet_03v3 ad=0.2097p pd=1.38u as=0.3168p ps=2.32u w=0.72u l=0.28u
X3613 a_22140_614# a_n884_614.t30 a_21952_614# VDD pfet_03v3 ad=0.1278p pd=1.07u as=0.2097p ps=1.38u w=0.36u l=0.28u
X3614 VSS a_n884_8454.t26 a_37170_8454# VSS nfet_03v3 ad=0.1584p pd=1.6u as=56.7f ps=0.675u w=0.36u l=0.28u
X3615 a_29754_3470# a_29690_3156# a_29556_2966# VSS nfet_03v3 ad=56.7f pd=0.675u as=0.1278p ps=1.07u w=0.36u l=0.28u
X3616 VSS RB12.t28 a_1394_1556# VSS nfet_03v3 ad=0.1584p pd=1.6u as=0.1854p ps=1.75u w=0.36u l=0.28u
X3617 a_661_n170# a_965_n170# a_1129_n862.t23 VDD.t2954 pfet_03v3 ad=0.1152p pd=1u as=0.1584p ps=1.6u w=0.36u l=0.28u
X3618 a_2562_5318# a_2498_5632# a_2364_5318# VSS nfet_03v3 ad=56.7f pd=0.675u as=0.1278p ps=1.07u w=0.36u l=0.28u
X3619 VSS a_7308_10806# a_7442_10996# VSS nfet_03v3 ad=97.2f pd=0.9u as=0.1584p ps=1.6u w=0.36u l=0.28u
X3620 VSS a_n884_5318.t27 a_37170_5318# VSS nfet_03v3 ad=0.1584p pd=1.6u as=56.7f ps=0.675u w=0.36u l=0.28u
X3621 a_19480_9238# a_19416_n708.t24 VDD VDD pfet_03v3 ad=0.2097p pd=1.38u as=0.3168p ps=2.32u w=0.72u l=0.28u
X3622 QB1b.t0 a_3871_n2146.t33 VDD VDD pfet_03v3 ad=0.4104p pd=2.58u as=0.2484p ps=1.41u w=0.72u l=0.28u
X3623 a_27853_n954# a_27084_n954# VDD.t2463 VDD.t2462 pfet_03v3 ad=0.36p pd=2.44u as=0.1764p ps=1.26u w=0.72u l=0.28u
X3624 a_8815_n2146.t3 RB15.t33 a_8077_n954# VSS nfet_03v3 ad=0.1584p pd=1.6u as=0.1152p ps=1u w=0.36u l=0.28u
X3625 VDD.t3331 a_29556_n170# a_29690_20# VDD.t3161 pfet_03v3 ad=0.1764p pd=1.26u as=0.1584p ps=1.6u w=0.36u l=0.28u
X3626 a_8381_706# RA13.t29 VSS VSS nfet_03v3 ad=0.1944p pd=1.8u as=0.1656p ps=1.64u w=0.36u l=0.28u
X3627 a_22909_9238# a_22140_9238# VDD VDD pfet_03v3 ad=0.36p pd=2.44u as=0.1764p ps=1.26u w=0.72u l=0.28u
X3628 a_25381_10806# a_24612_10806# VSS VSS nfet_03v3 ad=0.18p pd=1.72u as=97.2f ps=0.9u w=0.36u l=0.28u
X3629 a_27084_7670# a_n884_7670.t22 a_26896_7670# VDD pfet_03v3 ad=0.1278p pd=1.07u as=0.2097p ps=1.38u w=0.36u l=0.28u
X3630 QB13b.t1 a_33535_n2146.t32 VSS VSS nfet_03v3 ad=0.2052p pd=1.86u as=0.1242p ps=1.05u w=0.36u l=0.28u
X3631 VSS a_23377_n862.t32 QA9b.t1 VSS nfet_03v3 ad=0.1242p pd=1.05u as=0.2052p ps=1.86u w=0.36u l=0.28u
X3632 a_35269_10806# a_34500_10806# VDD VDD pfet_03v3 ad=0.36p pd=2.44u as=0.1764p ps=1.26u w=0.72u l=0.28u
X3633 VDD a_n1652_8886# a_n1204_8454.t0 VDD pfet_03v3 ad=0.3386p pd=1.86u as=0.3302p ps=1.79u w=1.27u l=0.28u
X3634 a_26896_6102# a_26832_n708.t27 VDD VDD pfet_03v3 ad=0.2097p pd=1.38u as=0.3168p ps=2.32u w=0.72u l=0.28u
X3635 a_27084_4534# a_n884_4534.t22 a_26896_4534# VDD pfet_03v3 ad=0.1278p pd=1.07u as=0.2097p ps=1.38u w=0.36u l=0.28u
X3636 a_29368_8454# a_29304_n708.t22 VDD VDD pfet_03v3 ad=0.2097p pd=1.38u as=0.3168p ps=2.32u w=0.72u l=0.28u
X3637 a_35573_5410# RA7.t30 VSS VSS nfet_03v3 ad=0.1944p pd=1.8u as=0.1656p ps=1.64u w=0.36u l=0.28u
X3638 a_23647_n2146.t16 a_23642_n608# a_22909_n954# VDD.t2547 pfet_03v3 ad=0.1584p pd=1.6u as=0.1152p ps=1u w=0.36u l=0.28u
X3639 a_38045_n170# RA14.t31 VDD.t1086 VDD.t459 pfet_03v3 ad=0.3888p pd=2.52u as=0.3312p ps=2.36u w=0.72u l=0.28u
X3640 a_32797_8454# a_32028_8454# VDD VDD pfet_03v3 ad=0.36p pd=2.44u as=0.1764p ps=1.26u w=0.72u l=0.28u
X3641 a_18703_n2146.t20 a_18698_6260# a_17965_6102# VDD pfet_03v3 ad=0.1584p pd=1.6u as=0.1152p ps=1u w=0.36u l=0.28u
X3642 a_15493_2182# RA11.t32 a_15961_n862.t0 VSS nfet_03v3 ad=0.1152p pd=1u as=0.1584p ps=1.6u w=0.36u l=0.28u
X3643 a_32226_n170# a_32162_20# a_32028_n170# VDD.t2185 pfet_03v3 ad=56.7f pd=0.675u as=0.1278p ps=1.07u w=0.36u l=0.28u
X3644 VDD a_n1204_9238.t33 a_32226_9238# VDD pfet_03v3 ad=0.1584p pd=1.6u as=56.7f ps=0.675u w=0.36u l=0.28u
X3645 a_9592_2182# a_9528_n708.t21 VSS VSS nfet_03v3 ad=0.1188p pd=1.02u as=0.1584p ps=1.6u w=0.36u l=0.28u
X3646 VSS.t2145 a_2364_n954# a_2498_n640# VSS nfet_03v3 ad=97.2f pd=0.9u as=0.1584p ps=1.6u w=0.36u l=0.28u
X3647 a_5909_n170# RA14.t32 VDD.t1087 VDD.t461 pfet_03v3 ad=0.3888p pd=2.52u as=0.3312p ps=2.36u w=0.72u l=0.28u
X3648 a_31063_n2146.t23 a_31058_2528# a_30325_2182# VDD pfet_03v3 ad=0.1584p pd=1.6u as=0.1152p ps=1u w=0.36u l=0.28u
X3649 a_10549_6886# a_10853_6978# a_11017_n862.t27 VDD pfet_03v3 ad=0.1152p pd=1u as=0.1584p ps=1.6u w=0.36u l=0.28u
X3650 VDD RB6.t30 a_31058_6260# VDD pfet_03v3 ad=0.3168p pd=2.32u as=0.3708p ps=2.47u w=0.72u l=0.28u
X3651 VSS.t2360 D12.t1 a_30421_n1738# VSS nfet_03v3 ad=0.1584p pd=1.6u as=0.1188p ps=1.02u w=0.36u l=0.28u
X3652 a_20437_8454# a_20741_8546# a_20905_n862.t13 VDD pfet_03v3 ad=0.1152p pd=1u as=0.1584p ps=1.6u w=0.36u l=0.28u
X3653 a_9780_10022# a_n1204_10022.t26 a_9592_10022# VSS nfet_03v3 ad=0.1278p pd=1.07u as=0.1188p ps=1.02u w=0.36u l=0.28u
X3654 a_10549_3750# a_10853_3842# a_11017_n862.t6 VDD pfet_03v3 ad=0.1152p pd=1u as=0.1584p ps=1.6u w=0.36u l=0.28u
X3655 a_7308_2966# a_n1204_2966.t31 a_7120_2966# VSS nfet_03v3 ad=0.1278p pd=1.07u as=0.1188p ps=1.02u w=0.36u l=0.28u
X3656 VDD a_22140_10806# a_22274_10996# VDD pfet_03v3 ad=0.1764p pd=1.26u as=0.1584p ps=1.6u w=0.36u l=0.28u
X3657 a_36972_6886# a_n884_6886.t26 a_36784_6886# VDD pfet_03v3 ad=0.1278p pd=1.07u as=0.2097p ps=1.38u w=0.36u l=0.28u
X3658 VDD.t1492 RB14.t34 a_8810_n12# VDD.t744 pfet_03v3 ad=0.3168p pd=2.32u as=0.3708p ps=2.47u w=0.72u l=0.28u
X3659 VDD a_n1204_2966.t32 a_17394_2966# VDD pfet_03v3 ad=0.1584p pd=1.6u as=56.7f ps=0.675u w=0.36u l=0.28u
X3660 a_10549_614# a_10853_706# a_11017_n862.t23 VDD pfet_03v3 ad=0.1152p pd=1u as=0.1584p ps=1.6u w=0.36u l=0.28u
X3661 a_36972_3750# a_n884_3750.t26 a_36784_3750# VDD pfet_03v3 ad=0.1278p pd=1.07u as=0.2097p ps=1.38u w=0.36u l=0.28u
X3662 VSS RB4.t27 a_33530_7828# VSS nfet_03v3 ad=0.1584p pd=1.6u as=0.1854p ps=1.75u w=0.36u l=0.28u
X3663 a_36972_614# a_n884_614.t31 a_36784_614# VDD pfet_03v3 ad=0.1278p pd=1.07u as=0.2097p ps=1.38u w=0.36u l=0.28u
X3664 a_18703_n2146.t5 RB12.t29 a_17965_1398# VSS nfet_03v3 ad=0.1584p pd=1.6u as=0.1152p ps=1u w=0.36u l=0.28u
X3665 VSS a_n884_6886.t27 a_2562_6886# VSS nfet_03v3 ad=0.1584p pd=1.6u as=56.7f ps=0.675u w=0.36u l=0.28u
X3666 a_37170_n450# a_37106_n640# a_36972_n954# VDD.t2497 pfet_03v3 ad=56.7f pd=0.675u as=0.1278p ps=1.07u w=0.36u l=0.28u
X3667 a_25685_n862# RA15.t27 VDD.t450 VDD.t449 pfet_03v3 ad=0.3888p pd=2.52u as=0.3312p ps=2.36u w=0.72u l=0.28u
X3668 a_22909_10806# RA0.t36 a_23377_n862.t4 VSS nfet_03v3 ad=0.1152p pd=1u as=0.1584p ps=1.6u w=0.36u l=0.28u
X3669 a_4584_n708.t0 a_4592_n1782# VSS.t2784 VSS nfet_03v3 ad=0.1612p pd=1.14u as=0.2728p ps=2.12u w=0.62u l=0.28u
X3670 a_26119_n2146.t24 a_26114_8800# a_25381_8454# VDD pfet_03v3 ad=0.1584p pd=1.6u as=0.1152p ps=1u w=0.36u l=0.28u
X3671 a_38479_n2146.t11 RB9.t29 a_37741_3750# VSS nfet_03v3 ad=0.1584p pd=1.6u as=0.1152p ps=1u w=0.36u l=0.28u
X3672 a_36007_n2146.t16 a_36002_3124# a_35269_2966# VDD pfet_03v3 ad=0.1584p pd=1.6u as=0.1152p ps=1u w=0.36u l=0.28u
X3673 VSS RB12.t30 a_31058_1556# VSS nfet_03v3 ad=0.1584p pd=1.6u as=0.1854p ps=1.75u w=0.36u l=0.28u
X3674 a_15797_10806# RA0.t37 VDD VDD pfet_03v3 ad=0.3888p pd=2.52u as=0.3312p ps=2.36u w=0.72u l=0.28u
X3675 a_17965_5318# RA7.t31 a_18433_n862.t14 VSS nfet_03v3 ad=0.1152p pd=1u as=0.1584p ps=1.6u w=0.36u l=0.28u
X3676 a_14724_8454# a_n884_8454.t27 a_14536_8454# VDD pfet_03v3 ad=0.1278p pd=1.07u as=0.2097p ps=1.38u w=0.36u l=0.28u
X3677 a_6343_n2146.t3 RB15.t34 a_5605_n954# VSS nfet_03v3 ad=0.1584p pd=1.6u as=0.1152p ps=1u w=0.36u l=0.28u
X3678 a_8815_n2146.t20 a_8810_8800# a_8077_8454# VDD pfet_03v3 ad=0.1584p pd=1.6u as=0.1152p ps=1u w=0.36u l=0.28u
X3679 a_24810_7390# a_24746_7200# a_24612_6886# VDD pfet_03v3 ad=56.7f pd=0.675u as=0.1278p ps=1.07u w=0.36u l=0.28u
X3680 a_n1204_5318.t1 a_n1652_5750# VDD VDD pfet_03v3 ad=0.3302p pd=1.79u as=0.5588p ps=3.42u w=1.27u l=0.28u
X3681 a_4836_2182# a_n1204_2182.t24 a_4648_2182# VSS nfet_03v3 ad=0.1278p pd=1.07u as=0.1188p ps=1.02u w=0.36u l=0.28u
X3682 VSS a_12252_1398# a_12386_1588# VSS nfet_03v3 ad=97.2f pd=0.9u as=0.1584p ps=1.6u w=0.36u l=0.28u
X3683 a_14724_10022# a_n1204_10022.t27 a_14536_10022# VSS nfet_03v3 ad=0.1278p pd=1.07u as=0.1188p ps=1.02u w=0.36u l=0.28u
X3684 a_20437_9238# a_19668_9238# VDD VDD pfet_03v3 ad=0.36p pd=2.44u as=0.1764p ps=1.26u w=0.72u l=0.28u
X3685 a_24810_4254# a_24746_4064# a_24612_3750# VDD pfet_03v3 ad=56.7f pd=0.675u as=0.1278p ps=1.07u w=0.36u l=0.28u
X3686 VDD RB10.t33 a_38474_3124# VDD pfet_03v3 ad=0.3168p pd=2.32u as=0.3708p ps=2.47u w=0.72u l=0.28u
X3687 a_29368_1398# a_29304_n708.t23 VSS VSS nfet_03v3 ad=0.1188p pd=1.02u as=0.1584p ps=1.6u w=0.36u l=0.28u
X3688 VDD RB0.t29 a_6338_10964# VDD pfet_03v3 ad=0.3168p pd=2.32u as=0.3708p ps=2.47u w=0.72u l=0.28u
X3689 a_n1204_2182.t1 a_n1652_2614# VDD VDD pfet_03v3 ad=0.3302p pd=1.79u as=0.5588p ps=3.42u w=1.27u l=0.28u
X3690 VSS a_22140_2182# a_22274_2496# VSS nfet_03v3 ad=97.2f pd=0.9u as=0.1584p ps=1.6u w=0.36u l=0.28u
X3691 a_32797_1398# a_32028_1398# VSS VSS nfet_03v3 ad=0.18p pd=1.72u as=97.2f ps=0.9u w=0.36u l=0.28u
X3692 a_9592_10806# a_9528_n708.t22 VSS VSS nfet_03v3 ad=0.1188p pd=1.02u as=0.1584p ps=1.6u w=0.36u l=0.28u
X3693 a_24810_1118# a_24746_928# a_24612_614# VDD pfet_03v3 ad=56.7f pd=0.675u as=0.1278p ps=1.07u w=0.36u l=0.28u
X3694 VDD a_n108_5318# a_26_5632# VDD pfet_03v3 ad=0.1764p pd=1.26u as=0.1584p ps=1.6u w=0.36u l=0.28u
X3695 VSS.t2531 a_32028_n954# a_32162_n640# VSS nfet_03v3 ad=97.2f pd=0.9u as=0.1584p ps=1.6u w=0.36u l=0.28u
X3696 a_21175_n2146.t15 a_21170_n608# a_20437_n954# VDD.t2146 pfet_03v3 ad=0.1584p pd=1.6u as=0.1152p ps=1u w=0.36u l=0.28u
X3697 a_33101_5410# RA7.t32 VSS VSS nfet_03v3 ad=0.1944p pd=1.8u as=0.1656p ps=1.64u w=0.36u l=0.28u
X3698 a_19480_6886# a_19416_n708.t25 VSS VSS nfet_03v3 ad=0.1188p pd=1.02u as=0.1584p ps=1.6u w=0.36u l=0.28u
X3699 a_16231_n2146.t20 a_16226_6260# a_15493_6102# VDD pfet_03v3 ad=0.1584p pd=1.6u as=0.1152p ps=1u w=0.36u l=0.28u
X3700 a_7120_2182# a_7056_n708.t20 VSS VSS nfet_03v3 ad=0.1188p pd=1.02u as=0.1584p ps=1.6u w=0.36u l=0.28u
X3701 a_3437_n170# RA14.t33 VDD.t1088 VDD.t463 pfet_03v3 ad=0.3888p pd=2.52u as=0.3312p ps=2.36u w=0.72u l=0.28u
X3702 a_8077_9238# a_7308_9238# VSS VSS nfet_03v3 ad=0.18p pd=1.72u as=97.2f ps=0.9u w=0.36u l=0.28u
X3703 VDD a_7064_n1782# a_7056_n708.t1 VDD pfet_03v3 ad=0.5456p pd=3.36u as=0.3224p ps=1.76u w=1.24u l=0.28u
X3704 VSS a_18433_n862.t32 QA7b.t1 VSS nfet_03v3 ad=0.1242p pd=1.05u as=0.2052p ps=1.86u w=0.36u l=0.28u
X3705 a_22909_6886# a_22140_6886# VSS VSS nfet_03v3 ad=0.18p pd=1.72u as=97.2f ps=0.9u w=0.36u l=0.28u
X3706 a_8077_6102# a_7308_6102# VSS VSS nfet_03v3 ad=0.18p pd=1.72u as=97.2f ps=0.9u w=0.36u l=0.28u
X3707 a_35573_9238# RA2.t28 VSS VSS nfet_03v3 ad=0.1944p pd=1.8u as=0.1656p ps=1.64u w=0.36u l=0.28u
X3708 a_9592_8454# a_9528_n708.t23 VDD VDD pfet_03v3 ad=0.2097p pd=1.38u as=0.3168p ps=2.32u w=0.72u l=0.28u
X3709 a_21896_n1782# a_22400_n1738# a_22688_n1738# VDD pfet_03v3 ad=0.1278p pd=1.07u as=56.7f ps=0.675u w=0.36u l=0.28u
X3710 a_9780_n170# a_n1204_n170.t30 a_9592_n170# VSS nfet_03v3 ad=0.1278p pd=1.07u as=0.1188p ps=1.02u w=0.36u l=0.28u
X3711 a_34500_6886# a_n884_6886.t28 a_34312_6886# VDD pfet_03v3 ad=0.1278p pd=1.07u as=0.2097p ps=1.38u w=0.36u l=0.28u
X3712 a_35573_6102# RA6.t30 VSS VSS nfet_03v3 ad=0.1944p pd=1.8u as=0.1656p ps=1.64u w=0.36u l=0.28u
X3713 a_26896_3750# a_26832_n708.t28 VSS VSS nfet_03v3 ad=0.1188p pd=1.02u as=0.1584p ps=1.6u w=0.36u l=0.28u
X3714 a_17965_7670# a_17196_7670# VSS VSS nfet_03v3 ad=0.18p pd=1.72u as=97.2f ps=0.9u w=0.36u l=0.28u
X3715 a_15493_2966# RA10.t27 a_15961_n862.t7 VSS nfet_03v3 ad=0.1152p pd=1u as=0.1584p ps=1.6u w=0.36u l=0.28u
X3716 WE0CLK.t3 a_n1652_10806# VSS VSS nfet_03v3 ad=0.1651p pd=1.155u as=0.2794p ps=2.15u w=0.635u l=0.28u
X3717 VSS a_17196_8454# a_17330_8768# VSS nfet_03v3 ad=97.2f pd=0.9u as=0.1584p ps=1.6u w=0.36u l=0.28u
X3718 VSS a_n884_6886.t29 a_32226_6886# VSS nfet_03v3 ad=0.1584p pd=1.6u as=56.7f ps=0.675u w=0.36u l=0.28u
X3719 a_n1652_6102# CLK a_n1652_6542# VSS nfet_03v3 ad=0.3168p pd=2.32u as=0.1872p ps=1.24u w=0.72u l=0.28u
X3720 a_17965_4534# a_17196_4534# VSS VSS nfet_03v3 ad=0.18p pd=1.72u as=97.2f ps=0.9u w=0.36u l=0.28u
X3721 a_34500_3750# a_n884_3750.t27 a_34312_3750# VDD pfet_03v3 ad=0.1278p pd=1.07u as=0.2097p ps=1.38u w=0.36u l=0.28u
X3722 VSS.t3047 D10.t1 a_25477_n1738# VSS nfet_03v3 ad=0.1584p pd=1.6u as=0.1188p ps=1.02u w=0.36u l=0.28u
X3723 a_32288_n1738# a_31784_n1782# VSS.t3148 VSS nfet_03v3 ad=0.1584p pd=1.6u as=0.1584p ps=1.6u w=0.36u l=0.28u
X3724 a_8077_10022# a_8381_10114# a_8545_n862.t5 VDD pfet_03v3 ad=0.1152p pd=1u as=0.1584p ps=1.6u w=0.36u l=0.28u
X3725 a_38479_n2146.t30 a_38474_9396# a_37741_9238# VDD pfet_03v3 ad=0.1584p pd=1.6u as=0.1152p ps=1u w=0.36u l=0.28u
X3726 VSS RB3.t27 a_23642_8800# VSS nfet_03v3 ad=0.1584p pd=1.6u as=0.1854p ps=1.75u w=0.36u l=0.28u
X3727 VSS a_17196_5318# a_17330_5632# VSS nfet_03v3 ad=97.2f pd=0.9u as=0.1584p ps=1.6u w=0.36u l=0.28u
X3728 a_n1652_2966# CLK a_n1652_3406# VSS nfet_03v3 ad=0.3168p pd=2.32u as=0.1872p ps=1.24u w=0.72u l=0.28u
X3729 a_23213_n862# RA15.t28 VDD.t452 VDD.t451 pfet_03v3 ad=0.3888p pd=2.52u as=0.3312p ps=2.36u w=0.72u l=0.28u
X3730 a_34500_614# a_n884_614.t32 a_34312_614# VDD pfet_03v3 ad=0.1278p pd=1.07u as=0.2097p ps=1.38u w=0.36u l=0.28u
X3731 a_16231_n2146.t6 RB12.t31 a_15493_1398# VSS nfet_03v3 ad=0.1584p pd=1.6u as=0.1152p ps=1u w=0.36u l=0.28u
X3732 a_24424_10806# a_24360_n708.t27 VDD VDD pfet_03v3 ad=0.2097p pd=1.38u as=0.3168p ps=2.32u w=0.72u l=0.28u
X3733 a_37741_8454# a_36972_8454# VSS VSS nfet_03v3 ad=0.18p pd=1.72u as=97.2f ps=0.9u w=0.36u l=0.28u
X3734 VDD a_19668_6886# a_19802_7200# VDD pfet_03v3 ad=0.1764p pd=1.26u as=0.1584p ps=1.6u w=0.36u l=0.28u
X3735 a_n1204_7670.t1 a_n1652_7670# VDD VDD pfet_03v3 ad=0.3302p pd=1.79u as=0.5588p ps=3.42u w=1.27u l=0.28u
X3736 a_37741_5318# a_36972_5318# VSS VSS nfet_03v3 ad=0.18p pd=1.72u as=97.2f ps=0.9u w=0.36u l=0.28u
X3737 VDD a_19668_3750# a_19802_4064# VDD pfet_03v3 ad=0.1764p pd=1.26u as=0.1584p ps=1.6u w=0.36u l=0.28u
X3738 a_21952_7670# a_21888_n708.t21 VDD VDD pfet_03v3 ad=0.2097p pd=1.38u as=0.3168p ps=2.32u w=0.72u l=0.28u
X3739 a_n1204_4534.t1 a_n1652_4534# VDD VDD pfet_03v3 ad=0.3302p pd=1.79u as=0.5588p ps=3.42u w=1.27u l=0.28u
X3740 a_9978_3470# a_9914_3156# a_9780_2966# VSS nfet_03v3 ad=56.7f pd=0.675u as=0.1278p ps=1.07u w=0.36u l=0.28u
X3741 VDD a_12008_n1782# a_12000_n708.t0 VDD pfet_03v3 ad=0.5456p pd=3.36u as=0.3224p ps=1.76u w=1.24u l=0.28u
X3742 VDD a_19668_614# a_19802_928# VDD pfet_03v3 ad=0.1764p pd=1.26u as=0.1584p ps=1.6u w=0.36u l=0.28u
X3743 a_12252_8454# a_n884_8454.t28 a_12064_8454# VDD pfet_03v3 ad=0.1278p pd=1.07u as=0.2097p ps=1.38u w=0.36u l=0.28u
X3744 a_21952_4534# a_21888_n708.t22 VDD VDD pfet_03v3 ad=0.2097p pd=1.38u as=0.3168p ps=2.32u w=0.72u l=0.28u
X3745 a_22338_7390# a_22274_7200# a_22140_6886# VDD pfet_03v3 ad=56.7f pd=0.675u as=0.1278p ps=1.07u w=0.36u l=0.28u
X3746 VDD a_n1204_2182.t25 a_24810_2686# VDD pfet_03v3 ad=0.1584p pd=1.6u as=56.7f ps=0.675u w=0.36u l=0.28u
X3747 a_6343_n2146.t26 a_6338_8800# a_5605_8454# VDD pfet_03v3 ad=0.1584p pd=1.6u as=0.1152p ps=1u w=0.36u l=0.28u
X3748 a_n1652_11246# WE0.t1 VSS VSS nfet_03v3 ad=0.1872p pd=1.24u as=0.3168p ps=2.32u w=0.72u l=0.28u
X3749 a_35269_10022# a_34500_10022# VDD VDD pfet_03v3 ad=0.36p pd=2.44u as=0.1764p ps=1.26u w=0.72u l=0.28u
X3750 a_38479_n2146.t26 RB8.t29 a_37741_4534# VSS nfet_03v3 ad=0.1584p pd=1.6u as=0.1152p ps=1u w=0.36u l=0.28u
X3751 a_22338_4254# a_22274_4064# a_22140_3750# VDD pfet_03v3 ad=56.7f pd=0.675u as=0.1278p ps=1.07u w=0.36u l=0.28u
X3752 a_34698_334# a_34634_20# a_34500_n170# VSS nfet_03v3 ad=56.7f pd=0.675u as=0.1278p ps=1.07u w=0.36u l=0.28u
X3753 a_17965_9238# RA2.t29 a_18433_n862.t21 VSS nfet_03v3 ad=0.1152p pd=1u as=0.1584p ps=1.6u w=0.36u l=0.28u
X3754 a_965_2274# RA11.t33 VSS VSS nfet_03v3 ad=0.1944p pd=1.8u as=0.1656p ps=1.64u w=0.36u l=0.28u
X3755 a_13759_n2146.t3 RB11.t33 a_13021_2182# VSS nfet_03v3 ad=0.1584p pd=1.6u as=0.1152p ps=1u w=0.36u l=0.28u
X3756 a_27853_2182# RA11.t34 a_28321_n862.t1 VSS nfet_03v3 ad=0.1152p pd=1u as=0.1584p ps=1.6u w=0.36u l=0.28u
X3757 a_22338_1118# a_22274_928# a_22140_614# VDD pfet_03v3 ad=56.7f pd=0.675u as=0.1278p ps=1.07u w=0.36u l=0.28u
X3758 a_13021_10022# a_13325_10114# a_13489_n862.t27 VDD pfet_03v3 ad=0.1152p pd=1u as=0.1584p ps=1.6u w=0.36u l=0.28u
X3759 a_5034_7390# a_4970_7200# a_4836_6886# VDD pfet_03v3 ad=56.7f pd=0.675u as=0.1278p ps=1.07u w=0.36u l=0.28u
X3760 a_17965_6102# RA6.t31 a_18433_n862.t15 VSS nfet_03v3 ad=0.1152p pd=1u as=0.1584p ps=1.6u w=0.36u l=0.28u
X3761 a_5034_4254# a_4970_4064# a_4836_3750# VDD pfet_03v3 ad=56.7f pd=0.675u as=0.1278p ps=1.07u w=0.36u l=0.28u
X3762 a_9592_1398# a_9528_n708.t24 VSS VSS nfet_03v3 ad=0.1188p pd=1.02u as=0.1584p ps=1.6u w=0.36u l=0.28u
X3763 a_30325_n954# RA15.t29 a_30793_n862.t10 VSS nfet_03v3 ad=0.1152p pd=1u as=0.1584p ps=1.6u w=0.36u l=0.28u
X3764 a_18269_7670# RA4.t29 VDD VDD pfet_03v3 ad=0.3888p pd=2.52u as=0.3312p ps=2.36u w=0.72u l=0.28u
X3765 VDD a_19668_10022# a_19802_10336# VDD pfet_03v3 ad=0.1764p pd=1.26u as=0.1584p ps=1.6u w=0.36u l=0.28u
X3766 a_20437_6886# a_19668_6886# VSS VSS nfet_03v3 ad=0.18p pd=1.72u as=97.2f ps=0.9u w=0.36u l=0.28u
X3767 a_18269_4534# RA8.t29 VDD VDD pfet_03v3 ad=0.3888p pd=2.52u as=0.3312p ps=2.36u w=0.72u l=0.28u
X3768 a_5034_1118# a_4970_928# a_4836_614# VDD pfet_03v3 ad=56.7f pd=0.675u as=0.1278p ps=1.07u w=0.36u l=0.28u
X3769 a_4648_6102# a_4584_n708.t27 VDD VDD pfet_03v3 ad=0.2097p pd=1.38u as=0.3168p ps=2.32u w=0.72u l=0.28u
X3770 a_33101_9238# RA2.t30 VSS VSS nfet_03v3 ad=0.1944p pd=1.8u as=0.1656p ps=1.64u w=0.36u l=0.28u
X3771 a_7120_8454# a_7056_n708.t21 VDD VDD pfet_03v3 ad=0.2097p pd=1.38u as=0.3168p ps=2.32u w=0.72u l=0.28u
X3772 a_27282_7670# a_27218_7860# a_27084_7670# VDD pfet_03v3 ad=56.7f pd=0.675u as=0.1278p ps=1.07u w=0.36u l=0.28u
X3773 VDD a_n1204_2966.t33 a_29754_2966# VDD pfet_03v3 ad=0.1584p pd=1.6u as=56.7f ps=0.675u w=0.36u l=0.28u
X3774 a_33101_6102# RA6.t32 VSS VSS nfet_03v3 ad=0.1944p pd=1.8u as=0.1656p ps=1.64u w=0.36u l=0.28u
X3775 a_30629_n170# RA14.t34 VSS VSS nfet_03v3 ad=0.1944p pd=1.8u as=0.1656p ps=1.64u w=0.36u l=0.28u
X3776 a_15493_7670# a_14724_7670# VSS VSS nfet_03v3 ad=0.18p pd=1.72u as=97.2f ps=0.9u w=0.36u l=0.28u
X3777 a_27282_4534# a_27218_4724# a_27084_4534# VDD pfet_03v3 ad=56.7f pd=0.675u as=0.1278p ps=1.07u w=0.36u l=0.28u
X3778 VSS a_14724_8454# a_14858_8768# VSS nfet_03v3 ad=97.2f pd=0.9u as=0.1584p ps=1.6u w=0.36u l=0.28u
X3779 a_15493_4534# a_14724_4534# VSS VSS nfet_03v3 ad=0.18p pd=1.72u as=97.2f ps=0.9u w=0.36u l=0.28u
X3780 a_16952_n1782# a_17456_n1738# a_17744_n1738# VDD pfet_03v3 ad=0.1278p pd=1.07u as=56.7f ps=0.675u w=0.36u l=0.28u
X3781 a_18703_n2146.t11 a_18698_10368# a_17965_10022# VDD pfet_03v3 ad=0.1584p pd=1.6u as=0.1152p ps=1u w=0.36u l=0.28u
X3782 VSS a_14724_5318# a_14858_5632# VSS nfet_03v3 ad=97.2f pd=0.9u as=0.1584p ps=1.6u w=0.36u l=0.28u
X3783 VSS RB3.t28 a_21170_8800# VSS nfet_03v3 ad=0.1584p pd=1.6u as=0.1854p ps=1.75u w=0.36u l=0.28u
X3784 a_13021_3750# RA9.t28 a_13489_n862.t8 VSS nfet_03v3 ad=0.1152p pd=1u as=0.1584p ps=1.6u w=0.36u l=0.28u
X3785 a_17394_n954# a_17330_n640# a_17196_n954# VSS nfet_03v3 ad=56.7f pd=0.675u as=0.1278p ps=1.07u w=0.36u l=0.28u
X3786 a_15797_10114# RA1.t37 VDD VDD pfet_03v3 ad=0.3888p pd=2.52u as=0.3312p ps=2.36u w=0.72u l=0.28u
X3787 VDD a_12252_9238# a_12386_9428# VDD pfet_03v3 ad=0.1764p pd=1.26u as=0.1584p ps=1.6u w=0.36u l=0.28u
X3788 a_29368_9238# a_29304_n708.t24 VDD VDD pfet_03v3 ad=0.2097p pd=1.38u as=0.3168p ps=2.32u w=0.72u l=0.28u
X3789 a_7506_3470# a_7442_3156# a_7308_2966# VSS nfet_03v3 ad=56.7f pd=0.675u as=0.1278p ps=1.07u w=0.36u l=0.28u
X3790 a_37741_n954# a_36972_n954# VDD.t2553 VDD.t2552 pfet_03v3 ad=0.36p pd=2.44u as=0.1764p ps=1.26u w=0.72u l=0.28u
X3791 VDD.t1239 a_n1204_n954.t25 a_14922_n450# VDD.t1238 pfet_03v3 ad=0.1584p pd=1.6u as=56.7f ps=0.675u w=0.36u l=0.28u
X3792 a_32797_n170# a_32028_n170# VSS VSS nfet_03v3 ad=0.18p pd=1.72u as=97.2f ps=0.9u w=0.36u l=0.28u
X3793 VDD a_n1204_8454.t28 a_n884_8454.t3 VDD pfet_03v3 ad=0.5896p pd=3.56u as=0.3886p ps=1.92u w=1.34u l=0.28u
X3794 a_32797_9238# a_32028_9238# VDD VDD pfet_03v3 ad=0.36p pd=2.44u as=0.1764p ps=1.26u w=0.72u l=0.28u
X3795 a_11287_n2146.t7 a_11282_7828# a_10549_7670# VDD pfet_03v3 ad=0.1584p pd=1.6u as=0.1152p ps=1u w=0.36u l=0.28u
X3796 a_10040_n1738# a_9536_n1782# VSS.t2853 VSS nfet_03v3 ad=0.1584p pd=1.6u as=0.1584p ps=1.6u w=0.36u l=0.28u
X3797 VDD a_n1204_5318.t26 a_n884_5318.t3 VDD pfet_03v3 ad=0.5896p pd=3.56u as=0.3886p ps=1.92u w=1.34u l=0.28u
X3798 a_4836_1398# a_n1204_1398.t26 a_4648_1398# VSS nfet_03v3 ad=0.1278p pd=1.07u as=0.1188p ps=1.02u w=0.36u l=0.28u
X3799 VDD RB1.t28 a_6338_10368# VDD pfet_03v3 ad=0.3168p pd=2.32u as=0.3708p ps=2.47u w=0.72u l=0.28u
X3800 a_661_7670# a_n108_7670# VDD VDD pfet_03v3 ad=0.36p pd=2.44u as=0.1764p ps=1.26u w=0.72u l=0.28u
X3801 a_11287_n2146.t19 a_11282_4692# a_10549_4534# VDD pfet_03v3 ad=0.1584p pd=1.6u as=0.1152p ps=1u w=0.36u l=0.28u
X3802 VSS a_2364_2182# a_2498_2496# VSS nfet_03v3 ad=97.2f pd=0.9u as=0.1584p ps=1.6u w=0.36u l=0.28u
X3803 a_33535_n2146.t6 a_33530_n608# a_32797_n954# VDD.t2019 pfet_03v3 ad=0.1584p pd=1.6u as=0.1152p ps=1u w=0.36u l=0.28u
X3804 VSS a_n884_n170.t30 a_34698_334# VSS nfet_03v3 ad=0.1584p pd=1.6u as=56.7f ps=0.675u w=0.36u l=0.28u
X3805 VSS a_n884_9238.t23 a_12450_9742# VSS nfet_03v3 ad=0.1584p pd=1.6u as=56.7f ps=0.675u w=0.36u l=0.28u
X3806 a_n296_7670# a_n360_n708.t22 VSS VSS nfet_03v3 ad=0.1188p pd=1.02u as=0.1584p ps=1.6u w=0.36u l=0.28u
X3807 a_661_4534# a_n108_4534# VDD VDD pfet_03v3 ad=0.36p pd=2.44u as=0.1764p ps=1.26u w=0.72u l=0.28u
X3808 VSS a_22140_1398# a_22274_1588# VSS nfet_03v3 ad=97.2f pd=0.9u as=0.1584p ps=1.6u w=0.36u l=0.28u
X3809 a_n296_4534# a_n360_n708.t23 VSS VSS nfet_03v3 ad=0.1188p pd=1.02u as=0.1584p ps=1.6u w=0.36u l=0.28u
X3810 a_1399_n2146.t28 a_1394_n608# a_661_n954# VDD.t3204 pfet_03v3 ad=0.1584p pd=1.6u as=0.1152p ps=1u w=0.36u l=0.28u
X3811 VSS a_n884_6102.t20 a_12450_6606# VSS nfet_03v3 ad=0.1584p pd=1.6u as=56.7f ps=0.675u w=0.36u l=0.28u
X3812 a_33535_n2146.t12 RB14.t35 a_32797_n170# VSS nfet_03v3 ad=0.1584p pd=1.6u as=0.1152p ps=1u w=0.36u l=0.28u
X3813 a_14922_8958# a_14858_8768# a_14724_8454# VDD pfet_03v3 ad=56.7f pd=0.675u as=0.1278p ps=1.07u w=0.36u l=0.28u
X3814 a_30325_8454# a_30629_8546# a_30793_n862.t30 VDD pfet_03v3 ad=0.1152p pd=1u as=0.1584p ps=1.6u w=0.36u l=0.28u
X3815 a_7120_1398# a_7056_n708.t22 VSS VSS nfet_03v3 ad=0.1188p pd=1.02u as=0.1584p ps=1.6u w=0.36u l=0.28u
X3816 a_27084_n954# a_n1204_n954.t26 a_26896_n954# VSS nfet_03v3 ad=0.1278p pd=1.07u as=0.1188p ps=1.02u w=0.36u l=0.28u
X3817 VDD RB10.t34 a_18698_3124# VDD pfet_03v3 ad=0.3168p pd=2.32u as=0.3708p ps=2.47u w=0.72u l=0.28u
X3818 a_12008_n1782# a_12512_n1738# a_12800_n1234# VSS nfet_03v3 ad=0.1278p pd=1.07u as=56.7f ps=0.675u w=0.36u l=0.28u
X3819 VDD RB12.t32 a_11282_1556# VDD pfet_03v3 ad=0.3168p pd=2.32u as=0.3708p ps=2.47u w=0.72u l=0.28u
X3820 a_965_2966# RA10.t28 VSS VSS nfet_03v3 ad=0.1944p pd=1.8u as=0.1656p ps=1.64u w=0.36u l=0.28u
X3821 a_13759_n2146.t11 RB10.t35 a_13021_2966# VSS nfet_03v3 ad=0.1584p pd=1.6u as=0.1152p ps=1u w=0.36u l=0.28u
X3822 a_27853_2966# RA10.t29 a_28321_n862.t6 VSS nfet_03v3 ad=0.1152p pd=1u as=0.1584p ps=1.6u w=0.36u l=0.28u
X3823 VDD a_n1204_2966.t34 a_27282_2966# VDD pfet_03v3 ad=0.1584p pd=1.6u as=56.7f ps=0.675u w=0.36u l=0.28u
X3824 a_965_706# RA13.t30 VSS VSS nfet_03v3 ad=0.1944p pd=1.8u as=0.1656p ps=1.64u w=0.36u l=0.28u
X3825 VSS a_34500_2966# a_34634_3156# VSS nfet_03v3 ad=97.2f pd=0.9u as=0.1584p ps=1.6u w=0.36u l=0.28u
X3826 a_90_8454# a_26_8768# a_n108_8454# VSS nfet_03v3 ad=56.7f pd=0.675u as=0.1278p ps=1.07u w=0.36u l=0.28u
X3827 VSS a_27084_10806# a_27218_10996# VSS nfet_03v3 ad=97.2f pd=0.9u as=0.1584p ps=1.6u w=0.36u l=0.28u
X3828 a_13021_9238# a_13325_9238# a_13489_n862.t19 VDD pfet_03v3 ad=0.1152p pd=1u as=0.1584p ps=1.6u w=0.36u l=0.28u
X3829 a_35573_n862# RA15.t30 VDD.t454 VDD.t453 pfet_03v3 ad=0.3888p pd=2.52u as=0.3312p ps=2.36u w=0.72u l=0.28u
X3830 VDD a_36972_10806# a_37106_10996# VDD pfet_03v3 ad=0.1764p pd=1.26u as=0.1584p ps=1.6u w=0.36u l=0.28u
X3831 a_90_5318# a_26_5632# a_n108_5318# VSS nfet_03v3 ad=56.7f pd=0.675u as=0.1278p ps=1.07u w=0.36u l=0.28u
X3832 a_24424_10022# a_24360_n708.t28 VDD VDD pfet_03v3 ad=0.2097p pd=1.38u as=0.3168p ps=2.32u w=0.72u l=0.28u
X3833 QB9b.t0 a_23647_n2146.t33 VDD VDD pfet_03v3 ad=0.4104p pd=2.58u as=0.2484p ps=1.41u w=0.72u l=0.28u
X3834 VDD a_13489_n862.t33 QA5b.t0 VDD pfet_03v3 ad=0.2484p pd=1.41u as=0.4104p ps=2.58u w=0.72u l=0.28u
X3835 a_3871_n2146.t11 RB14.t36 a_3133_n170# VSS nfet_03v3 ad=0.1584p pd=1.6u as=0.1152p ps=1u w=0.36u l=0.28u
X3836 a_29754_11310# a_29690_10996# a_29556_10806# VSS nfet_03v3 ad=56.7f pd=0.675u as=0.1278p ps=1.07u w=0.36u l=0.28u
X3837 a_28591_n2146.t2 RB4.t28 a_27853_7670# VSS nfet_03v3 ad=0.1584p pd=1.6u as=0.1152p ps=1u w=0.36u l=0.28u
X3838 a_4648_3750# a_4584_n708.t28 VSS VSS nfet_03v3 ad=0.1188p pd=1.02u as=0.1584p ps=1.6u w=0.36u l=0.28u
X3839 a_7308_10806# WE0CLK.t31 a_7120_10806# VSS nfet_03v3 ad=0.1278p pd=1.07u as=0.1188p ps=1.02u w=0.36u l=0.28u
X3840 a_20437_6102# a_20741_6102# a_20905_n862.t31 VDD pfet_03v3 ad=0.1152p pd=1u as=0.1584p ps=1.6u w=0.36u l=0.28u
X3841 VSS a_n884_10022.t25 a_32226_10022# VSS nfet_03v3 ad=0.1584p pd=1.6u as=56.7f ps=0.675u w=0.36u l=0.28u
X3842 a_24612_8454# a_n884_8454.t29 a_24424_8454# VDD pfet_03v3 ad=0.1278p pd=1.07u as=0.2097p ps=1.38u w=0.36u l=0.28u
X3843 a_21952_3750# a_21888_n708.t23 VDD VDD pfet_03v3 ad=0.2097p pd=1.38u as=0.3168p ps=2.32u w=0.72u l=0.28u
X3844 a_34698_7390# a_34634_7200# a_34500_6886# VDD pfet_03v3 ad=56.7f pd=0.675u as=0.1278p ps=1.07u w=0.36u l=0.28u
X3845 a_2364_2966# a_n884_2966.t22 a_2176_2966# VDD pfet_03v3 ad=0.1278p pd=1.07u as=0.2097p ps=1.38u w=0.36u l=0.28u
X3846 a_21952_614# a_21888_n708.t24 VDD VDD pfet_03v3 ad=0.2097p pd=1.38u as=0.3168p ps=2.32u w=0.72u l=0.28u
X3847 a_90_10022# a_26_10336# a_n108_10022# VSS nfet_03v3 ad=56.7f pd=0.675u as=0.1278p ps=1.07u w=0.36u l=0.28u
X3848 a_13021_4534# RA8.t30 a_13489_n862.t3 VSS nfet_03v3 ad=0.1152p pd=1u as=0.1584p ps=1.6u w=0.36u l=0.28u
X3849 a_34698_4254# a_34634_4064# a_34500_3750# VDD pfet_03v3 ad=56.7f pd=0.675u as=0.1278p ps=1.07u w=0.36u l=0.28u
X3850 VSS a_n884_n170.t31 a_22338_334# VSS nfet_03v3 ad=0.1584p pd=1.6u as=56.7f ps=0.675u w=0.36u l=0.28u
X3851 a_32028_5318# a_n884_5318.t28 a_31840_5318# VDD pfet_03v3 ad=0.1278p pd=1.07u as=0.2097p ps=1.38u w=0.36u l=0.28u
X3852 VSS a_32028_2182# a_32162_2496# VSS nfet_03v3 ad=97.2f pd=0.9u as=0.1584p ps=1.6u w=0.36u l=0.28u
X3853 a_34698_1118# a_34634_928# a_34500_614# VDD pfet_03v3 ad=56.7f pd=0.675u as=0.1278p ps=1.07u w=0.36u l=0.28u
X3854 VDD a_9780_8454# a_9914_8768# VDD pfet_03v3 ad=0.1764p pd=1.26u as=0.1584p ps=1.6u w=0.36u l=0.28u
X3855 VDD a_30793_n862.t33 QA12b.t0 VDD pfet_03v3 ad=0.2484p pd=1.41u as=0.4104p ps=2.58u w=0.72u l=0.28u
X3856 VSS a_n884_9238.t24 a_9978_9742# VSS nfet_03v3 ad=0.1584p pd=1.6u as=56.7f ps=0.675u w=0.36u l=0.28u
X3857 a_9592_9238# a_9528_n708.t25 VDD VDD pfet_03v3 ad=0.2097p pd=1.38u as=0.3168p ps=2.32u w=0.72u l=0.28u
X3858 VSS a_12252_6886# a_12386_7200# VSS nfet_03v3 ad=97.2f pd=0.9u as=0.1584p ps=1.6u w=0.36u l=0.28u
X3859 a_31063_n2146.t30 a_31058_n608# a_30325_n954# VDD.t3351 pfet_03v3 ad=0.1584p pd=1.6u as=0.1152p ps=1u w=0.36u l=0.28u
X3860 a_29556_10022# a_n1204_10022.t28 a_29368_10022# VSS nfet_03v3 ad=0.1278p pd=1.07u as=0.1188p ps=1.02u w=0.36u l=0.28u
X3861 a_26119_n2146.t18 a_26114_6260# a_25381_6102# VDD pfet_03v3 ad=0.1584p pd=1.6u as=0.1152p ps=1u w=0.36u l=0.28u
X3862 a_13325_2966# RA10.t30 VDD VDD pfet_03v3 ad=0.3888p pd=2.52u as=0.3312p ps=2.36u w=0.72u l=0.28u
X3863 a_29368_6886# a_29304_n708.t25 VSS VSS nfet_03v3 ad=0.1188p pd=1.02u as=0.1584p ps=1.6u w=0.36u l=0.28u
X3864 VSS a_n884_6102.t21 a_9978_6606# VSS nfet_03v3 ad=0.1584p pd=1.6u as=56.7f ps=0.675u w=0.36u l=0.28u
X3865 a_20437_1398# RA12.t34 a_20905_n862.t9 VSS nfet_03v3 ad=0.1152p pd=1u as=0.1584p ps=1.6u w=0.36u l=0.28u
X3866 a_32797_6886# a_32028_6886# VSS VSS nfet_03v3 ad=0.18p pd=1.72u as=97.2f ps=0.9u w=0.36u l=0.28u
X3867 a_12252_10806# WE0CLK.t32 a_12064_10806# VSS nfet_03v3 ad=0.1278p pd=1.07u as=0.1188p ps=1.02u w=0.36u l=0.28u
X3868 VSS a_9780_10022# a_9914_10336# VSS nfet_03v3 ad=97.2f pd=0.9u as=0.1584p ps=1.6u w=0.36u l=0.28u
X3869 a_18269_3842# RA9.t29 VDD VDD pfet_03v3 ad=0.3888p pd=2.52u as=0.3312p ps=2.36u w=0.72u l=0.28u
X3870 a_22140_10806# a_n884_10806.t28 a_21952_10806# VDD pfet_03v3 ad=0.1278p pd=1.07u as=0.2097p ps=1.38u w=0.36u l=0.28u
X3871 a_12450_8958# a_12386_8768# a_12252_8454# VDD pfet_03v3 ad=56.7f pd=0.675u as=0.1278p ps=1.07u w=0.36u l=0.28u
X3872 a_14724_6102# a_n884_6102.t22 a_14536_6102# VDD pfet_03v3 ad=0.1278p pd=1.07u as=0.2097p ps=1.38u w=0.36u l=0.28u
X3873 a_33101_10114# RA1.t38 VSS VSS nfet_03v3 ad=0.1944p pd=1.8u as=0.1656p ps=1.64u w=0.36u l=0.28u
X3874 a_8815_n2146.t24 a_8810_6260# a_8077_6102# VDD pfet_03v3 ad=0.1584p pd=1.6u as=0.1152p ps=1u w=0.36u l=0.28u
X3875 a_18269_706# RA13.t31 VDD VDD pfet_03v3 ad=0.3888p pd=2.52u as=0.3312p ps=2.36u w=0.72u l=0.28u
X3876 a_17008_6886# a_16944_n708.t27 VDD VDD pfet_03v3 ad=0.2097p pd=1.38u as=0.3168p ps=2.32u w=0.72u l=0.28u
X3877 VSS a_27084_8454# a_27218_8768# VSS nfet_03v3 ad=97.2f pd=0.9u as=0.1584p ps=1.6u w=0.36u l=0.28u
X3878 VSS RB1.t29 a_21170_10368# VSS nfet_03v3 ad=0.1584p pd=1.6u as=0.1854p ps=1.75u w=0.36u l=0.28u
X3879 a_661_6886# a_965_6978# a_1129_n862.t31 VDD pfet_03v3 ad=0.1152p pd=1u as=0.1584p ps=1.6u w=0.36u l=0.28u
X3880 a_30104_n1738# WEM.t22 VDD VDD pfet_03v3 ad=56.7f pd=0.675u as=0.1584p ps=1.6u w=0.36u l=0.28u
X3881 VSS a_29556_n170# a_29690_20# VSS nfet_03v3 ad=97.2f pd=0.9u as=0.1584p ps=1.6u w=0.36u l=0.28u
X3882 VSS a_27084_5318# a_27218_5632# VSS nfet_03v3 ad=97.2f pd=0.9u as=0.1584p ps=1.6u w=0.36u l=0.28u
X3883 a_661_3750# a_965_3842# a_1129_n862.t10 VDD pfet_03v3 ad=0.1152p pd=1u as=0.1584p ps=1.6u w=0.36u l=0.28u
X3884 a_25381_3750# RA9.t30 a_25849_n862.t8 VSS nfet_03v3 ad=0.1152p pd=1u as=0.1584p ps=1.6u w=0.36u l=0.28u
X3885 a_10549_n954# RA15.t31 a_11017_n862.t10 VSS nfet_03v3 ad=0.1152p pd=1u as=0.1584p ps=1.6u w=0.36u l=0.28u
X3886 a_26119_n2146.t5 RB12.t33 a_25381_1398# VSS nfet_03v3 ad=0.1584p pd=1.6u as=0.1152p ps=1u w=0.36u l=0.28u
X3887 a_10549_10022# a_9780_10022# VSS VSS nfet_03v3 ad=0.18p pd=1.72u as=97.2f ps=0.9u w=0.36u l=0.28u
X3888 VSS RB3.t29 a_33530_8800# VSS nfet_03v3 ad=0.1584p pd=1.6u as=0.1854p ps=1.75u w=0.36u l=0.28u
X3889 a_33101_n862# RA15.t32 VDD.t456 VDD.t455 pfet_03v3 ad=0.3888p pd=2.52u as=0.3312p ps=2.36u w=0.72u l=0.28u
X3890 VDD a_29556_6886# a_29690_7200# VDD pfet_03v3 ad=0.1764p pd=1.26u as=0.1584p ps=1.6u w=0.36u l=0.28u
X3891 a_661_614# a_965_706# a_1129_n862.t27 VDD pfet_03v3 ad=0.1152p pd=1u as=0.1584p ps=1.6u w=0.36u l=0.28u
X3892 VDD a_29556_3750# a_29690_4064# VDD pfet_03v3 ad=0.1764p pd=1.26u as=0.1584p ps=1.6u w=0.36u l=0.28u
X3893 VDD a_n1204_2966.t35 a_7506_2966# VDD pfet_03v3 ad=0.1584p pd=1.6u as=56.7f ps=0.675u w=0.36u l=0.28u
X3894 VDD RB0.t30 a_26114_10964# VDD pfet_03v3 ad=0.3168p pd=2.32u as=0.3708p ps=2.47u w=0.72u l=0.28u
X3895 a_31840_7670# a_31776_n708.t21 VDD VDD pfet_03v3 ad=0.2097p pd=1.38u as=0.3168p ps=2.32u w=0.72u l=0.28u
X3896 a_29368_10806# a_29304_n708.t26 VSS VSS nfet_03v3 ad=0.1188p pd=1.02u as=0.1584p ps=1.6u w=0.36u l=0.28u
X3897 a_8815_n2146.t2 RB12.t34 a_8077_1398# VSS nfet_03v3 ad=0.1584p pd=1.6u as=0.1152p ps=1u w=0.36u l=0.28u
X3898 a_20533_n1738# a_n884_n1738.t23 a_19424_n1782# VDD pfet_03v3 ad=0.2097p pd=1.38u as=0.1278p ps=1.07u w=0.36u l=0.28u
X3899 VDD a_29556_614# a_29690_928# VDD pfet_03v3 ad=0.1764p pd=1.26u as=0.1584p ps=1.6u w=0.36u l=0.28u
X3900 a_4836_9238# a_n884_9238.t25 a_4648_9238# VDD pfet_03v3 ad=0.1278p pd=1.07u as=0.2097p ps=1.38u w=0.36u l=0.28u
X3901 a_23647_n2146.t15 a_23642_7828# a_22909_7670# VDD pfet_03v3 ad=0.1584p pd=1.6u as=0.1152p ps=1u w=0.36u l=0.28u
X3902 a_31840_4534# a_31776_n708.t22 VDD VDD pfet_03v3 ad=0.2097p pd=1.38u as=0.3168p ps=2.32u w=0.72u l=0.28u
X3903 a_22140_8454# a_n884_8454.t30 a_21952_8454# VDD pfet_03v3 ad=0.1278p pd=1.07u as=0.2097p ps=1.38u w=0.36u l=0.28u
X3904 a_32226_7390# a_32162_7200# a_32028_6886# VDD pfet_03v3 ad=56.7f pd=0.675u as=0.1278p ps=1.07u w=0.36u l=0.28u
X3905 a_30325_5318# a_29556_5318# VDD VDD pfet_03v3 ad=0.36p pd=2.44u as=0.1764p ps=1.26u w=0.72u l=0.28u
X3906 VDD a_n1204_2182.t26 a_34698_2686# VDD pfet_03v3 ad=0.1584p pd=1.6u as=56.7f ps=0.675u w=0.36u l=0.28u
X3907 VDD a_2364_10806# a_2498_10996# VDD pfet_03v3 ad=0.1764p pd=1.26u as=0.1584p ps=1.6u w=0.36u l=0.28u
X3908 VDD a_22140_9238# a_22274_9428# VDD pfet_03v3 ad=0.1764p pd=1.26u as=0.1584p ps=1.6u w=0.36u l=0.28u
X3909 a_23647_n2146.t10 a_23642_4692# a_22909_4534# VDD pfet_03v3 ad=0.1584p pd=1.6u as=0.1152p ps=1u w=0.36u l=0.28u
X3910 a_32226_4254# a_32162_4064# a_32028_3750# VDD pfet_03v3 ad=56.7f pd=0.675u as=0.1278p ps=1.07u w=0.36u l=0.28u
X3911 a_30325_2182# a_29556_2182# VDD VDD pfet_03v3 ad=0.36p pd=2.44u as=0.1764p ps=1.26u w=0.72u l=0.28u
X3912 a_n1652_1398# WE12.t0 VDD VDD pfet_03v3 ad=0.1872p pd=1.24u as=0.3168p ps=2.32u w=0.72u l=0.28u
X3913 a_13021_9238# a_12252_9238# VSS VSS nfet_03v3 ad=0.18p pd=1.72u as=97.2f ps=0.9u w=0.36u l=0.28u
X3914 VDD a_26840_n1782# a_26832_n708.t0 VDD pfet_03v3 ad=0.5456p pd=3.36u as=0.3224p ps=1.76u w=1.24u l=0.28u
X3915 a_15797_n862# RA15.t33 VSS.t496 VSS nfet_03v3 ad=0.1944p pd=1.8u as=0.1656p ps=1.64u w=0.36u l=0.28u
X3916 a_n1204_n954.t3 a_n1652_n522# VSS.t1267 VSS nfet_03v3 ad=0.1651p pd=1.155u as=0.2794p ps=2.15u w=0.635u l=0.28u
X3917 a_5034_10806# a_4970_10996# a_4836_10806# VDD pfet_03v3 ad=56.7f pd=0.675u as=0.1278p ps=1.07u w=0.36u l=0.28u
X3918 a_13021_6102# a_12252_6102# VSS VSS nfet_03v3 ad=0.18p pd=1.72u as=97.2f ps=0.9u w=0.36u l=0.28u
X3919 a_8077_5318# RA7.t33 a_8545_n862.t12 VSS nfet_03v3 ad=0.1152p pd=1u as=0.1584p ps=1.6u w=0.36u l=0.28u
X3920 a_661_3750# a_n108_3750# VDD VDD pfet_03v3 ad=0.36p pd=2.44u as=0.1764p ps=1.26u w=0.72u l=0.28u
X3921 a_21952_n954# a_21888_n708.t25 VSS.t1231 VSS nfet_03v3 ad=0.1188p pd=1.02u as=0.1584p ps=1.6u w=0.36u l=0.28u
X3922 a_32226_1118# a_32162_928# a_32028_614# VDD pfet_03v3 ad=56.7f pd=0.675u as=0.1278p ps=1.07u w=0.36u l=0.28u
X3923 a_7120_9238# a_7056_n708.t23 VDD VDD pfet_03v3 ad=0.2097p pd=1.38u as=0.3168p ps=2.32u w=0.72u l=0.28u
X3924 a_19668_7670# a_n1204_7670.t27 a_19480_7670# VSS nfet_03v3 ad=0.1278p pd=1.07u as=0.1188p ps=1.02u w=0.36u l=0.28u
X3925 VSS a_2364_1398# a_2498_1588# VSS nfet_03v3 ad=97.2f pd=0.9u as=0.1584p ps=1.6u w=0.36u l=0.28u
X3926 a_661_614# a_n108_614# VDD VDD pfet_03v3 ad=0.36p pd=2.44u as=0.1764p ps=1.26u w=0.72u l=0.28u
X3927 a_28157_7670# RA4.t30 VDD VDD pfet_03v3 ad=0.3888p pd=2.52u as=0.3312p ps=2.36u w=0.72u l=0.28u
X3928 a_19668_4534# a_n1204_4534.t28 a_19480_4534# VSS nfet_03v3 ad=0.1278p pd=1.07u as=0.1188p ps=1.02u w=0.36u l=0.28u
X3929 VDD.t1493 RB14.t37 a_11282_n12# VDD.t746 pfet_03v3 ad=0.3168p pd=2.32u as=0.3708p ps=2.47u w=0.72u l=0.28u
X3930 a_28157_4534# RA8.t31 VDD VDD pfet_03v3 ad=0.3888p pd=2.52u as=0.3312p ps=2.36u w=0.72u l=0.28u
X3931 VDD RB12.t35 a_23642_1556# VDD pfet_03v3 ad=0.3168p pd=2.32u as=0.3708p ps=2.47u w=0.72u l=0.28u
X3932 a_12252_6102# a_n884_6102.t23 a_12064_6102# VDD pfet_03v3 ad=0.1278p pd=1.07u as=0.2097p ps=1.38u w=0.36u l=0.28u
X3933 a_27853_2966# a_27084_2966# VDD VDD pfet_03v3 ad=0.36p pd=2.44u as=0.1764p ps=1.26u w=0.72u l=0.28u
X3934 a_37170_7670# a_37106_7860# a_36972_7670# VDD pfet_03v3 ad=56.7f pd=0.675u as=0.1278p ps=1.07u w=0.36u l=0.28u
X3935 a_6343_n2146.t21 a_6338_6260# a_5605_6102# VDD pfet_03v3 ad=0.1584p pd=1.6u as=0.1152p ps=1u w=0.36u l=0.28u
X3936 a_9592_6886# a_9528_n708.t26 VSS VSS nfet_03v3 ad=0.1188p pd=1.02u as=0.1584p ps=1.6u w=0.36u l=0.28u
X3937 a_14536_6886# a_14472_n708.t28 VDD VDD pfet_03v3 ad=0.2097p pd=1.38u as=0.3168p ps=2.32u w=0.72u l=0.28u
X3938 a_15493_6886# RA5.t32 a_15961_n862.t20 VSS nfet_03v3 ad=0.1152p pd=1u as=0.1584p ps=1.6u w=0.36u l=0.28u
X3939 a_37170_4534# a_37106_4724# a_36972_4534# VDD pfet_03v3 ad=56.7f pd=0.675u as=0.1278p ps=1.07u w=0.36u l=0.28u
X3940 a_25381_9238# a_25685_9238# a_25849_n862.t20 VDD pfet_03v3 ad=0.1152p pd=1u as=0.1584p ps=1.6u w=0.36u l=0.28u
X3941 a_25381_7670# a_24612_7670# VSS VSS nfet_03v3 ad=0.18p pd=1.72u as=97.2f ps=0.9u w=0.36u l=0.28u
X3942 a_12064_10022# a_12000_n708.t20 VSS VSS nfet_03v3 ad=0.1188p pd=1.02u as=0.1584p ps=1.6u w=0.36u l=0.28u
X3943 VSS a_24612_8454# a_24746_8768# VSS nfet_03v3 ad=97.2f pd=0.9u as=0.1584p ps=1.6u w=0.36u l=0.28u
X3944 a_25381_4534# a_24612_4534# VSS VSS nfet_03v3 ad=0.18p pd=1.72u as=97.2f ps=0.9u w=0.36u l=0.28u
X3945 a_37170_10526# a_37106_10336# a_36972_10022# VDD pfet_03v3 ad=56.7f pd=0.675u as=0.1278p ps=1.07u w=0.36u l=0.28u
X3946 a_10549_8454# a_10853_8546# a_11017_n862.t19 VDD pfet_03v3 ad=0.1152p pd=1u as=0.1584p ps=1.6u w=0.36u l=0.28u
X3947 VSS a_24612_5318# a_24746_5632# VSS nfet_03v3 ad=97.2f pd=0.9u as=0.1584p ps=1.6u w=0.36u l=0.28u
X3948 a_22909_3750# RA9.t31 a_23377_n862.t2 VSS nfet_03v3 ad=0.1152p pd=1u as=0.1584p ps=1.6u w=0.36u l=0.28u
X3949 a_17394_2182# a_17330_2496# a_17196_2182# VSS nfet_03v3 ad=56.7f pd=0.675u as=0.1278p ps=1.07u w=0.36u l=0.28u
X3950 a_35573_n170# RA14.t35 VSS VSS nfet_03v3 ad=0.1944p pd=1.8u as=0.1656p ps=1.64u w=0.36u l=0.28u
X3951 a_9978_334# a_9914_20# a_9780_n170# VSS nfet_03v3 ad=56.7f pd=0.675u as=0.1278p ps=1.07u w=0.36u l=0.28u
X3952 a_33101_10806# RA0.t38 VSS VSS nfet_03v3 ad=0.1944p pd=1.8u as=0.1656p ps=1.64u w=0.36u l=0.28u
X3953 a_14724_3750# a_n1204_3750.t27 a_14536_3750# VSS nfet_03v3 ad=0.1278p pd=1.07u as=0.1188p ps=1.02u w=0.36u l=0.28u
X3954 a_19416_n708.t2 a_19424_n1782# VSS.t2809 VSS nfet_03v3 ad=0.1612p pd=1.14u as=0.2728p ps=2.12u w=0.62u l=0.28u
X3955 VDD a_n1204_2966.t36 a_5034_2966# VDD pfet_03v3 ad=0.1584p pd=1.6u as=56.7f ps=0.675u w=0.36u l=0.28u
X3956 a_27282_n954# a_27218_n640# a_27084_n954# VSS nfet_03v3 ad=56.7f pd=0.675u as=0.1278p ps=1.07u w=0.36u l=0.28u
X3957 VSS RB1.t30 a_16226_10368# VSS nfet_03v3 ad=0.1584p pd=1.6u as=0.1854p ps=1.75u w=0.36u l=0.28u
X3958 VSS a_7308_8454# a_7442_8768# VSS nfet_03v3 ad=97.2f pd=0.9u as=0.1584p ps=1.6u w=0.36u l=0.28u
X3959 a_36972_8454# a_n884_8454.t31 a_36784_8454# VDD pfet_03v3 ad=0.1278p pd=1.07u as=0.2097p ps=1.38u w=0.36u l=0.28u
X3960 VSS RB0.t31 a_21170_10964# VSS nfet_03v3 ad=0.1584p pd=1.6u as=0.1854p ps=1.75u w=0.36u l=0.28u
X3961 VSS a_7308_5318# a_7442_5632# VSS nfet_03v3 ad=97.2f pd=0.9u as=0.1584p ps=1.6u w=0.36u l=0.28u
X3962 a_6343_n2146.t6 RB12.t36 a_5605_1398# VSS nfet_03v3 ad=0.1584p pd=1.6u as=0.1152p ps=1u w=0.36u l=0.28u
X3963 VDD.t1241 a_n1204_n954.t27 a_24810_n450# VDD.t1240 pfet_03v3 ad=0.1584p pd=1.6u as=56.7f ps=0.675u w=0.36u l=0.28u
X3964 a_n108_9238# a_n1204_9238.t34 a_n296_9238# VSS nfet_03v3 ad=0.1278p pd=1.07u as=0.1188p ps=1.02u w=0.36u l=0.28u
X3965 a_21175_n2146.t31 a_21170_7828# a_20437_7670# VDD pfet_03v3 ad=0.1584p pd=1.6u as=0.1152p ps=1u w=0.36u l=0.28u
X3966 a_25381_4534# RA8.t32 a_25849_n862.t4 VSS nfet_03v3 ad=0.1152p pd=1u as=0.1584p ps=1.6u w=0.36u l=0.28u
X3967 a_8077_1398# a_7308_1398# VDD VDD pfet_03v3 ad=0.36p pd=2.44u as=0.1764p ps=1.26u w=0.72u l=0.28u
X3968 a_n108_6102# a_n1204_6102.t32 a_n296_6102# VSS nfet_03v3 ad=0.1278p pd=1.07u as=0.1188p ps=1.02u w=0.36u l=0.28u
X3969 a_37741_5318# RA7.t34 a_38209_n862.t13 VSS nfet_03v3 ad=0.1152p pd=1u as=0.1584p ps=1.6u w=0.36u l=0.28u
X3970 a_21175_n2146.t25 a_21170_4692# a_20437_4534# VDD pfet_03v3 ad=0.1584p pd=1.6u as=0.1152p ps=1u w=0.36u l=0.28u
X3971 a_10549_9238# a_9780_9238# VSS VSS nfet_03v3 ad=0.18p pd=1.72u as=97.2f ps=0.9u w=0.36u l=0.28u
X3972 VSS a_n884_9238.t26 a_22338_9742# VSS nfet_03v3 ad=0.1584p pd=1.6u as=56.7f ps=0.675u w=0.36u l=0.28u
X3973 VSS a_32028_1398# a_32162_1588# VSS nfet_03v3 ad=97.2f pd=0.9u as=0.1584p ps=1.6u w=0.36u l=0.28u
X3974 VSS a_n884_10806.t29 a_90_11310# VSS nfet_03v3 ad=0.1584p pd=1.6u as=56.7f ps=0.675u w=0.36u l=0.28u
X3975 a_5605_5318# RA7.t35 a_6073_n862.t2 VSS nfet_03v3 ad=0.1152p pd=1u as=0.1584p ps=1.6u w=0.36u l=0.28u
X3976 a_25685_2966# RA10.t31 VDD VDD pfet_03v3 ad=0.3888p pd=2.52u as=0.3312p ps=2.36u w=0.72u l=0.28u
X3977 a_36720_n708.t0 a_36728_n1782# VSS.t1977 VSS nfet_03v3 ad=0.1612p pd=1.14u as=0.2728p ps=2.12u w=0.62u l=0.28u
X3978 a_5909_n170# RA14.t36 VSS VSS nfet_03v3 ad=0.1944p pd=1.8u as=0.1656p ps=1.64u w=0.36u l=0.28u
X3979 a_10549_6102# a_9780_6102# VSS VSS nfet_03v3 ad=0.18p pd=1.72u as=97.2f ps=0.9u w=0.36u l=0.28u
X3980 VSS a_n884_6102.t24 a_22338_6606# VSS nfet_03v3 ad=0.1584p pd=1.6u as=56.7f ps=0.675u w=0.36u l=0.28u
X3981 VDD a_n1204_5318.t27 a_19866_5822# VDD pfet_03v3 ad=0.1584p pd=1.6u as=56.7f ps=0.675u w=0.36u l=0.28u
X3982 a_27084_2182# a_n1204_2182.t27 a_26896_2182# VSS nfet_03v3 ad=0.1278p pd=1.07u as=0.1188p ps=1.02u w=0.36u l=0.28u
X3983 a_17196_7670# a_n1204_7670.t28 a_17008_7670# VSS nfet_03v3 ad=0.1278p pd=1.07u as=0.1188p ps=1.02u w=0.36u l=0.28u
X3984 a_4836_6886# a_n1204_6886.t31 a_4648_6886# VSS nfet_03v3 ad=0.1278p pd=1.07u as=0.1188p ps=1.02u w=0.36u l=0.28u
X3985 a_90_334# a_26_20# a_n108_n170# VSS nfet_03v3 ad=56.7f pd=0.675u as=0.1278p ps=1.07u w=0.36u l=0.28u
X3986 a_17196_4534# a_n1204_4534.t29 a_17008_4534# VSS nfet_03v3 ad=0.1278p pd=1.07u as=0.1188p ps=1.02u w=0.36u l=0.28u
X3987 a_5701_n1738# WEM.t23 a_4592_n1782# VSS nfet_03v3 ad=0.1188p pd=1.02u as=0.1278p ps=1.07u w=0.36u l=0.28u
X3988 a_5034_334# a_4970_20# a_4836_n170# VSS nfet_03v3 ad=56.7f pd=0.675u as=0.1278p ps=1.07u w=0.36u l=0.28u
X3989 a_24810_8958# a_24746_8768# a_24612_8454# VDD pfet_03v3 ad=56.7f pd=0.675u as=0.1278p ps=1.07u w=0.36u l=0.28u
X3990 a_3871_n2146.t16 RB11.t34 a_3133_2182# VSS nfet_03v3 ad=0.1584p pd=1.6u as=0.1152p ps=1u w=0.36u l=0.28u
X3991 a_661_n954# a_n108_n954# VSS.t2483 VSS nfet_03v3 ad=0.18p pd=1.72u as=97.2f ps=0.9u w=0.36u l=0.28u
X3992 a_8077_9238# RA2.t31 a_8545_n862.t17 VSS nfet_03v3 ad=0.1152p pd=1u as=0.1584p ps=1.6u w=0.36u l=0.28u
X3993 VSS a_22140_6886# a_22274_7200# VSS nfet_03v3 ad=97.2f pd=0.9u as=0.1584p ps=1.6u w=0.36u l=0.28u
X3994 VDD RB12.t37 a_21170_1556# VDD pfet_03v3 ad=0.3168p pd=2.32u as=0.3708p ps=2.47u w=0.72u l=0.28u
X3995 a_32226_10022# a_32162_10336# a_32028_10022# VSS nfet_03v3 ad=56.7f pd=0.675u as=0.1278p ps=1.07u w=0.36u l=0.28u
X3996 a_8077_6102# RA6.t33 a_8545_n862.t27 VSS nfet_03v3 ad=0.1152p pd=1u as=0.1584p ps=1.6u w=0.36u l=0.28u
X3997 a_2562_2966# a_2498_3156# a_2364_2966# VDD pfet_03v3 ad=56.7f pd=0.675u as=0.1278p ps=1.07u w=0.36u l=0.28u
X3998 VDD a_n1204_2966.t37 a_37170_2966# VDD pfet_03v3 ad=0.1584p pd=1.6u as=56.7f ps=0.675u w=0.36u l=0.28u
X3999 a_8381_7670# RA4.t31 VDD VDD pfet_03v3 ad=0.3888p pd=2.52u as=0.3312p ps=2.36u w=0.72u l=0.28u
X4000 VDD a_n1204_10022.t29 a_9978_10526# VDD pfet_03v3 ad=0.1584p pd=1.6u as=56.7f ps=0.675u w=0.36u l=0.28u
X4001 a_7120_6886# a_7056_n708.t24 VSS VSS nfet_03v3 ad=0.1188p pd=1.02u as=0.1584p ps=1.6u w=0.36u l=0.28u
X4002 a_30629_706# RA13.t32 VSS VSS nfet_03v3 ad=0.1944p pd=1.8u as=0.1656p ps=1.64u w=0.36u l=0.28u
X4003 a_22909_9238# a_23213_9238# a_23377_n862.t16 VDD pfet_03v3 ad=0.1152p pd=1u as=0.1584p ps=1.6u w=0.36u l=0.28u
X4004 a_8381_4534# RA8.t33 VDD VDD pfet_03v3 ad=0.3888p pd=2.52u as=0.3312p ps=2.36u w=0.72u l=0.28u
X4005 a_38479_n2146.t14 RB4.t29 a_37741_7670# VSS nfet_03v3 ad=0.1584p pd=1.6u as=0.1152p ps=1u w=0.36u l=0.28u
X4006 VDD RB5.t35 a_1394_7232# VDD pfet_03v3 ad=0.3168p pd=2.32u as=0.3708p ps=2.47u w=0.72u l=0.28u
X4007 a_29816_n1738# a_29312_n1782# VSS.t3032 VSS nfet_03v3 ad=0.1584p pd=1.6u as=0.1584p ps=1.6u w=0.36u l=0.28u
X4008 VDD RB1.t31 a_26114_10368# VDD pfet_03v3 ad=0.3168p pd=2.32u as=0.3708p ps=2.47u w=0.72u l=0.28u
X4009 a_5605_7670# a_4836_7670# VSS VSS nfet_03v3 ad=0.18p pd=1.72u as=97.2f ps=0.9u w=0.36u l=0.28u
X4010 a_14922_6102# a_14858_6292# a_14724_6102# VDD pfet_03v3 ad=56.7f pd=0.675u as=0.1278p ps=1.07u w=0.36u l=0.28u
X4011 a_30325_6102# a_30629_6102# a_30793_n862.t23 VDD pfet_03v3 ad=0.1152p pd=1u as=0.1584p ps=1.6u w=0.36u l=0.28u
X4012 a_12252_3750# a_n1204_3750.t28 a_12064_3750# VSS nfet_03v3 ad=0.1278p pd=1.07u as=0.1188p ps=1.02u w=0.36u l=0.28u
X4013 VSS a_4836_8454# a_4970_8768# VSS nfet_03v3 ad=97.2f pd=0.9u as=0.1584p ps=1.6u w=0.36u l=0.28u
X4014 a_10645_n1738# WEM.t24 a_9536_n1782# VSS nfet_03v3 ad=0.1188p pd=1.02u as=0.1278p ps=1.07u w=0.36u l=0.28u
X4015 a_34500_8454# a_n884_8454.t32 a_34312_8454# VDD pfet_03v3 ad=0.1278p pd=1.07u as=0.2097p ps=1.38u w=0.36u l=0.28u
X4016 a_15797_5410# RA7.t36 VDD VDD pfet_03v3 ad=0.3888p pd=2.52u as=0.3312p ps=2.36u w=0.72u l=0.28u
X4017 a_5605_4534# a_4836_4534# VSS VSS nfet_03v3 ad=0.18p pd=1.72u as=97.2f ps=0.9u w=0.36u l=0.28u
X4018 a_31840_3750# a_31776_n708.t23 VDD VDD pfet_03v3 ad=0.2097p pd=1.38u as=0.3168p ps=2.32u w=0.72u l=0.28u
X4019 a_8815_n2146.t9 RB14.t38 a_8077_n170# VSS nfet_03v3 ad=0.1584p pd=1.6u as=0.1152p ps=1u w=0.36u l=0.28u
X4020 a_n1652_n170# WE14.t1 VDD.t3142 VDD.t3141 pfet_03v3 ad=0.1872p pd=1.24u as=0.3168p ps=2.32u w=0.72u l=0.28u
X4021 VSS a_4836_5318# a_4970_5632# VSS nfet_03v3 ad=97.2f pd=0.9u as=0.1584p ps=1.6u w=0.36u l=0.28u
X4022 a_3133_3750# RA9.t32 a_3601_n862.t17 VSS nfet_03v3 ad=0.1152p pd=1u as=0.1584p ps=1.6u w=0.36u l=0.28u
X4023 a_15797_2274# RA11.t35 VDD VDD pfet_03v3 ad=0.3888p pd=2.52u as=0.3312p ps=2.36u w=0.72u l=0.28u
X4024 a_31840_614# a_31776_n708.t24 VDD VDD pfet_03v3 ad=0.2097p pd=1.38u as=0.3168p ps=2.32u w=0.72u l=0.28u
X4025 a_5605_10806# a_5909_10806# a_6073_n862.t29 VDD pfet_03v3 ad=0.1152p pd=1u as=0.1584p ps=1.6u w=0.36u l=0.28u
X4026 a_2562_10526# a_2498_10336# a_2364_10022# VDD pfet_03v3 ad=56.7f pd=0.675u as=0.1278p ps=1.07u w=0.36u l=0.28u
X4027 VDD a_2364_9238# a_2498_9428# VDD pfet_03v3 ad=0.1764p pd=1.26u as=0.1584p ps=1.6u w=0.36u l=0.28u
X4028 a_22909_4534# RA8.t34 a_23377_n862.t10 VSS nfet_03v3 ad=0.1152p pd=1u as=0.1584p ps=1.6u w=0.36u l=0.28u
X4029 VDD a_19668_8454# a_19802_8768# VDD pfet_03v3 ad=0.1764p pd=1.26u as=0.1584p ps=1.6u w=0.36u l=0.28u
X4030 VSS RB0.t32 a_16226_10964# VSS nfet_03v3 ad=0.1584p pd=1.6u as=0.1854p ps=1.75u w=0.36u l=0.28u
X4031 a_23213_2966# RA10.t32 VDD VDD pfet_03v3 ad=0.3888p pd=2.52u as=0.3312p ps=2.36u w=0.72u l=0.28u
X4032 a_12064_7670# a_12000_n708.t21 VDD VDD pfet_03v3 ad=0.2097p pd=1.38u as=0.3168p ps=2.32u w=0.72u l=0.28u
X4033 VDD a_n1204_5318.t28 a_17394_5822# VDD pfet_03v3 ad=0.1584p pd=1.6u as=56.7f ps=0.675u w=0.36u l=0.28u
X4034 VDD.t1494 RB14.t39 a_23642_n12# VDD.t748 pfet_03v3 ad=0.3168p pd=2.32u as=0.3708p ps=2.47u w=0.72u l=0.28u
X4035 a_30325_1398# RA12.t35 a_30793_n862.t3 VSS nfet_03v3 ad=0.1152p pd=1u as=0.1584p ps=1.6u w=0.36u l=0.28u
X4036 a_12064_4534# a_12000_n708.t22 VDD VDD pfet_03v3 ad=0.2097p pd=1.38u as=0.3168p ps=2.32u w=0.72u l=0.28u
X4037 VSS a_n108_2966# a_26_3156# VSS nfet_03v3 ad=97.2f pd=0.9u as=0.1584p ps=1.6u w=0.36u l=0.28u
X4038 a_37741_9238# RA2.t32 a_38209_n862.t23 VSS nfet_03v3 ad=0.1152p pd=1u as=0.1584p ps=1.6u w=0.36u l=0.28u
X4039 a_33535_n2146.t1 RB13.t33 a_32797_614# VSS nfet_03v3 ad=0.1584p pd=1.6u as=0.1152p ps=1u w=0.36u l=0.28u
X4040 a_22338_8958# a_22274_8768# a_22140_8454# VDD pfet_03v3 ad=56.7f pd=0.675u as=0.1278p ps=1.07u w=0.36u l=0.28u
X4041 a_24612_6102# a_n884_6102.t25 a_24424_6102# VDD pfet_03v3 ad=0.1278p pd=1.07u as=0.2097p ps=1.38u w=0.36u l=0.28u
X4042 a_28157_3842# RA9.t33 VDD VDD pfet_03v3 ad=0.3888p pd=2.52u as=0.3312p ps=2.36u w=0.72u l=0.28u
X4043 VSS a_n884_9238.t27 a_2562_9742# VSS nfet_03v3 ad=0.1584p pd=1.6u as=56.7f ps=0.675u w=0.36u l=0.28u
X4044 a_5605_9238# RA2.t33 a_6073_n862.t0 VSS nfet_03v3 ad=0.1152p pd=1u as=0.1584p ps=1.6u w=0.36u l=0.28u
X4045 a_13759_n2146.t0 RB5.t36 a_13021_6886# VSS nfet_03v3 ad=0.1584p pd=1.6u as=0.1152p ps=1u w=0.36u l=0.28u
X4046 a_37741_6102# RA6.t34 a_38209_n862.t28 VSS nfet_03v3 ad=0.1152p pd=1u as=0.1584p ps=1.6u w=0.36u l=0.28u
X4047 a_28157_706# RA13.t33 VDD VDD pfet_03v3 ad=0.3888p pd=2.52u as=0.3312p ps=2.36u w=0.72u l=0.28u
X4048 a_965_6978# RA5.t33 VSS VSS nfet_03v3 ad=0.1944p pd=1.8u as=0.1656p ps=1.64u w=0.36u l=0.28u
X4049 a_26896_6886# a_26832_n708.t29 VDD VDD pfet_03v3 ad=0.2097p pd=1.38u as=0.3168p ps=2.32u w=0.72u l=0.28u
X4050 a_27853_6886# RA5.t34 a_28321_n862.t21 VSS nfet_03v3 ad=0.1152p pd=1u as=0.1584p ps=1.6u w=0.36u l=0.28u
X4051 VSS a_n884_6102.t26 a_2562_6606# VSS nfet_03v3 ad=0.1584p pd=1.6u as=56.7f ps=0.675u w=0.36u l=0.28u
X4052 a_36007_n2146.t24 a_36002_5664# a_35269_5318# VDD pfet_03v3 ad=0.1584p pd=1.6u as=0.1152p ps=1u w=0.36u l=0.28u
X4053 VDD a_17196_10022# a_17330_10336# VDD pfet_03v3 ad=0.1764p pd=1.26u as=0.1584p ps=1.6u w=0.36u l=0.28u
X4054 a_5605_6102# RA6.t35 a_6073_n862.t13 VSS nfet_03v3 ad=0.1152p pd=1u as=0.1584p ps=1.6u w=0.36u l=0.28u
X4055 a_24424_2966# a_24360_n708.t29 VSS VSS nfet_03v3 ad=0.1188p pd=1.02u as=0.1584p ps=1.6u w=0.36u l=0.28u
X4056 VSS a_36972_8454# a_37106_8768# VSS nfet_03v3 ad=97.2f pd=0.9u as=0.1584p ps=1.6u w=0.36u l=0.28u
X4057 a_5034_8958# a_4970_8768# a_4836_8454# VDD pfet_03v3 ad=56.7f pd=0.675u as=0.1278p ps=1.07u w=0.36u l=0.28u
X4058 VDD a_9780_6102# a_9914_6292# VDD pfet_03v3 ad=0.1764p pd=1.26u as=0.1584p ps=1.6u w=0.36u l=0.28u
X4059 a_19866_8174# a_19802_7860# a_19668_7670# VSS nfet_03v3 ad=56.7f pd=0.675u as=0.1278p ps=1.07u w=0.36u l=0.28u
X4060 VSS a_36972_5318# a_37106_5632# VSS nfet_03v3 ad=97.2f pd=0.9u as=0.1584p ps=1.6u w=0.36u l=0.28u
X4061 a_35269_3750# RA9.t34 a_35737_n862.t10 VSS nfet_03v3 ad=0.1152p pd=1u as=0.1584p ps=1.6u w=0.36u l=0.28u
X4062 a_27282_10022# a_27218_10336# a_27084_10022# VSS nfet_03v3 ad=56.7f pd=0.675u as=0.1278p ps=1.07u w=0.36u l=0.28u
X4063 VDD a_n1204_7670.t29 a_14922_7670# VDD pfet_03v3 ad=0.1584p pd=1.6u as=56.7f ps=0.675u w=0.36u l=0.28u
X4064 VDD RB5.t37 a_31058_7232# VDD pfet_03v3 ad=0.3168p pd=2.32u as=0.3708p ps=2.47u w=0.72u l=0.28u
X4065 a_3871_n2146.t9 RB10.t36 a_3133_2966# VSS nfet_03v3 ad=0.1584p pd=1.6u as=0.1152p ps=1u w=0.36u l=0.28u
X4066 a_30325_6102# a_29556_6102# VDD VDD pfet_03v3 ad=0.36p pd=2.44u as=0.1764p ps=1.26u w=0.72u l=0.28u
X4067 a_19866_5038# a_19802_4724# a_19668_4534# VSS nfet_03v3 ad=56.7f pd=0.675u as=0.1278p ps=1.07u w=0.36u l=0.28u
X4068 a_17394_1902# a_17330_1588# a_17196_1398# VSS nfet_03v3 ad=56.7f pd=0.675u as=0.1278p ps=1.07u w=0.36u l=0.28u
X4069 a_28591_n2146.t14 RB3.t30 a_27853_8454# VSS nfet_03v3 ad=0.1584p pd=1.6u as=0.1152p ps=1u w=0.36u l=0.28u
X4070 VDD a_n1204_4534.t30 a_14922_4534# VDD pfet_03v3 ad=0.1584p pd=1.6u as=56.7f ps=0.675u w=0.36u l=0.28u
X4071 a_3871_n2146.t30 RB13.t34 a_3133_614# VSS nfet_03v3 ad=0.1584p pd=1.6u as=0.1152p ps=1u w=0.36u l=0.28u
X4072 a_3133_7670# a_2364_7670# VSS VSS nfet_03v3 ad=0.18p pd=1.72u as=97.2f ps=0.9u w=0.36u l=0.28u
X4073 a_8077_n170# a_7308_n170# VDD.t2861 VDD.t2860 pfet_03v3 ad=0.36p pd=2.44u as=0.1764p ps=1.26u w=0.72u l=0.28u
X4074 a_3133_9238# a_3437_9238# a_3601_n862.t24 VDD pfet_03v3 ad=0.1152p pd=1u as=0.1584p ps=1.6u w=0.36u l=0.28u
X4075 a_12450_6102# a_12386_6292# a_12252_6102# VDD pfet_03v3 ad=56.7f pd=0.675u as=0.1278p ps=1.07u w=0.36u l=0.28u
X4076 VDD a_n1204_1398.t27 a_12450_1398# VDD pfet_03v3 ad=0.1584p pd=1.6u as=56.7f ps=0.675u w=0.36u l=0.28u
X4077 a_33535_n2146.t24 a_33530_7828# a_32797_7670# VDD pfet_03v3 ad=0.1584p pd=1.6u as=0.1152p ps=1u w=0.36u l=0.28u
X4078 a_3133_4534# a_2364_4534# VSS VSS nfet_03v3 ad=0.18p pd=1.72u as=97.2f ps=0.9u w=0.36u l=0.28u
X4079 a_n1204_2182.t2 a_n1652_2614# VSS VSS nfet_03v3 ad=0.1651p pd=1.155u as=0.2794p ps=2.15u w=0.635u l=0.28u
X4080 a_19480_9238# a_19416_n708.t26 VSS VSS nfet_03v3 ad=0.1188p pd=1.02u as=0.1584p ps=1.6u w=0.36u l=0.28u
X4081 VDD a_32028_9238# a_32162_9428# VDD pfet_03v3 ad=0.1764p pd=1.26u as=0.1584p ps=1.6u w=0.36u l=0.28u
X4082 a_1399_n2146.t29 a_1394_7828# a_661_7670# VDD pfet_03v3 ad=0.1584p pd=1.6u as=0.1152p ps=1u w=0.36u l=0.28u
X4083 a_33535_n2146.t13 a_33530_4692# a_32797_4534# VDD pfet_03v3 ad=0.1584p pd=1.6u as=0.1152p ps=1u w=0.36u l=0.28u
X4084 a_21952_2182# a_21888_n708.t26 VSS VSS nfet_03v3 ad=0.1188p pd=1.02u as=0.1584p ps=1.6u w=0.36u l=0.28u
X4085 a_15493_n170# RA14.t37 a_15961_n862.t9 VSS nfet_03v3 ad=0.1152p pd=1u as=0.1584p ps=1.6u w=0.36u l=0.28u
X4086 a_22909_9238# a_22140_9238# VSS VSS nfet_03v3 ad=0.18p pd=1.72u as=97.2f ps=0.9u w=0.36u l=0.28u
X4087 a_16231_n2146.t29 a_16226_10964# a_15493_10806# VDD pfet_03v3 ad=0.1584p pd=1.6u as=0.1152p ps=1u w=0.36u l=0.28u
X4088 a_19480_6102# a_19416_n708.t27 VSS VSS nfet_03v3 ad=0.1188p pd=1.02u as=0.1584p ps=1.6u w=0.36u l=0.28u
X4089 a_1399_n2146.t26 a_1394_4692# a_661_4534# VDD pfet_03v3 ad=0.1584p pd=1.6u as=0.1152p ps=1u w=0.36u l=0.28u
X4090 a_22909_6102# a_22140_6102# VSS VSS nfet_03v3 ad=0.18p pd=1.72u as=97.2f ps=0.9u w=0.36u l=0.28u
X4091 a_31840_n954# a_31776_n708.t25 VSS.t1202 VSS nfet_03v3 ad=0.1188p pd=1.02u as=0.1584p ps=1.6u w=0.36u l=0.28u
X4092 a_32028_n170# a_n1204_n170.t31 a_31840_n170# VSS nfet_03v3 ad=0.1278p pd=1.07u as=0.1188p ps=1.02u w=0.36u l=0.28u
X4093 a_29556_7670# a_n1204_7670.t30 a_29368_7670# VSS nfet_03v3 ad=0.1278p pd=1.07u as=0.1188p ps=1.02u w=0.36u l=0.28u
X4094 a_14922_3750# a_14858_4064# a_14724_3750# VSS nfet_03v3 ad=56.7f pd=0.675u as=0.1278p ps=1.07u w=0.36u l=0.28u
X4095 a_29556_4534# a_n1204_4534.t31 a_29368_4534# VSS nfet_03v3 ad=0.1278p pd=1.07u as=0.1188p ps=1.02u w=0.36u l=0.28u
X4096 VDD D3.t0 a_8173_n1738# VDD pfet_03v3 ad=0.3168p pd=2.32u as=0.2097p ps=1.38u w=0.72u l=0.28u
X4097 VDD.t1495 RB14.t40 a_21170_n12# VDD.t750 pfet_03v3 ad=0.3168p pd=2.32u as=0.3708p ps=2.47u w=0.72u l=0.28u
X4098 a_9978_11310# a_9914_10996# a_9780_10806# VSS nfet_03v3 ad=56.7f pd=0.675u as=0.1278p ps=1.07u w=0.36u l=0.28u
X4099 VSS a_n884_10806.t30 a_34698_11310# VSS nfet_03v3 ad=0.1584p pd=1.6u as=56.7f ps=0.675u w=0.36u l=0.28u
X4100 a_3133_4534# RA8.t35 a_3601_n862.t11 VSS nfet_03v3 ad=0.1152p pd=1u as=0.1584p ps=1.6u w=0.36u l=0.28u
X4101 VDD a_17196_2966# a_17330_3156# VDD pfet_03v3 ad=0.1764p pd=1.26u as=0.1584p ps=1.6u w=0.36u l=0.28u
X4102 a_27084_1398# a_n1204_1398.t28 a_26896_1398# VSS nfet_03v3 ad=0.1278p pd=1.07u as=0.1188p ps=1.02u w=0.36u l=0.28u
X4103 VSS a_n884_9238.t28 a_32226_9742# VSS nfet_03v3 ad=0.1584p pd=1.6u as=56.7f ps=0.675u w=0.36u l=0.28u
X4104 VDD RB12.t38 a_33530_1556# VDD pfet_03v3 ad=0.3168p pd=2.32u as=0.3708p ps=2.47u w=0.72u l=0.28u
X4105 VSS.t2634 a_24368_n1782# a_24360_n708.t1 VSS nfet_03v3 ad=0.2728p pd=2.12u as=0.1612p ps=1.14u w=0.62u l=0.28u
X4106 VSS a_2364_6886# a_2498_7200# VSS nfet_03v3 ad=97.2f pd=0.9u as=0.1584p ps=1.6u w=0.36u l=0.28u
X4107 a_22140_6102# a_n884_6102.t27 a_21952_6102# VDD pfet_03v3 ad=0.1278p pd=1.07u as=0.2097p ps=1.38u w=0.36u l=0.28u
X4108 VSS a_n884_6102.t28 a_32226_6606# VSS nfet_03v3 ad=0.1584p pd=1.6u as=56.7f ps=0.675u w=0.36u l=0.28u
X4109 a_37741_2966# a_36972_2966# VDD VDD pfet_03v3 ad=0.36p pd=2.44u as=0.1764p ps=1.26u w=0.72u l=0.28u
X4110 VSS RB7.t31 a_1394_5664# VSS nfet_03v3 ad=0.1584p pd=1.6u as=0.1854p ps=1.75u w=0.36u l=0.28u
X4111 a_17008_8454# a_16944_n708.t28 VSS VSS nfet_03v3 ad=0.1188p pd=1.02u as=0.1584p ps=1.6u w=0.36u l=0.28u
X4112 a_35269_7670# a_34500_7670# VSS VSS nfet_03v3 ad=0.18p pd=1.72u as=97.2f ps=0.9u w=0.36u l=0.28u
X4113 a_33535_n2146.t25 a_33530_10964# a_32797_10806# VDD pfet_03v3 ad=0.1584p pd=1.6u as=0.1152p ps=1u w=0.36u l=0.28u
X4114 a_35269_9238# a_35573_9238# a_35737_n862.t23 VDD pfet_03v3 ad=0.1152p pd=1u as=0.1584p ps=1.6u w=0.36u l=0.28u
X4115 a_17008_5318# a_16944_n708.t29 VSS VSS nfet_03v3 ad=0.1188p pd=1.02u as=0.1584p ps=1.6u w=0.36u l=0.28u
X4116 a_35269_4534# a_34500_4534# VSS VSS nfet_03v3 ad=0.18p pd=1.72u as=97.2f ps=0.9u w=0.36u l=0.28u
X4117 a_8381_3842# RA9.t35 VDD VDD pfet_03v3 ad=0.3888p pd=2.52u as=0.3312p ps=2.36u w=0.72u l=0.28u
X4118 a_661_10806# a_n108_10806# VDD VDD pfet_03v3 ad=0.36p pd=2.44u as=0.1764p ps=1.26u w=0.72u l=0.28u
X4119 a_32797_3750# RA9.t36 a_33265_n862.t12 VSS nfet_03v3 ad=0.1152p pd=1u as=0.1584p ps=1.6u w=0.36u l=0.28u
X4120 a_27282_2182# a_27218_2496# a_27084_2182# VSS nfet_03v3 ad=56.7f pd=0.675u as=0.1278p ps=1.07u w=0.36u l=0.28u
X4121 a_13021_7670# RA4.t32 a_13489_n862.t30 VSS nfet_03v3 ad=0.1152p pd=1u as=0.1584p ps=1.6u w=0.36u l=0.28u
X4122 QB2b.t1 a_6343_n2146.t32 VSS VSS nfet_03v3 ad=0.2052p pd=1.86u as=0.1242p ps=1.05u w=0.36u l=0.28u
X4123 a_8381_706# RA13.t34 VDD VDD pfet_03v3 ad=0.3888p pd=2.52u as=0.3312p ps=2.36u w=0.72u l=0.28u
X4124 a_8077_10806# a_7308_10806# VDD VDD pfet_03v3 ad=0.36p pd=2.44u as=0.1764p ps=1.26u w=0.72u l=0.28u
X4125 VSS a_12252_10806# a_12386_10996# VSS nfet_03v3 ad=97.2f pd=0.9u as=0.1584p ps=1.6u w=0.36u l=0.28u
X4126 a_24612_3750# a_n1204_3750.t29 a_24424_3750# VSS nfet_03v3 ad=0.1278p pd=1.07u as=0.1188p ps=1.02u w=0.36u l=0.28u
X4127 a_37170_n954# a_37106_n640# a_36972_n954# VSS nfet_03v3 ad=56.7f pd=0.675u as=0.1278p ps=1.07u w=0.36u l=0.28u
X4128 a_14922_11310# a_14858_10996# a_14724_10806# VSS nfet_03v3 ad=56.7f pd=0.675u as=0.1278p ps=1.07u w=0.36u l=0.28u
X4129 VDD.t1243 a_n1204_n954.t28 a_34698_n450# VDD.t1242 pfet_03v3 ad=0.1584p pd=1.6u as=56.7f ps=0.675u w=0.36u l=0.28u
X4130 VDD D5.t0 a_13117_n1738# VDD pfet_03v3 ad=0.3168p pd=2.32u as=0.2097p ps=1.38u w=0.72u l=0.28u
X4131 a_24810_10806# a_24746_10996# a_24612_10806# VDD pfet_03v3 ad=56.7f pd=0.675u as=0.1278p ps=1.07u w=0.36u l=0.28u
X4132 a_661_n954# RA15.t34 a_1129_n862.t11 VSS nfet_03v3 ad=0.1152p pd=1u as=0.1584p ps=1.6u w=0.36u l=0.28u
X4133 VDD a_n1204_1398.t29 a_9978_1398# VDD pfet_03v3 ad=0.1584p pd=1.6u as=56.7f ps=0.675u w=0.36u l=0.28u
X4134 a_31063_n2146.t22 a_31058_7828# a_30325_7670# VDD pfet_03v3 ad=0.1584p pd=1.6u as=0.1152p ps=1u w=0.36u l=0.28u
X4135 VSS a_9780_3750# a_9914_4064# VSS nfet_03v3 ad=97.2f pd=0.9u as=0.1584p ps=1.6u w=0.36u l=0.28u
X4136 a_35269_4534# RA8.t36 a_35737_n862.t5 VSS nfet_03v3 ad=0.1152p pd=1u as=0.1584p ps=1.6u w=0.36u l=0.28u
X4137 VSS.t3234 D1.t1 a_3229_n1738# VSS nfet_03v3 ad=0.1584p pd=1.6u as=0.1188p ps=1.02u w=0.36u l=0.28u
X4138 a_31063_n2146.t24 a_31058_4692# a_30325_4534# VDD pfet_03v3 ad=0.1584p pd=1.6u as=0.1152p ps=1u w=0.36u l=0.28u
X4139 a_20437_9238# a_19668_9238# VSS VSS nfet_03v3 ad=0.18p pd=1.72u as=97.2f ps=0.9u w=0.36u l=0.28u
X4140 a_30325_3750# a_29556_3750# VSS VSS nfet_03v3 ad=0.18p pd=1.72u as=97.2f ps=0.9u w=0.36u l=0.28u
X4141 a_35573_2966# RA10.t33 VDD VDD pfet_03v3 ad=0.3888p pd=2.52u as=0.3312p ps=2.36u w=0.72u l=0.28u
X4142 a_10549_6102# a_10853_6102# a_11017_n862.t18 VDD pfet_03v3 ad=0.1152p pd=1u as=0.1584p ps=1.6u w=0.36u l=0.28u
X4143 a_20437_6102# a_19668_6102# VSS VSS nfet_03v3 ad=0.18p pd=1.72u as=97.2f ps=0.9u w=0.36u l=0.28u
X4144 VDD a_n1204_5318.t29 a_29754_5822# VDD pfet_03v3 ad=0.1584p pd=1.6u as=56.7f ps=0.675u w=0.36u l=0.28u
X4145 a_21952_8454# a_21888_n708.t27 VDD VDD pfet_03v3 ad=0.2097p pd=1.38u as=0.3168p ps=2.32u w=0.72u l=0.28u
X4146 a_12450_3750# a_12386_4064# a_12252_3750# VSS nfet_03v3 ad=56.7f pd=0.675u as=0.1278p ps=1.07u w=0.36u l=0.28u
X4147 a_38045_n862# RA15.t35 VSS.t497 VSS nfet_03v3 ad=0.1944p pd=1.8u as=0.1656p ps=1.64u w=0.36u l=0.28u
X4148 a_12064_3750# a_12000_n708.t23 VDD VDD pfet_03v3 ad=0.2097p pd=1.38u as=0.3168p ps=2.32u w=0.72u l=0.28u
X4149 a_661_2182# a_n108_2182# VSS VSS nfet_03v3 ad=0.18p pd=1.72u as=97.2f ps=0.9u w=0.36u l=0.28u
X4150 QB4b.t1 a_11287_n2146.t32 VSS VSS nfet_03v3 ad=0.2052p pd=1.86u as=0.1242p ps=1.05u w=0.36u l=0.28u
X4151 a_34698_8958# a_34634_8768# a_34500_8454# VDD pfet_03v3 ad=56.7f pd=0.675u as=0.1278p ps=1.07u w=0.36u l=0.28u
X4152 a_36972_6102# a_n884_6102.t29 a_36784_6102# VDD pfet_03v3 ad=0.1278p pd=1.07u as=0.2097p ps=1.38u w=0.36u l=0.28u
X4153 a_18703_n2146.t17 RB7.t32 a_17965_5318# VSS nfet_03v3 ad=0.1584p pd=1.6u as=0.1152p ps=1u w=0.36u l=0.28u
X4154 VDD a_14724_2966# a_14858_3156# VDD pfet_03v3 ad=0.1764p pd=1.26u as=0.1584p ps=1.6u w=0.36u l=0.28u
X4155 VSS a_32028_6886# a_32162_7200# VSS nfet_03v3 ad=97.2f pd=0.9u as=0.1584p ps=1.6u w=0.36u l=0.28u
X4156 a_5909_n862# RA15.t36 VSS.t498 VSS nfet_03v3 ad=0.1944p pd=1.8u as=0.1656p ps=1.64u w=0.36u l=0.28u
X4157 a_12064_614# a_12000_n708.t24 VDD VDD pfet_03v3 ad=0.2097p pd=1.38u as=0.3168p ps=2.32u w=0.72u l=0.28u
X4158 a_9780_7670# a_n1204_7670.t31 a_9592_7670# VSS nfet_03v3 ad=0.1278p pd=1.07u as=0.1188p ps=1.02u w=0.36u l=0.28u
X4159 VSS RB7.t33 a_31058_5664# VSS nfet_03v3 ad=0.1584p pd=1.6u as=0.1854p ps=1.75u w=0.36u l=0.28u
X4160 a_36784_2966# a_36720_n708.t31 VSS VSS nfet_03v3 ad=0.1188p pd=1.02u as=0.1584p ps=1.6u w=0.36u l=0.28u
X4161 a_14536_10022# a_14472_n708.t29 VSS VSS nfet_03v3 ad=0.1188p pd=1.02u as=0.1584p ps=1.6u w=0.36u l=0.28u
X4162 VSS a_n884_10806.t31 a_29754_11310# VSS nfet_03v3 ad=0.1584p pd=1.6u as=56.7f ps=0.675u w=0.36u l=0.28u
X4163 a_23647_n2146.t4 RB1.t32 a_22909_10022# VSS nfet_03v3 ad=0.1584p pd=1.6u as=0.1152p ps=1u w=0.36u l=0.28u
X4164 VSS a_n884_7670.t23 a_90_8174# VSS nfet_03v3 ad=0.1584p pd=1.6u as=56.7f ps=0.675u w=0.36u l=0.28u
X4165 VDD CLK a_n1652_7670# VDD pfet_03v3 ad=0.3168p pd=2.32u as=0.1872p ps=1.24u w=0.72u l=0.28u
X4166 a_9780_4534# a_n1204_4534.t32 a_9592_4534# VSS nfet_03v3 ad=0.1278p pd=1.07u as=0.1188p ps=1.02u w=0.36u l=0.28u
X4167 VSS.t752 RB15.t35 a_8810_n608# VSS nfet_03v3 ad=0.1584p pd=1.6u as=0.1854p ps=1.75u w=0.36u l=0.28u
X4168 a_17394_9238# a_17330_9428# a_17196_9238# VDD pfet_03v3 ad=56.7f pd=0.675u as=0.1278p ps=1.07u w=0.36u l=0.28u
X4169 a_32797_9238# a_33101_9238# a_33265_n862.t20 VDD pfet_03v3 ad=0.1152p pd=1u as=0.1584p ps=1.6u w=0.36u l=0.28u
X4170 a_14536_8454# a_14472_n708.t30 VSS VSS nfet_03v3 ad=0.1188p pd=1.02u as=0.1584p ps=1.6u w=0.36u l=0.28u
X4171 a_10549_1398# RA12.t36 a_11017_n862.t3 VSS nfet_03v3 ad=0.1152p pd=1u as=0.1584p ps=1.6u w=0.36u l=0.28u
X4172 a_15797_6102# RA6.t36 VDD VDD pfet_03v3 ad=0.3888p pd=2.52u as=0.3312p ps=2.36u w=0.72u l=0.28u
X4173 a_14536_5318# a_14472_n708.t31 VSS VSS nfet_03v3 ad=0.1188p pd=1.02u as=0.1584p ps=1.6u w=0.36u l=0.28u
X4174 VSS a_n884_4534.t23 a_90_5038# VSS nfet_03v3 ad=0.1584p pd=1.6u as=56.7f ps=0.675u w=0.36u l=0.28u
X4175 VDD CLK a_n1652_4534# VDD pfet_03v3 ad=0.3168p pd=2.32u as=0.1872p ps=1.24u w=0.72u l=0.28u
X4176 a_18269_8546# RA3.t30 VDD VDD pfet_03v3 ad=0.3888p pd=2.52u as=0.3312p ps=2.36u w=0.72u l=0.28u
X4177 WE0CLK.t1 a_n1652_10806# VDD VDD pfet_03v3 ad=0.3302p pd=1.79u as=0.5588p ps=3.42u w=1.27u l=0.28u
X4178 VSS RB2.t30 a_1394_9396# VSS nfet_03v3 ad=0.1584p pd=1.6u as=0.1854p ps=1.75u w=0.36u l=0.28u
X4179 a_27632_n1738# WEM.t25 VDD VDD pfet_03v3 ad=56.7f pd=0.675u as=0.1584p ps=1.6u w=0.36u l=0.28u
X4180 a_17008_n954# a_16944_n708.t30 VDD.t985 VDD.t975 pfet_03v3 ad=0.2097p pd=1.38u as=0.3168p ps=2.32u w=0.72u l=0.28u
X4181 VDD.t1567 a_n1204_n170.t32 a_12450_n170# VDD.t1228 pfet_03v3 ad=0.1584p pd=1.6u as=56.7f ps=0.675u w=0.36u l=0.28u
X4182 a_30325_10806# a_29556_10806# VDD VDD pfet_03v3 ad=0.36p pd=2.44u as=0.1764p ps=1.26u w=0.72u l=0.28u
X4183 a_4648_6886# a_4584_n708.t29 VDD VDD pfet_03v3 ad=0.2097p pd=1.38u as=0.3168p ps=2.32u w=0.72u l=0.28u
X4184 a_22140_3750# a_n1204_3750.t30 a_21952_3750# VSS nfet_03v3 ad=0.1278p pd=1.07u as=0.1188p ps=1.02u w=0.36u l=0.28u
X4185 a_35573_706# RA13.t35 VSS VSS nfet_03v3 ad=0.1944p pd=1.8u as=0.1656p ps=1.64u w=0.36u l=0.28u
X4186 a_13021_1398# a_12252_1398# VDD VDD pfet_03v3 ad=0.36p pd=2.44u as=0.1764p ps=1.26u w=0.72u l=0.28u
X4187 a_29754_8174# a_29690_7860# a_29556_7670# VSS nfet_03v3 ad=56.7f pd=0.675u as=0.1278p ps=1.07u w=0.36u l=0.28u
X4188 VSS RB6.t31 a_1394_6260# VSS nfet_03v3 ad=0.1584p pd=1.6u as=0.1854p ps=1.75u w=0.36u l=0.28u
X4189 a_24810_6102# a_24746_6292# a_24612_6102# VDD pfet_03v3 ad=56.7f pd=0.675u as=0.1278p ps=1.07u w=0.36u l=0.28u
X4190 a_17965_2966# a_18269_2966# a_18433_n862.t22 VDD pfet_03v3 ad=0.1152p pd=1u as=0.1584p ps=1.6u w=0.36u l=0.28u
X4191 a_5909_10806# RA0.t39 VDD VDD pfet_03v3 ad=0.3888p pd=2.52u as=0.3312p ps=2.36u w=0.72u l=0.28u
X4192 a_31840_10022# a_31776_n708.t26 VSS VSS nfet_03v3 ad=0.1188p pd=1.02u as=0.1584p ps=1.6u w=0.36u l=0.28u
X4193 a_29754_5038# a_29690_4724# a_29556_4534# VSS nfet_03v3 ad=56.7f pd=0.675u as=0.1278p ps=1.07u w=0.36u l=0.28u
X4194 a_37741_10022# a_38045_10114# a_38209_n862.t10 VDD pfet_03v3 ad=0.1152p pd=1u as=0.1584p ps=1.6u w=0.36u l=0.28u
X4195 a_661_8454# a_965_8546# a_1129_n862.t25 VDD pfet_03v3 ad=0.1152p pd=1u as=0.1584p ps=1.6u w=0.36u l=0.28u
X4196 a_32797_4534# RA8.t37 a_33265_n862.t7 VSS nfet_03v3 ad=0.1152p pd=1u as=0.1584p ps=1.6u w=0.36u l=0.28u
X4197 a_15797_1398# RA12.t37 VSS VSS nfet_03v3 ad=0.1944p pd=1.8u as=0.1656p ps=1.64u w=0.36u l=0.28u
X4198 VDD a_29556_8454# a_29690_8768# VDD pfet_03v3 ad=0.1764p pd=1.26u as=0.1584p ps=1.6u w=0.36u l=0.28u
X4199 a_25477_n1738# WEM.t26 a_24368_n1782# VSS nfet_03v3 ad=0.1188p pd=1.02u as=0.1278p ps=1.07u w=0.36u l=0.28u
X4200 a_21952_1398# a_21888_n708.t28 VSS VSS nfet_03v3 ad=0.1188p pd=1.02u as=0.1584p ps=1.6u w=0.36u l=0.28u
X4201 a_27084_9238# a_n884_9238.t29 a_26896_9238# VDD pfet_03v3 ad=0.1278p pd=1.07u as=0.2097p ps=1.38u w=0.36u l=0.28u
X4202 a_32028_2966# a_n1204_2966.t38 a_31840_2966# VSS nfet_03v3 ad=0.1278p pd=1.07u as=0.1188p ps=1.02u w=0.36u l=0.28u
X4203 a_33101_2966# RA10.t34 VDD VDD pfet_03v3 ad=0.3888p pd=2.52u as=0.3312p ps=2.36u w=0.72u l=0.28u
X4204 VDD.t1496 RB14.t41 a_33530_n12# VDD.t720 pfet_03v3 ad=0.3168p pd=2.32u as=0.3708p ps=2.47u w=0.72u l=0.28u
X4205 a_5909_706# RA13.t36 VSS VSS nfet_03v3 ad=0.1944p pd=1.8u as=0.1656p ps=1.64u w=0.36u l=0.28u
X4206 VDD a_n1204_5318.t30 a_27282_5822# VDD pfet_03v3 ad=0.1584p pd=1.6u as=56.7f ps=0.675u w=0.36u l=0.28u
X4207 a_90_2966# a_26_3156# a_n108_2966# VDD pfet_03v3 ad=56.7f pd=0.675u as=0.1278p ps=1.07u w=0.36u l=0.28u
X4208 a_5096_n1738# a_4592_n1782# VSS.t2783 VSS nfet_03v3 ad=0.1584p pd=1.6u as=0.1584p ps=1.6u w=0.36u l=0.28u
X4209 a_34500_6102# a_n884_6102.t30 a_34312_6102# VDD pfet_03v3 ad=0.1278p pd=1.07u as=0.2097p ps=1.38u w=0.36u l=0.28u
X4210 a_32226_8958# a_32162_8768# a_32028_8454# VDD pfet_03v3 ad=56.7f pd=0.675u as=0.1278p ps=1.07u w=0.36u l=0.28u
X4211 a_16231_n2146.t15 RB7.t34 a_15493_5318# VSS nfet_03v3 ad=0.1584p pd=1.6u as=0.1152p ps=1u w=0.36u l=0.28u
X4212 VSS a_8545_n862.t32 QA3b.t1 VSS nfet_03v3 ad=0.1242p pd=1.05u as=0.2052p ps=1.86u w=0.36u l=0.28u
X4213 a_3437_n862# RA15.t37 VSS.t499 VSS nfet_03v3 ad=0.1944p pd=1.8u as=0.1656p ps=1.64u w=0.36u l=0.28u
X4214 a_661_8454# a_n108_8454# VDD VDD pfet_03v3 ad=0.36p pd=2.44u as=0.1764p ps=1.26u w=0.72u l=0.28u
X4215 a_14536_614# a_14472_n708.t32 VSS VSS nfet_03v3 ad=0.1188p pd=1.02u as=0.1584p ps=1.6u w=0.36u l=0.28u
X4216 a_10853_10806# RA0.t40 VDD VDD pfet_03v3 ad=0.3888p pd=2.52u as=0.3312p ps=2.36u w=0.72u l=0.28u
X4217 a_7308_7670# a_n1204_7670.t32 a_7120_7670# VSS nfet_03v3 ad=0.1278p pd=1.07u as=0.1188p ps=1.02u w=0.36u l=0.28u
X4218 a_34312_2966# a_34248_n708.t29 VSS VSS nfet_03v3 ad=0.1188p pd=1.02u as=0.1584p ps=1.6u w=0.36u l=0.28u
X4219 a_12064_n954# a_12000_n708.t25 VSS.t1859 VSS nfet_03v3 ad=0.1188p pd=1.02u as=0.1584p ps=1.6u w=0.36u l=0.28u
X4220 a_18703_n2146.t2 RB2.t31 a_17965_9238# VSS nfet_03v3 ad=0.1584p pd=1.6u as=0.1152p ps=1u w=0.36u l=0.28u
X4221 VDD RB4.t30 a_16226_7828# VDD pfet_03v3 ad=0.3168p pd=2.32u as=0.3708p ps=2.47u w=0.72u l=0.28u
X4222 VDD a_19668_6102# a_19802_6292# VDD pfet_03v3 ad=0.1764p pd=1.26u as=0.1584p ps=1.6u w=0.36u l=0.28u
X4223 a_7308_4534# a_n1204_4534.t33 a_7120_4534# VSS nfet_03v3 ad=0.1278p pd=1.07u as=0.1188p ps=1.02u w=0.36u l=0.28u
X4224 a_2176_2966# a_2112_n708.t33 VSS VSS nfet_03v3 ad=0.1188p pd=1.02u as=0.1584p ps=1.6u w=0.36u l=0.28u
X4225 a_661_10022# a_n108_10022# VDD VDD pfet_03v3 ad=0.36p pd=2.44u as=0.1764p ps=1.26u w=0.72u l=0.28u
X4226 a_25381_7670# RA4.t33 a_25849_n862.t30 VSS nfet_03v3 ad=0.1152p pd=1u as=0.1584p ps=1.6u w=0.36u l=0.28u
X4227 VDD a_n1204_7670.t33 a_24810_7670# VDD pfet_03v3 ad=0.1584p pd=1.6u as=56.7f ps=0.675u w=0.36u l=0.28u
X4228 a_18703_n2146.t7 RB6.t32 a_17965_6102# VSS nfet_03v3 ad=0.1584p pd=1.6u as=0.1152p ps=1u w=0.36u l=0.28u
X4229 VDD RB8.t30 a_16226_4692# VDD pfet_03v3 ad=0.3168p pd=2.32u as=0.3708p ps=2.47u w=0.72u l=0.28u
X4230 a_n108_1398# a_n884_1398.t29 a_n296_1398# VDD pfet_03v3 ad=0.1278p pd=1.07u as=0.2097p ps=1.38u w=0.36u l=0.28u
X4231 VSS RB2.t32 a_31058_9396# VSS nfet_03v3 ad=0.1584p pd=1.6u as=0.1854p ps=1.75u w=0.36u l=0.28u
X4232 a_2364_5318# a_n884_5318.t29 a_2176_5318# VDD pfet_03v3 ad=0.1278p pd=1.07u as=0.2097p ps=1.38u w=0.36u l=0.28u
X4233 a_36972_3750# a_n1204_3750.t31 a_36784_3750# VSS nfet_03v3 ad=0.1278p pd=1.07u as=0.1188p ps=1.02u w=0.36u l=0.28u
X4234 a_8077_10022# a_7308_10022# VDD VDD pfet_03v3 ad=0.36p pd=2.44u as=0.1764p ps=1.26u w=0.72u l=0.28u
X4235 VSS RB6.t33 a_31058_6260# VSS nfet_03v3 ad=0.1584p pd=1.6u as=0.1854p ps=1.75u w=0.36u l=0.28u
X4236 VDD a_n1204_4534.t34 a_24810_4534# VDD pfet_03v3 ad=0.1584p pd=1.6u as=56.7f ps=0.675u w=0.36u l=0.28u
X4237 a_14536_n954# a_14472_n708.t33 VDD.t956 VDD.t946 pfet_03v3 ad=0.2097p pd=1.38u as=0.3168p ps=2.32u w=0.72u l=0.28u
X4238 VDD.t1568 a_n1204_n170.t33 a_9978_n170# VDD.t1230 pfet_03v3 ad=0.1584p pd=1.6u as=56.7f ps=0.675u w=0.36u l=0.28u
X4239 a_27282_1902# a_27218_1588# a_27084_1398# VSS nfet_03v3 ad=56.7f pd=0.675u as=0.1278p ps=1.07u w=0.36u l=0.28u
X4240 a_38479_n2146.t10 RB3.t31 a_37741_8454# VSS nfet_03v3 ad=0.1584p pd=1.6u as=0.1152p ps=1u w=0.36u l=0.28u
X4241 a_22338_6102# a_22274_6292# a_22140_6102# VDD pfet_03v3 ad=56.7f pd=0.675u as=0.1278p ps=1.07u w=0.36u l=0.28u
X4242 VDD a_n1204_1398.t30 a_22338_1398# VDD pfet_03v3 ad=0.1584p pd=1.6u as=56.7f ps=0.675u w=0.36u l=0.28u
X4243 a_10549_1398# a_9780_1398# VDD VDD pfet_03v3 ad=0.36p pd=2.44u as=0.1764p ps=1.26u w=0.72u l=0.28u
X4244 a_23647_n2146.t20 RB0.t33 a_22909_10806# VSS nfet_03v3 ad=0.1584p pd=1.6u as=0.1152p ps=1u w=0.36u l=0.28u
X4245 VSS a_12252_9238# a_12386_9428# VSS nfet_03v3 ad=97.2f pd=0.9u as=0.1584p ps=1.6u w=0.36u l=0.28u
X4246 a_29368_9238# a_29304_n708.t27 VSS VSS nfet_03v3 ad=0.1188p pd=1.02u as=0.1584p ps=1.6u w=0.36u l=0.28u
X4247 a_17394_6886# a_17330_7200# a_17196_6886# VSS nfet_03v3 ad=56.7f pd=0.675u as=0.1278p ps=1.07u w=0.36u l=0.28u
X4248 VSS a_12252_6102# a_12386_6292# VSS nfet_03v3 ad=97.2f pd=0.9u as=0.1584p ps=1.6u w=0.36u l=0.28u
X4249 VSS.t1260 a_n884_n954.t26 a_14922_n954# VSS nfet_03v3 ad=0.1584p pd=1.6u as=56.7f ps=0.675u w=0.36u l=0.28u
X4250 a_8815_n2146.t7 RB13.t35 a_8077_614# VSS nfet_03v3 ad=0.1584p pd=1.6u as=0.1152p ps=1u w=0.36u l=0.28u
X4251 a_32797_9238# a_32028_9238# VSS VSS nfet_03v3 ad=0.18p pd=1.72u as=97.2f ps=0.9u w=0.36u l=0.28u
X4252 a_38045_5410# RA7.t37 VDD VDD pfet_03v3 ad=0.3888p pd=2.52u as=0.3312p ps=2.36u w=0.72u l=0.28u
X4253 a_31840_2182# a_31776_n708.t27 VSS VSS nfet_03v3 ad=0.1188p pd=1.02u as=0.1584p ps=1.6u w=0.36u l=0.28u
X4254 a_5034_6102# a_4970_6292# a_4836_6102# VDD pfet_03v3 ad=56.7f pd=0.675u as=0.1278p ps=1.07u w=0.36u l=0.28u
X4255 a_29368_6102# a_29304_n708.t28 VSS VSS nfet_03v3 ad=0.1188p pd=1.02u as=0.1584p ps=1.6u w=0.36u l=0.28u
X4256 a_n1204_6886.t0 a_n1652_7318# VDD VDD pfet_03v3 ad=0.3302p pd=1.79u as=0.5588p ps=3.42u w=1.27u l=0.28u
X4257 a_32797_6102# a_32028_6102# VSS VSS nfet_03v3 ad=0.18p pd=1.72u as=97.2f ps=0.9u w=0.36u l=0.28u
X4258 a_5909_5410# RA7.t38 VDD VDD pfet_03v3 ad=0.3888p pd=2.52u as=0.3312p ps=2.36u w=0.72u l=0.28u
X4259 a_38045_2274# RA11.t36 VDD VDD pfet_03v3 ad=0.3888p pd=2.52u as=0.3312p ps=2.36u w=0.72u l=0.28u
X4260 a_24810_3750# a_24746_4064# a_24612_3750# VSS nfet_03v3 ad=56.7f pd=0.675u as=0.1278p ps=1.07u w=0.36u l=0.28u
X4261 a_36728_n1782# a_37232_n1738# a_37520_n1234# VSS nfet_03v3 ad=0.1278p pd=1.07u as=56.7f ps=0.675u w=0.36u l=0.28u
X4262 a_5909_2274# RA11.t37 VDD VDD pfet_03v3 ad=0.3888p pd=2.52u as=0.3312p ps=2.36u w=0.72u l=0.28u
X4263 VDD a_27084_2966# a_27218_3156# VDD pfet_03v3 ad=0.1764p pd=1.26u as=0.1584p ps=1.6u w=0.36u l=0.28u
X4264 a_3133_10022# a_3437_10114# a_3601_n862.t28 VDD pfet_03v3 ad=0.1152p pd=1u as=0.1584p ps=1.6u w=0.36u l=0.28u
X4265 a_661_1398# a_n108_1398# VSS VSS nfet_03v3 ad=0.18p pd=1.72u as=97.2f ps=0.9u w=0.36u l=0.28u
X4266 VDD RB7.t35 a_8810_5664# VDD pfet_03v3 ad=0.3168p pd=2.32u as=0.3708p ps=2.47u w=0.72u l=0.28u
X4267 a_36972_n170# a_n1204_n170.t34 a_36784_n170# VSS nfet_03v3 ad=0.1278p pd=1.07u as=0.1188p ps=1.02u w=0.36u l=0.28u
X4268 a_10853_7670# RA4.t34 VDD VDD pfet_03v3 ad=0.3888p pd=2.52u as=0.3312p ps=2.36u w=0.72u l=0.28u
X4269 a_17196_10022# a_n884_10022.t26 a_17008_10022# VDD pfet_03v3 ad=0.1278p pd=1.07u as=0.2097p ps=1.38u w=0.36u l=0.28u
X4270 a_10853_4534# RA8.t38 VDD VDD pfet_03v3 ad=0.3888p pd=2.52u as=0.3312p ps=2.36u w=0.72u l=0.28u
X4271 VDD RB11.t35 a_8810_2528# VDD pfet_03v3 ad=0.3168p pd=2.32u as=0.3708p ps=2.47u w=0.72u l=0.28u
X4272 VDD a_38209_n862.t33 QA15b.t0 VDD pfet_03v3 ad=0.2484p pd=1.41u as=0.4104p ps=2.58u w=0.72u l=0.28u
X4273 VDD a_n1204_5318.t31 a_7506_5822# VDD pfet_03v3 ad=0.1584p pd=1.6u as=56.7f ps=0.675u w=0.36u l=0.28u
X4274 a_28591_n2146.t20 a_28586_1556# a_27853_1398# VDD pfet_03v3 ad=0.1584p pd=1.6u as=0.1152p ps=1u w=0.36u l=0.28u
X4275 a_26896_8454# a_26832_n708.t30 VSS VSS nfet_03v3 ad=0.1188p pd=1.02u as=0.1584p ps=1.6u w=0.36u l=0.28u
X4276 a_27084_6886# a_n1204_6886.t32 a_26896_6886# VSS nfet_03v3 ad=0.1278p pd=1.07u as=0.1188p ps=1.02u w=0.36u l=0.28u
X4277 a_18269_3842# RA9.t37 VSS VSS nfet_03v3 ad=0.1944p pd=1.8u as=0.1656p ps=1.64u w=0.36u l=0.28u
X4278 VDD RB4.t31 a_13754_7828# VDD pfet_03v3 ad=0.3168p pd=2.32u as=0.3708p ps=2.47u w=0.72u l=0.28u
X4279 a_26896_5318# a_26832_n708.t31 VSS VSS nfet_03v3 ad=0.1188p pd=1.02u as=0.1584p ps=1.6u w=0.36u l=0.28u
X4280 a_16231_n2146.t2 RB2.t33 a_15493_9238# VSS nfet_03v3 ad=0.1584p pd=1.6u as=0.1152p ps=1u w=0.36u l=0.28u
X4281 VDD CLK a_n1652_4182# VDD pfet_03v3 ad=0.3168p pd=2.32u as=0.1872p ps=1.24u w=0.72u l=0.28u
X4282 a_37170_2182# a_37106_2496# a_36972_2182# VSS nfet_03v3 ad=56.7f pd=0.675u as=0.1278p ps=1.07u w=0.36u l=0.28u
X4283 a_13021_n170# a_12252_n170# VDD.t3430 VDD.t3325 pfet_03v3 ad=0.36p pd=2.44u as=0.1764p ps=1.26u w=0.72u l=0.28u
X4284 a_22909_7670# RA4.t35 a_23377_n862.t15 VSS nfet_03v3 ad=0.1152p pd=1u as=0.1584p ps=1.6u w=0.36u l=0.28u
X4285 a_3871_n2146.t4 RB5.t38 a_3133_6886# VSS nfet_03v3 ad=0.1584p pd=1.6u as=0.1152p ps=1u w=0.36u l=0.28u
X4286 VDD RB8.t31 a_13754_4692# VDD pfet_03v3 ad=0.3168p pd=2.32u as=0.3708p ps=2.47u w=0.72u l=0.28u
X4287 a_n884_10806.t2 WE0CLK.t33 VSS VSS nfet_03v3 ad=0.1943p pd=1.25u as=0.1693p ps=1.19u w=0.67u l=0.28u
X4288 a_16231_n2146.t8 RB6.t34 a_15493_6102# VSS nfet_03v3 ad=0.1584p pd=1.6u as=0.1152p ps=1u w=0.36u l=0.28u
X4289 a_34500_3750# a_n1204_3750.t32 a_34312_3750# VSS nfet_03v3 ad=0.1278p pd=1.07u as=0.1188p ps=1.02u w=0.36u l=0.28u
X4290 a_17744_n1234# a_n884_n1738.t24 VSS.t15 VSS nfet_03v3 ad=56.7f pd=0.675u as=0.1584p ps=1.6u w=0.36u l=0.28u
X4291 VDD CLK a_n1652_1046# VDD pfet_03v3 ad=0.3168p pd=2.32u as=0.1872p ps=1.24u w=0.72u l=0.28u
X4292 a_30325_10022# a_29556_10022# VDD VDD pfet_03v3 ad=0.36p pd=2.44u as=0.1764p ps=1.26u w=0.72u l=0.28u
X4293 a_7064_n1782# a_7568_n1738# a_7856_n1738# VDD pfet_03v3 ad=0.1278p pd=1.07u as=56.7f ps=0.675u w=0.36u l=0.28u
X4294 a_8815_n2146.t30 a_8810_10368# a_8077_10022# VDD pfet_03v3 ad=0.1584p pd=1.6u as=0.1152p ps=1u w=0.36u l=0.28u
X4295 a_9978_8174# a_9914_7860# a_9780_7670# VSS nfet_03v3 ad=56.7f pd=0.675u as=0.1278p ps=1.07u w=0.36u l=0.28u
X4296 a_5909_10114# RA1.t39 VDD VDD pfet_03v3 ad=0.3888p pd=2.52u as=0.3312p ps=2.36u w=0.72u l=0.28u
X4297 a_34500_10022# a_n884_10022.t27 a_34312_10022# VDD pfet_03v3 ad=0.1278p pd=1.07u as=0.2097p ps=1.38u w=0.36u l=0.28u
X4298 a_n1204_9238.t0 a_n1652_9238# VDD VDD pfet_03v3 ad=0.3302p pd=1.79u as=0.5588p ps=3.42u w=1.27u l=0.28u
X4299 a_19668_2182# a_n884_2182.t25 a_19480_2182# VDD pfet_03v3 ad=0.1278p pd=1.07u as=0.2097p ps=1.38u w=0.36u l=0.28u
X4300 VSS RB11.t36 a_28586_2528# VSS nfet_03v3 ad=0.1584p pd=1.6u as=0.1854p ps=1.75u w=0.36u l=0.28u
X4301 a_n1652_10454# CLK.t1 a_n1652_10014# VSS nfet_03v3 ad=0.3168p pd=2.32u as=0.1872p ps=1.24u w=0.72u l=0.28u
X4302 a_21952_9238# a_21888_n708.t29 VDD VDD pfet_03v3 ad=0.2097p pd=1.38u as=0.3168p ps=2.32u w=0.72u l=0.28u
X4303 a_9978_5038# a_9914_4724# a_9780_4534# VSS nfet_03v3 ad=56.7f pd=0.675u as=0.1278p ps=1.07u w=0.36u l=0.28u
X4304 VSS a_19668_3750# a_19802_4064# VSS nfet_03v3 ad=97.2f pd=0.9u as=0.1584p ps=1.6u w=0.36u l=0.28u
X4305 VDD.t741 RB15.t36 a_1394_n608# VDD.t740 pfet_03v3 ad=0.3168p pd=2.32u as=0.3708p ps=2.47u w=0.72u l=0.28u
X4306 VSS a_34500_10022# a_34634_10336# VSS nfet_03v3 ad=97.2f pd=0.9u as=0.1584p ps=1.6u w=0.36u l=0.28u
X4307 VDD a_n1204_1398.t31 a_2562_1398# VDD pfet_03v3 ad=0.1584p pd=1.6u as=56.7f ps=0.675u w=0.36u l=0.28u
X4308 a_15493_614# RA13.t37 a_15961_n862.t1 VSS nfet_03v3 ad=0.1152p pd=1u as=0.1584p ps=1.6u w=0.36u l=0.28u
X4309 VDD a_n1204_10022.t30 a_24810_10526# VDD pfet_03v3 ad=0.1584p pd=1.6u as=56.7f ps=0.675u w=0.36u l=0.28u
X4310 a_31840_8454# a_31776_n708.t28 VDD VDD pfet_03v3 ad=0.2097p pd=1.38u as=0.3168p ps=2.32u w=0.72u l=0.28u
X4311 a_3437_5410# RA7.t39 VDD VDD pfet_03v3 ad=0.3888p pd=2.52u as=0.3312p ps=2.36u w=0.72u l=0.28u
X4312 a_11287_n2146.t14 RB9.t30 a_10549_3750# VSS nfet_03v3 ad=0.1584p pd=1.6u as=0.1152p ps=1u w=0.36u l=0.28u
X4313 a_9592_9238# a_9528_n708.t27 VSS VSS nfet_03v3 ad=0.1188p pd=1.02u as=0.1584p ps=1.6u w=0.36u l=0.28u
X4314 a_22338_3750# a_22274_4064# a_22140_3750# VSS nfet_03v3 ad=56.7f pd=0.675u as=0.1278p ps=1.07u w=0.36u l=0.28u
X4315 a_3437_2274# RA11.t38 VDD VDD pfet_03v3 ad=0.3888p pd=2.52u as=0.3312p ps=2.36u w=0.72u l=0.28u
X4316 a_32797_10022# RA1.t40 a_33265_n862.t3 VSS nfet_03v3 ad=0.1152p pd=1u as=0.1584p ps=1.6u w=0.36u l=0.28u
X4317 a_9592_6102# a_9528_n708.t28 VSS VSS nfet_03v3 ad=0.1188p pd=1.02u as=0.1584p ps=1.6u w=0.36u l=0.28u
X4318 VSS a_n884_2966.t23 a_19866_3470# VSS nfet_03v3 ad=0.1584p pd=1.6u as=56.7f ps=0.675u w=0.36u l=0.28u
X4319 VDD a_24612_2966# a_24746_3156# VDD pfet_03v3 ad=0.1764p pd=1.26u as=0.1584p ps=1.6u w=0.36u l=0.28u
X4320 a_18269_9238# RA2.t34 VDD VDD pfet_03v3 ad=0.3888p pd=2.52u as=0.3312p ps=2.36u w=0.72u l=0.28u
X4321 a_5034_3750# a_4970_4064# a_4836_3750# VSS nfet_03v3 ad=56.7f pd=0.675u as=0.1278p ps=1.07u w=0.36u l=0.28u
X4322 VSS a_n1204_614.t30 a_n884_614.t2 VSS nfet_03v3 ad=0.2948p pd=2.22u as=0.1943p ps=1.25u w=0.67u l=0.28u
X4323 a_10853_10114# RA1.t41 VDD VDD pfet_03v3 ad=0.3888p pd=2.52u as=0.3312p ps=2.36u w=0.72u l=0.28u
X4324 a_n1652_8110# WE4.t1 VSS VSS nfet_03v3 ad=0.1872p pd=1.24u as=0.3168p ps=2.32u w=0.72u l=0.28u
X4325 VDD a_n1204_5318.t32 a_5034_5822# VDD pfet_03v3 ad=0.1584p pd=1.6u as=56.7f ps=0.675u w=0.36u l=0.28u
X4326 VDD a_7308_2966# a_7442_3156# VDD pfet_03v3 ad=0.1764p pd=1.26u as=0.1584p ps=1.6u w=0.36u l=0.28u
X4327 a_2120_n1782# a_2624_n1738# a_2912_n1234# VSS nfet_03v3 ad=0.1278p pd=1.07u as=56.7f ps=0.675u w=0.36u l=0.28u
X4328 a_n108_n170# a_n884_n170.t32 a_n296_n170# VDD.t1354 pfet_03v3 ad=0.1278p pd=1.07u as=0.2097p ps=1.38u w=0.36u l=0.28u
X4329 VSS a_n884_10022.t28 a_5034_10022# VSS nfet_03v3 ad=0.1584p pd=1.6u as=56.7f ps=0.675u w=0.36u l=0.28u
X4330 a_34248_n708.t0 a_34256_n1782# VDD VDD pfet_03v3 ad=0.3224p pd=1.76u as=0.5456p ps=3.36u w=1.24u l=0.28u
X4331 a_27282_9238# a_27218_9428# a_27084_9238# VDD pfet_03v3 ad=56.7f pd=0.675u as=0.1278p ps=1.07u w=0.36u l=0.28u
X4332 VDD RB9.t31 a_16226_4096# VDD pfet_03v3 ad=0.3168p pd=2.32u as=0.3708p ps=2.47u w=0.72u l=0.28u
X4333 a_28157_8546# RA3.t31 VDD VDD pfet_03v3 ad=0.3888p pd=2.52u as=0.3312p ps=2.36u w=0.72u l=0.28u
X4334 a_26896_n954# a_26832_n708.t32 VDD.t160 VDD.t150 pfet_03v3 ad=0.2097p pd=1.38u as=0.3168p ps=2.32u w=0.72u l=0.28u
X4335 VDD.t1569 a_n1204_n170.t35 a_22338_n170# VDD.t1232 pfet_03v3 ad=0.1584p pd=1.6u as=56.7f ps=0.675u w=0.36u l=0.28u
X4336 a_10549_n170# a_9780_n170# VDD.t3075 VDD.t2773 pfet_03v3 ad=0.36p pd=2.44u as=0.1764p ps=1.26u w=0.72u l=0.28u
X4337 VDD RB13.t36 a_16226_960# VDD pfet_03v3 ad=0.3168p pd=2.32u as=0.3708p ps=2.47u w=0.72u l=0.28u
X4338 a_13021_8454# RA3.t32 a_13489_n862.t22 VSS nfet_03v3 ad=0.1152p pd=1u as=0.1584p ps=1.6u w=0.36u l=0.28u
X4339 a_19480_1398# a_19416_n708.t28 VDD VDD pfet_03v3 ad=0.2097p pd=1.38u as=0.3168p ps=2.32u w=0.72u l=0.28u
X4340 a_34698_6102# a_34634_6292# a_34500_6102# VDD pfet_03v3 ad=56.7f pd=0.675u as=0.1278p ps=1.07u w=0.36u l=0.28u
X4341 VDD a_3601_n862.t33 QA1b.t0 VDD pfet_03v3 ad=0.2484p pd=1.41u as=0.4104p ps=2.58u w=0.72u l=0.28u
X4342 a_22909_1398# a_22140_1398# VDD VDD pfet_03v3 ad=0.36p pd=2.44u as=0.1764p ps=1.26u w=0.72u l=0.28u
X4343 a_18269_4534# RA8.t39 VSS VSS nfet_03v3 ad=0.1944p pd=1.8u as=0.1656p ps=1.64u w=0.36u l=0.28u
X4344 VDD a_14724_10806# a_14858_10996# VDD pfet_03v3 ad=0.1764p pd=1.26u as=0.1584p ps=1.6u w=0.36u l=0.28u
X4345 a_35269_10806# a_34500_10806# VSS VSS nfet_03v3 ad=0.18p pd=1.72u as=97.2f ps=0.9u w=0.36u l=0.28u
X4346 a_3133_7670# RA4.t36 a_3601_n862.t15 VSS nfet_03v3 ad=0.1152p pd=1u as=0.1584p ps=1.6u w=0.36u l=0.28u
X4347 a_7506_8174# a_7442_7860# a_7308_7670# VSS nfet_03v3 ad=56.7f pd=0.675u as=0.1278p ps=1.07u w=0.36u l=0.28u
X4348 VDD.t743 RB15.t37 a_31058_n608# VDD.t742 pfet_03v3 ad=0.3168p pd=2.32u as=0.3708p ps=2.47u w=0.72u l=0.28u
X4349 a_20437_5318# RA7.t40 a_20905_n862.t6 VSS nfet_03v3 ad=0.1152p pd=1u as=0.1584p ps=1.6u w=0.36u l=0.28u
X4350 a_17196_2182# a_n884_2182.t26 a_17008_2182# VDD pfet_03v3 ad=0.1278p pd=1.07u as=0.2097p ps=1.38u w=0.36u l=0.28u
X4351 a_4836_9238# a_n1204_9238.t35 a_4648_9238# VSS nfet_03v3 ad=0.1278p pd=1.07u as=0.1188p ps=1.02u w=0.36u l=0.28u
X4352 a_7506_5038# a_7442_4724# a_7308_4534# VSS nfet_03v3 ad=56.7f pd=0.675u as=0.1278p ps=1.07u w=0.36u l=0.28u
X4353 a_4836_6102# a_n1204_6102.t33 a_4648_6102# VSS nfet_03v3 ad=0.1278p pd=1.07u as=0.1188p ps=1.02u w=0.36u l=0.28u
X4354 VDD a_n1204_1398.t32 a_32226_1398# VDD pfet_03v3 ad=0.1584p pd=1.6u as=56.7f ps=0.675u w=0.36u l=0.28u
X4355 a_11287_n2146.t20 a_11282_9396# a_10549_9238# VDD pfet_03v3 ad=0.1584p pd=1.6u as=0.1152p ps=1u w=0.36u l=0.28u
X4356 VSS a_22140_9238# a_22274_9428# VSS nfet_03v3 ad=97.2f pd=0.9u as=0.1584p ps=1.6u w=0.36u l=0.28u
X4357 a_2364_n170# a_n1204_n170.t36 a_2176_n170# VSS nfet_03v3 ad=0.1278p pd=1.07u as=0.1188p ps=1.02u w=0.36u l=0.28u
X4358 a_31840_1398# a_31776_n708.t29 VSS VSS nfet_03v3 ad=0.1188p pd=1.02u as=0.1584p ps=1.6u w=0.36u l=0.28u
X4359 a_2562_5822# a_2498_5632# a_2364_5318# VDD pfet_03v3 ad=56.7f pd=0.675u as=0.1278p ps=1.07u w=0.36u l=0.28u
X4360 a_661_9238# a_n108_9238# VDD VDD pfet_03v3 ad=0.36p pd=2.44u as=0.1764p ps=1.26u w=0.72u l=0.28u
X4361 VSS a_22140_6102# a_22274_6292# VSS nfet_03v3 ad=97.2f pd=0.9u as=0.1584p ps=1.6u w=0.36u l=0.28u
X4362 VDD a_n1204_5318.t33 a_37170_5822# VDD pfet_03v3 ad=0.1584p pd=1.6u as=56.7f ps=0.675u w=0.36u l=0.28u
X4363 VSS RB10.t37 a_28586_3124# VSS nfet_03v3 ad=0.1584p pd=1.6u as=0.1854p ps=1.75u w=0.36u l=0.28u
X4364 VSS a_22140_10806# a_22274_10996# VSS nfet_03v3 ad=97.2f pd=0.9u as=0.1584p ps=1.6u w=0.36u l=0.28u
X4365 a_7120_9238# a_7056_n708.t25 VSS VSS nfet_03v3 ad=0.1188p pd=1.02u as=0.1584p ps=1.6u w=0.36u l=0.28u
X4366 a_n1204_6886.t2 a_n1652_7318# VSS VSS nfet_03v3 ad=0.1651p pd=1.155u as=0.2794p ps=2.15u w=0.635u l=0.28u
X4367 VDD a_32028_10806# a_32162_10996# VDD pfet_03v3 ad=0.1764p pd=1.26u as=0.1584p ps=1.6u w=0.36u l=0.28u
X4368 a_21952_6886# a_21888_n708.t30 VSS VSS nfet_03v3 ad=0.1188p pd=1.02u as=0.1584p ps=1.6u w=0.36u l=0.28u
X4369 a_26119_n2146.t20 RB7.t36 a_25381_5318# VSS nfet_03v3 ad=0.1584p pd=1.6u as=0.1152p ps=1u w=0.36u l=0.28u
X4370 VSS a_n884_2966.t24 a_17394_3470# VSS nfet_03v3 ad=0.1584p pd=1.6u as=56.7f ps=0.675u w=0.36u l=0.28u
X4371 a_28591_n2146.t12 a_28586_n12# a_27853_n170# VDD.t2137 pfet_03v3 ad=0.1584p pd=1.6u as=0.1152p ps=1u w=0.36u l=0.28u
X4372 a_7120_6102# a_7056_n708.t26 VSS VSS nfet_03v3 ad=0.1188p pd=1.02u as=0.1584p ps=1.6u w=0.36u l=0.28u
X4373 a_12064_2182# a_12000_n708.t26 VSS VSS nfet_03v3 ad=0.1188p pd=1.02u as=0.1584p ps=1.6u w=0.36u l=0.28u
X4374 VDD a_n1204_10022.t31 a_19866_10526# VDD pfet_03v3 ad=0.1584p pd=1.6u as=56.7f ps=0.675u w=0.36u l=0.28u
X4375 a_661_6102# a_965_6102# a_1129_n862.t21 VDD pfet_03v3 ad=0.1152p pd=1u as=0.1584p ps=1.6u w=0.36u l=0.28u
X4376 a_10853_3842# RA9.t38 VDD VDD pfet_03v3 ad=0.3888p pd=2.52u as=0.3312p ps=2.36u w=0.72u l=0.28u
X4377 a_27853_10022# RA1.t42 a_28321_n862.t9 VSS nfet_03v3 ad=0.1152p pd=1u as=0.1584p ps=1.6u w=0.36u l=0.28u
X4378 VDD RB4.t32 a_26114_7828# VDD pfet_03v3 ad=0.3168p pd=2.32u as=0.3708p ps=2.47u w=0.72u l=0.28u
X4379 a_11287_n2146.t29 RB8.t32 a_10549_4534# VSS nfet_03v3 ad=0.1584p pd=1.6u as=0.1152p ps=1u w=0.36u l=0.28u
X4380 a_10853_706# RA13.t38 VDD VDD pfet_03v3 ad=0.3888p pd=2.52u as=0.3312p ps=2.36u w=0.72u l=0.28u
X4381 a_32797_10806# RA0.t41 a_33265_n862.t15 VSS nfet_03v3 ad=0.1152p pd=1u as=0.1584p ps=1.6u w=0.36u l=0.28u
X4382 VSS a_34500_7670# a_34634_7860# VSS nfet_03v3 ad=97.2f pd=0.9u as=0.1584p ps=1.6u w=0.36u l=0.28u
X4383 VDD a_29556_6102# a_29690_6292# VDD pfet_03v3 ad=0.1764p pd=1.26u as=0.1584p ps=1.6u w=0.36u l=0.28u
X4384 a_8815_n2146.t14 RB7.t37 a_8077_5318# VSS nfet_03v3 ad=0.1584p pd=1.6u as=0.1152p ps=1u w=0.36u l=0.28u
X4385 VDD a_4836_2966# a_4970_3156# VDD pfet_03v3 ad=0.1764p pd=1.26u as=0.1584p ps=1.6u w=0.36u l=0.28u
X4386 a_35269_7670# RA4.t37 a_35737_n862.t9 VSS nfet_03v3 ad=0.1152p pd=1u as=0.1584p ps=1.6u w=0.36u l=0.28u
X4387 VDD RB8.t33 a_26114_4692# VDD pfet_03v3 ad=0.3168p pd=2.32u as=0.3708p ps=2.47u w=0.72u l=0.28u
X4388 a_19480_614# a_19416_n708.t29 VSS VSS nfet_03v3 ad=0.1188p pd=1.02u as=0.1584p ps=1.6u w=0.36u l=0.28u
X4389 VDD a_n1204_7670.t34 a_34698_7670# VDD pfet_03v3 ad=0.1584p pd=1.6u as=56.7f ps=0.675u w=0.36u l=0.28u
X4390 VSS a_34500_4534# a_34634_4724# VSS nfet_03v3 ad=97.2f pd=0.9u as=0.1584p ps=1.6u w=0.36u l=0.28u
X4391 VDD RB9.t32 a_13754_4096# VDD pfet_03v3 ad=0.3168p pd=2.32u as=0.3708p ps=2.47u w=0.72u l=0.28u
X4392 a_37170_1902# a_37106_1588# a_36972_1398# VSS nfet_03v3 ad=56.7f pd=0.675u as=0.1278p ps=1.07u w=0.36u l=0.28u
X4393 a_38045_6102# RA6.t37 VDD VDD pfet_03v3 ad=0.3888p pd=2.52u as=0.3312p ps=2.36u w=0.72u l=0.28u
X4394 VDD a_n1204_4534.t35 a_34698_4534# VDD pfet_03v3 ad=0.1584p pd=1.6u as=56.7f ps=0.675u w=0.36u l=0.28u
X4395 VDD RB13.t37 a_13754_960# VDD pfet_03v3 ad=0.3168p pd=2.32u as=0.3708p ps=2.47u w=0.72u l=0.28u
X4396 a_4648_8454# a_4584_n708.t30 VSS VSS nfet_03v3 ad=0.1188p pd=1.02u as=0.1584p ps=1.6u w=0.36u l=0.28u
X4397 a_20437_1398# a_19668_1398# VDD VDD pfet_03v3 ad=0.36p pd=2.44u as=0.1764p ps=1.26u w=0.72u l=0.28u
X4398 a_32226_6102# a_32162_6292# a_32028_6102# VDD pfet_03v3 ad=56.7f pd=0.675u as=0.1278p ps=1.07u w=0.36u l=0.28u
X4399 a_661_1398# RA12.t38 a_1129_n862.t3 VSS nfet_03v3 ad=0.1152p pd=1u as=0.1584p ps=1.6u w=0.36u l=0.28u
X4400 a_n108_10022# a_n1204_10022.t32 a_n296_10022# VSS nfet_03v3 ad=0.1278p pd=1.07u as=0.1188p ps=1.02u w=0.36u l=0.28u
X4401 a_24612_10022# a_n1204_10022.t33 a_24424_10022# VSS nfet_03v3 ad=0.1278p pd=1.07u as=0.1188p ps=1.02u w=0.36u l=0.28u
X4402 a_8381_8546# RA3.t33 VDD VDD pfet_03v3 ad=0.3888p pd=2.52u as=0.3312p ps=2.36u w=0.72u l=0.28u
X4403 a_5909_6102# RA6.t38 VDD VDD pfet_03v3 ad=0.3888p pd=2.52u as=0.3312p ps=2.36u w=0.72u l=0.28u
X4404 a_4648_5318# a_4584_n708.t31 VSS VSS nfet_03v3 ad=0.1188p pd=1.02u as=0.1584p ps=1.6u w=0.36u l=0.28u
X4405 VSS a_n884_2182.t27 a_14922_2182# VSS nfet_03v3 ad=0.1584p pd=1.6u as=56.7f ps=0.675u w=0.36u l=0.28u
X4406 a_27282_6886# a_27218_7200# a_27084_6886# VSS nfet_03v3 ad=56.7f pd=0.675u as=0.1278p ps=1.07u w=0.36u l=0.28u
X4407 VDD.t1570 a_n1204_n170.t37 a_2562_n170# VDD.t1234 pfet_03v3 ad=0.1584p pd=1.6u as=56.7f ps=0.675u w=0.36u l=0.28u
X4408 VSS.t1261 a_n884_n954.t27 a_24810_n954# VSS nfet_03v3 ad=0.1584p pd=1.6u as=56.7f ps=0.675u w=0.36u l=0.28u
X4409 VDD RB6.t35 a_8810_6260# VDD pfet_03v3 ad=0.3168p pd=2.32u as=0.3708p ps=2.47u w=0.72u l=0.28u
X4410 a_23647_n2146.t9 RB9.t33 a_22909_3750# VSS nfet_03v3 ad=0.1584p pd=1.6u as=0.1152p ps=1u w=0.36u l=0.28u
X4411 a_8077_2966# a_8381_2966# a_8545_n862.t24 VDD pfet_03v3 ad=0.1152p pd=1u as=0.1584p ps=1.6u w=0.36u l=0.28u
X4412 VSS a_n884_10022.t29 a_14922_10022# VSS nfet_03v3 ad=0.1584p pd=1.6u as=56.7f ps=0.675u w=0.36u l=0.28u
X4413 a_34698_3750# a_34634_4064# a_34500_3750# VSS nfet_03v3 ad=56.7f pd=0.675u as=0.1278p ps=1.07u w=0.36u l=0.28u
X4414 VSS a_28321_n862.t32 QA11b.t1 VSS nfet_03v3 ad=0.1242p pd=1.05u as=0.2052p ps=1.86u w=0.36u l=0.28u
X4415 a_n1652_n522# CLK a_n1652_n962# VSS nfet_03v3 ad=0.3168p pd=2.32u as=0.1872p ps=1.24u w=0.72u l=0.28u
X4416 a_38045_1398# RA12.t39 VSS VSS nfet_03v3 ad=0.1944p pd=1.8u as=0.1656p ps=1.64u w=0.36u l=0.28u
X4417 a_20437_9238# RA2.t35 a_20905_n862.t0 VSS nfet_03v3 ad=0.1152p pd=1u as=0.1584p ps=1.6u w=0.36u l=0.28u
X4418 a_20437_6102# RA6.t39 a_20905_n862.t18 VSS nfet_03v3 ad=0.1152p pd=1u as=0.1584p ps=1.6u w=0.36u l=0.28u
X4419 VDD a_36972_2966# a_37106_3156# VDD pfet_03v3 ad=0.1764p pd=1.26u as=0.1584p ps=1.6u w=0.36u l=0.28u
X4420 a_5909_1398# RA12.t40 VSS VSS nfet_03v3 ad=0.1944p pd=1.8u as=0.1656p ps=1.64u w=0.36u l=0.28u
X4421 a_7856_n1738# WEM.t27 VDD VDD pfet_03v3 ad=56.7f pd=0.675u as=0.1584p ps=1.6u w=0.36u l=0.28u
X4422 a_20741_7670# RA4.t38 VDD VDD pfet_03v3 ad=0.3888p pd=2.52u as=0.3312p ps=2.36u w=0.72u l=0.28u
X4423 a_19866_2686# a_19802_2496# a_19668_2182# VDD pfet_03v3 ad=56.7f pd=0.675u as=0.1278p ps=1.07u w=0.36u l=0.28u
X4424 a_n1652_2614# CLK a_n1652_2174# VSS nfet_03v3 ad=0.3168p pd=2.32u as=0.1872p ps=1.24u w=0.72u l=0.28u
X4425 VSS.t753 RB15.t38 a_11282_n608# VSS nfet_03v3 ad=0.1584p pd=1.6u as=0.1854p ps=1.75u w=0.36u l=0.28u
X4426 a_20741_4534# RA8.t40 VDD VDD pfet_03v3 ad=0.3888p pd=2.52u as=0.3312p ps=2.36u w=0.72u l=0.28u
X4427 a_38479_n2146.t6 a_38474_1556# a_37741_1398# VDD pfet_03v3 ad=0.1584p pd=1.6u as=0.1152p ps=1u w=0.36u l=0.28u
X4428 VDD a_n1204_6886.t33 a_12450_7390# VDD pfet_03v3 ad=0.1584p pd=1.6u as=56.7f ps=0.675u w=0.36u l=0.28u
X4429 a_28157_3842# RA9.t39 VSS VSS nfet_03v3 ad=0.1944p pd=1.8u as=0.1656p ps=1.64u w=0.36u l=0.28u
X4430 VSS RB12.t39 a_8810_1556# VSS nfet_03v3 ad=0.1584p pd=1.6u as=0.1854p ps=1.75u w=0.36u l=0.28u
X4431 a_24424_10806# a_24360_n708.t30 VSS VSS nfet_03v3 ad=0.1188p pd=1.02u as=0.1584p ps=1.6u w=0.36u l=0.28u
X4432 a_661_6886# a_n108_6886# VSS VSS nfet_03v3 ad=0.18p pd=1.72u as=97.2f ps=0.9u w=0.36u l=0.28u
X4433 a_34312_10806# a_34248_n708.t30 VDD VDD pfet_03v3 ad=0.2097p pd=1.38u as=0.3168p ps=2.32u w=0.72u l=0.28u
X4434 a_26119_n2146.t8 RB2.t34 a_25381_9238# VSS nfet_03v3 ad=0.1584p pd=1.6u as=0.1152p ps=1u w=0.36u l=0.28u
X4435 a_12064_8454# a_12000_n708.t27 VDD VDD pfet_03v3 ad=0.2097p pd=1.38u as=0.3168p ps=2.32u w=0.72u l=0.28u
X4436 VDD a_n1204_3750.t33 a_12450_4254# VDD pfet_03v3 ad=0.1584p pd=1.6u as=56.7f ps=0.675u w=0.36u l=0.28u
X4437 a_36007_n2146.t12 RB11.t37 a_35269_2182# VSS nfet_03v3 ad=0.1584p pd=1.6u as=0.1152p ps=1u w=0.36u l=0.28u
X4438 a_19480_n170# a_19416_n708.t30 VDD.t1808 VDD.t1786 pfet_03v3 ad=0.2097p pd=1.38u as=0.3168p ps=2.32u w=0.72u l=0.28u
X4439 a_6343_n2146.t19 RB7.t38 a_5605_5318# VSS nfet_03v3 ad=0.1584p pd=1.6u as=0.1152p ps=1u w=0.36u l=0.28u
X4440 a_22909_n170# a_22140_n170# VDD.t2566 VDD.t2382 pfet_03v3 ad=0.36p pd=2.44u as=0.1764p ps=1.26u w=0.72u l=0.28u
X4441 a_15797_10114# RA1.t43 VSS VSS nfet_03v3 ad=0.1944p pd=1.8u as=0.1656p ps=1.64u w=0.36u l=0.28u
X4442 a_25381_8454# RA3.t34 a_25849_n862.t21 VSS nfet_03v3 ad=0.1152p pd=1u as=0.1584p ps=1.6u w=0.36u l=0.28u
X4443 a_32797_7670# RA4.t39 a_33265_n862.t11 VSS nfet_03v3 ad=0.1152p pd=1u as=0.1584p ps=1.6u w=0.36u l=0.28u
X4444 a_26119_n2146.t7 RB6.t36 a_25381_6102# VSS nfet_03v3 ad=0.1584p pd=1.6u as=0.1152p ps=1u w=0.36u l=0.28u
X4445 VDD a_n1204_614.t31 a_12450_1118# VDD pfet_03v3 ad=0.1584p pd=1.6u as=56.7f ps=0.675u w=0.36u l=0.28u
X4446 VDD RB4.t33 a_6338_7828# VDD pfet_03v3 ad=0.3168p pd=2.32u as=0.3708p ps=2.47u w=0.72u l=0.28u
X4447 VDD a_21896_n1782# a_21888_n708.t0 VDD pfet_03v3 ad=0.5456p pd=3.36u as=0.3224p ps=1.76u w=1.24u l=0.28u
X4448 a_1399_n2146.t13 RB14.t42 a_661_n170# VSS nfet_03v3 ad=0.1584p pd=1.6u as=0.1152p ps=1u w=0.36u l=0.28u
X4449 a_27853_10806# RA0.t42 a_28321_n862.t3 VSS nfet_03v3 ad=0.1152p pd=1u as=0.1584p ps=1.6u w=0.36u l=0.28u
X4450 a_8815_n2146.t5 RB2.t35 a_8077_9238# VSS nfet_03v3 ad=0.1584p pd=1.6u as=0.1152p ps=1u w=0.36u l=0.28u
X4451 a_9528_n708.t2 a_9536_n1782# VSS.t2852 VSS nfet_03v3 ad=0.1612p pd=1.14u as=0.2728p ps=2.12u w=0.62u l=0.28u
X4452 VDD RB8.t34 a_6338_4692# VDD pfet_03v3 ad=0.3168p pd=2.32u as=0.3708p ps=2.47u w=0.72u l=0.28u
X4453 a_29556_2182# a_n884_2182.t28 a_29368_2182# VDD pfet_03v3 ad=0.1278p pd=1.07u as=0.2097p ps=1.38u w=0.36u l=0.28u
X4454 VSS RB11.t38 a_38474_2528# VSS nfet_03v3 ad=0.1584p pd=1.6u as=0.1854p ps=1.75u w=0.36u l=0.28u
X4455 a_12800_n1738# WEM.t28 VDD VDD pfet_03v3 ad=56.7f pd=0.675u as=0.1584p ps=1.6u w=0.36u l=0.28u
X4456 a_27853_10806# a_27084_10806# VDD VDD pfet_03v3 ad=0.36p pd=2.44u as=0.1764p ps=1.26u w=0.72u l=0.28u
X4457 VSS RB1.t33 a_6338_10368# VSS nfet_03v3 ad=0.1584p pd=1.6u as=0.1854p ps=1.75u w=0.36u l=0.28u
X4458 a_3437_6102# RA6.t40 VDD VDD pfet_03v3 ad=0.3888p pd=2.52u as=0.3312p ps=2.36u w=0.72u l=0.28u
X4459 a_8815_n2146.t4 RB6.t37 a_8077_6102# VSS nfet_03v3 ad=0.1584p pd=1.6u as=0.1152p ps=1u w=0.36u l=0.28u
X4460 VSS a_29556_3750# a_29690_4064# VSS nfet_03v3 ad=97.2f pd=0.9u as=0.1584p ps=1.6u w=0.36u l=0.28u
X4461 VDD.t1571 a_n1204_n170.t38 a_32226_n170# VDD.t1236 pfet_03v3 ad=0.1584p pd=1.6u as=56.7f ps=0.675u w=0.36u l=0.28u
X4462 a_31840_9238# a_31776_n708.t30 VDD VDD pfet_03v3 ad=0.2097p pd=1.38u as=0.3168p ps=2.32u w=0.72u l=0.28u
X4463 VDD a_17196_5318# a_17330_5632# VDD pfet_03v3 ad=0.1764p pd=1.26u as=0.1584p ps=1.6u w=0.36u l=0.28u
X4464 a_4648_n954# a_4584_n708.t32 VDD.t1645 VDD.t1587 pfet_03v3 ad=0.2097p pd=1.38u as=0.3168p ps=2.32u w=0.72u l=0.28u
X4465 a_23647_n2146.t31 a_23642_9396# a_22909_9238# VDD pfet_03v3 ad=0.1584p pd=1.6u as=0.1152p ps=1u w=0.36u l=0.28u
X4466 a_37741_2966# a_38045_2966# a_38209_n862.t22 VDD pfet_03v3 ad=0.1152p pd=1u as=0.1584p ps=1.6u w=0.36u l=0.28u
X4467 a_22909_10022# a_23213_10114# a_23377_n862.t14 VDD pfet_03v3 ad=0.1152p pd=1u as=0.1584p ps=1.6u w=0.36u l=0.28u
X4468 a_30325_6886# a_29556_6886# VDD VDD pfet_03v3 ad=0.36p pd=2.44u as=0.1764p ps=1.26u w=0.72u l=0.28u
X4469 VSS a_2364_9238# a_2498_9428# VSS nfet_03v3 ad=97.2f pd=0.9u as=0.1584p ps=1.6u w=0.36u l=0.28u
X4470 a_5605_2966# a_5909_2966# a_6073_n862.t26 VDD pfet_03v3 ad=0.1152p pd=1u as=0.1584p ps=1.6u w=0.36u l=0.28u
X4471 a_21175_n2146.t0 RB9.t34 a_20437_3750# VSS nfet_03v3 ad=0.1584p pd=1.6u as=0.1152p ps=1u w=0.36u l=0.28u
X4472 a_32226_3750# a_32162_4064# a_32028_3750# VSS nfet_03v3 ad=56.7f pd=0.675u as=0.1278p ps=1.07u w=0.36u l=0.28u
X4473 VDD a_29556_10022# a_29690_10336# VDD pfet_03v3 ad=0.1764p pd=1.26u as=0.1584p ps=1.6u w=0.36u l=0.28u
X4474 VSS a_2364_6102# a_2498_6292# VSS nfet_03v3 ad=97.2f pd=0.9u as=0.1584p ps=1.6u w=0.36u l=0.28u
X4475 a_17008_2966# a_16944_n708.t31 VDD VDD pfet_03v3 ad=0.2097p pd=1.38u as=0.3168p ps=2.32u w=0.72u l=0.28u
X4476 VSS a_n884_2966.t25 a_29754_3470# VSS nfet_03v3 ad=0.1584p pd=1.6u as=56.7f ps=0.675u w=0.36u l=0.28u
X4477 a_3437_1398# RA12.t41 VSS VSS nfet_03v3 ad=0.1944p pd=1.8u as=0.1656p ps=1.64u w=0.36u l=0.28u
X4478 a_n1652_1046# CLK a_n1652_606# VSS nfet_03v3 ad=0.3168p pd=2.32u as=0.1872p ps=1.24u w=0.72u l=0.28u
X4479 a_28157_9238# RA2.t36 VDD VDD pfet_03v3 ad=0.3888p pd=2.52u as=0.3312p ps=2.36u w=0.72u l=0.28u
X4480 a_23647_n2146.t27 RB8.t35 a_22909_4534# VSS nfet_03v3 ad=0.1584p pd=1.6u as=0.1152p ps=1u w=0.36u l=0.28u
X4481 a_12064_1398# a_12000_n708.t28 VSS VSS nfet_03v3 ad=0.1188p pd=1.02u as=0.1584p ps=1.6u w=0.36u l=0.28u
X4482 a_37170_9238# a_37106_9428# a_36972_9238# VDD pfet_03v3 ad=56.7f pd=0.675u as=0.1278p ps=1.07u w=0.36u l=0.28u
X4483 VDD a_n1204_6886.t34 a_9978_7390# VDD pfet_03v3 ad=0.1584p pd=1.6u as=56.7f ps=0.675u w=0.36u l=0.28u
X4484 VDD RB9.t35 a_26114_4096# VDD pfet_03v3 ad=0.3168p pd=2.32u as=0.3708p ps=2.47u w=0.72u l=0.28u
X4485 VDD a_n1204_3750.t34 a_9978_4254# VDD pfet_03v3 ad=0.1584p pd=1.6u as=56.7f ps=0.675u w=0.36u l=0.28u
X4486 a_20437_n170# a_19668_n170# VDD.t2801 VDD.t2370 pfet_03v3 ad=0.36p pd=2.44u as=0.1764p ps=1.26u w=0.72u l=0.28u
X4487 VDD a_12252_1398# a_12386_1588# VDD pfet_03v3 ad=0.1764p pd=1.26u as=0.1584p ps=1.6u w=0.36u l=0.28u
X4488 VDD RB13.t38 a_26114_960# VDD pfet_03v3 ad=0.3168p pd=2.32u as=0.3708p ps=2.47u w=0.72u l=0.28u
X4489 VDD a_n1204_614.t32 a_9978_1118# VDD pfet_03v3 ad=0.1584p pd=1.6u as=56.7f ps=0.675u w=0.36u l=0.28u
X4490 a_29368_1398# a_29304_n708.t29 VDD VDD pfet_03v3 ad=0.2097p pd=1.38u as=0.3168p ps=2.32u w=0.72u l=0.28u
X4491 a_22909_8454# RA3.t35 a_23377_n862.t7 VSS nfet_03v3 ad=0.1152p pd=1u as=0.1584p ps=1.6u w=0.36u l=0.28u
X4492 a_8381_3842# RA9.t40 VSS VSS nfet_03v3 ad=0.1944p pd=1.8u as=0.1656p ps=1.64u w=0.36u l=0.28u
X4493 a_32797_1398# a_32028_1398# VDD VDD pfet_03v3 ad=0.36p pd=2.44u as=0.1764p ps=1.26u w=0.72u l=0.28u
X4494 a_14724_8454# a_n1204_8454.t29 a_14536_8454# VSS nfet_03v3 ad=0.1278p pd=1.07u as=0.1188p ps=1.02u w=0.36u l=0.28u
X4495 VSS.t3190 a_2120_n1782# a_2112_n708.t2 VSS nfet_03v3 ad=0.2728p pd=2.12u as=0.1612p ps=1.14u w=0.62u l=0.28u
X4496 a_19668_n954# a_n884_n954.t28 a_19480_n954# VDD.t1357 pfet_03v3 ad=0.1278p pd=1.07u as=0.2097p ps=1.38u w=0.36u l=0.28u
X4497 VDD RB4.t34 a_3866_7828# VDD pfet_03v3 ad=0.3168p pd=2.32u as=0.3708p ps=2.47u w=0.72u l=0.28u
X4498 a_28157_4534# RA8.t41 VSS VSS nfet_03v3 ad=0.1944p pd=1.8u as=0.1656p ps=1.64u w=0.36u l=0.28u
X4499 VSS RB14.t43 a_13754_n12# VSS nfet_03v3 ad=0.1584p pd=1.6u as=0.1854p ps=1.75u w=0.36u l=0.28u
X4500 a_6343_n2146.t2 RB2.t36 a_5605_9238# VSS nfet_03v3 ad=0.1584p pd=1.6u as=0.1152p ps=1u w=0.36u l=0.28u
X4501 a_14724_5318# a_n1204_5318.t34 a_14536_5318# VSS nfet_03v3 ad=0.1278p pd=1.07u as=0.1188p ps=1.02u w=0.36u l=0.28u
X4502 a_19866_10526# a_19802_10336# a_19668_10022# VDD pfet_03v3 ad=56.7f pd=0.675u as=0.1278p ps=1.07u w=0.36u l=0.28u
X4503 a_6343_n2146.t9 RB6.t38 a_5605_6102# VSS nfet_03v3 ad=0.1584p pd=1.6u as=0.1152p ps=1u w=0.36u l=0.28u
X4504 a_30325_5318# RA7.t41 a_30793_n862.t14 VSS nfet_03v3 ad=0.1152p pd=1u as=0.1584p ps=1.6u w=0.36u l=0.28u
X4505 VDD RB8.t36 a_3866_4692# VDD pfet_03v3 ad=0.3168p pd=2.32u as=0.3708p ps=2.47u w=0.72u l=0.28u
X4506 a_36007_n2146.t7 RB10.t38 a_35269_2966# VSS nfet_03v3 ad=0.1584p pd=1.6u as=0.1152p ps=1u w=0.36u l=0.28u
X4507 a_15493_2182# a_15797_2274# a_15961_n862.t14 VDD pfet_03v3 ad=0.1152p pd=1u as=0.1584p ps=1.6u w=0.36u l=0.28u
X4508 VSS a_n884_1398.t30 a_14922_1902# VSS nfet_03v3 ad=0.1584p pd=1.6u as=56.7f ps=0.675u w=0.36u l=0.28u
X4509 a_15797_10806# RA0.t43 VSS VSS nfet_03v3 ad=0.1944p pd=1.8u as=0.1656p ps=1.64u w=0.36u l=0.28u
X4510 a_21175_n2146.t26 a_21170_9396# a_20437_9238# VDD pfet_03v3 ad=0.1584p pd=1.6u as=0.1152p ps=1u w=0.36u l=0.28u
X4511 VDD a_14724_5318# a_14858_5632# VDD pfet_03v3 ad=0.1764p pd=1.26u as=0.1584p ps=1.6u w=0.36u l=0.28u
X4512 VSS a_32028_9238# a_32162_9428# VSS nfet_03v3 ad=97.2f pd=0.9u as=0.1584p ps=1.6u w=0.36u l=0.28u
X4513 VSS a_32028_6102# a_32162_6292# VSS nfet_03v3 ad=97.2f pd=0.9u as=0.1584p ps=1.6u w=0.36u l=0.28u
X4514 VDD RB7.t39 a_11282_5664# VDD pfet_03v3 ad=0.3168p pd=2.32u as=0.3708p ps=2.47u w=0.72u l=0.28u
X4515 a_9780_2182# a_n884_2182.t29 a_9592_2182# VDD pfet_03v3 ad=0.1278p pd=1.07u as=0.2097p ps=1.38u w=0.36u l=0.28u
X4516 VSS RB10.t39 a_38474_3124# VSS nfet_03v3 ad=0.1584p pd=1.6u as=0.1854p ps=1.75u w=0.36u l=0.28u
X4517 VSS RB0.t34 a_6338_10964# VSS nfet_03v3 ad=0.1584p pd=1.6u as=0.1854p ps=1.75u w=0.36u l=0.28u
X4518 a_14536_2966# a_14472_n708.t34 VDD VDD pfet_03v3 ad=0.2097p pd=1.38u as=0.3168p ps=2.32u w=0.72u l=0.28u
X4519 VDD a_n1204_2182.t28 a_90_2686# VDD pfet_03v3 ad=0.1584p pd=1.6u as=56.7f ps=0.675u w=0.36u l=0.28u
X4520 VDD RB11.t39 a_11282_2528# VDD pfet_03v3 ad=0.3168p pd=2.32u as=0.3708p ps=2.47u w=0.72u l=0.28u
X4521 a_31840_6886# a_31776_n708.t31 VSS VSS nfet_03v3 ad=0.1188p pd=1.02u as=0.1584p ps=1.6u w=0.36u l=0.28u
X4522 a_21896_n1782# a_22400_n1738# a_22688_n1234# VSS nfet_03v3 ad=0.1278p pd=1.07u as=56.7f ps=0.675u w=0.36u l=0.28u
X4523 a_38479_n2146.t24 a_38474_n12# a_37741_n170# VDD.t2810 pfet_03v3 ad=0.1584p pd=1.6u as=0.1152p ps=1u w=0.36u l=0.28u
X4524 VSS a_n884_2966.t26 a_27282_3470# VSS nfet_03v3 ad=0.1584p pd=1.6u as=56.7f ps=0.675u w=0.36u l=0.28u
X4525 VSS.t754 RB15.t39 a_23642_n608# VSS nfet_03v3 ad=0.1584p pd=1.6u as=0.1854p ps=1.75u w=0.36u l=0.28u
X4526 VSS a_n1652_4534# a_n1204_4534.t2 VSS nfet_03v3 ad=0.1693p pd=1.19u as=0.1651p ps=1.155u w=0.635u l=0.28u
X4527 a_20741_3842# RA9.t41 VDD VDD pfet_03v3 ad=0.3888p pd=2.52u as=0.3312p ps=2.36u w=0.72u l=0.28u
X4528 a_13021_1398# a_13325_1398# a_13489_n862.t12 VDD pfet_03v3 ad=0.1152p pd=1u as=0.1584p ps=1.6u w=0.36u l=0.28u
X4529 VSS a_n1652_1398# a_n1204_1398.t2 VSS nfet_03v3 ad=0.1693p pd=1.19u as=0.1651p ps=1.155u w=0.635u l=0.28u
X4530 VSS a_36972_10806# a_37106_10996# VSS nfet_03v3 ad=97.2f pd=0.9u as=0.1584p ps=1.6u w=0.36u l=0.28u
X4531 VDD RB4.t35 a_36002_7828# VDD pfet_03v3 ad=0.3168p pd=2.32u as=0.3708p ps=2.47u w=0.72u l=0.28u
X4532 a_21175_n2146.t2 RB8.t37 a_20437_4534# VSS nfet_03v3 ad=0.1584p pd=1.6u as=0.1152p ps=1u w=0.36u l=0.28u
X4533 a_29754_2686# a_29690_2496# a_29556_2182# VDD pfet_03v3 ad=56.7f pd=0.675u as=0.1278p ps=1.07u w=0.36u l=0.28u
X4534 a_20741_706# RA13.t39 VDD VDD pfet_03v3 ad=0.3888p pd=2.52u as=0.3312p ps=2.36u w=0.72u l=0.28u
X4535 a_n1204_614.t2 a_n1652_1046# VSS VSS nfet_03v3 ad=0.1651p pd=1.155u as=0.2794p ps=2.15u w=0.635u l=0.28u
X4536 VSS WE0CLK.t34 a_n884_10806.t3 VSS nfet_03v3 ad=0.2948p pd=2.22u as=0.1943p ps=1.25u w=0.67u l=0.28u
X4537 VDD a_7308_10022# a_7442_10336# VDD pfet_03v3 ad=0.1764p pd=1.26u as=0.1584p ps=1.6u w=0.36u l=0.28u
X4538 a_34312_10022# a_34248_n708.t31 VDD VDD pfet_03v3 ad=0.2097p pd=1.38u as=0.3168p ps=2.32u w=0.72u l=0.28u
X4539 VDD RB8.t38 a_36002_4692# VDD pfet_03v3 ad=0.3168p pd=2.32u as=0.3708p ps=2.47u w=0.72u l=0.28u
X4540 QB13b.t0 a_33535_n2146.t33 VDD VDD pfet_03v3 ad=0.4104p pd=2.58u as=0.2484p ps=1.41u w=0.72u l=0.28u
X4541 VDD a_23377_n862.t33 QA9b.t0 VDD pfet_03v3 ad=0.2484p pd=1.41u as=0.4104p ps=2.58u w=0.72u l=0.28u
X4542 a_17965_5318# a_18269_5410# a_18433_n862.t3 VDD pfet_03v3 ad=0.1152p pd=1u as=0.1584p ps=1.6u w=0.36u l=0.28u
X4543 a_8381_9238# RA2.t37 VDD VDD pfet_03v3 ad=0.3888p pd=2.52u as=0.3312p ps=2.36u w=0.72u l=0.28u
X4544 a_757_n1738# a_n884_n1738.t25 a_n352_n1782# VDD pfet_03v3 ad=0.2097p pd=1.38u as=0.1278p ps=1.07u w=0.36u l=0.28u
X4545 a_12252_8454# a_n1204_8454.t30 a_12064_8454# VSS nfet_03v3 ad=0.1278p pd=1.07u as=0.1188p ps=1.02u w=0.36u l=0.28u
X4546 a_2364_2966# a_n1204_2966.t39 a_2176_2966# VSS nfet_03v3 ad=0.1278p pd=1.07u as=0.1188p ps=1.02u w=0.36u l=0.28u
X4547 VDD RB9.t36 a_6338_4096# VDD pfet_03v3 ad=0.3168p pd=2.32u as=0.3708p ps=2.47u w=0.72u l=0.28u
X4548 VSS a_n884_2182.t30 a_24810_2182# VSS nfet_03v3 ad=0.1584p pd=1.6u as=56.7f ps=0.675u w=0.36u l=0.28u
X4549 a_17196_n954# a_n884_n954.t29 a_17008_n954# VDD.t1358 pfet_03v3 ad=0.1278p pd=1.07u as=0.2097p ps=1.38u w=0.36u l=0.28u
X4550 a_27853_10022# a_27084_10022# VDD VDD pfet_03v3 ad=0.36p pd=2.44u as=0.1764p ps=1.26u w=0.72u l=0.28u
X4551 VDD CLK a_n1652_8886# VDD pfet_03v3 ad=0.3168p pd=2.32u as=0.1872p ps=1.24u w=0.72u l=0.28u
X4552 a_17965_7670# a_17196_7670# VDD VDD pfet_03v3 ad=0.36p pd=2.44u as=0.1764p ps=1.26u w=0.72u l=0.28u
X4553 a_12252_5318# a_n1204_5318.t35 a_12064_5318# VSS nfet_03v3 ad=0.1278p pd=1.07u as=0.1188p ps=1.02u w=0.36u l=0.28u
X4554 a_37170_6886# a_37106_7200# a_36972_6886# VSS nfet_03v3 ad=56.7f pd=0.675u as=0.1278p ps=1.07u w=0.36u l=0.28u
X4555 VSS.t1262 a_n884_n954.t30 a_34698_n954# VSS nfet_03v3 ad=0.1584p pd=1.6u as=56.7f ps=0.675u w=0.36u l=0.28u
X4556 VDD RB13.t39 a_6338_960# VDD pfet_03v3 ad=0.3168p pd=2.32u as=0.3708p ps=2.47u w=0.72u l=0.28u
X4557 a_9592_1398# a_9528_n708.t29 VDD VDD pfet_03v3 ad=0.2097p pd=1.38u as=0.3168p ps=2.32u w=0.72u l=0.28u
X4558 a_3133_8454# RA3.t36 a_3601_n862.t4 VSS nfet_03v3 ad=0.1152p pd=1u as=0.1584p ps=1.6u w=0.36u l=0.28u
X4559 a_15797_6978# RA5.t35 VDD VDD pfet_03v3 ad=0.3888p pd=2.52u as=0.3312p ps=2.36u w=0.72u l=0.28u
X4560 a_17965_4534# a_17196_4534# VDD VDD pfet_03v3 ad=0.36p pd=2.44u as=0.1764p ps=1.26u w=0.72u l=0.28u
X4561 a_90_5822# a_26_5632# a_n108_5318# VDD pfet_03v3 ad=56.7f pd=0.675u as=0.1278p ps=1.07u w=0.36u l=0.28u
X4562 a_8381_4534# RA8.t42 VSS VSS nfet_03v3 ad=0.1944p pd=1.8u as=0.1656p ps=1.64u w=0.36u l=0.28u
X4563 a_33535_n2146.t15 RB9.t37 a_32797_3750# VSS nfet_03v3 ad=0.1584p pd=1.6u as=0.1152p ps=1u w=0.36u l=0.28u
X4564 a_30325_9238# RA2.t38 a_30793_n862.t22 VSS nfet_03v3 ad=0.1152p pd=1u as=0.1584p ps=1.6u w=0.36u l=0.28u
X4565 VSS RB5.t39 a_28586_7232# VSS nfet_03v3 ad=0.1584p pd=1.6u as=0.1854p ps=1.75u w=0.36u l=0.28u
X4566 a_7308_2182# a_n884_2182.t31 a_7120_2182# VDD pfet_03v3 ad=0.1278p pd=1.07u as=0.2097p ps=1.38u w=0.36u l=0.28u
X4567 a_6343_n2146.t11 a_6338_10964# a_5605_10806# VDD pfet_03v3 ad=0.1584p pd=1.6u as=0.1152p ps=1u w=0.36u l=0.28u
X4568 VSS a_19668_10022# a_19802_10336# VSS nfet_03v3 ad=97.2f pd=0.9u as=0.1584p ps=1.6u w=0.36u l=0.28u
X4569 a_1399_n2146.t0 RB9.t38 a_661_3750# VSS nfet_03v3 ad=0.1584p pd=1.6u as=0.1152p ps=1u w=0.36u l=0.28u
X4570 VSS RB11.t40 a_18698_2528# VSS nfet_03v3 ad=0.1584p pd=1.6u as=0.1854p ps=1.75u w=0.36u l=0.28u
X4571 a_22140_10806# WE0CLK.t35 a_21952_10806# VSS nfet_03v3 ad=0.1278p pd=1.07u as=0.1188p ps=1.02u w=0.36u l=0.28u
X4572 a_30325_6102# RA6.t41 a_30793_n862.t15 VSS nfet_03v3 ad=0.1152p pd=1u as=0.1584p ps=1.6u w=0.36u l=0.28u
X4573 a_37741_n170# RA14.t38 a_38209_n862.t12 VSS nfet_03v3 ad=0.1152p pd=1u as=0.1584p ps=1.6u w=0.36u l=0.28u
X4574 a_12064_9238# a_12000_n708.t29 VDD VDD pfet_03v3 ad=0.2097p pd=1.38u as=0.3168p ps=2.32u w=0.72u l=0.28u
X4575 VSS a_n108_7670# a_26_7860# VSS nfet_03v3 ad=97.2f pd=0.9u as=0.1584p ps=1.6u w=0.36u l=0.28u
X4576 a_n108_6886# a_n884_6886.t30 a_n296_6886# VDD pfet_03v3 ad=0.1278p pd=1.07u as=0.2097p ps=1.38u w=0.36u l=0.28u
X4577 a_13117_n1738# a_n884_n1738.t26 a_12008_n1782# VDD pfet_03v3 ad=0.2097p pd=1.38u as=0.1278p ps=1.07u w=0.36u l=0.28u
X4578 a_30629_7670# RA4.t40 VDD VDD pfet_03v3 ad=0.3888p pd=2.52u as=0.3312p ps=2.36u w=0.72u l=0.28u
X4579 VSS a_n108_4534# a_26_4724# VSS nfet_03v3 ad=97.2f pd=0.9u as=0.1584p ps=1.6u w=0.36u l=0.28u
X4580 a_n108_3750# a_n884_3750.t28 a_n296_3750# VDD pfet_03v3 ad=0.1278p pd=1.07u as=0.2097p ps=1.38u w=0.36u l=0.28u
X4581 VSS.t755 RB15.t40 a_21170_n608# VSS nfet_03v3 ad=0.1584p pd=1.6u as=0.1854p ps=1.75u w=0.36u l=0.28u
X4582 a_2562_334# a_2498_20# a_2364_n170# VSS nfet_03v3 ad=56.7f pd=0.675u as=0.1278p ps=1.07u w=0.36u l=0.28u
X4583 a_30629_4534# RA8.t43 VDD VDD pfet_03v3 ad=0.3888p pd=2.52u as=0.3312p ps=2.36u w=0.72u l=0.28u
X4584 a_n108_614# a_n884_614.t33 a_n296_614# VDD pfet_03v3 ad=0.1278p pd=1.07u as=0.2097p ps=1.38u w=0.36u l=0.28u
X4585 a_18269_7670# RA4.t41 VSS VSS nfet_03v3 ad=0.1944p pd=1.8u as=0.1656p ps=1.64u w=0.36u l=0.28u
X4586 VDD a_n1204_6886.t35 a_22338_7390# VDD pfet_03v3 ad=0.1584p pd=1.6u as=56.7f ps=0.675u w=0.36u l=0.28u
X4587 VDD RB10.t40 a_1394_3124# VDD pfet_03v3 ad=0.3168p pd=2.32u as=0.3708p ps=2.47u w=0.72u l=0.28u
X4588 VDD.t3429 a_12252_n170# a_12386_20# VDD.t3323 pfet_03v3 ad=0.1764p pd=1.26u as=0.1584p ps=1.6u w=0.36u l=0.28u
X4589 a_20437_10022# a_19668_10022# VSS VSS nfet_03v3 ad=0.18p pd=1.72u as=97.2f ps=0.9u w=0.36u l=0.28u
X4590 a_24424_7670# a_24360_n708.t31 VSS VSS nfet_03v3 ad=0.1188p pd=1.02u as=0.1584p ps=1.6u w=0.36u l=0.28u
X4591 a_16952_n1782# a_17456_n1738# a_17744_n1234# VSS nfet_03v3 ad=0.1278p pd=1.07u as=56.7f ps=0.675u w=0.36u l=0.28u
X4592 a_29368_n170# a_29304_n708.t30 VDD.t713 VDD.t691 pfet_03v3 ad=0.2097p pd=1.38u as=0.3168p ps=2.32u w=0.72u l=0.28u
X4593 VDD a_n1204_3750.t35 a_22338_4254# VDD pfet_03v3 ad=0.1584p pd=1.6u as=56.7f ps=0.675u w=0.36u l=0.28u
X4594 VSS a_n884_2966.t27 a_7506_3470# VSS nfet_03v3 ad=0.1584p pd=1.6u as=56.7f ps=0.675u w=0.36u l=0.28u
X4595 a_32797_n170# a_32028_n170# VDD.t3306 VDD.t2761 pfet_03v3 ad=0.36p pd=2.44u as=0.1764p ps=1.26u w=0.72u l=0.28u
X4596 a_24424_4534# a_24360_n708.t32 VSS VSS nfet_03v3 ad=0.1188p pd=1.02u as=0.1584p ps=1.6u w=0.36u l=0.28u
X4597 VDD a_n1204_614.t33 a_22338_1118# VDD pfet_03v3 ad=0.1584p pd=1.6u as=56.7f ps=0.675u w=0.36u l=0.28u
X4598 a_17394_9742# a_17330_9428# a_17196_9238# VSS nfet_03v3 ad=56.7f pd=0.675u as=0.1278p ps=1.07u w=0.36u l=0.28u
X4599 a_35269_8454# RA3.t37 a_35737_n862.t22 VSS nfet_03v3 ad=0.1152p pd=1u as=0.1584p ps=1.6u w=0.36u l=0.28u
X4600 a_4836_1398# a_n884_1398.t31 a_4648_1398# VDD pfet_03v3 ad=0.1278p pd=1.07u as=0.2097p ps=1.38u w=0.36u l=0.28u
X4601 VDD RB0.t35 a_36002_10964# VDD pfet_03v3 ad=0.3168p pd=2.32u as=0.3708p ps=2.47u w=0.72u l=0.28u
X4602 a_30421_n1738# a_n884_n1738.t27 a_29312_n1782# VDD pfet_03v3 ad=0.2097p pd=1.38u as=0.1278p ps=1.07u w=0.36u l=0.28u
X4603 a_17965_n170# RA14.t39 a_18433_n862.t13 VSS nfet_03v3 ad=0.1152p pd=1u as=0.1584p ps=1.6u w=0.36u l=0.28u
X4604 a_11287_n2146.t27 a_11282_10964# a_10549_10806# VDD pfet_03v3 ad=0.1584p pd=1.6u as=0.1152p ps=1u w=0.36u l=0.28u
X4605 a_17394_6606# a_17330_6292# a_17196_6102# VSS nfet_03v3 ad=56.7f pd=0.675u as=0.1278p ps=1.07u w=0.36u l=0.28u
X4606 VDD a_n1204_9238.t36 a_14922_9238# VDD pfet_03v3 ad=0.1584p pd=1.6u as=56.7f ps=0.675u w=0.36u l=0.28u
X4607 a_n1652_5750# WE7.t1 VDD VDD pfet_03v3 ad=0.1872p pd=1.24u as=0.3168p ps=2.32u w=0.72u l=0.28u
X4608 a_13759_n2146.t19 a_13754_2528# a_13021_2182# VDD pfet_03v3 ad=0.1584p pd=1.6u as=0.1152p ps=1u w=0.36u l=0.28u
X4609 VDD a_18433_n862.t33 QA7b.t0 VDD pfet_03v3 ad=0.2484p pd=1.41u as=0.4104p ps=2.58u w=0.72u l=0.28u
X4610 VDD a_22140_1398# a_22274_1588# VDD pfet_03v3 ad=0.1764p pd=1.26u as=0.1584p ps=1.6u w=0.36u l=0.28u
X4611 VSS a_2364_10806# a_2498_10996# VSS nfet_03v3 ad=97.2f pd=0.9u as=0.1584p ps=1.6u w=0.36u l=0.28u
X4612 a_n1652_2614# WE11.t1 VDD VDD pfet_03v3 ad=0.1872p pd=1.24u as=0.3168p ps=2.32u w=0.72u l=0.28u
X4613 a_27853_2182# a_28157_2274# a_28321_n862.t16 VDD pfet_03v3 ad=0.1152p pd=1u as=0.1584p ps=1.6u w=0.36u l=0.28u
X4614 VDD RB3.t32 a_16226_8800# VDD pfet_03v3 ad=0.3168p pd=2.32u as=0.3708p ps=2.47u w=0.72u l=0.28u
X4615 VDD RB9.t39 a_3866_4096# VDD pfet_03v3 ad=0.3168p pd=2.32u as=0.3708p ps=2.47u w=0.72u l=0.28u
X4616 a_5034_11310# a_4970_10996# a_4836_10806# VSS nfet_03v3 ad=56.7f pd=0.675u as=0.1278p ps=1.07u w=0.36u l=0.28u
X4617 a_15493_7670# a_14724_7670# VDD VDD pfet_03v3 ad=0.36p pd=2.44u as=0.1764p ps=1.26u w=0.72u l=0.28u
X4618 VDD RB13.t40 a_3866_960# VDD pfet_03v3 ad=0.3168p pd=2.32u as=0.3708p ps=2.47u w=0.72u l=0.28u
X4619 a_33535_n2146.t22 a_33530_9396# a_32797_9238# VDD pfet_03v3 ad=0.1584p pd=1.6u as=0.1152p ps=1u w=0.36u l=0.28u
X4620 VDD a_27084_5318# a_27218_5632# VDD pfet_03v3 ad=0.1764p pd=1.26u as=0.1584p ps=1.6u w=0.36u l=0.28u
X4621 a_7120_1398# a_7056_n708.t27 VDD VDD pfet_03v3 ad=0.2097p pd=1.38u as=0.3168p ps=2.32u w=0.72u l=0.28u
X4622 a_15493_4534# a_14724_4534# VDD VDD pfet_03v3 ad=0.36p pd=2.44u as=0.1764p ps=1.26u w=0.72u l=0.28u
X4623 a_13325_2274# RA11.t39 VSS VSS nfet_03v3 ad=0.1944p pd=1.8u as=0.1656p ps=1.64u w=0.36u l=0.28u
X4624 VDD RB7.t40 a_23642_5664# VDD pfet_03v3 ad=0.3168p pd=2.32u as=0.3708p ps=2.47u w=0.72u l=0.28u
X4625 a_1399_n2146.t24 a_1394_9396# a_661_9238# VDD pfet_03v3 ad=0.1584p pd=1.6u as=0.1152p ps=1u w=0.36u l=0.28u
X4626 a_28591_n2146.t28 a_28586_7232# a_27853_6886# VDD pfet_03v3 ad=0.1584p pd=1.6u as=0.1152p ps=1u w=0.36u l=0.28u
X4627 a_31063_n2146.t0 RB9.t40 a_30325_3750# VSS nfet_03v3 ad=0.1584p pd=1.6u as=0.1152p ps=1u w=0.36u l=0.28u
X4628 a_11287_n2146.t16 RB4.t36 a_10549_7670# VSS nfet_03v3 ad=0.1584p pd=1.6u as=0.1152p ps=1u w=0.36u l=0.28u
X4629 a_28591_n2146.t30 a_28586_4096# a_27853_3750# VDD pfet_03v3 ad=0.1584p pd=1.6u as=0.1152p ps=1u w=0.36u l=0.28u
X4630 a_26896_2966# a_26832_n708.t33 VDD VDD pfet_03v3 ad=0.2097p pd=1.38u as=0.3168p ps=2.32u w=0.72u l=0.28u
X4631 VDD RB11.t41 a_23642_2528# VDD pfet_03v3 ad=0.3168p pd=2.32u as=0.3708p ps=2.47u w=0.72u l=0.28u
X4632 a_27084_9238# a_n1204_9238.t37 a_26896_9238# VSS nfet_03v3 ad=0.1278p pd=1.07u as=0.1188p ps=1.02u w=0.36u l=0.28u
X4633 a_14922_8454# a_14858_8768# a_14724_8454# VSS nfet_03v3 ad=56.7f pd=0.675u as=0.1278p ps=1.07u w=0.36u l=0.28u
X4634 a_27853_2966# a_27084_2966# VSS VSS nfet_03v3 ad=0.18p pd=1.72u as=97.2f ps=0.9u w=0.36u l=0.28u
X4635 a_19866_n450# a_19802_n640# a_19668_n954# VDD.t3026 pfet_03v3 ad=56.7f pd=0.675u as=0.1278p ps=1.07u w=0.36u l=0.28u
X4636 a_10549_5318# RA7.t42 a_11017_n862.t14 VSS nfet_03v3 ad=0.1152p pd=1u as=0.1584p ps=1.6u w=0.36u l=0.28u
X4637 a_14922_5318# a_14858_5632# a_14724_5318# VSS nfet_03v3 ad=56.7f pd=0.675u as=0.1278p ps=1.07u w=0.36u l=0.28u
X4638 a_13021_n170# a_13325_n170# a_13489_n862.t4 VDD.t2065 pfet_03v3 ad=0.1152p pd=1u as=0.1584p ps=1.6u w=0.36u l=0.28u
X4639 a_13021_n170# RA14.t40 a_13489_n862.t9 VSS nfet_03v3 ad=0.1152p pd=1u as=0.1584p ps=1.6u w=0.36u l=0.28u
X4640 a_28591_n2146.t26 a_28586_960# a_27853_614# VDD pfet_03v3 ad=0.1584p pd=1.6u as=0.1152p ps=1u w=0.36u l=0.28u
X4641 a_27084_6102# a_n1204_6102.t34 a_26896_6102# VSS nfet_03v3 ad=0.1278p pd=1.07u as=0.1188p ps=1.02u w=0.36u l=0.28u
X4642 a_18703_n2146.t27 a_18698_3124# a_17965_2966# VDD pfet_03v3 ad=0.1584p pd=1.6u as=0.1152p ps=1u w=0.36u l=0.28u
X4643 VSS a_n884_n170.t33 a_2562_334# VSS nfet_03v3 ad=0.1584p pd=1.6u as=56.7f ps=0.675u w=0.36u l=0.28u
X4644 a_25381_1398# a_25685_1398# a_25849_n862.t17 VDD pfet_03v3 ad=0.1152p pd=1u as=0.1584p ps=1.6u w=0.36u l=0.28u
X4645 a_3133_10806# a_2364_10806# VDD VDD pfet_03v3 ad=0.36p pd=2.44u as=0.1764p ps=1.26u w=0.72u l=0.28u
X4646 a_33535_n2146.t28 RB8.t39 a_32797_4534# VSS nfet_03v3 ad=0.1584p pd=1.6u as=0.1152p ps=1u w=0.36u l=0.28u
X4647 VDD RB10.t41 a_31058_3124# VDD pfet_03v3 ad=0.3168p pd=2.32u as=0.3708p ps=2.47u w=0.72u l=0.28u
X4648 a_n296_7670# a_n360_n708.t24 VDD VDD pfet_03v3 ad=0.2097p pd=1.38u as=0.3168p ps=2.32u w=0.72u l=0.28u
X4649 VSS a_2364_n170# a_2498_20# VSS nfet_03v3 ad=97.2f pd=0.9u as=0.1584p ps=1.6u w=0.36u l=0.28u
X4650 a_27084_10806# a_n884_10806.t32 a_26896_10806# VDD pfet_03v3 ad=0.1278p pd=1.07u as=0.2097p ps=1.38u w=0.36u l=0.28u
X4651 a_4648_10022# a_4584_n708.t33 VSS VSS nfet_03v3 ad=0.1188p pd=1.02u as=0.1584p ps=1.6u w=0.36u l=0.28u
X4652 a_1399_n2146.t2 RB8.t40 a_661_4534# VSS nfet_03v3 ad=0.1584p pd=1.6u as=0.1152p ps=1u w=0.36u l=0.28u
X4653 VDD RB9.t41 a_36002_4096# VDD pfet_03v3 ad=0.3168p pd=2.32u as=0.3708p ps=2.47u w=0.72u l=0.28u
X4654 VSS RB10.t42 a_18698_3124# VSS nfet_03v3 ad=0.1584p pd=1.6u as=0.1854p ps=1.75u w=0.36u l=0.28u
X4655 a_9978_2686# a_9914_2496# a_9780_2182# VDD pfet_03v3 ad=56.7f pd=0.675u as=0.1278p ps=1.07u w=0.36u l=0.28u
X4656 a_n296_4534# a_n360_n708.t25 VDD VDD pfet_03v3 ad=0.2097p pd=1.38u as=0.3168p ps=2.32u w=0.72u l=0.28u
X4657 VSS a_n884_2966.t28 a_5034_3470# VSS nfet_03v3 ad=0.1584p pd=1.6u as=56.7f ps=0.675u w=0.36u l=0.28u
X4658 a_29304_n708.t2 a_29312_n1782# VSS.t3031 VSS nfet_03v3 ad=0.1612p pd=1.14u as=0.2728p ps=2.12u w=0.62u l=0.28u
X4659 VDD RB13.t41 a_36002_960# VDD pfet_03v3 ad=0.3168p pd=2.32u as=0.3708p ps=2.47u w=0.72u l=0.28u
X4660 VSS RB1.t34 a_26114_10368# VSS nfet_03v3 ad=0.1584p pd=1.6u as=0.1854p ps=1.75u w=0.36u l=0.28u
X4661 a_32797_8454# RA3.t38 a_33265_n862.t21 VSS nfet_03v3 ad=0.1152p pd=1u as=0.1584p ps=1.6u w=0.36u l=0.28u
X4662 a_12064_6886# a_12000_n708.t30 VSS VSS nfet_03v3 ad=0.1188p pd=1.02u as=0.1584p ps=1.6u w=0.36u l=0.28u
X4663 a_10853_8546# RA3.t39 VDD VDD pfet_03v3 ad=0.3888p pd=2.52u as=0.3312p ps=2.36u w=0.72u l=0.28u
X4664 a_24612_8454# a_n1204_8454.t31 a_24424_8454# VSS nfet_03v3 ad=0.1278p pd=1.07u as=0.1188p ps=1.02u w=0.36u l=0.28u
X4665 VDD a_n1204_6886.t36 a_2562_7390# VDD pfet_03v3 ad=0.1584p pd=1.6u as=56.7f ps=0.675u w=0.36u l=0.28u
X4666 a_8077_5318# a_7308_5318# VDD VDD pfet_03v3 ad=0.36p pd=2.44u as=0.1764p ps=1.26u w=0.72u l=0.28u
X4667 a_15797_5410# RA7.t43 VSS VSS nfet_03v3 ad=0.1944p pd=1.8u as=0.1656p ps=1.64u w=0.36u l=0.28u
X4668 VDD WE0CLK.t36 a_17394_10806# VDD pfet_03v3 ad=0.1584p pd=1.6u as=56.7f ps=0.675u w=0.36u l=0.28u
X4669 a_15493_10022# a_14724_10022# VSS VSS nfet_03v3 ad=0.18p pd=1.72u as=97.2f ps=0.9u w=0.36u l=0.28u
X4670 a_29556_n954# a_n884_n954.t31 a_29368_n954# VDD.t1359 pfet_03v3 ad=0.1278p pd=1.07u as=0.2097p ps=1.38u w=0.36u l=0.28u
X4671 a_9592_n170# a_9528_n708.t30 VDD.t189 VDD.t167 pfet_03v3 ad=0.2097p pd=1.38u as=0.3168p ps=2.32u w=0.72u l=0.28u
X4672 a_24612_5318# a_n1204_5318.t36 a_24424_5318# VSS nfet_03v3 ad=0.1278p pd=1.07u as=0.1188p ps=1.02u w=0.36u l=0.28u
X4673 VDD a_n1204_3750.t36 a_2562_4254# VDD pfet_03v3 ad=0.1584p pd=1.6u as=56.7f ps=0.675u w=0.36u l=0.28u
X4674 a_8077_2182# a_7308_2182# VDD VDD pfet_03v3 ad=0.36p pd=2.44u as=0.1764p ps=1.26u w=0.72u l=0.28u
X4675 a_1399_n2146.t14 RB13.t42 a_661_614# VSS nfet_03v3 ad=0.1584p pd=1.6u as=0.1152p ps=1u w=0.36u l=0.28u
X4676 VDD RB3.t33 a_13754_8800# VDD pfet_03v3 ad=0.3168p pd=2.32u as=0.3708p ps=2.47u w=0.72u l=0.28u
X4677 VDD RB6.t39 a_11282_6260# VDD pfet_03v3 ad=0.3168p pd=2.32u as=0.3708p ps=2.47u w=0.72u l=0.28u
X4678 VDD a_n1204_614.t34 a_2562_1118# VDD pfet_03v3 ad=0.1584p pd=1.6u as=56.7f ps=0.675u w=0.36u l=0.28u
X4679 VSS a_n884_1398.t32 a_24810_1902# VSS nfet_03v3 ad=0.1584p pd=1.6u as=56.7f ps=0.675u w=0.36u l=0.28u
X4680 VSS a_9780_8454# a_9914_8768# VSS nfet_03v3 ad=97.2f pd=0.9u as=0.1584p ps=1.6u w=0.36u l=0.28u
X4681 a_17965_3750# a_17196_3750# VDD VDD pfet_03v3 ad=0.36p pd=2.44u as=0.1764p ps=1.26u w=0.72u l=0.28u
X4682 VDD a_24612_5318# a_24746_5632# VDD pfet_03v3 ad=0.1764p pd=1.26u as=0.1584p ps=1.6u w=0.36u l=0.28u
X4683 VSS RB14.t44 a_18698_n12# VSS nfet_03v3 ad=0.1584p pd=1.6u as=0.1854p ps=1.75u w=0.36u l=0.28u
X4684 VDD RB0.t36 a_1394_10964# VDD pfet_03v3 ad=0.3168p pd=2.32u as=0.3708p ps=2.47u w=0.72u l=0.28u
X4685 a_31063_n2146.t20 a_31058_9396# a_30325_9238# VDD pfet_03v3 ad=0.1584p pd=1.6u as=0.1152p ps=1u w=0.36u l=0.28u
X4686 VSS a_9780_5318# a_9914_5632# VSS nfet_03v3 ad=97.2f pd=0.9u as=0.1584p ps=1.6u w=0.36u l=0.28u
X4687 a_17965_614# a_17196_614# VDD VDD pfet_03v3 ad=0.36p pd=2.44u as=0.1764p ps=1.26u w=0.72u l=0.28u
X4688 a_30325_8454# a_29556_8454# VSS VSS nfet_03v3 ad=0.18p pd=1.72u as=97.2f ps=0.9u w=0.36u l=0.28u
X4689 VSS a_n884_6886.t31 a_14922_6886# VSS nfet_03v3 ad=0.1584p pd=1.6u as=56.7f ps=0.675u w=0.36u l=0.28u
X4690 VDD RB7.t41 a_21170_5664# VDD pfet_03v3 ad=0.3168p pd=2.32u as=0.3708p ps=2.47u w=0.72u l=0.28u
X4691 a_30325_5318# a_29556_5318# VSS VSS nfet_03v3 ad=0.18p pd=1.72u as=97.2f ps=0.9u w=0.36u l=0.28u
X4692 VDD RB11.t42 a_21170_2528# VDD pfet_03v3 ad=0.3168p pd=2.32u as=0.3708p ps=2.47u w=0.72u l=0.28u
X4693 a_12450_8454# a_12386_8768# a_12252_8454# VSS nfet_03v3 ad=56.7f pd=0.675u as=0.1278p ps=1.07u w=0.36u l=0.28u
X4694 VDD a_7308_5318# a_7442_5632# VDD pfet_03v3 ad=0.1764p pd=1.26u as=0.1584p ps=1.6u w=0.36u l=0.28u
X4695 a_2562_3470# a_2498_3156# a_2364_2966# VSS nfet_03v3 ad=56.7f pd=0.675u as=0.1278p ps=1.07u w=0.36u l=0.28u
X4696 VSS a_n884_2966.t29 a_37170_3470# VSS nfet_03v3 ad=0.1584p pd=1.6u as=56.7f ps=0.675u w=0.36u l=0.28u
X4697 VSS.t756 RB15.t41 a_33530_n608# VSS nfet_03v3 ad=0.1584p pd=1.6u as=0.1854p ps=1.75u w=0.36u l=0.28u
X4698 a_12450_5318# a_12386_5632# a_12252_5318# VSS nfet_03v3 ad=56.7f pd=0.675u as=0.1278p ps=1.07u w=0.36u l=0.28u
X4699 a_16231_n2146.t16 a_16226_3124# a_15493_2966# VDD pfet_03v3 ad=0.1584p pd=1.6u as=0.1152p ps=1u w=0.36u l=0.28u
X4700 VSS RB12.t40 a_11282_1556# VSS nfet_03v3 ad=0.1584p pd=1.6u as=0.1854p ps=1.75u w=0.36u l=0.28u
X4701 a_30629_3842# RA9.t42 VDD VDD pfet_03v3 ad=0.3888p pd=2.52u as=0.3312p ps=2.36u w=0.72u l=0.28u
X4702 a_13325_2966# RA10.t35 VSS VSS nfet_03v3 ad=0.1944p pd=1.8u as=0.1656p ps=1.64u w=0.36u l=0.28u
X4703 a_22909_1398# a_23213_1398# a_23377_n862.t21 VDD pfet_03v3 ad=0.1152p pd=1u as=0.1584p ps=1.6u w=0.36u l=0.28u
X4704 a_36784_7670# a_36720_n708.t32 VSS VSS nfet_03v3 ad=0.1188p pd=1.02u as=0.1584p ps=1.6u w=0.36u l=0.28u
X4705 a_31063_n2146.t2 RB8.t41 a_30325_4534# VSS nfet_03v3 ad=0.1584p pd=1.6u as=0.1152p ps=1u w=0.36u l=0.28u
X4706 a_30104_n1234# a_n884_n1738.t28 VSS.t16 VSS nfet_03v3 ad=56.7f pd=0.675u as=0.1584p ps=1.6u w=0.36u l=0.28u
X4707 a_30629_706# RA13.t40 VDD VDD pfet_03v3 ad=0.3888p pd=2.52u as=0.3312p ps=2.36u w=0.72u l=0.28u
X4708 a_10549_9238# RA2.t39 a_11017_n862.t26 VSS nfet_03v3 ad=0.1152p pd=1u as=0.1584p ps=1.6u w=0.36u l=0.28u
X4709 a_36784_4534# a_36720_n708.t33 VSS VSS nfet_03v3 ad=0.1188p pd=1.02u as=0.1584p ps=1.6u w=0.36u l=0.28u
X4710 a_4836_n170# a_n884_n170.t34 a_4648_n170# VDD.t1355 pfet_03v3 ad=0.1278p pd=1.07u as=0.2097p ps=1.38u w=0.36u l=0.28u
X4711 a_10549_6102# RA6.t42 a_11017_n862.t15 VSS nfet_03v3 ad=0.1152p pd=1u as=0.1584p ps=1.6u w=0.36u l=0.28u
X4712 a_7506_2686# a_7442_2496# a_7308_2182# VDD pfet_03v3 ad=56.7f pd=0.675u as=0.1278p ps=1.07u w=0.36u l=0.28u
X4713 VDD CLK a_n1652_9238# VDD pfet_03v3 ad=0.3168p pd=2.32u as=0.1872p ps=1.24u w=0.72u l=0.28u
X4714 a_n1652_7318# CLK a_n1652_6878# VSS nfet_03v3 ad=0.3168p pd=2.32u as=0.1872p ps=1.24u w=0.72u l=0.28u
X4715 VDD a_n1204_6886.t37 a_32226_7390# VDD pfet_03v3 ad=0.1584p pd=1.6u as=56.7f ps=0.675u w=0.36u l=0.28u
X4716 VDD.t2565 a_22140_n170# a_22274_20# VDD.t2380 pfet_03v3 ad=0.1764p pd=1.26u as=0.1584p ps=1.6u w=0.36u l=0.28u
X4717 VDD RB1.t35 a_36002_10368# VDD pfet_03v3 ad=0.3168p pd=2.32u as=0.3708p ps=2.47u w=0.72u l=0.28u
X4718 a_20533_n1738# WEM.t29 a_19424_n1782# VSS nfet_03v3 ad=0.1188p pd=1.02u as=0.1278p ps=1.07u w=0.36u l=0.28u
X4719 VSS RB9.t42 a_16226_4096# VSS nfet_03v3 ad=0.1584p pd=1.6u as=0.1854p ps=1.75u w=0.36u l=0.28u
X4720 VDD a_n1204_3750.t37 a_32226_4254# VDD pfet_03v3 ad=0.1584p pd=1.6u as=56.7f ps=0.675u w=0.36u l=0.28u
X4721 a_22140_8454# a_n1204_8454.t32 a_21952_8454# VSS nfet_03v3 ad=0.1278p pd=1.07u as=0.1188p ps=1.02u w=0.36u l=0.28u
X4722 VSS a_n884_2182.t32 a_34698_2182# VSS nfet_03v3 ad=0.1584p pd=1.6u as=56.7f ps=0.675u w=0.36u l=0.28u
X4723 a_15493_n954# a_15797_n862# a_15961_n862.t30 VDD.t3048 pfet_03v3 ad=0.1152p pd=1u as=0.1584p ps=1.6u w=0.36u l=0.28u
X4724 VDD a_2364_1398# a_2498_1588# VDD pfet_03v3 ad=0.1764p pd=1.26u as=0.1584p ps=1.6u w=0.36u l=0.28u
X4725 VDD a_19424_n1782# a_19416_n708.t0 VDD pfet_03v3 ad=0.5456p pd=3.36u as=0.3224p ps=1.76u w=1.24u l=0.28u
X4726 a_7120_n170# a_7056_n708.t28 VDD.t1140 VDD.t1122 pfet_03v3 ad=0.2097p pd=1.38u as=0.3168p ps=2.32u w=0.72u l=0.28u
X4727 VDD a_n1204_614.t35 a_32226_1118# VDD pfet_03v3 ad=0.1584p pd=1.6u as=56.7f ps=0.675u w=0.36u l=0.28u
X4728 VSS RB13.t43 a_13754_960# VSS nfet_03v3 ad=0.1584p pd=1.6u as=0.1854p ps=1.75u w=0.36u l=0.28u
X4729 VDD a_n1204_8454.t33 a_12450_8958# VDD pfet_03v3 ad=0.1584p pd=1.6u as=56.7f ps=0.675u w=0.36u l=0.28u
X4730 a_36007_n2146.t3 RB5.t40 a_35269_6886# VSS nfet_03v3 ad=0.1584p pd=1.6u as=0.1152p ps=1u w=0.36u l=0.28u
X4731 a_22140_5318# a_n1204_5318.t37 a_21952_5318# VSS nfet_03v3 ad=0.1278p pd=1.07u as=0.1188p ps=1.02u w=0.36u l=0.28u
X4732 a_15797_9238# RA2.t40 VSS VSS nfet_03v3 ad=0.1944p pd=1.8u as=0.1656p ps=1.64u w=0.36u l=0.28u
X4733 a_15493_3750# a_14724_3750# VDD VDD pfet_03v3 ad=0.36p pd=2.44u as=0.1764p ps=1.26u w=0.72u l=0.28u
X4734 a_25685_2274# RA11.t40 VSS VSS nfet_03v3 ad=0.1944p pd=1.8u as=0.1656p ps=1.64u w=0.36u l=0.28u
X4735 a_n1652_n170# CLK a_n1652_270# VSS nfet_03v3 ad=0.3168p pd=2.32u as=0.1872p ps=1.24u w=0.72u l=0.28u
X4736 a_13021_10806# a_12252_10806# VDD VDD pfet_03v3 ad=0.36p pd=2.44u as=0.1764p ps=1.26u w=0.72u l=0.28u
X4737 VSS RB0.t37 a_26114_10964# VSS nfet_03v3 ad=0.1584p pd=1.6u as=0.1854p ps=1.75u w=0.36u l=0.28u
X4738 a_21952_9238# a_21888_n708.t31 VSS VSS nfet_03v3 ad=0.1188p pd=1.02u as=0.1584p ps=1.6u w=0.36u l=0.28u
X4739 a_9780_n954# a_n884_n954.t32 a_9592_n954# VDD.t1360 pfet_03v3 ad=0.1278p pd=1.07u as=0.2097p ps=1.38u w=0.36u l=0.28u
X4740 a_15797_6102# RA6.t43 VSS VSS nfet_03v3 ad=0.1944p pd=1.8u as=0.1656p ps=1.64u w=0.36u l=0.28u
X4741 a_15493_614# a_14724_614# VDD VDD pfet_03v3 ad=0.36p pd=2.44u as=0.1764p ps=1.26u w=0.72u l=0.28u
X4742 a_23647_n2146.t11 RB4.t37 a_22909_7670# VSS nfet_03v3 ad=0.1584p pd=1.6u as=0.1152p ps=1u w=0.36u l=0.28u
X4743 a_21952_6102# a_21888_n708.t32 VSS VSS nfet_03v3 ad=0.1188p pd=1.02u as=0.1584p ps=1.6u w=0.36u l=0.28u
X4744 VDD.t1245 a_n1204_n954.t29 a_90_n450# VDD.t1244 pfet_03v3 ad=0.1584p pd=1.6u as=56.7f ps=0.675u w=0.36u l=0.28u
X4745 a_n108_614# a_n1204_614.t36 a_n296_614# VSS nfet_03v3 ad=0.1278p pd=1.07u as=0.1188p ps=1.02u w=0.36u l=0.28u
X4746 VSS RB5.t41 a_38474_7232# VSS nfet_03v3 ad=0.1584p pd=1.6u as=0.1854p ps=1.75u w=0.36u l=0.28u
X4747 a_32028_7670# a_n1204_7670.t35 a_31840_7670# VSS nfet_03v3 ad=0.1278p pd=1.07u as=0.1188p ps=1.02u w=0.36u l=0.28u
X4748 a_17965_n954# a_17196_n954# VSS.t3029 VSS nfet_03v3 ad=0.18p pd=1.72u as=97.2f ps=0.9u w=0.36u l=0.28u
X4749 a_25381_n170# a_25685_n170# a_25849_n862.t15 VDD.t2628 pfet_03v3 ad=0.1152p pd=1u as=0.1584p ps=1.6u w=0.36u l=0.28u
X4750 VDD a_4836_5318# a_4970_5632# VDD pfet_03v3 ad=0.1764p pd=1.26u as=0.1584p ps=1.6u w=0.36u l=0.28u
X4751 VDD a_34500_2182# a_34634_2496# VDD pfet_03v3 ad=0.1764p pd=1.26u as=0.1584p ps=1.6u w=0.36u l=0.28u
X4752 a_32028_4534# a_n1204_4534.t36 a_31840_4534# VSS nfet_03v3 ad=0.1278p pd=1.07u as=0.1188p ps=1.02u w=0.36u l=0.28u
X4753 a_30325_n954# a_29556_n954# VDD.t3160 VDD.t3159 pfet_03v3 ad=0.36p pd=2.44u as=0.1764p ps=1.26u w=0.72u l=0.28u
X4754 VDD a_36728_n1782# a_36720_n708.t2 VDD pfet_03v3 ad=0.5456p pd=3.36u as=0.3224p ps=1.76u w=1.24u l=0.28u
X4755 VDD a_27084_10022# a_27218_10336# VDD pfet_03v3 ad=0.1764p pd=1.26u as=0.1584p ps=1.6u w=0.36u l=0.28u
X4756 a_3133_10022# a_2364_10022# VDD VDD pfet_03v3 ad=0.36p pd=2.44u as=0.1764p ps=1.26u w=0.72u l=0.28u
X4757 a_29754_n450# a_29690_n640# a_29556_n954# VDD.t3047 pfet_03v3 ad=56.7f pd=0.675u as=0.1278p ps=1.07u w=0.36u l=0.28u
X4758 a_29754_10526# a_29690_10336# a_29556_10022# VDD pfet_03v3 ad=56.7f pd=0.675u as=0.1278p ps=1.07u w=0.36u l=0.28u
X4759 a_28157_7670# RA4.t42 VSS VSS nfet_03v3 ad=0.1944p pd=1.8u as=0.1656p ps=1.64u w=0.36u l=0.28u
X4760 a_34312_7670# a_34248_n708.t32 VSS VSS nfet_03v3 ad=0.1188p pd=1.02u as=0.1584p ps=1.6u w=0.36u l=0.28u
X4761 a_4648_2966# a_4584_n708.t34 VDD VDD pfet_03v3 ad=0.2097p pd=1.38u as=0.3168p ps=2.32u w=0.72u l=0.28u
X4762 a_7308_10022# a_n884_10022.t30 a_7120_10022# VDD pfet_03v3 ad=0.1278p pd=1.07u as=0.2097p ps=1.38u w=0.36u l=0.28u
X4763 a_37170_10022# a_37106_10336# a_36972_10022# VSS nfet_03v3 ad=56.7f pd=0.675u as=0.1278p ps=1.07u w=0.36u l=0.28u
X4764 a_n1652_6102# WE6.t1 VDD VDD pfet_03v3 ad=0.1872p pd=1.24u as=0.3168p ps=2.32u w=0.72u l=0.28u
X4765 a_19668_7670# a_n884_7670.t24 a_19480_7670# VDD pfet_03v3 ad=0.1278p pd=1.07u as=0.2097p ps=1.38u w=0.36u l=0.28u
X4766 a_34312_4534# a_34248_n708.t33 VSS VSS nfet_03v3 ad=0.1188p pd=1.02u as=0.1584p ps=1.6u w=0.36u l=0.28u
X4767 a_n296_3750# a_n360_n708.t26 VDD VDD pfet_03v3 ad=0.2097p pd=1.38u as=0.3168p ps=2.32u w=0.72u l=0.28u
X4768 a_n1652_3742# WE9.t1 VSS VSS nfet_03v3 ad=0.1872p pd=1.24u as=0.3168p ps=2.32u w=0.72u l=0.28u
X4769 a_10853_3842# RA9.t43 VSS VSS nfet_03v3 ad=0.1944p pd=1.8u as=0.1656p ps=1.64u w=0.36u l=0.28u
X4770 VDD RB2.t37 a_16226_9396# VDD pfet_03v3 ad=0.3168p pd=2.32u as=0.3708p ps=2.47u w=0.72u l=0.28u
X4771 a_2176_7670# a_2112_n708.t34 VSS VSS nfet_03v3 ad=0.1188p pd=1.02u as=0.1584p ps=1.6u w=0.36u l=0.28u
X4772 a_19668_4534# a_n884_4534.t24 a_19480_4534# VDD pfet_03v3 ad=0.1278p pd=1.07u as=0.2097p ps=1.38u w=0.36u l=0.28u
X4773 a_n296_614# a_n360_n708.t27 VDD VDD pfet_03v3 ad=0.2097p pd=1.38u as=0.3168p ps=2.32u w=0.72u l=0.28u
X4774 a_27282_9742# a_27218_9428# a_27084_9238# VSS nfet_03v3 ad=56.7f pd=0.675u as=0.1278p ps=1.07u w=0.36u l=0.28u
X4775 a_36972_8454# a_n1204_8454.t34 a_36784_8454# VSS nfet_03v3 ad=0.1278p pd=1.07u as=0.1188p ps=1.02u w=0.36u l=0.28u
X4776 a_2176_4534# a_2112_n708.t35 VSS VSS nfet_03v3 ad=0.1188p pd=1.02u as=0.1584p ps=1.6u w=0.36u l=0.28u
X4777 a_3133_1398# a_3437_1398# a_3601_n862.t13 VDD pfet_03v3 ad=0.1152p pd=1u as=0.1584p ps=1.6u w=0.36u l=0.28u
X4778 VDD a_n1204_9238.t38 a_24810_9238# VDD pfet_03v3 ad=0.1584p pd=1.6u as=56.7f ps=0.675u w=0.36u l=0.28u
X4779 a_27282_6606# a_27218_6292# a_27084_6102# VSS nfet_03v3 ad=56.7f pd=0.675u as=0.1278p ps=1.07u w=0.36u l=0.28u
X4780 a_36972_5318# a_n1204_5318.t38 a_36784_5318# VSS nfet_03v3 ad=0.1278p pd=1.07u as=0.1188p ps=1.02u w=0.36u l=0.28u
X4781 VSS RB9.t43 a_13754_4096# VSS nfet_03v3 ad=0.1584p pd=1.6u as=0.1854p ps=1.75u w=0.36u l=0.28u
X4782 a_14984_n1738# a_14480_n1782# VDD VDD pfet_03v3 ad=0.1584p pd=1.6u as=0.1584p ps=1.6u w=0.36u l=0.28u
X4783 VDD a_32028_1398# a_32162_1588# VDD pfet_03v3 ad=0.1764p pd=1.26u as=0.1584p ps=1.6u w=0.36u l=0.28u
X4784 a_8077_5318# a_8381_5410# a_8545_n862.t18 VDD pfet_03v3 ad=0.1152p pd=1u as=0.1584p ps=1.6u w=0.36u l=0.28u
X4785 VSS.t2589 a_16952_n1782# a_16944_n708.t2 VSS nfet_03v3 ad=0.2728p pd=2.12u as=0.1612p ps=1.14u w=0.62u l=0.28u
X4786 VDD RB3.t34 a_26114_8800# VDD pfet_03v3 ad=0.3168p pd=2.32u as=0.3708p ps=2.47u w=0.72u l=0.28u
X4787 VDD RB6.t40 a_23642_6260# VDD pfet_03v3 ad=0.3168p pd=2.32u as=0.3708p ps=2.47u w=0.72u l=0.28u
X4788 a_5605_10022# RA1.t44 a_6073_n862.t3 VSS nfet_03v3 ad=0.1152p pd=1u as=0.1584p ps=1.6u w=0.36u l=0.28u
X4789 VDD a_n1204_8454.t35 a_9978_8958# VDD pfet_03v3 ad=0.1584p pd=1.6u as=56.7f ps=0.675u w=0.36u l=0.28u
X4790 a_25381_7670# a_24612_7670# VDD VDD pfet_03v3 ad=0.36p pd=2.44u as=0.1764p ps=1.26u w=0.72u l=0.28u
X4791 VDD a_36972_5318# a_37106_5632# VDD pfet_03v3 ad=0.1764p pd=1.26u as=0.1584p ps=1.6u w=0.36u l=0.28u
X4792 a_26119_n2146.t13 a_26114_10964# a_25381_10806# VDD pfet_03v3 ad=0.1584p pd=1.6u as=0.1152p ps=1u w=0.36u l=0.28u
X4793 a_25381_4534# a_24612_4534# VDD VDD pfet_03v3 ad=0.36p pd=2.44u as=0.1764p ps=1.26u w=0.72u l=0.28u
X4794 VDD RB1.t36 a_1394_10368# VDD pfet_03v3 ad=0.3168p pd=2.32u as=0.3708p ps=2.47u w=0.72u l=0.28u
X4795 VSS RB8.t42 a_16226_4692# VSS nfet_03v3 ad=0.1584p pd=1.6u as=0.1854p ps=1.75u w=0.36u l=0.28u
X4796 a_23213_2274# RA11.t41 VSS VSS nfet_03v3 ad=0.1944p pd=1.8u as=0.1656p ps=1.64u w=0.36u l=0.28u
X4797 a_7308_n954# a_n884_n954.t33 a_7120_n954# VDD.t1361 pfet_03v3 ad=0.1278p pd=1.07u as=0.2097p ps=1.38u w=0.36u l=0.28u
X4798 a_12252_10022# a_n884_10022.t31 a_12064_10022# VDD pfet_03v3 ad=0.1278p pd=1.07u as=0.2097p ps=1.38u w=0.36u l=0.28u
X4799 a_38479_n2146.t31 a_38474_7232# a_37741_6886# VDD pfet_03v3 ad=0.1584p pd=1.6u as=0.1152p ps=1u w=0.36u l=0.28u
X4800 VDD RB7.t42 a_33530_5664# VDD pfet_03v3 ad=0.3168p pd=2.32u as=0.3708p ps=2.47u w=0.72u l=0.28u
X4801 VSS a_17196_2966# a_17330_3156# VSS nfet_03v3 ad=97.2f pd=0.9u as=0.1584p ps=1.6u w=0.36u l=0.28u
X4802 a_21175_n2146.t3 RB4.t38 a_20437_7670# VSS nfet_03v3 ad=0.1584p pd=1.6u as=0.1152p ps=1u w=0.36u l=0.28u
X4803 a_38045_6978# RA5.t36 VDD VDD pfet_03v3 ad=0.3888p pd=2.52u as=0.3312p ps=2.36u w=0.72u l=0.28u
X4804 VDD RB11.t43 a_33530_2528# VDD pfet_03v3 ad=0.3168p pd=2.32u as=0.3708p ps=2.47u w=0.72u l=0.28u
X4805 a_24810_8454# a_24746_8768# a_24612_8454# VSS nfet_03v3 ad=56.7f pd=0.675u as=0.1278p ps=1.07u w=0.36u l=0.28u
X4806 a_38479_n2146.t12 a_38474_4096# a_37741_3750# VDD pfet_03v3 ad=0.1584p pd=1.6u as=0.1152p ps=1u w=0.36u l=0.28u
X4807 a_7056_n708.t0 a_7064_n1782# VDD VDD pfet_03v3 ad=0.3224p pd=1.76u as=0.5456p ps=3.36u w=1.24u l=0.28u
X4808 a_5909_6978# RA5.t37 VDD VDD pfet_03v3 ad=0.3888p pd=2.52u as=0.3312p ps=2.36u w=0.72u l=0.28u
X4809 a_37741_2966# a_36972_2966# VSS VSS nfet_03v3 ad=0.18p pd=1.72u as=97.2f ps=0.9u w=0.36u l=0.28u
X4810 VSS.t2345 a_34256_n1782# a_34248_n708.t2 VSS nfet_03v3 ad=0.2728p pd=2.12u as=0.1612p ps=1.14u w=0.62u l=0.28u
X4811 a_15493_n954# a_14724_n954# VSS.t3068 VSS nfet_03v3 ad=0.18p pd=1.72u as=97.2f ps=0.9u w=0.36u l=0.28u
X4812 a_22909_n170# a_23213_n170# a_23377_n862.t23 VDD.t2603 pfet_03v3 ad=0.1152p pd=1u as=0.1584p ps=1.6u w=0.36u l=0.28u
X4813 a_661_9238# a_n108_9238# VSS VSS nfet_03v3 ad=0.18p pd=1.72u as=97.2f ps=0.9u w=0.36u l=0.28u
X4814 a_24810_5318# a_24746_5632# a_24612_5318# VSS nfet_03v3 ad=56.7f pd=0.675u as=0.1278p ps=1.07u w=0.36u l=0.28u
X4815 a_38479_n2146.t25 a_38474_960# a_37741_614# VDD pfet_03v3 ad=0.1584p pd=1.6u as=0.1152p ps=1u w=0.36u l=0.28u
X4816 VSS RB12.t41 a_23642_1556# VSS nfet_03v3 ad=0.1584p pd=1.6u as=0.1854p ps=1.75u w=0.36u l=0.28u
X4817 a_661_6102# a_n108_6102# VSS VSS nfet_03v3 ad=0.18p pd=1.72u as=97.2f ps=0.9u w=0.36u l=0.28u
X4818 a_25685_2966# RA10.t36 VSS VSS nfet_03v3 ad=0.1944p pd=1.8u as=0.1656p ps=1.64u w=0.36u l=0.28u
X4819 a_37741_614# RA13.t41 a_38209_n862.t5 VSS nfet_03v3 ad=0.1152p pd=1u as=0.1584p ps=1.6u w=0.36u l=0.28u
X4820 a_35269_1398# a_35573_1398# a_35737_n862.t28 VDD pfet_03v3 ad=0.1152p pd=1u as=0.1584p ps=1.6u w=0.36u l=0.28u
X4821 VDD RB5.t42 a_8810_7232# VDD pfet_03v3 ad=0.3168p pd=2.32u as=0.3708p ps=2.47u w=0.72u l=0.28u
X4822 VSS a_n1652_10806# WE0CLK.t2 VSS nfet_03v3 ad=0.1693p pd=1.19u as=0.1651p ps=1.155u w=0.635u l=0.28u
X4823 a_661_10806# a_n108_10806# VSS VSS nfet_03v3 ad=0.18p pd=1.72u as=97.2f ps=0.9u w=0.36u l=0.28u
X4824 VSS a_n884_10022.t32 a_9978_10022# VSS nfet_03v3 ad=0.1584p pd=1.6u as=56.7f ps=0.675u w=0.36u l=0.28u
X4825 a_10853_9238# RA2.t41 VDD VDD pfet_03v3 ad=0.3888p pd=2.52u as=0.3312p ps=2.36u w=0.72u l=0.28u
X4826 a_8077_6102# a_7308_6102# VDD VDD pfet_03v3 ad=0.36p pd=2.44u as=0.1764p ps=1.26u w=0.72u l=0.28u
X4827 a_18269_8546# RA3.t40 VSS VSS nfet_03v3 ad=0.1944p pd=1.8u as=0.1656p ps=1.64u w=0.36u l=0.28u
X4828 a_8077_10806# a_7308_10806# VSS VSS nfet_03v3 ad=0.18p pd=1.72u as=97.2f ps=0.9u w=0.36u l=0.28u
X4829 a_17196_7670# a_n884_7670.t25 a_17008_7670# VDD pfet_03v3 ad=0.1278p pd=1.07u as=0.2097p ps=1.38u w=0.36u l=0.28u
X4830 VDD RB2.t38 a_13754_9396# VDD pfet_03v3 ad=0.3168p pd=2.32u as=0.3708p ps=2.47u w=0.72u l=0.28u
X4831 a_20741_8546# RA3.t41 VDD VDD pfet_03v3 ad=0.3888p pd=2.52u as=0.3312p ps=2.36u w=0.72u l=0.28u
X4832 a_8381_7670# RA4.t43 VSS VSS nfet_03v3 ad=0.1944p pd=1.8u as=0.1656p ps=1.64u w=0.36u l=0.28u
X4833 a_17196_4534# a_n884_4534.t25 a_17008_4534# VDD pfet_03v3 ad=0.1278p pd=1.07u as=0.2097p ps=1.38u w=0.36u l=0.28u
X4834 VDD D9.t1 a_23005_n1738# VDD pfet_03v3 ad=0.3168p pd=2.32u as=0.2097p ps=1.38u w=0.72u l=0.28u
X4835 a_13759_n2146.t30 a_13754_n608# a_13021_n954# VDD.t2007 pfet_03v3 ad=0.1584p pd=1.6u as=0.1152p ps=1u w=0.36u l=0.28u
X4836 VDD.t2533 a_2364_n170# a_2498_20# VDD.t2322 pfet_03v3 ad=0.1764p pd=1.26u as=0.1584p ps=1.6u w=0.36u l=0.28u
X4837 a_15493_10806# a_15797_10806# a_15961_n862.t13 VDD pfet_03v3 ad=0.1152p pd=1u as=0.1584p ps=1.6u w=0.36u l=0.28u
X4838 a_24810_11310# a_24746_10996# a_24612_10806# VSS nfet_03v3 ad=56.7f pd=0.675u as=0.1278p ps=1.07u w=0.36u l=0.28u
X4839 a_34500_8454# a_n1204_8454.t36 a_34312_8454# VSS nfet_03v3 ad=0.1278p pd=1.07u as=0.1188p ps=1.02u w=0.36u l=0.28u
X4840 a_37741_5318# a_38045_5410# a_38209_n862.t20 VDD pfet_03v3 ad=0.1152p pd=1u as=0.1584p ps=1.6u w=0.36u l=0.28u
X4841 a_27853_n954# a_28157_n862# a_28321_n862.t30 VDD.t2866 pfet_03v3 ad=0.1152p pd=1u as=0.1584p ps=1.6u w=0.36u l=0.28u
X4842 a_34698_10806# a_34634_10996# a_34500_10806# VDD pfet_03v3 ad=56.7f pd=0.675u as=0.1278p ps=1.07u w=0.36u l=0.28u
X4843 a_n296_n954# a_n360_n708.t28 VSS.t246 VSS nfet_03v3 ad=0.1188p pd=1.02u as=0.1584p ps=1.6u w=0.36u l=0.28u
X4844 a_17965_614# RA13.t42 a_18433_n862.t7 VSS nfet_03v3 ad=0.1152p pd=1u as=0.1584p ps=1.6u w=0.36u l=0.28u
X4845 a_34500_5318# a_n1204_5318.t39 a_34312_5318# VSS nfet_03v3 ad=0.1278p pd=1.07u as=0.1188p ps=1.02u w=0.36u l=0.28u
X4846 a_2562_10022# a_2498_10336# a_2364_10022# VSS nfet_03v3 ad=56.7f pd=0.675u as=0.1278p ps=1.07u w=0.36u l=0.28u
X4847 VDD RB6.t41 a_21170_6260# VDD pfet_03v3 ad=0.3168p pd=2.32u as=0.3708p ps=2.47u w=0.72u l=0.28u
X4848 a_5605_5318# a_5909_5410# a_6073_n862.t19 VDD pfet_03v3 ad=0.1152p pd=1u as=0.1584p ps=1.6u w=0.36u l=0.28u
X4849 a_10853_4534# RA8.t44 VSS VSS nfet_03v3 ad=0.1944p pd=1.8u as=0.1656p ps=1.64u w=0.36u l=0.28u
X4850 VDD.t1366 a_n1652_n522# a_n1204_n954.t0 VDD.t1365 pfet_03v3 ad=0.3386p pd=1.86u as=0.3302p ps=1.79u w=1.27u l=0.28u
X4851 VSS a_n884_1398.t33 a_34698_1902# VSS nfet_03v3 ad=0.1584p pd=1.6u as=56.7f ps=0.675u w=0.36u l=0.28u
X4852 a_20437_2966# a_20741_2966# a_20905_n862.t19 VDD pfet_03v3 ad=0.1152p pd=1u as=0.1584p ps=1.6u w=0.36u l=0.28u
X4853 a_n1652_10806# CLK a_n1652_11246# VSS nfet_03v3 ad=0.3168p pd=2.32u as=0.1872p ps=1.24u w=0.72u l=0.28u
X4854 VDD a_4836_10806# a_4970_10996# VDD pfet_03v3 ad=0.1764p pd=1.26u as=0.1584p ps=1.6u w=0.36u l=0.28u
X4855 a_13021_10022# a_12252_10022# VDD VDD pfet_03v3 ad=0.36p pd=2.44u as=0.1764p ps=1.26u w=0.72u l=0.28u
X4856 a_16231_n2146.t0 RB1.t37 a_15493_10022# VSS nfet_03v3 ad=0.1584p pd=1.6u as=0.1152p ps=1u w=0.36u l=0.28u
X4857 VSS a_19668_8454# a_19802_8768# VSS nfet_03v3 ad=97.2f pd=0.9u as=0.1584p ps=1.6u w=0.36u l=0.28u
X4858 VSS a_19668_5318# a_19802_5632# VSS nfet_03v3 ad=97.2f pd=0.9u as=0.1584p ps=1.6u w=0.36u l=0.28u
X4859 a_3871_n2146.t19 a_3866_2528# a_3133_2182# VDD pfet_03v3 ad=0.1584p pd=1.6u as=0.1152p ps=1u w=0.36u l=0.28u
X4860 VSS RB8.t43 a_13754_4692# VSS nfet_03v3 ad=0.1584p pd=1.6u as=0.1854p ps=1.75u w=0.36u l=0.28u
X4861 QB8b.t1 a_21175_n2146.t33 VSS VSS nfet_03v3 ad=0.2052p pd=1.86u as=0.1242p ps=1.05u w=0.36u l=0.28u
X4862 VDD RB3.t35 a_6338_8800# VDD pfet_03v3 ad=0.3168p pd=2.32u as=0.3708p ps=2.47u w=0.72u l=0.28u
X4863 a_5605_7670# a_4836_7670# VDD VDD pfet_03v3 ad=0.36p pd=2.44u as=0.1764p ps=1.26u w=0.72u l=0.28u
X4864 VSS a_n884_6886.t32 a_24810_6886# VSS nfet_03v3 ad=0.1584p pd=1.6u as=56.7f ps=0.675u w=0.36u l=0.28u
X4865 VSS a_14724_2966# a_14858_3156# VSS nfet_03v3 ad=97.2f pd=0.9u as=0.1584p ps=1.6u w=0.36u l=0.28u
X4866 a_5605_10806# RA0.t44 a_6073_n862.t14 VSS nfet_03v3 ad=0.1152p pd=1u as=0.1584p ps=1.6u w=0.36u l=0.28u
X4867 a_11287_n2146.t13 RB3.t36 a_10549_8454# VSS nfet_03v3 ad=0.1584p pd=1.6u as=0.1152p ps=1u w=0.36u l=0.28u
X4868 a_15797_n862# RA15.t38 VDD.t458 VDD.t457 pfet_03v3 ad=0.3888p pd=2.52u as=0.3312p ps=2.36u w=0.72u l=0.28u
X4869 a_22338_8454# a_22274_8768# a_22140_8454# VSS nfet_03v3 ad=56.7f pd=0.675u as=0.1278p ps=1.07u w=0.36u l=0.28u
X4870 a_3437_6978# RA5.t38 VDD VDD pfet_03v3 ad=0.3888p pd=2.52u as=0.3312p ps=2.36u w=0.72u l=0.28u
X4871 VDD a_12252_6886# a_12386_7200# VDD pfet_03v3 ad=0.1764p pd=1.26u as=0.1584p ps=1.6u w=0.36u l=0.28u
X4872 a_5605_4534# a_4836_4534# VDD VDD pfet_03v3 ad=0.36p pd=2.44u as=0.1764p ps=1.26u w=0.72u l=0.28u
X4873 a_22338_5318# a_22274_5632# a_22140_5318# VSS nfet_03v3 ad=56.7f pd=0.675u as=0.1278p ps=1.07u w=0.36u l=0.28u
X4874 a_26119_n2146.t23 a_26114_3124# a_25381_2966# VDD pfet_03v3 ad=0.1584p pd=1.6u as=0.1152p ps=1u w=0.36u l=0.28u
X4875 VSS RB12.t42 a_21170_1556# VSS nfet_03v3 ad=0.1584p pd=1.6u as=0.1854p ps=1.75u w=0.36u l=0.28u
X4876 VSS a_17196_10022# a_17330_10336# VSS nfet_03v3 ad=97.2f pd=0.9u as=0.1584p ps=1.6u w=0.36u l=0.28u
X4877 VSS a_n884_7670.t26 a_19866_8174# VSS nfet_03v3 ad=0.1584p pd=1.6u as=56.7f ps=0.675u w=0.36u l=0.28u
X4878 VDD a_12252_3750# a_12386_4064# VDD pfet_03v3 ad=0.1764p pd=1.26u as=0.1584p ps=1.6u w=0.36u l=0.28u
X4879 a_23213_2966# RA10.t37 VSS VSS nfet_03v3 ad=0.1944p pd=1.8u as=0.1656p ps=1.64u w=0.36u l=0.28u
X4880 a_13021_614# RA13.t43 a_13489_n862.t5 VSS nfet_03v3 ad=0.1152p pd=1u as=0.1584p ps=1.6u w=0.36u l=0.28u
X4881 a_33535_n2146.t0 RB1.t38 a_32797_10022# VSS nfet_03v3 ad=0.1584p pd=1.6u as=0.1152p ps=1u w=0.36u l=0.28u
X4882 VSS a_n884_4534.t26 a_19866_5038# VSS nfet_03v3 ad=0.1584p pd=1.6u as=56.7f ps=0.675u w=0.36u l=0.28u
X4883 a_32797_1398# a_33101_1398# a_33265_n862.t26 VDD pfet_03v3 ad=0.1152p pd=1u as=0.1584p ps=1.6u w=0.36u l=0.28u
X4884 a_17394_1398# a_17330_1588# a_17196_1398# VDD pfet_03v3 ad=56.7f pd=0.675u as=0.1278p ps=1.07u w=0.36u l=0.28u
X4885 a_5034_8454# a_4970_8768# a_4836_8454# VSS nfet_03v3 ad=56.7f pd=0.675u as=0.1278p ps=1.07u w=0.36u l=0.28u
X4886 a_28591_n2146.t6 RB15.t42 a_27853_n954# VSS nfet_03v3 ad=0.1584p pd=1.6u as=0.1152p ps=1u w=0.36u l=0.28u
X4887 a_9978_n450# a_9914_n640# a_9780_n954# VDD.t2819 pfet_03v3 ad=56.7f pd=0.675u as=0.1278p ps=1.07u w=0.36u l=0.28u
X4888 VDD a_12252_614# a_12386_928# VDD pfet_03v3 ad=0.1764p pd=1.26u as=0.1584p ps=1.6u w=0.36u l=0.28u
X4889 a_14724_2966# a_n884_2966.t30 a_14536_2966# VDD pfet_03v3 ad=0.1278p pd=1.07u as=0.2097p ps=1.38u w=0.36u l=0.28u
X4890 VSS RB5.t43 a_18698_7232# VSS nfet_03v3 ad=0.1584p pd=1.6u as=0.1854p ps=1.75u w=0.36u l=0.28u
X4891 a_661_5318# RA7.t44 a_1129_n862.t16 VSS nfet_03v3 ad=0.1152p pd=1u as=0.1584p ps=1.6u w=0.36u l=0.28u
X4892 a_5034_5318# a_4970_5632# a_4836_5318# VSS nfet_03v3 ad=56.7f pd=0.675u as=0.1278p ps=1.07u w=0.36u l=0.28u
X4893 a_13021_5318# a_12252_5318# VDD VDD pfet_03v3 ad=0.36p pd=2.44u as=0.1764p ps=1.26u w=0.72u l=0.28u
X4894 a_8815_n2146.t23 a_8810_3124# a_8077_2966# VDD pfet_03v3 ad=0.1584p pd=1.6u as=0.1152p ps=1u w=0.36u l=0.28u
X4895 a_3133_n170# a_3437_n170# a_3601_n862.t30 VDD.t3360 pfet_03v3 ad=0.1152p pd=1u as=0.1584p ps=1.6u w=0.36u l=0.28u
X4896 a_30325_10806# a_29556_10806# VSS VSS nfet_03v3 ad=0.18p pd=1.72u as=97.2f ps=0.9u w=0.36u l=0.28u
X4897 a_13021_2182# a_12252_2182# VDD VDD pfet_03v3 ad=0.36p pd=2.44u as=0.1764p ps=1.26u w=0.72u l=0.28u
X4898 a_37520_n1738# WEM.t30 VDD VDD pfet_03v3 ad=56.7f pd=0.675u as=0.1584p ps=1.6u w=0.36u l=0.28u
X4899 VDD.t3305 a_32028_n170# a_32162_20# VDD.t2759 pfet_03v3 ad=0.1764p pd=1.26u as=0.1584p ps=1.6u w=0.36u l=0.28u
X4900 a_n108_8454# a_n884_8454.t33 a_n296_8454# VDD pfet_03v3 ad=0.1278p pd=1.07u as=0.2097p ps=1.38u w=0.36u l=0.28u
X4901 VSS RB9.t44 a_26114_4096# VSS nfet_03v3 ad=0.1584p pd=1.6u as=0.1854p ps=1.75u w=0.36u l=0.28u
X4902 a_16944_n708.t0 a_16952_n1782# VDD VDD pfet_03v3 ad=0.3224p pd=1.76u as=0.5456p ps=3.36u w=1.24u l=0.28u
X4903 VDD a_n1204_8454.t37 a_22338_8958# VDD pfet_03v3 ad=0.1584p pd=1.6u as=56.7f ps=0.675u w=0.36u l=0.28u
X4904 a_8077_3750# a_7308_3750# VSS VSS nfet_03v3 ad=0.18p pd=1.72u as=97.2f ps=0.9u w=0.36u l=0.28u
X4905 a_27949_n1738# a_n884_n1738.t29 a_26840_n1782# VDD pfet_03v3 ad=0.2097p pd=1.38u as=0.1278p ps=1.07u w=0.36u l=0.28u
X4906 VDD a_n1204_10022.t34 a_90_10526# VDD pfet_03v3 ad=0.1584p pd=1.6u as=56.7f ps=0.675u w=0.36u l=0.28u
X4907 a_38045_5410# RA7.t45 VSS VSS nfet_03v3 ad=0.1944p pd=1.8u as=0.1656p ps=1.64u w=0.36u l=0.28u
X4908 a_27084_1398# a_n884_1398.t34 a_26896_1398# VDD pfet_03v3 ad=0.1278p pd=1.07u as=0.2097p ps=1.38u w=0.36u l=0.28u
X4909 a_19866_7670# a_19802_7860# a_19668_7670# VDD pfet_03v3 ad=56.7f pd=0.675u as=0.1278p ps=1.07u w=0.36u l=0.28u
X4910 a_5909_5410# RA7.t46 VSS VSS nfet_03v3 ad=0.1944p pd=1.8u as=0.1656p ps=1.64u w=0.36u l=0.28u
X4911 a_25381_3750# a_24612_3750# VDD VDD pfet_03v3 ad=0.36p pd=2.44u as=0.1764p ps=1.26u w=0.72u l=0.28u
X4912 a_35573_2274# RA11.t42 VSS VSS nfet_03v3 ad=0.1944p pd=1.8u as=0.1656p ps=1.64u w=0.36u l=0.28u
X4913 a_31840_9238# a_31776_n708.t32 VSS VSS nfet_03v3 ad=0.1188p pd=1.02u as=0.1584p ps=1.6u w=0.36u l=0.28u
X4914 VSS RB13.t44 a_18698_960# VSS nfet_03v3 ad=0.1584p pd=1.6u as=0.1854p ps=1.75u w=0.36u l=0.28u
X4915 a_33535_n2146.t18 RB4.t39 a_32797_7670# VSS nfet_03v3 ad=0.1584p pd=1.6u as=0.1152p ps=1u w=0.36u l=0.28u
X4916 a_13021_6886# a_13325_6978# a_13489_n862.t25 VDD pfet_03v3 ad=0.1152p pd=1u as=0.1584p ps=1.6u w=0.36u l=0.28u
X4917 a_31840_6102# a_31776_n708.t33 VSS VSS nfet_03v3 ad=0.1188p pd=1.02u as=0.1584p ps=1.6u w=0.36u l=0.28u
X4918 a_19866_4534# a_19802_4724# a_19668_4534# VDD pfet_03v3 ad=56.7f pd=0.675u as=0.1278p ps=1.07u w=0.36u l=0.28u
X4919 a_90_3470# a_26_3156# a_n108_2966# VSS nfet_03v3 ad=56.7f pd=0.675u as=0.1278p ps=1.07u w=0.36u l=0.28u
X4920 a_17965_2182# a_17196_2182# VSS VSS nfet_03v3 ad=0.18p pd=1.72u as=97.2f ps=0.9u w=0.36u l=0.28u
X4921 a_25381_614# a_24612_614# VDD VDD pfet_03v3 ad=0.36p pd=2.44u as=0.1764p ps=1.26u w=0.72u l=0.28u
X4922 a_13021_3750# a_13325_3842# a_13489_n862.t20 VDD pfet_03v3 ad=0.1152p pd=1u as=0.1584p ps=1.6u w=0.36u l=0.28u
X4923 VSS.t3262 D3.t1 a_8173_n1738# VSS nfet_03v3 ad=0.1584p pd=1.6u as=0.1188p ps=1.02u w=0.36u l=0.28u
X4924 VDD RB3.t37 a_3866_8800# VDD pfet_03v3 ad=0.3168p pd=2.32u as=0.3708p ps=2.47u w=0.72u l=0.28u
X4925 a_1399_n2146.t3 RB4.t40 a_661_7670# VSS nfet_03v3 ad=0.1584p pd=1.6u as=0.1152p ps=1u w=0.36u l=0.28u
X4926 VSS RB7.t43 a_8810_5664# VSS nfet_03v3 ad=0.1584p pd=1.6u as=0.1854p ps=1.75u w=0.36u l=0.28u
X4927 a_35269_n170# a_35573_n170# a_35737_n862.t31 VDD.t3437 pfet_03v3 ad=0.1152p pd=1u as=0.1584p ps=1.6u w=0.36u l=0.28u
X4928 a_7120_10806# a_7056_n708.t29 VDD VDD pfet_03v3 ad=0.2097p pd=1.38u as=0.3168p ps=2.32u w=0.72u l=0.28u
X4929 a_3133_7670# a_2364_7670# VDD VDD pfet_03v3 ad=0.36p pd=2.44u as=0.1764p ps=1.26u w=0.72u l=0.28u
X4930 a_13021_614# a_13325_706# a_13489_n862.t23 VDD pfet_03v3 ad=0.1152p pd=1u as=0.1584p ps=1.6u w=0.36u l=0.28u
X4931 a_16231_n2146.t18 RB0.t38 a_15493_10806# VSS nfet_03v3 ad=0.1584p pd=1.6u as=0.1152p ps=1u w=0.36u l=0.28u
X4932 a_3133_4534# a_2364_4534# VDD VDD pfet_03v3 ad=0.36p pd=2.44u as=0.1764p ps=1.26u w=0.72u l=0.28u
X4933 a_20741_10806# RA0.t45 VDD VDD pfet_03v3 ad=0.3888p pd=2.52u as=0.3312p ps=2.36u w=0.72u l=0.28u
X4934 VSS a_n884_7670.t27 a_17394_8174# VSS nfet_03v3 ad=0.1584p pd=1.6u as=56.7f ps=0.675u w=0.36u l=0.28u
X4935 a_13325_6978# RA5.t39 VSS VSS nfet_03v3 ad=0.1944p pd=1.8u as=0.1656p ps=1.64u w=0.36u l=0.28u
X4936 VDD a_n1204_6102.t35 a_12450_6102# VDD pfet_03v3 ad=0.1584p pd=1.6u as=56.7f ps=0.675u w=0.36u l=0.28u
X4937 QB6b.t1 a_16231_n2146.t33 VSS VSS nfet_03v3 ad=0.2052p pd=1.86u as=0.1242p ps=1.05u w=0.36u l=0.28u
X4938 VDD a_n1204_614.t37 a_n884_614.t0 VDD pfet_03v3 ad=0.5896p pd=3.56u as=0.3886p ps=1.92u w=1.34u l=0.28u
X4939 VSS a_n884_4534.t27 a_17394_5038# VSS nfet_03v3 ad=0.1584p pd=1.6u as=56.7f ps=0.675u w=0.36u l=0.28u
X4940 a_28591_n2146.t19 a_28586_8800# a_27853_8454# VDD pfet_03v3 ad=0.1584p pd=1.6u as=0.1152p ps=1u w=0.36u l=0.28u
X4941 a_12252_2966# a_n884_2966.t31 a_12064_2966# VDD pfet_03v3 ad=0.1278p pd=1.07u as=0.2097p ps=1.38u w=0.36u l=0.28u
X4942 a_9536_n1782# a_10040_n1738# a_10328_n1738# VDD pfet_03v3 ad=0.1278p pd=1.07u as=56.7f ps=0.675u w=0.36u l=0.28u
X4943 a_7506_n450# a_7442_n640# a_7308_n954# VDD.t2953 pfet_03v3 ad=56.7f pd=0.675u as=0.1278p ps=1.07u w=0.36u l=0.28u
X4944 a_29556_7670# a_n884_7670.t28 a_29368_7670# VDD pfet_03v3 ad=0.1278p pd=1.07u as=0.2097p ps=1.38u w=0.36u l=0.28u
X4945 a_10549_5318# a_9780_5318# VDD VDD pfet_03v3 ad=0.36p pd=2.44u as=0.1764p ps=1.26u w=0.72u l=0.28u
X4946 a_20741_3842# RA9.t44 VSS VSS nfet_03v3 ad=0.1944p pd=1.8u as=0.1656p ps=1.64u w=0.36u l=0.28u
X4947 a_19480_10022# a_19416_n708.t31 VSS VSS nfet_03v3 ad=0.1188p pd=1.02u as=0.1584p ps=1.6u w=0.36u l=0.28u
X4948 a_6343_n2146.t8 a_6338_3124# a_5605_2966# VDD pfet_03v3 ad=0.1584p pd=1.6u as=0.1152p ps=1u w=0.36u l=0.28u
X4949 VDD RB2.t39 a_26114_9396# VDD pfet_03v3 ad=0.3168p pd=2.32u as=0.3708p ps=2.47u w=0.72u l=0.28u
X4950 a_37170_9742# a_37106_9428# a_36972_9238# VSS nfet_03v3 ad=56.7f pd=0.675u as=0.1278p ps=1.07u w=0.36u l=0.28u
X4951 a_29556_4534# a_n884_4534.t28 a_29368_4534# VDD pfet_03v3 ad=0.1278p pd=1.07u as=0.2097p ps=1.38u w=0.36u l=0.28u
X4952 a_10549_2182# a_9780_2182# VDD VDD pfet_03v3 ad=0.36p pd=2.44u as=0.1764p ps=1.26u w=0.72u l=0.28u
X4953 VSS.t2806 D5.t1 a_13117_n1738# VSS nfet_03v3 ad=0.1584p pd=1.6u as=0.1188p ps=1.02u w=0.36u l=0.28u
X4954 a_33535_n2146.t26 RB0.t39 a_32797_10806# VSS nfet_03v3 ad=0.1584p pd=1.6u as=0.1152p ps=1u w=0.36u l=0.28u
X4955 VDD a_n1204_9238.t39 a_34698_9238# VDD pfet_03v3 ad=0.1584p pd=1.6u as=56.7f ps=0.675u w=0.36u l=0.28u
X4956 a_37170_6606# a_37106_6292# a_36972_6102# VSS nfet_03v3 ad=56.7f pd=0.675u as=0.1278p ps=1.07u w=0.36u l=0.28u
X4957 a_17965_2182# RA11.t43 a_18433_n862.t8 VSS nfet_03v3 ad=0.1152p pd=1u as=0.1584p ps=1.6u w=0.36u l=0.28u
X4958 a_5909_10114# RA1.t45 VSS VSS nfet_03v3 ad=0.1944p pd=1.8u as=0.1656p ps=1.64u w=0.36u l=0.28u
X4959 a_661_9238# RA2.t42 a_1129_n862.t20 VSS nfet_03v3 ad=0.1152p pd=1u as=0.1584p ps=1.6u w=0.36u l=0.28u
X4960 a_29368_614# a_29304_n708.t31 VSS VSS nfet_03v3 ad=0.1188p pd=1.02u as=0.1584p ps=1.6u w=0.36u l=0.28u
X4961 VDD RB6.t42 a_33530_6260# VDD pfet_03v3 ad=0.3168p pd=2.32u as=0.3708p ps=2.47u w=0.72u l=0.28u
X4962 VDD RB3.t38 a_36002_8800# VDD pfet_03v3 ad=0.3168p pd=2.32u as=0.3708p ps=2.47u w=0.72u l=0.28u
X4963 a_661_6102# RA6.t44 a_1129_n862.t6 VSS nfet_03v3 ad=0.1152p pd=1u as=0.1584p ps=1.6u w=0.36u l=0.28u
X4964 a_19668_n954# a_n1204_n954.t30 a_19480_n954# VSS nfet_03v3 ad=0.1278p pd=1.07u as=0.1188p ps=1.02u w=0.36u l=0.28u
X4965 a_35269_7670# a_34500_7670# VDD VDD pfet_03v3 ad=0.36p pd=2.44u as=0.1764p ps=1.26u w=0.72u l=0.28u
X4966 a_2912_n1738# WEM.t31 VDD VDD pfet_03v3 ad=56.7f pd=0.675u as=0.1584p ps=1.6u w=0.36u l=0.28u
X4967 a_17008_614# a_16944_n708.t32 VSS VSS nfet_03v3 ad=0.1188p pd=1.02u as=0.1584p ps=1.6u w=0.36u l=0.28u
X4968 a_35269_4534# a_34500_4534# VDD VDD pfet_03v3 ad=0.36p pd=2.44u as=0.1764p ps=1.26u w=0.72u l=0.28u
X4969 VSS RB9.t45 a_6338_4096# VSS nfet_03v3 ad=0.1584p pd=1.6u as=0.1854p ps=1.75u w=0.36u l=0.28u
X4970 a_3437_5410# RA7.t47 VSS VSS nfet_03v3 ad=0.1944p pd=1.8u as=0.1656p ps=1.64u w=0.36u l=0.28u
X4971 VDD a_n108_2182# a_26_2496# VDD pfet_03v3 ad=0.1764p pd=1.26u as=0.1584p ps=1.6u w=0.36u l=0.28u
X4972 a_33101_2274# RA11.t44 VSS VSS nfet_03v3 ad=0.1944p pd=1.8u as=0.1656p ps=1.64u w=0.36u l=0.28u
X4973 a_36784_10022# a_36720_n708.t34 VSS VSS nfet_03v3 ad=0.1188p pd=1.02u as=0.1584p ps=1.6u w=0.36u l=0.28u
X4974 VSS RB8.t44 a_26114_4692# VSS nfet_03v3 ad=0.1584p pd=1.6u as=0.1854p ps=1.75u w=0.36u l=0.28u
X4975 VSS a_27084_2966# a_27218_3156# VSS nfet_03v3 ad=97.2f pd=0.9u as=0.1584p ps=1.6u w=0.36u l=0.28u
X4976 VDD a_n1204_8454.t38 a_2562_8958# VDD pfet_03v3 ad=0.1584p pd=1.6u as=56.7f ps=0.675u w=0.36u l=0.28u
X4977 a_15493_2182# a_14724_2182# VSS VSS nfet_03v3 ad=0.18p pd=1.72u as=97.2f ps=0.9u w=0.36u l=0.28u
X4978 a_38045_9238# RA2.t43 VSS VSS nfet_03v3 ad=0.1944p pd=1.8u as=0.1656p ps=1.64u w=0.36u l=0.28u
X4979 a_23647_n2146.t8 RB3.t39 a_22909_8454# VSS nfet_03v3 ad=0.1584p pd=1.6u as=0.1152p ps=1u w=0.36u l=0.28u
X4980 a_31063_n2146.t3 RB4.t41 a_30325_7670# VSS nfet_03v3 ad=0.1584p pd=1.6u as=0.1152p ps=1u w=0.36u l=0.28u
X4981 VDD.t2451 a_34500_n954# a_34634_n640# VDD.t2450 pfet_03v3 ad=0.1764p pd=1.26u as=0.1584p ps=1.6u w=0.36u l=0.28u
X4982 a_34698_8454# a_34634_8768# a_34500_8454# VSS nfet_03v3 ad=56.7f pd=0.675u as=0.1278p ps=1.07u w=0.36u l=0.28u
X4983 a_38045_6102# RA6.t45 VSS VSS nfet_03v3 ad=0.1944p pd=1.8u as=0.1656p ps=1.64u w=0.36u l=0.28u
X4984 a_5909_9238# RA2.t44 VSS VSS nfet_03v3 ad=0.1944p pd=1.8u as=0.1656p ps=1.64u w=0.36u l=0.28u
X4985 a_17965_8454# a_17196_8454# VDD VDD pfet_03v3 ad=0.36p pd=2.44u as=0.1764p ps=1.26u w=0.72u l=0.28u
X4986 a_34698_5318# a_34634_5632# a_34500_5318# VSS nfet_03v3 ad=56.7f pd=0.675u as=0.1278p ps=1.07u w=0.36u l=0.28u
X4987 a_5605_3750# a_4836_3750# VDD VDD pfet_03v3 ad=0.36p pd=2.44u as=0.1764p ps=1.26u w=0.72u l=0.28u
X4988 a_25381_n954# a_24612_n954# VSS.t2559 VSS nfet_03v3 ad=0.18p pd=1.72u as=97.2f ps=0.9u w=0.36u l=0.28u
X4989 a_32797_n170# a_33101_n170# a_33265_n862.t17 VDD.t2042 pfet_03v3 ad=0.1152p pd=1u as=0.1584p ps=1.6u w=0.36u l=0.28u
X4990 a_17394_n170# a_17330_20# a_17196_n170# VDD.t2056 pfet_03v3 ad=56.7f pd=0.675u as=0.1278p ps=1.07u w=0.36u l=0.28u
X4991 VSS RB12.t43 a_33530_1556# VSS nfet_03v3 ad=0.1584p pd=1.6u as=0.1854p ps=1.75u w=0.36u l=0.28u
X4992 a_35573_2966# RA10.t38 VSS VSS nfet_03v3 ad=0.1944p pd=1.8u as=0.1656p ps=1.64u w=0.36u l=0.28u
X4993 VSS a_14724_614# a_14858_928# VSS nfet_03v3 ad=97.2f pd=0.9u as=0.1584p ps=1.6u w=0.36u l=0.28u
X4994 a_10853_10114# RA1.t46 VSS VSS nfet_03v3 ad=0.1944p pd=1.8u as=0.1656p ps=1.64u w=0.36u l=0.28u
X4995 a_4836_6886# a_n884_6886.t33 a_4648_6886# VDD pfet_03v3 ad=0.1278p pd=1.07u as=0.2097p ps=1.38u w=0.36u l=0.28u
X4996 a_5909_6102# RA6.t46 VSS VSS nfet_03v3 ad=0.1944p pd=1.8u as=0.1656p ps=1.64u w=0.36u l=0.28u
X4997 a_5605_614# a_4836_614# VDD VDD pfet_03v3 ad=0.36p pd=2.44u as=0.1764p ps=1.26u w=0.72u l=0.28u
X4998 VDD a_n1204_6102.t36 a_9978_6102# VDD pfet_03v3 ad=0.1584p pd=1.6u as=56.7f ps=0.675u w=0.36u l=0.28u
X4999 a_24424_614# a_24360_n708.t33 VSS VSS nfet_03v3 ad=0.1188p pd=1.02u as=0.1584p ps=1.6u w=0.36u l=0.28u
X5000 VSS RB2.t40 a_8810_9396# VSS nfet_03v3 ad=0.1584p pd=1.6u as=0.1854p ps=1.75u w=0.36u l=0.28u
X5001 a_4836_3750# a_n884_3750.t29 a_4648_3750# VDD pfet_03v3 ad=0.1278p pd=1.07u as=0.2097p ps=1.38u w=0.36u l=0.28u
X5002 a_20741_9238# RA2.t45 VDD VDD pfet_03v3 ad=0.3888p pd=2.52u as=0.3312p ps=2.36u w=0.72u l=0.28u
X5003 VDD a_22140_6886# a_22274_7200# VDD pfet_03v3 ad=0.1764p pd=1.26u as=0.1584p ps=1.6u w=0.36u l=0.28u
X5004 a_28157_8546# RA3.t42 VSS VSS nfet_03v3 ad=0.1944p pd=1.8u as=0.1656p ps=1.64u w=0.36u l=0.28u
X5005 VSS RB6.t43 a_8810_6260# VSS nfet_03v3 ad=0.1584p pd=1.6u as=0.1854p ps=1.75u w=0.36u l=0.28u
X5006 VDD a_22140_3750# a_22274_4064# VDD pfet_03v3 ad=0.1764p pd=1.26u as=0.1584p ps=1.6u w=0.36u l=0.28u
X5007 a_4836_614# a_n884_614.t34 a_4648_614# VDD pfet_03v3 ad=0.1278p pd=1.07u as=0.2097p ps=1.38u w=0.36u l=0.28u
X5008 a_15493_7670# a_15797_7670# a_15961_n862.t21 VDD pfet_03v3 ad=0.1152p pd=1u as=0.1584p ps=1.6u w=0.36u l=0.28u
X5009 a_27632_n1234# a_n884_n1738.t30 VSS.t17 VSS nfet_03v3 ad=56.7f pd=0.675u as=0.1584p ps=1.6u w=0.36u l=0.28u
X5010 VDD a_22140_614# a_22274_928# VDD pfet_03v3 ad=0.1764p pd=1.26u as=0.1584p ps=1.6u w=0.36u l=0.28u
X5011 a_15493_4534# a_15797_4534# a_15961_n862.t25 VDD pfet_03v3 ad=0.1152p pd=1u as=0.1584p ps=1.6u w=0.36u l=0.28u
X5012 a_7120_614# a_7056_n708.t30 VSS VSS nfet_03v3 ad=0.1188p pd=1.02u as=0.1584p ps=1.6u w=0.36u l=0.28u
X5013 a_30629_8546# RA3.t43 VDD VDD pfet_03v3 ad=0.3888p pd=2.52u as=0.3312p ps=2.36u w=0.72u l=0.28u
X5014 VSS a_n884_3750.t30 a_12450_3750# VSS nfet_03v3 ad=0.1584p pd=1.6u as=56.7f ps=0.675u w=0.36u l=0.28u
X5015 a_n296_2182# a_n360_n708.t29 VSS VSS nfet_03v3 ad=0.1188p pd=1.02u as=0.1584p ps=1.6u w=0.36u l=0.28u
X5016 a_n1204_1398.t0 a_n1652_1398# VDD VDD pfet_03v3 ad=0.3302p pd=1.79u as=0.5588p ps=3.42u w=1.27u l=0.28u
X5017 a_21952_1398# a_21888_n708.t33 VDD VDD pfet_03v3 ad=0.2097p pd=1.38u as=0.3168p ps=2.32u w=0.72u l=0.28u
X5018 a_9780_7670# a_n884_7670.t29 a_9592_7670# VDD pfet_03v3 ad=0.1278p pd=1.07u as=0.2097p ps=1.38u w=0.36u l=0.28u
X5019 a_27084_n170# a_n884_n170.t35 a_26896_n170# VDD.t1356 pfet_03v3 ad=0.1278p pd=1.07u as=0.2097p ps=1.38u w=0.36u l=0.28u
X5020 a_17008_10806# a_16944_n708.t33 VDD VDD pfet_03v3 ad=0.2097p pd=1.38u as=0.3168p ps=2.32u w=0.72u l=0.28u
X5021 VDD RB2.t41 a_6338_9396# VDD pfet_03v3 ad=0.3168p pd=2.32u as=0.3708p ps=2.47u w=0.72u l=0.28u
X5022 VDD a_n1204_7670.t36 a_90_7670# VDD pfet_03v3 ad=0.1584p pd=1.6u as=56.7f ps=0.675u w=0.36u l=0.28u
X5023 a_9780_4534# a_n884_4534.t29 a_9592_4534# VDD pfet_03v3 ad=0.1278p pd=1.07u as=0.2097p ps=1.38u w=0.36u l=0.28u
X5024 a_20741_4534# RA8.t45 VSS VSS nfet_03v3 ad=0.1944p pd=1.8u as=0.1656p ps=1.64u w=0.36u l=0.28u
X5025 a_30325_2966# a_30629_2966# a_30793_n862.t17 VDD pfet_03v3 ad=0.1152p pd=1u as=0.1584p ps=1.6u w=0.36u l=0.28u
X5026 VSS a_29556_8454# a_29690_8768# VSS nfet_03v3 ad=97.2f pd=0.9u as=0.1584p ps=1.6u w=0.36u l=0.28u
X5027 a_14922_2966# a_14858_3156# a_14724_2966# VDD pfet_03v3 ad=56.7f pd=0.675u as=0.1278p ps=1.07u w=0.36u l=0.28u
X5028 a_17196_n954# a_n1204_n954.t31 a_17008_n954# VSS nfet_03v3 ad=0.1278p pd=1.07u as=0.1188p ps=1.02u w=0.36u l=0.28u
X5029 a_n884_n954.t1 a_n1204_n954.t32 VDD.t1247 VDD.t1246 pfet_03v3 ad=0.3886p pd=1.92u as=0.3386p ps=1.86u w=1.34u l=0.28u
X5030 VDD a_n1204_4534.t37 a_90_4534# VDD pfet_03v3 ad=0.1584p pd=1.6u as=56.7f ps=0.675u w=0.36u l=0.28u
X5031 a_9978_10526# a_9914_10336# a_9780_10022# VDD pfet_03v3 ad=56.7f pd=0.675u as=0.1278p ps=1.07u w=0.36u l=0.28u
X5032 VDD a_n1204_10022.t35 a_34698_10526# VDD pfet_03v3 ad=0.1584p pd=1.6u as=56.7f ps=0.675u w=0.36u l=0.28u
X5033 a_25381_6886# a_25685_6978# a_25849_n862.t29 VDD pfet_03v3 ad=0.1152p pd=1u as=0.1584p ps=1.6u w=0.36u l=0.28u
X5034 a_18703_n2146.t14 a_18698_5664# a_17965_5318# VDD pfet_03v3 ad=0.1584p pd=1.6u as=0.1152p ps=1u w=0.36u l=0.28u
X5035 VSS a_29556_5318# a_29690_5632# VSS nfet_03v3 ad=97.2f pd=0.9u as=0.1584p ps=1.6u w=0.36u l=0.28u
X5036 VSS RB9.t46 a_3866_4096# VSS nfet_03v3 ad=0.1584p pd=1.6u as=0.1854p ps=1.75u w=0.36u l=0.28u
X5037 a_17965_2966# RA10.t39 a_18433_n862.t4 VSS nfet_03v3 ad=0.1152p pd=1u as=0.1584p ps=1.6u w=0.36u l=0.28u
X5038 a_5909_10806# RA0.t46 VSS VSS nfet_03v3 ad=0.1944p pd=1.8u as=0.1656p ps=1.64u w=0.36u l=0.28u
X5039 VDD a_n1204_8454.t39 a_32226_8958# VDD pfet_03v3 ad=0.1584p pd=1.6u as=56.7f ps=0.675u w=0.36u l=0.28u
X5040 a_25381_3750# a_25685_3842# a_25849_n862.t19 VDD pfet_03v3 ad=0.1152p pd=1u as=0.1584p ps=1.6u w=0.36u l=0.28u
X5041 VSS a_n884_6886.t34 a_34698_6886# VSS nfet_03v3 ad=0.1584p pd=1.6u as=56.7f ps=0.675u w=0.36u l=0.28u
X5042 VSS a_24612_2966# a_24746_3156# VSS nfet_03v3 ad=97.2f pd=0.9u as=0.1584p ps=1.6u w=0.36u l=0.28u
X5043 a_n1204_n170.t2 a_n1652_n170# VSS VSS nfet_03v3 ad=0.1651p pd=1.155u as=0.2794p ps=2.15u w=0.635u l=0.28u
X5044 a_25381_614# a_25685_706# a_25849_n862.t23 VDD pfet_03v3 ad=0.1152p pd=1u as=0.1584p ps=1.6u w=0.36u l=0.28u
X5045 a_17965_1398# a_17196_1398# VSS VSS nfet_03v3 ad=0.18p pd=1.72u as=97.2f ps=0.9u w=0.36u l=0.28u
X5046 a_7120_10022# a_7056_n708.t31 VDD VDD pfet_03v3 ad=0.2097p pd=1.38u as=0.3168p ps=2.32u w=0.72u l=0.28u
X5047 a_23647_n2146.t28 a_23642_10368# a_22909_10022# VDD pfet_03v3 ad=0.1584p pd=1.6u as=0.1152p ps=1u w=0.36u l=0.28u
X5048 a_21175_n2146.t18 RB3.t40 a_20437_8454# VSS nfet_03v3 ad=0.1584p pd=1.6u as=0.1152p ps=1u w=0.36u l=0.28u
X5049 a_32226_8454# a_32162_8768# a_32028_8454# VSS nfet_03v3 ad=56.7f pd=0.675u as=0.1278p ps=1.07u w=0.36u l=0.28u
X5050 a_29754_7670# a_29690_7860# a_29556_7670# VDD pfet_03v3 ad=56.7f pd=0.675u as=0.1278p ps=1.07u w=0.36u l=0.28u
X5051 QB2b.t0 a_6343_n2146.t33 VDD VDD pfet_03v3 ad=0.4104p pd=2.58u as=0.2484p ps=1.41u w=0.72u l=0.28u
X5052 a_18269_1398# RA12.t42 VDD VDD pfet_03v3 ad=0.3888p pd=2.52u as=0.3312p ps=2.36u w=0.72u l=0.28u
X5053 a_3437_9238# RA2.t46 VSS VSS nfet_03v3 ad=0.1944p pd=1.8u as=0.1656p ps=1.64u w=0.36u l=0.28u
X5054 a_13021_6102# a_12252_6102# VDD VDD pfet_03v3 ad=0.36p pd=2.44u as=0.1764p ps=1.26u w=0.72u l=0.28u
X5055 a_12064_614# a_12000_n708.t31 VSS VSS nfet_03v3 ad=0.1188p pd=1.02u as=0.1584p ps=1.6u w=0.36u l=0.28u
X5056 a_15493_8454# a_14724_8454# VDD VDD pfet_03v3 ad=0.36p pd=2.44u as=0.1764p ps=1.26u w=0.72u l=0.28u
X5057 VSS a_n884_7670.t30 a_29754_8174# VSS nfet_03v3 ad=0.1584p pd=1.6u as=56.7f ps=0.675u w=0.36u l=0.28u
X5058 a_25685_6978# RA5.t40 VSS VSS nfet_03v3 ad=0.1944p pd=1.8u as=0.1656p ps=1.64u w=0.36u l=0.28u
X5059 a_32226_5318# a_32162_5632# a_32028_5318# VSS nfet_03v3 ad=56.7f pd=0.675u as=0.1278p ps=1.07u w=0.36u l=0.28u
X5060 VSS RB8.t45 a_6338_4692# VSS nfet_03v3 ad=0.1584p pd=1.6u as=0.1854p ps=1.75u w=0.36u l=0.28u
X5061 a_29754_4534# a_29690_4724# a_29556_4534# VDD pfet_03v3 ad=56.7f pd=0.675u as=0.1278p ps=1.07u w=0.36u l=0.28u
X5062 a_3133_3750# a_2364_3750# VDD VDD pfet_03v3 ad=0.36p pd=2.44u as=0.1764p ps=1.26u w=0.72u l=0.28u
X5063 a_20741_10114# RA1.t47 VDD VDD pfet_03v3 ad=0.3888p pd=2.52u as=0.3312p ps=2.36u w=0.72u l=0.28u
X5064 a_3437_6102# RA6.t47 VSS VSS nfet_03v3 ad=0.1944p pd=1.8u as=0.1656p ps=1.64u w=0.36u l=0.28u
X5065 VSS a_7308_2966# a_7442_3156# VSS nfet_03v3 ad=97.2f pd=0.9u as=0.1584p ps=1.6u w=0.36u l=0.28u
X5066 a_33101_2966# RA10.t40 VSS VSS nfet_03v3 ad=0.1944p pd=1.8u as=0.1656p ps=1.64u w=0.36u l=0.28u
X5067 a_3133_614# a_2364_614# VDD VDD pfet_03v3 ad=0.36p pd=2.44u as=0.1764p ps=1.26u w=0.72u l=0.28u
X5068 a_12064_9238# a_12000_n708.t32 VSS VSS nfet_03v3 ad=0.1188p pd=1.02u as=0.1584p ps=1.6u w=0.36u l=0.28u
X5069 VSS a_n884_4534.t30 a_29754_5038# VSS nfet_03v3 ad=0.1584p pd=1.6u as=56.7f ps=0.675u w=0.36u l=0.28u
X5070 a_38479_n2146.t1 RB15.t43 a_37741_n954# VSS nfet_03v3 ad=0.1584p pd=1.6u as=0.1152p ps=1u w=0.36u l=0.28u
X5071 a_27282_1398# a_27218_1588# a_27084_1398# VDD pfet_03v3 ad=56.7f pd=0.675u as=0.1278p ps=1.07u w=0.36u l=0.28u
X5072 a_19480_5318# a_19416_n708.t32 VDD VDD pfet_03v3 ad=0.2097p pd=1.38u as=0.3168p ps=2.32u w=0.72u l=0.28u
X5073 a_24612_2966# a_n884_2966.t32 a_24424_2966# VDD pfet_03v3 ad=0.1278p pd=1.07u as=0.2097p ps=1.38u w=0.36u l=0.28u
X5074 VDD a_12252_10022# a_12386_10336# VDD pfet_03v3 ad=0.1764p pd=1.26u as=0.1584p ps=1.6u w=0.36u l=0.28u
X5075 a_12064_6102# a_12000_n708.t33 VSS VSS nfet_03v3 ad=0.1188p pd=1.02u as=0.1584p ps=1.6u w=0.36u l=0.28u
X5076 a_22909_5318# a_22140_5318# VDD VDD pfet_03v3 ad=0.36p pd=2.44u as=0.1764p ps=1.26u w=0.72u l=0.28u
X5077 a_5605_n954# a_4836_n954# VSS.t2343 VSS nfet_03v3 ad=0.18p pd=1.72u as=97.2f ps=0.9u w=0.36u l=0.28u
X5078 a_19480_2182# a_19416_n708.t33 VDD VDD pfet_03v3 ad=0.2097p pd=1.38u as=0.3168p ps=2.32u w=0.72u l=0.28u
X5079 a_14922_10526# a_14858_10336# a_14724_10022# VDD pfet_03v3 ad=56.7f pd=0.675u as=0.1278p ps=1.07u w=0.36u l=0.28u
X5080 a_22909_2182# a_22140_2182# VDD VDD pfet_03v3 ad=0.36p pd=2.44u as=0.1764p ps=1.26u w=0.72u l=0.28u
X5081 a_10853_10806# RA0.t47 VSS VSS nfet_03v3 ad=0.1944p pd=1.8u as=0.1656p ps=1.64u w=0.36u l=0.28u
X5082 VDD a_9780_2966# a_9914_3156# VDD pfet_03v3 ad=0.1764p pd=1.26u as=0.1584p ps=1.6u w=0.36u l=0.28u
X5083 VSS a_14724_10806# a_14858_10996# VSS nfet_03v3 ad=97.2f pd=0.9u as=0.1584p ps=1.6u w=0.36u l=0.28u
X5084 VSS RB4.t42 a_16226_7828# VSS nfet_03v3 ad=0.1584p pd=1.6u as=0.1854p ps=1.75u w=0.36u l=0.28u
X5085 VSS RB9.t47 a_36002_4096# VSS nfet_03v3 ad=0.1584p pd=1.6u as=0.1854p ps=1.75u w=0.36u l=0.28u
X5086 VDD a_24612_10806# a_24746_10996# VDD pfet_03v3 ad=0.1764p pd=1.26u as=0.1584p ps=1.6u w=0.36u l=0.28u
X5087 a_8381_8546# RA3.t44 VSS VSS nfet_03v3 ad=0.1944p pd=1.8u as=0.1656p ps=1.64u w=0.36u l=0.28u
X5088 VSS a_n884_3750.t31 a_9978_3750# VSS nfet_03v3 ad=0.1584p pd=1.6u as=56.7f ps=0.675u w=0.36u l=0.28u
X5089 a_30325_2966# a_29556_2966# VDD VDD pfet_03v3 ad=0.36p pd=2.44u as=0.1764p ps=1.26u w=0.72u l=0.28u
X5090 QB4b.t0 a_11287_n2146.t33 VDD VDD pfet_03v3 ad=0.4104p pd=2.58u as=0.2484p ps=1.41u w=0.72u l=0.28u
X5091 VSS a_n884_9238.t30 a_14922_9742# VSS nfet_03v3 ad=0.1584p pd=1.6u as=56.7f ps=0.675u w=0.36u l=0.28u
X5092 a_n296_8454# a_n360_n708.t30 VDD VDD pfet_03v3 ad=0.2097p pd=1.38u as=0.3168p ps=2.32u w=0.72u l=0.28u
X5093 a_7308_7670# a_n884_7670.t31 a_7120_7670# VDD pfet_03v3 ad=0.1278p pd=1.07u as=0.2097p ps=1.38u w=0.36u l=0.28u
X5094 a_11287_n2146.t25 a_11282_1556# a_10549_1398# VDD pfet_03v3 ad=0.1584p pd=1.6u as=0.1152p ps=1u w=0.36u l=0.28u
X5095 VDD RB2.t42 a_3866_9396# VDD pfet_03v3 ad=0.3168p pd=2.32u as=0.3708p ps=2.47u w=0.72u l=0.28u
X5096 VSS a_n884_6102.t31 a_14922_6606# VSS nfet_03v3 ad=0.1584p pd=1.6u as=56.7f ps=0.675u w=0.36u l=0.28u
X5097 a_7308_4534# a_n884_4534.t31 a_7120_4534# VDD pfet_03v3 ad=0.1278p pd=1.07u as=0.2097p ps=1.38u w=0.36u l=0.28u
X5098 a_35269_3750# a_34500_3750# VDD VDD pfet_03v3 ad=0.36p pd=2.44u as=0.1764p ps=1.26u w=0.72u l=0.28u
X5099 a_12450_2966# a_12386_3156# a_12252_2966# VDD pfet_03v3 ad=56.7f pd=0.675u as=0.1278p ps=1.07u w=0.36u l=0.28u
X5100 a_661_1398# a_n108_1398# VDD VDD pfet_03v3 ad=0.36p pd=2.44u as=0.1764p ps=1.26u w=0.72u l=0.28u
X5101 a_3871_n2146.t18 a_3866_n608# a_3133_n954# VDD.t2400 pfet_03v3 ad=0.1584p pd=1.6u as=0.1152p ps=1u w=0.36u l=0.28u
X5102 a_22909_6886# a_23213_6978# a_23377_n862.t19 VDD pfet_03v3 ad=0.1152p pd=1u as=0.1584p ps=1.6u w=0.36u l=0.28u
X5103 a_16231_n2146.t21 a_16226_5664# a_15493_5318# VDD pfet_03v3 ad=0.1584p pd=1.6u as=0.1152p ps=1u w=0.36u l=0.28u
X5104 a_35269_614# a_34500_614# VDD VDD pfet_03v3 ad=0.36p pd=2.44u as=0.1764p ps=1.26u w=0.72u l=0.28u
X5105 VSS RB14.t45 a_11282_n12# VSS nfet_03v3 ad=0.1584p pd=1.6u as=0.1854p ps=1.75u w=0.36u l=0.28u
X5106 VSS a_32028_10806# a_32162_10996# VSS nfet_03v3 ad=97.2f pd=0.9u as=0.1584p ps=1.6u w=0.36u l=0.28u
X5107 a_n108_6102# a_n884_6102.t32 a_n296_6102# VDD pfet_03v3 ad=0.1278p pd=1.07u as=0.2097p ps=1.38u w=0.36u l=0.28u
X5108 a_22909_3750# a_23213_3842# a_23377_n862.t29 VDD pfet_03v3 ad=0.1152p pd=1u as=0.1584p ps=1.6u w=0.36u l=0.28u
X5109 a_15493_1398# a_14724_1398# VSS VSS nfet_03v3 ad=0.18p pd=1.72u as=97.2f ps=0.9u w=0.36u l=0.28u
X5110 a_22909_614# a_23213_706# a_23377_n862.t27 VDD pfet_03v3 ad=0.1152p pd=1u as=0.1584p ps=1.6u w=0.36u l=0.28u
X5111 VDD a_n1204_10022.t36 a_29754_10526# VDD pfet_03v3 ad=0.1584p pd=1.6u as=56.7f ps=0.675u w=0.36u l=0.28u
X5112 VDD RB5.t44 a_11282_7232# VDD pfet_03v3 ad=0.3168p pd=2.32u as=0.3708p ps=2.47u w=0.72u l=0.28u
X5113 a_17196_10022# a_n1204_10022.t37 a_17008_10022# VSS nfet_03v3 ad=0.1278p pd=1.07u as=0.1188p ps=1.02u w=0.36u l=0.28u
X5114 a_23213_6978# RA5.t41 VSS VSS nfet_03v3 ad=0.1944p pd=1.8u as=0.1656p ps=1.64u w=0.36u l=0.28u
X5115 a_10549_6102# a_9780_6102# VDD VDD pfet_03v3 ad=0.36p pd=2.44u as=0.1764p ps=1.26u w=0.72u l=0.28u
X5116 VDD a_n1204_6102.t37 a_22338_6102# VDD pfet_03v3 ad=0.1584p pd=1.6u as=56.7f ps=0.675u w=0.36u l=0.28u
X5117 a_19866_n954# a_19802_n640# a_19668_n954# VSS nfet_03v3 ad=56.7f pd=0.675u as=0.1278p ps=1.07u w=0.36u l=0.28u
X5118 VDD RB0.t40 a_8810_10964# VDD pfet_03v3 ad=0.3168p pd=2.32u as=0.3708p ps=2.47u w=0.72u l=0.28u
X5119 VSS a_n884_7670.t32 a_27282_8174# VSS nfet_03v3 ad=0.1584p pd=1.6u as=56.7f ps=0.675u w=0.36u l=0.28u
X5120 VSS RB8.t46 a_3866_4692# VSS nfet_03v3 ad=0.1584p pd=1.6u as=0.1854p ps=1.75u w=0.36u l=0.28u
X5121 VSS a_4836_2966# a_4970_3156# VSS nfet_03v3 ad=97.2f pd=0.9u as=0.1584p ps=1.6u w=0.36u l=0.28u
X5122 a_38045_n862# RA15.t39 VDD.t460 VDD.t459 pfet_03v3 ad=0.3888p pd=2.52u as=0.3312p ps=2.36u w=0.72u l=0.28u
X5123 VSS a_n1652_9238# a_n1204_9238.t2 VSS nfet_03v3 ad=0.1693p pd=1.19u as=0.1651p ps=1.155u w=0.635u l=0.28u
X5124 VSS a_n884_4534.t32 a_27282_5038# VSS nfet_03v3 ad=0.1584p pd=1.6u as=56.7f ps=0.675u w=0.36u l=0.28u
X5125 a_3229_n1738# a_n884_n1738.t31 a_2120_n1782# VDD pfet_03v3 ad=0.2097p pd=1.38u as=0.1278p ps=1.07u w=0.36u l=0.28u
X5126 a_38479_n2146.t20 a_38474_8800# a_37741_8454# VDD pfet_03v3 ad=0.1584p pd=1.6u as=0.1152p ps=1u w=0.36u l=0.28u
X5127 a_5909_n862# RA15.t40 VDD.t462 VDD.t461 pfet_03v3 ad=0.3888p pd=2.52u as=0.3312p ps=2.36u w=0.72u l=0.28u
X5128 a_965_7670# RA4.t44 VDD VDD pfet_03v3 ad=0.3888p pd=2.52u as=0.3312p ps=2.36u w=0.72u l=0.28u
X5129 a_13759_n2146.t29 a_13754_7828# a_13021_7670# VDD pfet_03v3 ad=0.1584p pd=1.6u as=0.1152p ps=1u w=0.36u l=0.28u
X5130 a_27853_7670# a_28157_7670# a_28321_n862.t29 VDD pfet_03v3 ad=0.1152p pd=1u as=0.1584p ps=1.6u w=0.36u l=0.28u
X5131 VDD a_2364_6886# a_2498_7200# VDD pfet_03v3 ad=0.1764p pd=1.26u as=0.1584p ps=1.6u w=0.36u l=0.28u
X5132 a_30629_3842# RA9.t45 VSS VSS nfet_03v3 ad=0.1944p pd=1.8u as=0.1656p ps=1.64u w=0.36u l=0.28u
X5133 a_22140_2966# a_n884_2966.t33 a_21952_2966# VDD pfet_03v3 ad=0.1278p pd=1.07u as=0.2097p ps=1.38u w=0.36u l=0.28u
X5134 a_3133_n954# a_2364_n954# VSS.t2144 VSS nfet_03v3 ad=0.18p pd=1.72u as=97.2f ps=0.9u w=0.36u l=0.28u
X5135 a_10853_7670# RA4.t45 VSS VSS nfet_03v3 ad=0.1944p pd=1.8u as=0.1656p ps=1.64u w=0.36u l=0.28u
X5136 a_20437_5318# a_19668_5318# VDD VDD pfet_03v3 ad=0.36p pd=2.44u as=0.1764p ps=1.26u w=0.72u l=0.28u
X5137 a_n1204_n170.t0 a_n1652_n170# VDD.t3171 VDD.t1367 pfet_03v3 ad=0.3302p pd=1.79u as=0.5588p ps=3.42u w=1.27u l=0.28u
X5138 VDD RB2.t43 a_36002_9396# VDD pfet_03v3 ad=0.3168p pd=2.32u as=0.3708p ps=2.47u w=0.72u l=0.28u
X5139 a_965_4534# RA8.t46 VDD VDD pfet_03v3 ad=0.3888p pd=2.52u as=0.3312p ps=2.36u w=0.72u l=0.28u
X5140 a_13759_n2146.t18 a_13754_4692# a_13021_4534# VDD pfet_03v3 ad=0.1584p pd=1.6u as=0.1152p ps=1u w=0.36u l=0.28u
X5141 a_27853_4534# a_28157_4534# a_28321_n862.t19 VDD pfet_03v3 ad=0.1152p pd=1u as=0.1584p ps=1.6u w=0.36u l=0.28u
X5142 VDD a_2364_3750# a_2498_4064# VDD pfet_03v3 ad=0.1764p pd=1.26u as=0.1584p ps=1.6u w=0.36u l=0.28u
X5143 a_20437_2182# a_19668_2182# VDD VDD pfet_03v3 ad=0.36p pd=2.44u as=0.1764p ps=1.26u w=0.72u l=0.28u
X5144 a_7064_n1782# a_7568_n1738# a_7856_n1234# VSS nfet_03v3 ad=0.1278p pd=1.07u as=56.7f ps=0.675u w=0.36u l=0.28u
X5145 a_21952_n170# a_21888_n708.t34 VDD.t1336 VDD.t1318 pfet_03v3 ad=0.2097p pd=1.38u as=0.3168p ps=2.32u w=0.72u l=0.28u
X5146 a_13021_3750# a_12252_3750# VSS VSS nfet_03v3 ad=0.18p pd=1.72u as=97.2f ps=0.9u w=0.36u l=0.28u
X5147 VDD.t745 RB15.t44 a_8810_n608# VDD.t744 pfet_03v3 ad=0.3168p pd=2.32u as=0.3708p ps=2.47u w=0.72u l=0.28u
X5148 VDD a_2364_614# a_2498_928# VDD pfet_03v3 ad=0.1764p pd=1.26u as=0.1584p ps=1.6u w=0.36u l=0.28u
X5149 a_34500_10022# a_n1204_10022.t38 a_34312_10022# VSS nfet_03v3 ad=0.1278p pd=1.07u as=0.1188p ps=1.02u w=0.36u l=0.28u
X5150 VSS RB4.t43 a_13754_7828# VSS nfet_03v3 ad=0.1584p pd=1.6u as=0.1854p ps=1.75u w=0.36u l=0.28u
X5151 a_19668_2182# a_n1204_2182.t29 a_19480_2182# VSS nfet_03v3 ad=0.1278p pd=1.07u as=0.1188p ps=1.02u w=0.36u l=0.28u
X5152 a_n296_1398# a_n360_n708.t31 VSS VSS nfet_03v3 ad=0.1188p pd=1.02u as=0.1584p ps=1.6u w=0.36u l=0.28u
X5153 a_17008_10022# a_16944_n708.t34 VDD VDD pfet_03v3 ad=0.2097p pd=1.38u as=0.3168p ps=2.32u w=0.72u l=0.28u
X5154 a_2364_7670# a_n1204_7670.t37 a_2176_7670# VSS nfet_03v3 ad=0.1278p pd=1.07u as=0.1188p ps=1.02u w=0.36u l=0.28u
X5155 a_29556_n954# a_n1204_n954.t33 a_29368_n954# VSS nfet_03v3 ad=0.1278p pd=1.07u as=0.1188p ps=1.02u w=0.36u l=0.28u
X5156 VDD a_8545_n862.t33 QA3b.t0 VDD pfet_03v3 ad=0.2484p pd=1.41u as=0.4104p ps=2.58u w=0.72u l=0.28u
X5157 VDD RB0.t41 a_13754_10964# VDD pfet_03v3 ad=0.3168p pd=2.32u as=0.3708p ps=2.47u w=0.72u l=0.28u
X5158 a_2364_4534# a_n1204_4534.t38 a_2176_4534# VSS nfet_03v3 ad=0.1278p pd=1.07u as=0.1188p ps=1.02u w=0.36u l=0.28u
X5159 a_32028_2182# a_n884_2182.t33 a_31840_2182# VDD pfet_03v3 ad=0.1278p pd=1.07u as=0.2097p ps=1.38u w=0.36u l=0.28u
X5160 a_28591_n2146.t16 a_28586_6260# a_27853_6102# VDD pfet_03v3 ad=0.1584p pd=1.6u as=0.1152p ps=1u w=0.36u l=0.28u
X5161 VSS a_n884_10022.t33 a_24810_10022# VSS nfet_03v3 ad=0.1584p pd=1.6u as=56.7f ps=0.675u w=0.36u l=0.28u
X5162 a_17965_9238# a_17196_9238# VDD VDD pfet_03v3 ad=0.36p pd=2.44u as=0.1764p ps=1.26u w=0.72u l=0.28u
X5163 VSS RB8.t47 a_36002_4692# VSS nfet_03v3 ad=0.1584p pd=1.6u as=0.1854p ps=1.75u w=0.36u l=0.28u
X5164 VSS a_36972_2966# a_37106_3156# VSS nfet_03v3 ad=97.2f pd=0.9u as=0.1584p ps=1.6u w=0.36u l=0.28u
X5165 a_18269_n170# RA14.t41 VDD.t1089 VDD.t435 pfet_03v3 ad=0.3888p pd=2.52u as=0.3312p ps=2.36u w=0.72u l=0.28u
X5166 a_25381_2182# a_24612_2182# VSS VSS nfet_03v3 ad=0.18p pd=1.72u as=97.2f ps=0.9u w=0.36u l=0.28u
X5167 a_33535_n2146.t14 RB3.t41 a_32797_8454# VSS nfet_03v3 ad=0.1584p pd=1.6u as=0.1152p ps=1u w=0.36u l=0.28u
X5168 a_35269_n954# a_34500_n954# VSS.t2285 VSS nfet_03v3 ad=0.18p pd=1.72u as=97.2f ps=0.9u w=0.36u l=0.28u
X5169 a_1399_n2146.t21 RB3.t42 a_661_8454# VSS nfet_03v3 ad=0.1584p pd=1.6u as=0.1152p ps=1u w=0.36u l=0.28u
X5170 a_9978_7670# a_9914_7860# a_9780_7670# VDD pfet_03v3 ad=56.7f pd=0.675u as=0.1278p ps=1.07u w=0.36u l=0.28u
X5171 a_10549_2966# a_10853_2966# a_11017_n862.t24 VDD pfet_03v3 ad=0.1152p pd=1u as=0.1584p ps=1.6u w=0.36u l=0.28u
X5172 VDD D15.t1 a_37837_n1738# VDD pfet_03v3 ad=0.3168p pd=2.32u as=0.2097p ps=1.38u w=0.72u l=0.28u
X5173 a_27282_n170# a_27218_20# a_27084_n170# VDD.t2466 pfet_03v3 ad=56.7f pd=0.675u as=0.1278p ps=1.07u w=0.36u l=0.28u
X5174 a_3133_6886# a_3437_6978# a_3601_n862.t29 VDD pfet_03v3 ad=0.1152p pd=1u as=0.1584p ps=1.6u w=0.36u l=0.28u
X5175 VDD RB0.t42 a_31058_10964# VDD pfet_03v3 ad=0.3168p pd=2.32u as=0.3708p ps=2.47u w=0.72u l=0.28u
X5176 a_n884_7670.t2 a_n1204_7670.t38 VSS VSS nfet_03v3 ad=0.1943p pd=1.25u as=0.1693p ps=1.19u w=0.67u l=0.28u
X5177 a_n1204_6102.t2 a_n1652_6102# VSS VSS nfet_03v3 ad=0.1651p pd=1.155u as=0.2794p ps=2.15u w=0.635u l=0.28u
X5178 a_9978_4534# a_9914_4724# a_9780_4534# VDD pfet_03v3 ad=56.7f pd=0.675u as=0.1278p ps=1.07u w=0.36u l=0.28u
X5179 a_34312_10806# a_34248_n708.t34 VSS VSS nfet_03v3 ad=0.1188p pd=1.02u as=0.1584p ps=1.6u w=0.36u l=0.28u
X5180 a_n884_7670.t3 a_n1204_7670.t39 VDD VDD pfet_03v3 ad=0.3886p pd=1.92u as=0.3386p ps=1.86u w=1.34u l=0.28u
X5181 a_3133_3750# a_3437_3842# a_3601_n862.t19 VDD pfet_03v3 ad=0.1152p pd=1u as=0.1584p ps=1.6u w=0.36u l=0.28u
X5182 a_n1204_2966.t2 a_n1652_2966# VSS VSS nfet_03v3 ad=0.1651p pd=1.155u as=0.2794p ps=2.15u w=0.635u l=0.28u
X5183 a_36972_2966# a_n884_2966.t34 a_36784_2966# VDD pfet_03v3 ad=0.1278p pd=1.07u as=0.2097p ps=1.38u w=0.36u l=0.28u
X5184 a_13021_n954# RA15.t41 a_13489_n862.t7 VSS nfet_03v3 ad=0.1152p pd=1u as=0.1584p ps=1.6u w=0.36u l=0.28u
X5185 a_28591_n2146.t5 RB12.t44 a_27853_1398# VSS nfet_03v3 ad=0.1584p pd=1.6u as=0.1152p ps=1u w=0.36u l=0.28u
X5186 a_30629_9238# RA2.t47 VDD VDD pfet_03v3 ad=0.3888p pd=2.52u as=0.3312p ps=2.36u w=0.72u l=0.28u
X5187 VDD a_32028_6886# a_32162_7200# VDD pfet_03v3 ad=0.1764p pd=1.26u as=0.1584p ps=1.6u w=0.36u l=0.28u
X5188 a_n884_4534.t3 a_n1204_4534.t39 VDD VDD pfet_03v3 ad=0.3886p pd=1.92u as=0.3386p ps=1.86u w=1.34u l=0.28u
X5189 a_n108_3750# a_n1204_3750.t38 a_n296_3750# VSS nfet_03v3 ad=0.1278p pd=1.07u as=0.1188p ps=1.02u w=0.36u l=0.28u
X5190 a_3437_n862# RA15.t42 VDD.t464 VDD.t463 pfet_03v3 ad=0.3888p pd=2.52u as=0.3312p ps=2.36u w=0.72u l=0.28u
X5191 a_3133_614# a_3437_706# a_3601_n862.t20 VDD pfet_03v3 ad=0.1152p pd=1u as=0.1584p ps=1.6u w=0.36u l=0.28u
X5192 VDD a_32028_3750# a_32162_4064# VDD pfet_03v3 ad=0.1764p pd=1.26u as=0.1584p ps=1.6u w=0.36u l=0.28u
X5193 VDD a_n1204_6102.t38 a_2562_6102# VDD pfet_03v3 ad=0.1584p pd=1.6u as=56.7f ps=0.675u w=0.36u l=0.28u
X5194 VDD a_12252_8454# a_12386_8768# VDD pfet_03v3 ad=0.1764p pd=1.26u as=0.1584p ps=1.6u w=0.36u l=0.28u
X5195 VSS a_n884_7670.t33 a_7506_8174# VSS nfet_03v3 ad=0.1584p pd=1.6u as=56.7f ps=0.675u w=0.36u l=0.28u
X5196 VDD a_32028_614# a_32162_928# VDD pfet_03v3 ad=0.1764p pd=1.26u as=0.1584p ps=1.6u w=0.36u l=0.28u
X5197 a_10549_3750# a_9780_3750# VSS VSS nfet_03v3 ad=0.18p pd=1.72u as=97.2f ps=0.9u w=0.36u l=0.28u
X5198 VSS a_n884_3750.t32 a_22338_3750# VSS nfet_03v3 ad=0.1584p pd=1.6u as=56.7f ps=0.675u w=0.36u l=0.28u
X5199 a_27853_10806# a_27084_10806# VSS VSS nfet_03v3 ad=0.18p pd=1.72u as=97.2f ps=0.9u w=0.36u l=0.28u
X5200 VSS a_n884_4534.t33 a_7506_5038# VSS nfet_03v3 ad=0.1584p pd=1.6u as=56.7f ps=0.675u w=0.36u l=0.28u
X5201 a_15797_2966# RA10.t41 VDD VDD pfet_03v3 ad=0.3888p pd=2.52u as=0.3312p ps=2.36u w=0.72u l=0.28u
X5202 a_22688_n1738# WEM.t32 VDD VDD pfet_03v3 ad=56.7f pd=0.675u as=0.1584p ps=1.6u w=0.36u l=0.28u
X5203 a_37741_10806# a_36972_10806# VDD VDD pfet_03v3 ad=0.36p pd=2.44u as=0.1764p ps=1.26u w=0.72u l=0.28u
X5204 a_11287_n2146.t31 a_11282_n12# a_10549_n170# VDD.t2041 pfet_03v3 ad=0.1584p pd=1.6u as=0.1152p ps=1u w=0.36u l=0.28u
X5205 a_31840_1398# a_31776_n708.t34 VDD VDD pfet_03v3 ad=0.2097p pd=1.38u as=0.3168p ps=2.32u w=0.72u l=0.28u
X5206 a_17196_2182# a_n1204_2182.t30 a_17008_2182# VSS nfet_03v3 ad=0.1278p pd=1.07u as=0.1188p ps=1.02u w=0.36u l=0.28u
X5207 a_661_n170# a_n108_n170# VDD.t2787 VDD.t2677 pfet_03v3 ad=0.36p pd=2.44u as=0.1764p ps=1.26u w=0.72u l=0.28u
X5208 a_5605_10022# a_4836_10022# VSS VSS nfet_03v3 ad=0.18p pd=1.72u as=97.2f ps=0.9u w=0.36u l=0.28u
X5209 a_30629_4534# RA8.t47 VSS VSS nfet_03v3 ad=0.1944p pd=1.8u as=0.1656p ps=1.64u w=0.36u l=0.28u
X5210 a_23647_n2146.t17 a_23642_1556# a_22909_1398# VDD pfet_03v3 ad=0.1584p pd=1.6u as=0.1152p ps=1u w=0.36u l=0.28u
X5211 VDD WE0CLK.t37 a_7506_10806# VDD pfet_03v3 ad=0.1584p pd=1.6u as=56.7f ps=0.675u w=0.36u l=0.28u
X5212 a_n1652_7318# WE5.t1 VDD VDD pfet_03v3 ad=0.1872p pd=1.24u as=0.3168p ps=2.32u w=0.72u l=0.28u
X5213 a_24810_2966# a_24746_3156# a_24612_2966# VDD pfet_03v3 ad=56.7f pd=0.675u as=0.1278p ps=1.07u w=0.36u l=0.28u
X5214 VDD.t2676 a_n108_n954# a_26_n640# VDD.t2675 pfet_03v3 ad=0.1764p pd=1.26u as=0.1584p ps=1.6u w=0.36u l=0.28u
X5215 a_32797_10022# a_33101_10114# a_33265_n862.t28 VDD pfet_03v3 ad=0.1152p pd=1u as=0.1584p ps=1.6u w=0.36u l=0.28u
X5216 a_8077_2182# RA11.t45 a_8545_n862.t6 VSS nfet_03v3 ad=0.1152p pd=1u as=0.1584p ps=1.6u w=0.36u l=0.28u
X5217 a_32028_10806# a_n884_10806.t33 a_31840_10806# VDD pfet_03v3 ad=0.1278p pd=1.07u as=0.2097p ps=1.38u w=0.36u l=0.28u
X5218 a_35269_6886# a_35573_6978# a_35737_n862.t24 VDD pfet_03v3 ad=0.1152p pd=1u as=0.1584p ps=1.6u w=0.36u l=0.28u
X5219 a_15493_9238# a_14724_9238# VDD VDD pfet_03v3 ad=0.36p pd=2.44u as=0.1764p ps=1.26u w=0.72u l=0.28u
X5220 VSS RB7.t44 a_11282_5664# VSS nfet_03v3 ad=0.1584p pd=1.6u as=0.1854p ps=1.75u w=0.36u l=0.28u
X5221 a_17008_2966# a_16944_n708.t35 VSS VSS nfet_03v3 ad=0.1188p pd=1.02u as=0.1584p ps=1.6u w=0.36u l=0.28u
X5222 a_35269_3750# a_35573_3842# a_35737_n862.t27 VDD pfet_03v3 ad=0.1152p pd=1u as=0.1584p ps=1.6u w=0.36u l=0.28u
X5223 a_9780_n954# a_n1204_n954.t34 a_9592_n954# VSS nfet_03v3 ad=0.1278p pd=1.07u as=0.1188p ps=1.02u w=0.36u l=0.28u
X5224 a_31063_n2146.t14 RB3.t43 a_30325_8454# VSS nfet_03v3 ad=0.1584p pd=1.6u as=0.1152p ps=1u w=0.36u l=0.28u
X5225 a_19480_6102# a_19416_n708.t34 VDD VDD pfet_03v3 ad=0.2097p pd=1.38u as=0.3168p ps=2.32u w=0.72u l=0.28u
X5226 a_35269_614# a_35573_706# a_35737_n862.t20 VDD pfet_03v3 ad=0.1152p pd=1u as=0.1584p ps=1.6u w=0.36u l=0.28u
X5227 a_28157_1398# RA12.t43 VDD VDD pfet_03v3 ad=0.3888p pd=2.52u as=0.3312p ps=2.36u w=0.72u l=0.28u
X5228 VDD RB5.t45 a_23642_7232# VDD pfet_03v3 ad=0.3168p pd=2.32u as=0.3708p ps=2.47u w=0.72u l=0.28u
X5229 VSS.t1263 a_n884_n954.t34 a_90_n954# VSS nfet_03v3 ad=0.1584p pd=1.6u as=56.7f ps=0.675u w=0.36u l=0.28u
X5230 VSS a_n884_10022.t34 a_19866_10022# VSS nfet_03v3 ad=0.1584p pd=1.6u as=56.7f ps=0.675u w=0.36u l=0.28u
X5231 a_25381_8454# a_24612_8454# VDD VDD pfet_03v3 ad=0.36p pd=2.44u as=0.1764p ps=1.26u w=0.72u l=0.28u
X5232 a_7506_7670# a_7442_7860# a_7308_7670# VDD pfet_03v3 ad=56.7f pd=0.675u as=0.1278p ps=1.07u w=0.36u l=0.28u
X5233 a_27853_7670# a_27084_7670# VSS VSS nfet_03v3 ad=0.18p pd=1.72u as=97.2f ps=0.9u w=0.36u l=0.28u
X5234 a_35573_6978# RA5.t42 VSS VSS nfet_03v3 ad=0.1944p pd=1.8u as=0.1656p ps=1.64u w=0.36u l=0.28u
X5235 a_22909_6102# a_22140_6102# VDD VDD pfet_03v3 ad=0.36p pd=2.44u as=0.1764p ps=1.26u w=0.72u l=0.28u
X5236 a_24360_n708.t0 a_24368_n1782# VSS.t2633 VSS nfet_03v3 ad=0.1612p pd=1.14u as=0.2728p ps=2.12u w=0.62u l=0.28u
X5237 VDD RB1.t39 a_8810_10368# VDD pfet_03v3 ad=0.3168p pd=2.32u as=0.3708p ps=2.47u w=0.72u l=0.28u
X5238 a_17965_6886# a_17196_6886# VSS VSS nfet_03v3 ad=0.18p pd=1.72u as=97.2f ps=0.9u w=0.36u l=0.28u
X5239 a_7506_4534# a_7442_4724# a_7308_4534# VDD pfet_03v3 ad=56.7f pd=0.675u as=0.1278p ps=1.07u w=0.36u l=0.28u
X5240 a_27853_4534# a_27084_4534# VSS VSS nfet_03v3 ad=0.18p pd=1.72u as=97.2f ps=0.9u w=0.36u l=0.28u
X5241 a_5605_2182# a_4836_2182# VSS VSS nfet_03v3 ad=0.18p pd=1.72u as=97.2f ps=0.9u w=0.36u l=0.28u
X5242 VSS RB14.t46 a_28586_n12# VSS nfet_03v3 ad=0.1584p pd=1.6u as=0.1854p ps=1.75u w=0.36u l=0.28u
X5243 a_37170_1398# a_37106_1588# a_36972_1398# VDD pfet_03v3 ad=56.7f pd=0.675u as=0.1278p ps=1.07u w=0.36u l=0.28u
X5244 VDD a_n1652_5750# a_n1204_5318.t0 VDD pfet_03v3 ad=0.3386p pd=1.86u as=0.3302p ps=1.79u w=1.27u l=0.28u
X5245 a_29368_5318# a_29304_n708.t32 VDD VDD pfet_03v3 ad=0.2097p pd=1.38u as=0.3168p ps=2.32u w=0.72u l=0.28u
X5246 a_13021_8454# a_13325_8546# a_13489_n862.t15 VDD pfet_03v3 ad=0.1152p pd=1u as=0.1584p ps=1.6u w=0.36u l=0.28u
X5247 a_34500_2966# a_n884_2966.t35 a_34312_2966# VDD pfet_03v3 ad=0.1278p pd=1.07u as=0.2097p ps=1.38u w=0.36u l=0.28u
X5248 VDD a_n1652_2614# a_n1204_2182.t0 VDD pfet_03v3 ad=0.3386p pd=1.86u as=0.3302p ps=1.79u w=1.27u l=0.28u
X5249 a_22909_n170# RA14.t42 a_23377_n862.t9 VSS nfet_03v3 ad=0.1152p pd=1u as=0.1584p ps=1.6u w=0.36u l=0.28u
X5250 VDD a_n1204_6102.t39 a_32226_6102# VDD pfet_03v3 ad=0.1584p pd=1.6u as=56.7f ps=0.675u w=0.36u l=0.28u
X5251 a_32797_5318# a_32028_5318# VDD VDD pfet_03v3 ad=0.36p pd=2.44u as=0.1764p ps=1.26u w=0.72u l=0.28u
X5252 a_29368_2182# a_29304_n708.t33 VDD VDD pfet_03v3 ad=0.2097p pd=1.38u as=0.3168p ps=2.32u w=0.72u l=0.28u
X5253 a_29754_n954# a_29690_n640# a_29556_n954# VSS nfet_03v3 ad=56.7f pd=0.675u as=0.1278p ps=1.07u w=0.36u l=0.28u
X5254 a_32797_2182# a_32028_2182# VDD VDD pfet_03v3 ad=0.36p pd=2.44u as=0.1764p ps=1.26u w=0.72u l=0.28u
X5255 a_965_3842# RA9.t46 VDD VDD pfet_03v3 ad=0.3888p pd=2.52u as=0.3312p ps=2.36u w=0.72u l=0.28u
X5256 a_n296_9238# a_n360_n708.t32 VDD VDD pfet_03v3 ad=0.2097p pd=1.38u as=0.3168p ps=2.32u w=0.72u l=0.28u
X5257 VSS a_n884_7670.t34 a_5034_8174# VSS nfet_03v3 ad=0.1584p pd=1.6u as=56.7f ps=0.675u w=0.36u l=0.28u
X5258 a_20437_5318# a_20741_5410# a_20905_n862.t23 VDD pfet_03v3 ad=0.1152p pd=1u as=0.1584p ps=1.6u w=0.36u l=0.28u
X5259 a_17196_614# a_n1204_614.t38 a_17008_614# VSS nfet_03v3 ad=0.1278p pd=1.07u as=0.1188p ps=1.02u w=0.36u l=0.28u
X5260 VSS RB4.t44 a_26114_7828# VSS nfet_03v3 ad=0.1584p pd=1.6u as=0.1854p ps=1.75u w=0.36u l=0.28u
X5261 VDD a_19668_2966# a_19802_3156# VDD pfet_03v3 ad=0.1764p pd=1.26u as=0.1584p ps=1.6u w=0.36u l=0.28u
X5262 a_965_706# RA13.t44 VDD VDD pfet_03v3 ad=0.3888p pd=2.52u as=0.3312p ps=2.36u w=0.72u l=0.28u
X5263 VSS a_n884_4534.t34 a_5034_5038# VSS nfet_03v3 ad=0.1584p pd=1.6u as=56.7f ps=0.675u w=0.36u l=0.28u
X5264 a_5605_n170# RA14.t43 a_6073_n862.t12 VSS nfet_03v3 ad=0.1152p pd=1u as=0.1584p ps=1.6u w=0.36u l=0.28u
X5265 a_8077_6886# a_7308_6886# VDD VDD pfet_03v3 ad=0.36p pd=2.44u as=0.1764p ps=1.26u w=0.72u l=0.28u
X5266 a_19668_1398# a_n1204_1398.t33 a_19480_1398# VSS nfet_03v3 ad=0.1278p pd=1.07u as=0.1188p ps=1.02u w=0.36u l=0.28u
X5267 VSS a_n884_9238.t31 a_24810_9742# VSS nfet_03v3 ad=0.1584p pd=1.6u as=56.7f ps=0.675u w=0.36u l=0.28u
X5268 a_21175_n2146.t21 a_21170_1556# a_20437_1398# VDD pfet_03v3 ad=0.1584p pd=1.6u as=0.1152p ps=1u w=0.36u l=0.28u
X5269 VDD RB1.t40 a_13754_10368# VDD pfet_03v3 ad=0.3168p pd=2.32u as=0.3708p ps=2.47u w=0.72u l=0.28u
X5270 a_22338_2966# a_22274_3156# a_22140_2966# VDD pfet_03v3 ad=56.7f pd=0.675u as=0.1278p ps=1.07u w=0.36u l=0.28u
X5271 a_37741_2182# RA11.t46 a_38209_n862.t7 VSS nfet_03v3 ad=0.1152p pd=1u as=0.1584p ps=1.6u w=0.36u l=0.28u
X5272 VDD a_34500_7670# a_34634_7860# VDD pfet_03v3 ad=0.1764p pd=1.26u as=0.1584p ps=1.6u w=0.36u l=0.28u
X5273 VSS a_n884_6102.t33 a_24810_6606# VSS nfet_03v3 ad=0.1584p pd=1.6u as=56.7f ps=0.675u w=0.36u l=0.28u
X5274 VSS a_n884_3750.t33 a_2562_3750# VSS nfet_03v3 ad=0.1584p pd=1.6u as=56.7f ps=0.675u w=0.36u l=0.28u
X5275 VDD a_9536_n1782# a_9528_n708.t0 VDD pfet_03v3 ad=0.5456p pd=3.36u as=0.3224p ps=1.76u w=1.24u l=0.28u
X5276 a_17965_6886# RA5.t43 a_18433_n862.t20 VSS nfet_03v3 ad=0.1152p pd=1u as=0.1584p ps=1.6u w=0.36u l=0.28u
X5277 a_32797_6886# a_33101_6978# a_33265_n862.t4 VDD pfet_03v3 ad=0.1152p pd=1u as=0.1584p ps=1.6u w=0.36u l=0.28u
X5278 a_5605_2182# RA11.t47 a_6073_n862.t8 VSS nfet_03v3 ad=0.1152p pd=1u as=0.1584p ps=1.6u w=0.36u l=0.28u
X5279 a_17394_7390# a_17330_7200# a_17196_6886# VDD pfet_03v3 ad=56.7f pd=0.675u as=0.1278p ps=1.07u w=0.36u l=0.28u
X5280 a_26119_n2146.t31 a_26114_5664# a_25381_5318# VDD pfet_03v3 ad=0.1584p pd=1.6u as=0.1152p ps=1u w=0.36u l=0.28u
X5281 VDD a_34500_4534# a_34634_4724# VDD pfet_03v3 ad=0.1764p pd=1.26u as=0.1584p ps=1.6u w=0.36u l=0.28u
X5282 VDD a_n1204_2182.t31 a_19866_2686# VDD pfet_03v3 ad=0.1584p pd=1.6u as=56.7f ps=0.675u w=0.36u l=0.28u
X5283 a_32797_3750# a_33101_3842# a_33265_n862.t16 VDD pfet_03v3 ad=0.1152p pd=1u as=0.1584p ps=1.6u w=0.36u l=0.28u
X5284 a_14536_2966# a_14472_n708.t35 VSS VSS nfet_03v3 ad=0.1188p pd=1.02u as=0.1584p ps=1.6u w=0.36u l=0.28u
X5285 a_17394_4254# a_17330_4064# a_17196_3750# VDD pfet_03v3 ad=56.7f pd=0.675u as=0.1278p ps=1.07u w=0.36u l=0.28u
X5286 a_5034_2966# a_4970_3156# a_4836_2966# VDD pfet_03v3 ad=56.7f pd=0.675u as=0.1278p ps=1.07u w=0.36u l=0.28u
X5287 a_7856_n1234# a_n884_n1738.t32 VSS.t18 VSS nfet_03v3 ad=56.7f pd=0.675u as=0.1584p ps=1.6u w=0.36u l=0.28u
X5288 a_7308_n954# a_n1204_n954.t35 a_7120_n954# VSS nfet_03v3 ad=0.1278p pd=1.07u as=0.1188p ps=1.02u w=0.36u l=0.28u
X5289 a_27853_10022# a_28157_10114# a_28321_n862.t10 VDD pfet_03v3 ad=0.1152p pd=1u as=0.1584p ps=1.6u w=0.36u l=0.28u
X5290 VDD a_n1652_7670# a_n1204_7670.t0 VDD pfet_03v3 ad=0.3386p pd=1.86u as=0.3302p ps=1.79u w=1.27u l=0.28u
X5291 a_14724_5318# a_n884_5318.t30 a_14536_5318# VDD pfet_03v3 ad=0.1278p pd=1.07u as=0.2097p ps=1.38u w=0.36u l=0.28u
X5292 a_19866_2182# a_19802_2496# a_19668_2182# VSS nfet_03v3 ad=56.7f pd=0.675u as=0.1278p ps=1.07u w=0.36u l=0.28u
X5293 a_32797_614# a_33101_706# a_33265_n862.t29 VDD pfet_03v3 ad=0.1152p pd=1u as=0.1584p ps=1.6u w=0.36u l=0.28u
X5294 a_17394_1118# a_17330_928# a_17196_614# VDD pfet_03v3 ad=56.7f pd=0.675u as=0.1278p ps=1.07u w=0.36u l=0.28u
X5295 a_12252_614# a_n1204_614.t39 a_12064_614# VSS nfet_03v3 ad=0.1278p pd=1.07u as=0.1188p ps=1.02u w=0.36u l=0.28u
X5296 a_25381_1398# a_24612_1398# VSS VSS nfet_03v3 ad=0.18p pd=1.72u as=97.2f ps=0.9u w=0.36u l=0.28u
X5297 VDD RB5.t46 a_21170_7232# VDD pfet_03v3 ad=0.3168p pd=2.32u as=0.3708p ps=2.47u w=0.72u l=0.28u
X5298 VDD a_n1652_4534# a_n1204_4534.t0 VDD pfet_03v3 ad=0.3386p pd=1.86u as=0.3302p ps=1.79u w=1.27u l=0.28u
X5299 VSS RB2.t44 a_11282_9396# VSS nfet_03v3 ad=0.1584p pd=1.6u as=0.1854p ps=1.75u w=0.36u l=0.28u
X5300 a_2562_8174# a_2498_7860# a_2364_7670# VSS nfet_03v3 ad=56.7f pd=0.675u as=0.1278p ps=1.07u w=0.36u l=0.28u
X5301 a_20437_6102# a_19668_6102# VDD VDD pfet_03v3 ad=0.36p pd=2.44u as=0.1764p ps=1.26u w=0.72u l=0.28u
X5302 a_8815_n2146.t16 a_8810_5664# a_8077_5318# VDD pfet_03v3 ad=0.1584p pd=1.6u as=0.1152p ps=1u w=0.36u l=0.28u
X5303 a_8077_2966# RA10.t42 a_8545_n862.t1 VSS nfet_03v3 ad=0.1152p pd=1u as=0.1584p ps=1.6u w=0.36u l=0.28u
X5304 VSS RB14.t47 a_16226_n12# VSS nfet_03v3 ad=0.1584p pd=1.6u as=0.1854p ps=1.75u w=0.36u l=0.28u
X5305 VDD RB1.t41 a_31058_10368# VDD pfet_03v3 ad=0.3168p pd=2.32u as=0.3708p ps=2.47u w=0.72u l=0.28u
X5306 VSS a_n884_7670.t35 a_37170_8174# VSS nfet_03v3 ad=0.1584p pd=1.6u as=56.7f ps=0.675u w=0.36u l=0.28u
X5307 a_33101_6978# RA5.t44 VSS VSS nfet_03v3 ad=0.1944p pd=1.8u as=0.1656p ps=1.64u w=0.36u l=0.28u
X5308 a_2562_5038# a_2498_4724# a_2364_4534# VSS nfet_03v3 ad=56.7f pd=0.675u as=0.1278p ps=1.07u w=0.36u l=0.28u
X5309 a_25381_n954# RA15.t43 a_25849_n862.t7 VSS nfet_03v3 ad=0.1152p pd=1u as=0.1584p ps=1.6u w=0.36u l=0.28u
X5310 VSS RB6.t44 a_11282_6260# VSS nfet_03v3 ad=0.1584p pd=1.6u as=0.1854p ps=1.75u w=0.36u l=0.28u
X5311 a_10549_n170# RA14.t44 a_11017_n862.t13 VSS nfet_03v3 ad=0.1152p pd=1u as=0.1584p ps=1.6u w=0.36u l=0.28u
X5312 a_15493_6886# a_14724_6886# VSS VSS nfet_03v3 ad=0.18p pd=1.72u as=97.2f ps=0.9u w=0.36u l=0.28u
X5313 VSS a_n884_4534.t35 a_37170_5038# VSS nfet_03v3 ad=0.1584p pd=1.6u as=56.7f ps=0.675u w=0.36u l=0.28u
X5314 a_3133_2182# a_2364_2182# VSS VSS nfet_03v3 ad=0.18p pd=1.72u as=97.2f ps=0.9u w=0.36u l=0.28u
X5315 a_8381_1398# RA12.t44 VDD VDD pfet_03v3 ad=0.3888p pd=2.52u as=0.3312p ps=2.36u w=0.72u l=0.28u
X5316 a_20741_7670# RA4.t46 VSS VSS nfet_03v3 ad=0.1944p pd=1.8u as=0.1656p ps=1.64u w=0.36u l=0.28u
X5317 a_5605_8454# a_4836_8454# VDD VDD pfet_03v3 ad=0.36p pd=2.44u as=0.1764p ps=1.26u w=0.72u l=0.28u
X5318 a_19480_3750# a_19416_n708.t35 VSS VSS nfet_03v3 ad=0.1188p pd=1.02u as=0.1584p ps=1.6u w=0.36u l=0.28u
X5319 VDD a_n1652_10806# WE0CLK.t0 VDD pfet_03v3 ad=0.3386p pd=1.86u as=0.3302p ps=1.79u w=1.27u l=0.28u
X5320 a_27084_6886# a_n884_6886.t35 a_26896_6886# VDD pfet_03v3 ad=0.1278p pd=1.07u as=0.2097p ps=1.38u w=0.36u l=0.28u
X5321 a_22909_3750# a_22140_3750# VSS VSS nfet_03v3 ad=0.18p pd=1.72u as=97.2f ps=0.9u w=0.36u l=0.28u
X5322 a_31840_n170# a_31776_n708.t35 VDD.t1315 VDD.t1293 pfet_03v3 ad=0.2097p pd=1.38u as=0.3168p ps=2.32u w=0.72u l=0.28u
X5323 a_27084_3750# a_n884_3750.t34 a_26896_3750# VDD pfet_03v3 ad=0.1278p pd=1.07u as=0.2097p ps=1.38u w=0.36u l=0.28u
X5324 a_4836_8454# a_n884_8454.t34 a_4648_8454# VDD pfet_03v3 ad=0.1278p pd=1.07u as=0.2097p ps=1.38u w=0.36u l=0.28u
X5325 a_9592_5318# a_9528_n708.t31 VDD VDD pfet_03v3 ad=0.2097p pd=1.38u as=0.3168p ps=2.32u w=0.72u l=0.28u
X5326 a_12800_n1234# a_n884_n1738.t33 VSS.t19 VSS nfet_03v3 ad=56.7f pd=0.675u as=0.1584p ps=1.6u w=0.36u l=0.28u
X5327 a_23647_n2146.t22 a_23642_n12# a_22909_n170# VDD.t2547 pfet_03v3 ad=0.1584p pd=1.6u as=0.1152p ps=1u w=0.36u l=0.28u
X5328 a_37741_10022# a_36972_10022# VDD VDD pfet_03v3 ad=0.36p pd=2.44u as=0.1764p ps=1.26u w=0.72u l=0.28u
X5329 a_9592_2182# a_9528_n708.t32 VDD VDD pfet_03v3 ad=0.2097p pd=1.38u as=0.3168p ps=2.32u w=0.72u l=0.28u
X5330 a_29556_2182# a_n1204_2182.t32 a_29368_2182# VSS nfet_03v3 ad=0.1278p pd=1.07u as=0.1188p ps=1.02u w=0.36u l=0.28u
X5331 a_27084_614# a_n884_614.t35 a_26896_614# VDD pfet_03v3 ad=0.1278p pd=1.07u as=0.2097p ps=1.38u w=0.36u l=0.28u
X5332 VSS RB3.t44 a_16226_8800# VSS nfet_03v3 ad=0.1584p pd=1.6u as=0.1854p ps=1.75u w=0.36u l=0.28u
X5333 VDD a_22140_8454# a_22274_8768# VDD pfet_03v3 ad=0.1764p pd=1.26u as=0.1584p ps=1.6u w=0.36u l=0.28u
X5334 VSS a_n884_3750.t35 a_32226_3750# VSS nfet_03v3 ad=0.1584p pd=1.6u as=56.7f ps=0.675u w=0.36u l=0.28u
X5335 a_n360_n708.t0 a_n352_n1782# VDD VDD pfet_03v3 ad=0.3224p pd=1.76u as=0.5456p ps=3.36u w=1.24u l=0.28u
X5336 VSS.t2128 a_7064_n1782# a_7056_n708.t2 VSS nfet_03v3 ad=0.2728p pd=2.12u as=0.1612p ps=1.14u w=0.62u l=0.28u
X5337 a_17196_1398# a_n1204_1398.t34 a_17008_1398# VSS nfet_03v3 ad=0.1278p pd=1.07u as=0.1188p ps=1.02u w=0.36u l=0.28u
X5338 a_38479_n2146.t9 a_38474_6260# a_37741_6102# VDD pfet_03v3 ad=0.1584p pd=1.6u as=0.1152p ps=1u w=0.36u l=0.28u
X5339 VSS RB4.t45 a_6338_7828# VSS nfet_03v3 ad=0.1584p pd=1.6u as=0.1854p ps=1.75u w=0.36u l=0.28u
X5340 a_n296_6886# a_n360_n708.t33 VSS VSS nfet_03v3 ad=0.1188p pd=1.02u as=0.1584p ps=1.6u w=0.36u l=0.28u
X5341 VSS RB7.t45 a_23642_5664# VSS nfet_03v3 ad=0.1584p pd=1.6u as=0.1854p ps=1.75u w=0.36u l=0.28u
X5342 VDD a_22140_10022# a_22274_10336# VDD pfet_03v3 ad=0.1764p pd=1.26u as=0.1584p ps=1.6u w=0.36u l=0.28u
X5343 a_28157_n170# RA14.t45 VDD.t1090 VDD.t437 pfet_03v3 ad=0.3888p pd=2.52u as=0.3312p ps=2.36u w=0.72u l=0.28u
X5344 VSS a_29556_10022# a_29690_10336# VSS nfet_03v3 ad=97.2f pd=0.9u as=0.1584p ps=1.6u w=0.36u l=0.28u
X5345 VDD a_n1204_2182.t33 a_17394_2686# VDD pfet_03v3 ad=0.1584p pd=1.6u as=56.7f ps=0.675u w=0.36u l=0.28u
X5346 a_35269_2182# a_34500_2182# VSS VSS nfet_03v3 ad=0.18p pd=1.72u as=97.2f ps=0.9u w=0.36u l=0.28u
X5347 a_12064_1398# a_12000_n708.t34 VDD VDD pfet_03v3 ad=0.2097p pd=1.38u as=0.3168p ps=2.32u w=0.72u l=0.28u
X5348 VSS RB13.t45 a_11282_960# VSS nfet_03v3 ad=0.1584p pd=1.6u as=0.1854p ps=1.75u w=0.36u l=0.28u
X5349 a_37741_2966# RA10.t43 a_38209_n862.t2 VSS nfet_03v3 ad=0.1152p pd=1u as=0.1584p ps=1.6u w=0.36u l=0.28u
X5350 a_37170_n170# a_37106_20# a_36972_n170# VDD.t2497 pfet_03v3 ad=56.7f pd=0.675u as=0.1278p ps=1.07u w=0.36u l=0.28u
X5351 a_12252_5318# a_n884_5318.t31 a_12064_5318# VDD pfet_03v3 ad=0.1278p pd=1.07u as=0.2097p ps=1.38u w=0.36u l=0.28u
X5352 a_6343_n2146.t22 a_6338_5664# a_5605_5318# VDD pfet_03v3 ad=0.1584p pd=1.6u as=0.1152p ps=1u w=0.36u l=0.28u
X5353 a_36007_n2146.t21 a_36002_2528# a_35269_2182# VDD pfet_03v3 ad=0.1584p pd=1.6u as=0.1152p ps=1u w=0.36u l=0.28u
X5354 a_5605_2966# RA10.t44 a_6073_n862.t1 VSS nfet_03v3 ad=0.1152p pd=1u as=0.1584p ps=1.6u w=0.36u l=0.28u
X5355 a_22909_n954# RA15.t44 a_23377_n862.t5 VSS nfet_03v3 ad=0.1152p pd=1u as=0.1584p ps=1.6u w=0.36u l=0.28u
X5356 a_38479_n2146.t3 RB12.t45 a_37741_1398# VSS nfet_03v3 ad=0.1584p pd=1.6u as=0.1152p ps=1u w=0.36u l=0.28u
X5357 a_25381_8454# a_25685_8546# a_25849_n862.t26 VDD pfet_03v3 ad=0.1152p pd=1u as=0.1584p ps=1.6u w=0.36u l=0.28u
X5358 a_7506_10806# a_7442_10996# a_7308_10806# VDD pfet_03v3 ad=56.7f pd=0.675u as=0.1278p ps=1.07u w=0.36u l=0.28u
X5359 a_5605_1398# a_4836_1398# VSS VSS nfet_03v3 ad=0.18p pd=1.72u as=97.2f ps=0.9u w=0.36u l=0.28u
X5360 VSS.t2656 a_12008_n1782# a_12000_n708.t2 VSS nfet_03v3 ad=0.2728p pd=2.12u as=0.1612p ps=1.14u w=0.62u l=0.28u
X5361 a_9978_n954# a_9914_n640# a_9780_n954# VSS nfet_03v3 ad=56.7f pd=0.675u as=0.1278p ps=1.07u w=0.36u l=0.28u
X5362 a_3133_8454# a_2364_8454# VDD VDD pfet_03v3 ad=0.36p pd=2.44u as=0.1764p ps=1.26u w=0.72u l=0.28u
X5363 a_10853_8546# RA3.t45 VSS VSS nfet_03v3 ad=0.1944p pd=1.8u as=0.1656p ps=1.64u w=0.36u l=0.28u
X5364 VDD a_n1204_1398.t35 a_14922_1398# VDD pfet_03v3 ad=0.1584p pd=1.6u as=56.7f ps=0.675u w=0.36u l=0.28u
X5365 a_21175_n2146.t29 a_21170_10964# a_20437_10806# VDD pfet_03v3 ad=0.1584p pd=1.6u as=0.1152p ps=1u w=0.36u l=0.28u
X5366 a_n1652_8446# WE3.t1 VSS VSS nfet_03v3 ad=0.1872p pd=1.24u as=0.3168p ps=2.32u w=0.72u l=0.28u
X5367 a_n1652_4974# WE8.t1 VSS VSS nfet_03v3 ad=0.1872p pd=1.24u as=0.3168p ps=2.32u w=0.72u l=0.28u
X5368 a_19668_9238# a_n884_9238.t32 a_19480_9238# VDD pfet_03v3 ad=0.1278p pd=1.07u as=0.2097p ps=1.38u w=0.36u l=0.28u
X5369 a_20437_3750# a_19668_3750# VSS VSS nfet_03v3 ad=0.18p pd=1.72u as=97.2f ps=0.9u w=0.36u l=0.28u
X5370 a_n1652_1838# WE12.t1 VSS VSS nfet_03v3 ad=0.1872p pd=1.24u as=0.3168p ps=2.32u w=0.72u l=0.28u
X5371 VDD a_28321_n862.t33 QA11b.t0 VDD pfet_03v3 ad=0.2484p pd=1.41u as=0.4104p ps=2.58u w=0.72u l=0.28u
X5372 a_n884_n954.t2 a_n1204_n954.t36 VSS.t1120 VSS nfet_03v3 ad=0.1943p pd=1.25u as=0.1693p ps=1.19u w=0.67u l=0.28u
X5373 a_7120_5318# a_7056_n708.t32 VDD VDD pfet_03v3 ad=0.2097p pd=1.38u as=0.3168p ps=2.32u w=0.72u l=0.28u
X5374 a_21175_n2146.t14 a_21170_n12# a_20437_n170# VDD.t2146 pfet_03v3 ad=0.1584p pd=1.6u as=0.1152p ps=1u w=0.36u l=0.28u
X5375 a_3871_n2146.t28 a_3866_7828# a_3133_7670# VDD pfet_03v3 ad=0.1584p pd=1.6u as=0.1152p ps=1u w=0.36u l=0.28u
X5376 a_19866_10022# a_19802_10336# a_19668_10022# VSS nfet_03v3 ad=56.7f pd=0.675u as=0.1278p ps=1.07u w=0.36u l=0.28u
X5377 VSS RB3.t45 a_13754_8800# VSS nfet_03v3 ad=0.1584p pd=1.6u as=0.1854p ps=1.75u w=0.36u l=0.28u
X5378 a_3871_n2146.t29 a_3866_4692# a_3133_4534# VDD pfet_03v3 ad=0.1584p pd=1.6u as=0.1152p ps=1u w=0.36u l=0.28u
X5379 a_7120_2182# a_7056_n708.t33 VDD VDD pfet_03v3 ad=0.2097p pd=1.38u as=0.3168p ps=2.32u w=0.72u l=0.28u
X5380 a_32028_n954# a_n884_n954.t35 a_31840_n954# VDD.t1362 pfet_03v3 ad=0.1278p pd=1.07u as=0.2097p ps=1.38u w=0.36u l=0.28u
X5381 a_33535_n2146.t9 a_33530_1556# a_32797_1398# VDD pfet_03v3 ad=0.1584p pd=1.6u as=0.1152p ps=1u w=0.36u l=0.28u
X5382 a_34698_2966# a_34634_3156# a_34500_2966# VDD pfet_03v3 ad=56.7f pd=0.675u as=0.1278p ps=1.07u w=0.36u l=0.28u
X5383 a_1399_n2146.t23 a_1394_1556# a_661_1398# VDD pfet_03v3 ad=0.1584p pd=1.6u as=0.1152p ps=1u w=0.36u l=0.28u
X5384 a_12450_10806# a_12386_10996# a_12252_10806# VDD pfet_03v3 ad=56.7f pd=0.675u as=0.1278p ps=1.07u w=0.36u l=0.28u
X5385 VSS RB4.t46 a_3866_7828# VSS nfet_03v3 ad=0.1584p pd=1.6u as=0.1854p ps=1.75u w=0.36u l=0.28u
X5386 VSS RB7.t46 a_21170_5664# VSS nfet_03v3 ad=0.1584p pd=1.6u as=0.1854p ps=1.75u w=0.36u l=0.28u
X5387 a_9780_2182# a_n1204_2182.t34 a_9592_2182# VSS nfet_03v3 ad=0.1278p pd=1.07u as=0.1188p ps=1.02u w=0.36u l=0.28u
X5388 a_6343_n2146.t0 RB1.t42 a_5605_10022# VSS nfet_03v3 ad=0.1584p pd=1.6u as=0.1152p ps=1u w=0.36u l=0.28u
X5389 a_25381_9238# a_24612_9238# VDD VDD pfet_03v3 ad=0.36p pd=2.44u as=0.1764p ps=1.26u w=0.72u l=0.28u
X5390 a_26896_2966# a_26832_n708.t34 VSS VSS nfet_03v3 ad=0.1188p pd=1.02u as=0.1584p ps=1.6u w=0.36u l=0.28u
X5391 VDD a_12252_6102# a_12386_6292# VDD pfet_03v3 ad=0.1764p pd=1.26u as=0.1584p ps=1.6u w=0.36u l=0.28u
X5392 VSS a_n884_2182.t34 a_90_2182# VSS nfet_03v3 ad=0.1584p pd=1.6u as=56.7f ps=0.675u w=0.36u l=0.28u
X5393 VSS a_17196_7670# a_17330_7860# VSS nfet_03v3 ad=97.2f pd=0.9u as=0.1584p ps=1.6u w=0.36u l=0.28u
X5394 a_20437_10806# a_20741_10806# a_20905_n862.t24 VDD pfet_03v3 ad=0.1152p pd=1u as=0.1584p ps=1.6u w=0.36u l=0.28u
X5395 VDD RB5.t47 a_33530_7232# VDD pfet_03v3 ad=0.3168p pd=2.32u as=0.3708p ps=2.47u w=0.72u l=0.28u
X5396 a_29368_6102# a_29304_n708.t34 VDD VDD pfet_03v3 ad=0.2097p pd=1.38u as=0.3168p ps=2.32u w=0.72u l=0.28u
X5397 a_3133_10806# a_2364_10806# VSS VSS nfet_03v3 ad=0.18p pd=1.72u as=97.2f ps=0.9u w=0.36u l=0.28u
X5398 VSS RB2.t45 a_23642_9396# VSS nfet_03v3 ad=0.1584p pd=1.6u as=0.1854p ps=1.75u w=0.36u l=0.28u
X5399 a_32797_6102# a_32028_6102# VDD VDD pfet_03v3 ad=0.36p pd=2.44u as=0.1764p ps=1.26u w=0.72u l=0.28u
X5400 VSS a_17196_4534# a_17330_4724# VSS nfet_03v3 ad=97.2f pd=0.9u as=0.1584p ps=1.6u w=0.36u l=0.28u
X5401 a_35269_8454# a_34500_8454# VDD VDD pfet_03v3 ad=0.36p pd=2.44u as=0.1764p ps=1.26u w=0.72u l=0.28u
X5402 a_37741_7670# a_36972_7670# VSS VSS nfet_03v3 ad=0.18p pd=1.72u as=97.2f ps=0.9u w=0.36u l=0.28u
X5403 a_19866_1902# a_19802_1588# a_19668_1398# VSS nfet_03v3 ad=56.7f pd=0.675u as=0.1278p ps=1.07u w=0.36u l=0.28u
X5404 VSS RB6.t45 a_23642_6260# VSS nfet_03v3 ad=0.1584p pd=1.6u as=0.1854p ps=1.75u w=0.36u l=0.28u
X5405 a_37741_4534# a_36972_4534# VSS VSS nfet_03v3 ad=0.18p pd=1.72u as=97.2f ps=0.9u w=0.36u l=0.28u
X5406 VSS RB11.t44 a_1394_2528# VSS nfet_03v3 ad=0.1584p pd=1.6u as=0.1854p ps=1.75u w=0.36u l=0.28u
X5407 a_8381_n170# RA14.t46 VDD.t1091 VDD.t439 pfet_03v3 ad=0.3888p pd=2.52u as=0.3312p ps=2.36u w=0.72u l=0.28u
X5408 a_27084_10806# WE0CLK.t38 a_26896_10806# VSS nfet_03v3 ad=0.1278p pd=1.07u as=0.1188p ps=1.02u w=0.36u l=0.28u
X5409 a_29754_2182# a_29690_2496# a_29556_2182# VSS nfet_03v3 ad=56.7f pd=0.675u as=0.1278p ps=1.07u w=0.36u l=0.28u
X5410 a_22909_8454# a_23213_8546# a_23377_n862.t28 VDD pfet_03v3 ad=0.1152p pd=1u as=0.1584p ps=1.6u w=0.36u l=0.28u
X5411 a_18061_n1738# a_n884_n1738.t34 a_16952_n1782# VDD pfet_03v3 ad=0.2097p pd=1.38u as=0.1278p ps=1.07u w=0.36u l=0.28u
X5412 VSS a_7308_10022# a_7442_10336# VSS nfet_03v3 ad=97.2f pd=0.9u as=0.1584p ps=1.6u w=0.36u l=0.28u
X5413 a_3133_1398# a_2364_1398# VSS VSS nfet_03v3 ad=0.18p pd=1.72u as=97.2f ps=0.9u w=0.36u l=0.28u
X5414 a_661_2966# a_965_2966# a_1129_n862.t18 VDD pfet_03v3 ad=0.1152p pd=1u as=0.1584p ps=1.6u w=0.36u l=0.28u
X5415 a_757_n1738# WEM.t33 a_n352_n1782# VSS nfet_03v3 ad=0.1188p pd=1.02u as=0.1278p ps=1.07u w=0.36u l=0.28u
X5416 VDD.t747 RB15.t45 a_11282_n608# VDD.t746 pfet_03v3 ad=0.3168p pd=2.32u as=0.3708p ps=2.47u w=0.72u l=0.28u
X5417 VSS RB1.t43 a_36002_10368# VSS nfet_03v3 ad=0.1584p pd=1.6u as=0.1854p ps=1.75u w=0.36u l=0.28u
X5418 a_7506_n954# a_7442_n640# a_7308_n954# VSS nfet_03v3 ad=56.7f pd=0.675u as=0.1278p ps=1.07u w=0.36u l=0.28u
X5419 a_3133_n954# RA15.t45 a_3601_n862.t2 VSS nfet_03v3 ad=0.1152p pd=1u as=0.1584p ps=1.6u w=0.36u l=0.28u
X5420 VSS a_n884_10806.t34 a_17394_11310# VSS nfet_03v3 ad=0.1584p pd=1.6u as=56.7f ps=0.675u w=0.36u l=0.28u
X5421 a_11287_n2146.t0 RB1.t44 a_10549_10022# VSS nfet_03v3 ad=0.1584p pd=1.6u as=0.1152p ps=1u w=0.36u l=0.28u
X5422 a_25381_10022# a_24612_10022# VSS VSS nfet_03v3 ad=0.18p pd=1.72u as=97.2f ps=0.9u w=0.36u l=0.28u
X5423 a_14922_5822# a_14858_5632# a_14724_5318# VDD pfet_03v3 ad=56.7f pd=0.675u as=0.1278p ps=1.07u w=0.36u l=0.28u
X5424 a_30325_5318# a_30629_5410# a_30793_n862.t18 VDD pfet_03v3 ad=0.1152p pd=1u as=0.1584p ps=1.6u w=0.36u l=0.28u
X5425 VDD a_29556_2966# a_29690_3156# VDD pfet_03v3 ad=0.1764p pd=1.26u as=0.1584p ps=1.6u w=0.36u l=0.28u
X5426 a_27853_n170# RA14.t47 a_28321_n862.t8 VSS nfet_03v3 ad=0.1152p pd=1u as=0.1584p ps=1.6u w=0.36u l=0.28u
X5427 VDD WE0CLK.t39 a_27282_10806# VDD pfet_03v3 ad=0.1584p pd=1.6u as=56.7f ps=0.675u w=0.36u l=0.28u
X5428 VSS RB4.t47 a_36002_7828# VSS nfet_03v3 ad=0.1584p pd=1.6u as=0.1854p ps=1.75u w=0.36u l=0.28u
X5429 a_17196_9238# a_n884_9238.t33 a_17008_9238# VDD pfet_03v3 ad=0.1278p pd=1.07u as=0.2097p ps=1.38u w=0.36u l=0.28u
X5430 VSS a_n884_9238.t34 a_34698_9742# VSS nfet_03v3 ad=0.1584p pd=1.6u as=56.7f ps=0.675u w=0.36u l=0.28u
X5431 a_29556_1398# a_n1204_1398.t36 a_29368_1398# VSS nfet_03v3 ad=0.1278p pd=1.07u as=0.1188p ps=1.02u w=0.36u l=0.28u
X5432 VDD a_2364_8454# a_2498_8768# VDD pfet_03v3 ad=0.1764p pd=1.26u as=0.1584p ps=1.6u w=0.36u l=0.28u
X5433 a_38045_2966# RA10.t45 VDD VDD pfet_03v3 ad=0.3888p pd=2.52u as=0.3312p ps=2.36u w=0.72u l=0.28u
X5434 a_35365_n1738# a_n884_n1738.t35 a_34256_n1782# VDD pfet_03v3 ad=0.2097p pd=1.38u as=0.1278p ps=1.07u w=0.36u l=0.28u
X5435 a_31063_n2146.t19 a_31058_1556# a_30325_1398# VDD pfet_03v3 ad=0.1584p pd=1.6u as=0.1152p ps=1u w=0.36u l=0.28u
X5436 a_13021_6102# a_13325_6102# a_13489_n862.t28 VDD pfet_03v3 ad=0.1152p pd=1u as=0.1584p ps=1.6u w=0.36u l=0.28u
X5437 VSS a_n884_6102.t34 a_34698_6606# VSS nfet_03v3 ad=0.1584p pd=1.6u as=56.7f ps=0.675u w=0.36u l=0.28u
X5438 a_32226_2966# a_32162_3156# a_32028_2966# VDD pfet_03v3 ad=56.7f pd=0.675u as=0.1278p ps=1.07u w=0.36u l=0.28u
X5439 a_n296_10806# a_n360_n708.t34 VDD VDD pfet_03v3 ad=0.2097p pd=1.38u as=0.3168p ps=2.32u w=0.72u l=0.28u
X5440 a_5909_2966# RA10.t46 VDD VDD pfet_03v3 ad=0.3888p pd=2.52u as=0.3312p ps=2.36u w=0.72u l=0.28u
X5441 a_12064_n170# a_12000_n708.t35 VDD.t2116 VDD.t2098 pfet_03v3 ad=0.2097p pd=1.38u as=0.3168p ps=2.32u w=0.72u l=0.28u
X5442 a_27282_7390# a_27218_7200# a_27084_6886# VDD pfet_03v3 ad=56.7f pd=0.675u as=0.1278p ps=1.07u w=0.36u l=0.28u
X5443 a_7308_2182# a_n1204_2182.t35 a_7120_2182# VSS nfet_03v3 ad=0.1278p pd=1.07u as=0.1188p ps=1.02u w=0.36u l=0.28u
X5444 VDD a_n1204_2182.t36 a_29754_2686# VDD pfet_03v3 ad=0.1584p pd=1.6u as=56.7f ps=0.675u w=0.36u l=0.28u
X5445 a_19668_6886# a_n1204_6886.t38 a_19480_6886# VSS nfet_03v3 ad=0.1278p pd=1.07u as=0.1188p ps=1.02u w=0.36u l=0.28u
X5446 a_27282_4254# a_27218_4064# a_27084_3750# VDD pfet_03v3 ad=56.7f pd=0.675u as=0.1278p ps=1.07u w=0.36u l=0.28u
X5447 VSS a_14724_7670# a_14858_7860# VSS nfet_03v3 ad=97.2f pd=0.9u as=0.1584p ps=1.6u w=0.36u l=0.28u
X5448 a_18703_n2146.t16 RB11.t45 a_17965_2182# VSS nfet_03v3 ad=0.1584p pd=1.6u as=0.1152p ps=1u w=0.36u l=0.28u
X5449 a_13117_n1738# WEM.t34 a_12008_n1782# VSS nfet_03v3 ad=0.1188p pd=1.02u as=0.1278p ps=1.07u w=0.36u l=0.28u
X5450 a_35269_1398# a_34500_1398# VSS VSS nfet_03v3 ad=0.18p pd=1.72u as=97.2f ps=0.9u w=0.36u l=0.28u
X5451 a_24612_5318# a_n884_5318.t32 a_24424_5318# VDD pfet_03v3 ad=0.1278p pd=1.07u as=0.2097p ps=1.38u w=0.36u l=0.28u
X5452 VDD RB10.t43 a_8810_3124# VDD pfet_03v3 ad=0.3168p pd=2.32u as=0.3708p ps=2.47u w=0.72u l=0.28u
X5453 a_27282_1118# a_27218_928# a_27084_614# VDD pfet_03v3 ad=56.7f pd=0.675u as=0.1278p ps=1.07u w=0.36u l=0.28u
X5454 VSS RB2.t46 a_21170_9396# VSS nfet_03v3 ad=0.1584p pd=1.6u as=0.1854p ps=1.75u w=0.36u l=0.28u
X5455 VSS a_14724_4534# a_14858_4724# VSS nfet_03v3 ad=97.2f pd=0.9u as=0.1584p ps=1.6u w=0.36u l=0.28u
X5456 VSS RB11.t46 a_31058_2528# VSS nfet_03v3 ad=0.1584p pd=1.6u as=0.1854p ps=1.75u w=0.36u l=0.28u
X5457 VSS.t2284 a_34500_n954# a_34634_n640# VSS nfet_03v3 ad=97.2f pd=0.9u as=0.1584p ps=1.6u w=0.36u l=0.28u
X5458 a_5605_9238# a_4836_9238# VDD VDD pfet_03v3 ad=0.36p pd=2.44u as=0.1764p ps=1.26u w=0.72u l=0.28u
X5459 a_35269_n954# RA15.t46 a_35737_n862.t8 VSS nfet_03v3 ad=0.1152p pd=1u as=0.1584p ps=1.6u w=0.36u l=0.28u
X5460 VSS RB6.t46 a_21170_6260# VSS nfet_03v3 ad=0.1584p pd=1.6u as=0.1854p ps=1.75u w=0.36u l=0.28u
X5461 a_13021_1398# RA12.t45 a_13489_n862.t2 VSS nfet_03v3 ad=0.1152p pd=1u as=0.1584p ps=1.6u w=0.36u l=0.28u
X5462 a_6343_n2146.t23 RB0.t43 a_5605_10806# VSS nfet_03v3 ad=0.1584p pd=1.6u as=0.1152p ps=1u w=0.36u l=0.28u
X5463 a_25381_6886# a_24612_6886# VSS VSS nfet_03v3 ad=0.18p pd=1.72u as=97.2f ps=0.9u w=0.36u l=0.28u
X5464 VDD a_9780_5318# a_9914_5632# VDD pfet_03v3 ad=0.1764p pd=1.26u as=0.1584p ps=1.6u w=0.36u l=0.28u
X5465 a_n1204_614.t0 a_n1652_1046# VDD VDD pfet_03v3 ad=0.3302p pd=1.79u as=0.5588p ps=3.42u w=1.27u l=0.28u
X5466 a_9592_6102# a_9528_n708.t33 VDD VDD pfet_03v3 ad=0.2097p pd=1.38u as=0.3168p ps=2.32u w=0.72u l=0.28u
X5467 VDD.t1572 a_n1204_n170.t39 a_14922_n170# VDD.t1238 pfet_03v3 ad=0.1584p pd=1.6u as=56.7f ps=0.675u w=0.36u l=0.28u
X5468 VSS RB13.t46 a_28586_960# VSS nfet_03v3 ad=0.1584p pd=1.6u as=0.1854p ps=1.75u w=0.36u l=0.28u
X5469 VDD RB0.t44 a_28586_10964# VDD pfet_03v3 ad=0.3168p pd=2.32u as=0.3708p ps=2.47u w=0.72u l=0.28u
X5470 VSS a_12252_3750# a_12386_4064# VSS nfet_03v3 ad=97.2f pd=0.9u as=0.1584p ps=1.6u w=0.36u l=0.28u
X5471 VDD CLK a_n1652_1398# VDD pfet_03v3 ad=0.3168p pd=2.32u as=0.1872p ps=1.24u w=0.72u l=0.28u
X5472 VSS.t1266 a_n1652_n522# a_n1204_n954.t2 VSS nfet_03v3 ad=0.1693p pd=1.19u as=0.1651p ps=1.155u w=0.635u l=0.28u
X5473 a_30629_7670# RA4.t47 VSS VSS nfet_03v3 ad=0.1944p pd=1.8u as=0.1656p ps=1.64u w=0.36u l=0.28u
X5474 a_11287_n2146.t23 a_11282_7232# a_10549_6886# VDD pfet_03v3 ad=0.1584p pd=1.6u as=0.1152p ps=1u w=0.36u l=0.28u
X5475 a_29368_3750# a_29304_n708.t35 VSS VSS nfet_03v3 ad=0.1188p pd=1.02u as=0.1584p ps=1.6u w=0.36u l=0.28u
X5476 a_22909_614# RA13.t45 a_23377_n862.t1 VSS nfet_03v3 ad=0.1152p pd=1u as=0.1584p ps=1.6u w=0.36u l=0.28u
X5477 a_13021_6886# a_12252_6886# VDD VDD pfet_03v3 ad=0.36p pd=2.44u as=0.1764p ps=1.26u w=0.72u l=0.28u
X5478 a_11287_n2146.t28 a_11282_4096# a_10549_3750# VDD pfet_03v3 ad=0.1584p pd=1.6u as=0.1152p ps=1u w=0.36u l=0.28u
X5479 a_32797_3750# a_32028_3750# VSS VSS nfet_03v3 ad=0.18p pd=1.72u as=97.2f ps=0.9u w=0.36u l=0.28u
X5480 a_30421_n1738# WEM.t35 a_29312_n1782# VSS nfet_03v3 ad=0.1188p pd=1.02u as=0.1278p ps=1.07u w=0.36u l=0.28u
X5481 a_3133_8454# a_3437_8546# a_3601_n862.t21 VDD pfet_03v3 ad=0.1152p pd=1u as=0.1584p ps=1.6u w=0.36u l=0.28u
X5482 VDD a_n108_7670# a_26_7860# VDD pfet_03v3 ad=0.1764p pd=1.26u as=0.1584p ps=1.6u w=0.36u l=0.28u
X5483 a_12450_5822# a_12386_5632# a_12252_5318# VDD pfet_03v3 ad=56.7f pd=0.675u as=0.1278p ps=1.07u w=0.36u l=0.28u
X5484 VSS RB10.t44 a_1394_3124# VSS nfet_03v3 ad=0.1584p pd=1.6u as=0.1854p ps=1.75u w=0.36u l=0.28u
X5485 a_33535_n2146.t31 a_33530_n12# a_32797_n170# VDD.t2019 pfet_03v3 ad=0.1584p pd=1.6u as=0.1152p ps=1u w=0.36u l=0.28u
X5486 a_9592_10022# a_9528_n708.t34 VSS VSS nfet_03v3 ad=0.1188p pd=1.02u as=0.1584p ps=1.6u w=0.36u l=0.28u
X5487 a_11287_n2146.t30 a_11282_960# a_10549_614# VDD pfet_03v3 ad=0.1584p pd=1.6u as=0.1152p ps=1u w=0.36u l=0.28u
X5488 a_2364_10806# a_n884_10806.t35 a_2176_10806# VDD pfet_03v3 ad=0.1278p pd=1.07u as=0.2097p ps=1.38u w=0.36u l=0.28u
X5489 VSS RB3.t46 a_26114_8800# VSS nfet_03v3 ad=0.1584p pd=1.6u as=0.1854p ps=1.75u w=0.36u l=0.28u
X5490 VDD a_n108_4534# a_26_4724# VDD pfet_03v3 ad=0.1764p pd=1.26u as=0.1584p ps=1.6u w=0.36u l=0.28u
X5491 VDD a_29312_n1782# a_29304_n708.t0 VDD pfet_03v3 ad=0.5456p pd=3.36u as=0.3224p ps=1.76u w=1.24u l=0.28u
X5492 a_1399_n2146.t27 a_1394_n12# a_661_n170# VDD.t3204 pfet_03v3 ad=0.1584p pd=1.6u as=0.1152p ps=1u w=0.36u l=0.28u
X5493 VDD a_32028_8454# a_32162_8768# VDD pfet_03v3 ad=0.1764p pd=1.26u as=0.1584p ps=1.6u w=0.36u l=0.28u
X5494 a_5605_614# RA13.t46 a_6073_n862.t7 VSS nfet_03v3 ad=0.1152p pd=1u as=0.1584p ps=1.6u w=0.36u l=0.28u
X5495 a_13021_10806# a_12252_10806# VSS VSS nfet_03v3 ad=0.18p pd=1.72u as=97.2f ps=0.9u w=0.36u l=0.28u
X5496 a_22909_10806# a_22140_10806# VDD VDD pfet_03v3 ad=0.36p pd=2.44u as=0.1764p ps=1.26u w=0.72u l=0.28u
X5497 VSS RB0.t45 a_36002_10964# VSS nfet_03v3 ad=0.1584p pd=1.6u as=0.1854p ps=1.75u w=0.36u l=0.28u
X5498 VSS RB1.t45 a_1394_10368# VSS nfet_03v3 ad=0.1584p pd=1.6u as=0.1854p ps=1.75u w=0.36u l=0.28u
X5499 a_8077_8454# a_7308_8454# VSS VSS nfet_03v3 ad=0.18p pd=1.72u as=97.2f ps=0.9u w=0.36u l=0.28u
X5500 a_11287_n2146.t22 RB0.t46 a_10549_10806# VSS nfet_03v3 ad=0.1584p pd=1.6u as=0.1152p ps=1u w=0.36u l=0.28u
X5501 a_24424_7670# a_24360_n708.t34 VDD VDD pfet_03v3 ad=0.2097p pd=1.38u as=0.3168p ps=2.32u w=0.72u l=0.28u
X5502 a_8077_5318# a_7308_5318# VSS VSS nfet_03v3 ad=0.18p pd=1.72u as=97.2f ps=0.9u w=0.36u l=0.28u
X5503 VSS RB7.t47 a_33530_5664# VSS nfet_03v3 ad=0.1584p pd=1.6u as=0.1854p ps=1.75u w=0.36u l=0.28u
X5504 VDD.t1249 a_n1204_n954.t37 a_19866_n450# VDD.t1248 pfet_03v3 ad=0.1584p pd=1.6u as=56.7f ps=0.675u w=0.36u l=0.28u
X5505 a_24424_4534# a_24360_n708.t35 VDD VDD pfet_03v3 ad=0.2097p pd=1.38u as=0.3168p ps=2.32u w=0.72u l=0.28u
X5506 a_3437_2966# RA10.t47 VDD VDD pfet_03v3 ad=0.3888p pd=2.52u as=0.3312p ps=2.36u w=0.72u l=0.28u
X5507 VDD a_n1204_2182.t37 a_27282_2686# VDD pfet_03v3 ad=0.1584p pd=1.6u as=56.7f ps=0.675u w=0.36u l=0.28u
X5508 a_17196_6886# a_n1204_6886.t39 a_17008_6886# VSS nfet_03v3 ad=0.1278p pd=1.07u as=0.1188p ps=1.02u w=0.36u l=0.28u
X5509 a_9780_1398# a_n1204_1398.t37 a_9592_1398# VSS nfet_03v3 ad=0.1278p pd=1.07u as=0.1188p ps=1.02u w=0.36u l=0.28u
X5510 a_19866_9238# a_19802_9428# a_19668_9238# VDD pfet_03v3 ad=56.7f pd=0.675u as=0.1278p ps=1.07u w=0.36u l=0.28u
X5511 a_90_8174# a_26_7860# a_n108_7670# VSS nfet_03v3 ad=56.7f pd=0.675u as=0.1278p ps=1.07u w=0.36u l=0.28u
X5512 a_n1652_n522# WE15.t1 VDD.t3217 VDD.t3141 pfet_03v3 ad=0.1872p pd=1.24u as=0.3168p ps=2.32u w=0.72u l=0.28u
X5513 a_4836_6102# a_n884_6102.t35 a_4648_6102# VDD pfet_03v3 ad=0.1278p pd=1.07u as=0.2097p ps=1.38u w=0.36u l=0.28u
X5514 VSS a_n884_1398.t35 a_90_1902# VSS nfet_03v3 ad=0.1584p pd=1.6u as=56.7f ps=0.675u w=0.36u l=0.28u
X5515 VDD a_36972_10022# a_37106_10336# VDD pfet_03v3 ad=0.1764p pd=1.26u as=0.1584p ps=1.6u w=0.36u l=0.28u
X5516 a_22140_5318# a_n884_5318.t33 a_21952_5318# VDD pfet_03v3 ad=0.1278p pd=1.07u as=0.2097p ps=1.38u w=0.36u l=0.28u
X5517 a_90_5038# a_26_4724# a_n108_4534# VSS nfet_03v3 ad=56.7f pd=0.675u as=0.1278p ps=1.07u w=0.36u l=0.28u
X5518 a_16231_n2146.t14 RB11.t47 a_15493_2182# VSS nfet_03v3 ad=0.1584p pd=1.6u as=0.1152p ps=1u w=0.36u l=0.28u
X5519 a_8077_6886# RA5.t45 a_8545_n862.t14 VSS nfet_03v3 ad=0.1152p pd=1u as=0.1584p ps=1.6u w=0.36u l=0.28u
X5520 a_3133_9238# a_2364_9238# VDD VDD pfet_03v3 ad=0.36p pd=2.44u as=0.1764p ps=1.26u w=0.72u l=0.28u
X5521 VDD a_22140_6102# a_22274_6292# VDD pfet_03v3 ad=0.1764p pd=1.26u as=0.1584p ps=1.6u w=0.36u l=0.28u
X5522 a_4648_2966# a_4584_n708.t35 VSS VSS nfet_03v3 ad=0.1188p pd=1.02u as=0.1584p ps=1.6u w=0.36u l=0.28u
X5523 a_35269_8454# a_35573_8546# a_35737_n862.t14 VDD pfet_03v3 ad=0.1152p pd=1u as=0.1584p ps=1.6u w=0.36u l=0.28u
X5524 a_32797_n954# RA15.t47 a_33265_n862.t10 VSS nfet_03v3 ad=0.1152p pd=1u as=0.1584p ps=1.6u w=0.36u l=0.28u
X5525 VSS RB13.t47 a_16226_960# VSS nfet_03v3 ad=0.1584p pd=1.6u as=0.1854p ps=1.75u w=0.36u l=0.28u
X5526 a_n884_10022.t2 a_n1204_10022.t39 VSS VSS nfet_03v3 ad=0.1943p pd=1.25u as=0.1693p ps=1.19u w=0.67u l=0.28u
X5527 a_10549_614# RA13.t47 a_11017_n862.t5 VSS nfet_03v3 ad=0.1152p pd=1u as=0.1584p ps=1.6u w=0.36u l=0.28u
X5528 a_9978_2182# a_9914_2496# a_9780_2182# VSS nfet_03v3 ad=56.7f pd=0.675u as=0.1278p ps=1.07u w=0.36u l=0.28u
X5529 VDD.t749 RB15.t46 a_23642_n608# VDD.t748 pfet_03v3 ad=0.3168p pd=2.32u as=0.3708p ps=2.47u w=0.72u l=0.28u
X5530 a_12450_614# a_12386_928# a_12252_614# VSS nfet_03v3 ad=56.7f pd=0.675u as=0.1278p ps=1.07u w=0.36u l=0.28u
X5531 a_29754_1902# a_29690_1588# a_29556_1398# VSS nfet_03v3 ad=56.7f pd=0.675u as=0.1278p ps=1.07u w=0.36u l=0.28u
X5532 VDD RB12.t46 a_16226_1556# VDD pfet_03v3 ad=0.3168p pd=2.32u as=0.3708p ps=2.47u w=0.72u l=0.28u
X5533 a_7120_6102# a_7056_n708.t34 VDD VDD pfet_03v3 ad=0.2097p pd=1.38u as=0.3168p ps=2.32u w=0.72u l=0.28u
X5534 a_18703_n2146.t9 RB10.t45 a_17965_2966# VSS nfet_03v3 ad=0.1584p pd=1.6u as=0.1152p ps=1u w=0.36u l=0.28u
X5535 a_2364_2182# a_n884_2182.t35 a_2176_2182# VDD pfet_03v3 ad=0.1278p pd=1.07u as=0.2097p ps=1.38u w=0.36u l=0.28u
X5536 a_20741_8546# RA3.t46 VSS VSS nfet_03v3 ad=0.1944p pd=1.8u as=0.1656p ps=1.64u w=0.36u l=0.28u
X5537 VSS RB10.t46 a_31058_3124# VSS nfet_03v3 ad=0.1584p pd=1.6u as=0.1854p ps=1.75u w=0.36u l=0.28u
X5538 a_n884_2182.t2 a_n1204_2182.t38 VSS VSS nfet_03v3 ad=0.1943p pd=1.25u as=0.1693p ps=1.19u w=0.67u l=0.28u
X5539 VDD a_n1204_1398.t38 a_24810_1398# VDD pfet_03v3 ad=0.1584p pd=1.6u as=56.7f ps=0.675u w=0.36u l=0.28u
X5540 a_24872_n1738# a_24368_n1782# VDD VDD pfet_03v3 ad=0.1584p pd=1.6u as=0.1584p ps=1.6u w=0.36u l=0.28u
X5541 a_29556_9238# a_n884_9238.t35 a_29368_9238# VDD pfet_03v3 ad=0.1278p pd=1.07u as=0.2097p ps=1.38u w=0.36u l=0.28u
X5542 a_5605_6886# a_4836_6886# VSS VSS nfet_03v3 ad=0.18p pd=1.72u as=97.2f ps=0.9u w=0.36u l=0.28u
X5543 a_10549_6886# a_9780_6886# VDD VDD pfet_03v3 ad=0.36p pd=2.44u as=0.1764p ps=1.26u w=0.72u l=0.28u
X5544 VSS.t2018 a_26840_n1782# a_26832_n708.t2 VSS nfet_03v3 ad=0.2728p pd=2.12u as=0.1612p ps=1.14u w=0.62u l=0.28u
X5545 a_31063_n2146.t28 a_31058_n12# a_30325_n170# VDD.t3351 pfet_03v3 ad=0.1584p pd=1.6u as=0.1152p ps=1u w=0.36u l=0.28u
X5546 a_15493_3750# RA9.t47 a_15961_n862.t2 VSS nfet_03v3 ad=0.1152p pd=1u as=0.1584p ps=1.6u w=0.36u l=0.28u
X5547 a_9592_3750# a_9528_n708.t35 VSS VSS nfet_03v3 ad=0.1188p pd=1.02u as=0.1584p ps=1.6u w=0.36u l=0.28u
X5548 a_965_8546# RA3.t47 VDD VDD pfet_03v3 ad=0.3888p pd=2.52u as=0.3312p ps=2.36u w=0.72u l=0.28u
X5549 a_25381_6102# a_25685_6102# a_25849_n862.t14 VDD pfet_03v3 ad=0.1152p pd=1u as=0.1584p ps=1.6u w=0.36u l=0.28u
X5550 a_n296_10022# a_n360_n708.t35 VDD VDD pfet_03v3 ad=0.2097p pd=1.38u as=0.3168p ps=2.32u w=0.72u l=0.28u
X5551 a_22140_10022# a_n884_10022.t35 a_21952_10022# VDD pfet_03v3 ad=0.1278p pd=1.07u as=0.2097p ps=1.38u w=0.36u l=0.28u
X5552 VDD.t1251 a_n1204_n954.t38 a_17394_n450# VDD.t1250 pfet_03v3 ad=0.1584p pd=1.6u as=56.7f ps=0.675u w=0.36u l=0.28u
X5553 a_35269_9238# a_34500_9238# VDD VDD pfet_03v3 ad=0.36p pd=2.44u as=0.1764p ps=1.26u w=0.72u l=0.28u
X5554 VSS RB3.t47 a_6338_8800# VSS nfet_03v3 ad=0.1584p pd=1.6u as=0.1854p ps=1.75u w=0.36u l=0.28u
X5555 a_10549_5318# a_10853_5410# a_11017_n862.t25 VDD pfet_03v3 ad=0.1152p pd=1u as=0.1584p ps=1.6u w=0.36u l=0.28u
X5556 a_8077_n954# a_7308_n954# VDD.t2961 VDD.t2860 pfet_03v3 ad=0.36p pd=2.44u as=0.1764p ps=1.26u w=0.72u l=0.28u
X5557 VSS a_27084_7670# a_27218_7860# VSS nfet_03v3 ad=97.2f pd=0.9u as=0.1584p ps=1.6u w=0.36u l=0.28u
X5558 a_7308_1398# a_n1204_1398.t39 a_7120_1398# VSS nfet_03v3 ad=0.1278p pd=1.07u as=0.1188p ps=1.02u w=0.36u l=0.28u
X5559 a_26896_614# a_26832_n708.t35 VSS VSS nfet_03v3 ad=0.1188p pd=1.02u as=0.1584p ps=1.6u w=0.36u l=0.28u
X5560 a_17965_10806# a_17196_10806# VDD VDD pfet_03v3 ad=0.36p pd=2.44u as=0.1764p ps=1.26u w=0.72u l=0.28u
X5561 a_36972_5318# a_n884_5318.t34 a_36784_5318# VDD pfet_03v3 ad=0.1278p pd=1.07u as=0.2097p ps=1.38u w=0.36u l=0.28u
X5562 VSS RB2.t47 a_33530_9396# VSS nfet_03v3 ad=0.1584p pd=1.6u as=0.1854p ps=1.75u w=0.36u l=0.28u
X5563 a_37741_6886# RA5.t46 a_38209_n862.t19 VSS nfet_03v3 ad=0.1152p pd=1u as=0.1584p ps=1.6u w=0.36u l=0.28u
X5564 VSS a_27084_4534# a_27218_4724# VSS nfet_03v3 ad=97.2f pd=0.9u as=0.1584p ps=1.6u w=0.36u l=0.28u
X5565 a_36007_n2146.t19 a_36002_n608# a_35269_n954# VDD.t2809 pfet_03v3 ad=0.1584p pd=1.6u as=0.1152p ps=1u w=0.36u l=0.28u
X5566 VSS RB0.t47 a_1394_10964# VSS nfet_03v3 ad=0.1584p pd=1.6u as=0.1854p ps=1.75u w=0.36u l=0.28u
X5567 a_10549_614# a_9780_614# VSS VSS nfet_03v3 ad=0.18p pd=1.72u as=97.2f ps=0.9u w=0.36u l=0.28u
X5568 a_5605_6886# RA5.t47 a_6073_n862.t21 VSS nfet_03v3 ad=0.1152p pd=1u as=0.1584p ps=1.6u w=0.36u l=0.28u
X5569 VSS RB6.t47 a_33530_6260# VSS nfet_03v3 ad=0.1584p pd=1.6u as=0.1854p ps=1.75u w=0.36u l=0.28u
X5570 a_25381_1398# RA12.t46 a_25849_n862.t3 VSS nfet_03v3 ad=0.1152p pd=1u as=0.1584p ps=1.6u w=0.36u l=0.28u
X5571 a_10853_1398# RA12.t47 VDD VDD pfet_03v3 ad=0.3888p pd=2.52u as=0.3312p ps=2.36u w=0.72u l=0.28u
X5572 VDD a_n1204_2182.t39 a_7506_2686# VDD pfet_03v3 ad=0.1584p pd=1.6u as=56.7f ps=0.675u w=0.36u l=0.28u
X5573 VDD.t3245 CLK a_n1652_n170# VDD.t3244 pfet_03v3 ad=0.3168p pd=2.32u as=0.1872p ps=1.24u w=0.72u l=0.28u
X5574 a_17394_8958# a_17330_8768# a_17196_8454# VDD pfet_03v3 ad=56.7f pd=0.675u as=0.1278p ps=1.07u w=0.36u l=0.28u
X5575 a_32797_8454# a_33101_8546# a_33265_n862.t25 VDD pfet_03v3 ad=0.1152p pd=1u as=0.1584p ps=1.6u w=0.36u l=0.28u
X5576 VDD.t1253 a_n1204_n954.t39 a_n884_n954.t0 VDD.t1252 pfet_03v3 ad=0.5896p pd=3.56u as=0.3886p ps=1.92u w=1.34u l=0.28u
X5577 VDD RB1.t46 a_28586_10368# VDD pfet_03v3 ad=0.3168p pd=2.32u as=0.3708p ps=2.47u w=0.72u l=0.28u
X5578 a_19866_6886# a_19802_7200# a_19668_6886# VSS nfet_03v3 ad=56.7f pd=0.675u as=0.1278p ps=1.07u w=0.36u l=0.28u
X5579 a_23647_n2146.t14 a_23642_7232# a_22909_6886# VDD pfet_03v3 ad=0.1584p pd=1.6u as=0.1152p ps=1u w=0.36u l=0.28u
X5580 a_7506_2182# a_7442_2496# a_7308_2182# VSS nfet_03v3 ad=56.7f pd=0.675u as=0.1278p ps=1.07u w=0.36u l=0.28u
X5581 VDD.t751 RB15.t47 a_21170_n608# VDD.t750 pfet_03v3 ad=0.3168p pd=2.32u as=0.3708p ps=2.47u w=0.72u l=0.28u
X5582 VSS a_24612_614# a_24746_928# VSS nfet_03v3 ad=97.2f pd=0.9u as=0.1584p ps=1.6u w=0.36u l=0.28u
X5583 a_16231_n2146.t9 RB10.t47 a_15493_2966# VSS nfet_03v3 ad=0.1584p pd=1.6u as=0.1152p ps=1u w=0.36u l=0.28u
X5584 a_34312_614# a_34248_n708.t35 VSS VSS nfet_03v3 ad=0.1188p pd=1.02u as=0.1584p ps=1.6u w=0.36u l=0.28u
X5585 VDD RB12.t47 a_13754_1556# VDD pfet_03v3 ad=0.3168p pd=2.32u as=0.3708p ps=2.47u w=0.72u l=0.28u
X5586 VDD a_2364_10022# a_2498_10336# VDD pfet_03v3 ad=0.1764p pd=1.26u as=0.1584p ps=1.6u w=0.36u l=0.28u
X5587 a_4836_3750# a_n1204_3750.t39 a_4648_3750# VSS nfet_03v3 ad=0.1278p pd=1.07u as=0.1188p ps=1.02u w=0.36u l=0.28u
X5588 a_23647_n2146.t18 a_23642_4096# a_22909_3750# VDD pfet_03v3 ad=0.1584p pd=1.6u as=0.1152p ps=1u w=0.36u l=0.28u
X5589 VDD D13.t1 a_32893_n1738# VDD pfet_03v3 ad=0.3168p pd=2.32u as=0.2097p ps=1.38u w=0.72u l=0.28u
X5590 a_34698_11310# a_34634_10996# a_34500_10806# VSS nfet_03v3 ad=56.7f pd=0.675u as=0.1278p ps=1.07u w=0.36u l=0.28u
X5591 a_24810_5822# a_24746_5632# a_24612_5318# VDD pfet_03v3 ad=56.7f pd=0.675u as=0.1278p ps=1.07u w=0.36u l=0.28u
X5592 VSS a_22140_3750# a_22274_4064# VSS nfet_03v3 ad=97.2f pd=0.9u as=0.1584p ps=1.6u w=0.36u l=0.28u
X5593 a_21952_614# a_21888_n708.t35 VSS VSS nfet_03v3 ad=0.1188p pd=1.02u as=0.1584p ps=1.6u w=0.36u l=0.28u
X5594 a_23647_n2146.t21 a_23642_960# a_22909_614# VDD pfet_03v3 ad=0.1584p pd=1.6u as=0.1152p ps=1u w=0.36u l=0.28u
X5595 a_5034_10526# a_4970_10336# a_4836_10022# VDD pfet_03v3 ad=56.7f pd=0.675u as=0.1278p ps=1.07u w=0.36u l=0.28u
X5596 a_15493_9238# a_15797_9238# a_15961_n862.t17 VDD pfet_03v3 ad=0.1152p pd=1u as=0.1584p ps=1.6u w=0.36u l=0.28u
X5597 a_3133_6886# a_2364_6886# VSS VSS nfet_03v3 ad=0.18p pd=1.72u as=97.2f ps=0.9u w=0.36u l=0.28u
X5598 VSS a_n884_8454.t35 a_12450_8454# VSS nfet_03v3 ad=0.1584p pd=1.6u as=56.7f ps=0.675u w=0.36u l=0.28u
X5599 VSS a_4836_10806# a_4970_10996# VSS nfet_03v3 ad=97.2f pd=0.9u as=0.1584p ps=1.6u w=0.36u l=0.28u
X5600 a_26119_n2146.t4 RB1.t47 a_25381_10022# VSS nfet_03v3 ad=0.1584p pd=1.6u as=0.1152p ps=1u w=0.36u l=0.28u
X5601 a_36784_7670# a_36720_n708.t35 VDD VDD pfet_03v3 ad=0.2097p pd=1.38u as=0.3168p ps=2.32u w=0.72u l=0.28u
X5602 VSS a_n884_5318.t35 a_12450_5318# VSS nfet_03v3 ad=0.1584p pd=1.6u as=56.7f ps=0.675u w=0.36u l=0.28u
X5603 a_7120_3750# a_7056_n708.t35 VSS VSS nfet_03v3 ad=0.1188p pd=1.02u as=0.1584p ps=1.6u w=0.36u l=0.28u
R0 VDD.t1268 VDD.t720 530.612
R1 VDD.t691 VDD.t734 530.612
R2 VDD.t150 VDD.t726 530.612
R3 VDD.t1318 VDD.t750 530.612
R4 VDD.t1786 VDD.t738 530.612
R5 VDD.t946 VDD.t724 530.612
R6 VDD.t2098 VDD.t746 530.612
R7 VDD.t1122 VDD.t728 530.612
R8 VDD.t1587 VDD.t730 530.612
R9 VDD.t234 VDD.t1252 492.38
R10 VDD.t459 VDD.t2206 392.858
R11 VDD.t3437 VDD.t453 392.858
R12 VDD.t2042 VDD.t455 392.858
R13 VDD.t3062 VDD.t443 392.858
R14 VDD.t2866 VDD.t437 392.858
R15 VDD.t2628 VDD.t449 392.858
R16 VDD.t2603 VDD.t451 392.858
R17 VDD.t3177 VDD.t395 392.858
R18 VDD.t2018 VDD.t435 392.858
R19 VDD.t3048 VDD.t457 392.858
R20 VDD.t2065 VDD.t447 392.858
R21 VDD.t2560 VDD.t433 392.858
R22 VDD.t2309 VDD.t439 392.858
R23 VDD.t2467 VDD.t461 392.858
R24 VDD.t3360 VDD.t463 392.858
R25 VDD.t2954 VDD.t445 392.858
R26 VDD.t2552 VDD.t459 387.755
R27 VDD.t453 VDD.t2452 387.755
R28 VDD.t455 VDD.t2761 387.755
R29 VDD.t443 VDD.t3159 387.755
R30 VDD.t437 VDD.t2462 387.755
R31 VDD.t449 VDD.t2789 387.755
R32 VDD.t451 VDD.t2382 387.755
R33 VDD.t395 VDD.t2370 387.755
R34 VDD.t435 VDD.t2374 387.755
R35 VDD.t457 VDD.t3119 387.755
R36 VDD.t447 VDD.t3325 387.755
R37 VDD.t433 VDD.t2773 387.755
R38 VDD.t439 VDD.t2860 387.755
R39 VDD.t461 VDD.t2522 387.755
R40 VDD.t463 VDD.t2324 387.755
R41 VDD.t445 VDD.t2677 387.755
R42 VDD.t2810 VDD.t736 386.481
R43 VDD.t732 VDD.t2809 386.481
R44 VDD.t720 VDD.t2019 386.481
R45 VDD.t742 VDD.t3351 386.481
R46 VDD.t734 VDD.t2137 386.481
R47 VDD.t726 VDD.t2405 386.481
R48 VDD.t748 VDD.t2547 386.481
R49 VDD.t750 VDD.t2146 386.481
R50 VDD.t738 VDD.t2971 386.481
R51 VDD.t722 VDD.t2051 386.481
R52 VDD.t724 VDD.t2007 386.481
R53 VDD.t746 VDD.t2041 386.481
R54 VDD.t744 VDD.t2490 386.481
R55 VDD.t728 VDD.t3049 386.481
R56 VDD.t730 VDD.t2400 386.481
R57 VDD.t740 VDD.t3204 386.481
R58 VDD.t1226 VDD.t2554 367.348
R59 VDD.t2450 VDD.t1242 367.348
R60 VDD.t2759 VDD.t1236 367.348
R61 VDD.t3161 VDD.t1218 367.348
R62 VDD.t2464 VDD.t1220 367.348
R63 VDD.t2791 VDD.t1240 367.348
R64 VDD.t2380 VDD.t1232 367.348
R65 VDD.t2368 VDD.t1248 367.348
R66 VDD.t2372 VDD.t1250 367.348
R67 VDD.t3117 VDD.t1238 367.348
R68 VDD.t3323 VDD.t1228 367.348
R69 VDD.t2771 VDD.t1230 367.348
R70 VDD.t2862 VDD.t1222 367.348
R71 VDD.t2524 VDD.t1224 367.348
R72 VDD.t2322 VDD.t1234 367.348
R73 VDD.t2675 VDD.t1244 367.348
R74 VDD.t1367 VDD.t3244 314.411
R75 VDD.n37 VDD.t1763 265.307
R76 VDD.n37 VDD.t732 265.307
R77 VDD.t1293 VDD.n32 265.307
R78 VDD.n32 VDD.t742 265.307
R79 VDD.t1730 VDD.n25 265.307
R80 VDD.n25 VDD.t748 265.307
R81 VDD.t975 VDD.n18 265.307
R82 VDD.n18 VDD.t722 265.307
R83 VDD.t167 VDD.n11 265.307
R84 VDD.n11 VDD.t744 265.307
R85 VDD.t1201 VDD.n4 265.307
R86 VDD.n4 VDD.t740 265.307
R87 VDD.t1352 VDD.t2497 252.552
R88 VDD.t1997 VDD.t1353 252.552
R89 VDD.t2185 VDD.t1362 252.552
R90 VDD.t3047 VDD.t1359 252.552
R91 VDD.t2466 VDD.t1356 252.552
R92 VDD.t2595 VDD.t1350 252.552
R93 VDD.t2598 VDD.t1351 252.552
R94 VDD.t3026 VDD.t1357 252.552
R95 VDD.t2056 VDD.t1358 252.552
R96 VDD.t2803 VDD.t1348 252.552
R97 VDD.t2804 VDD.t1349 252.552
R98 VDD.t2819 VDD.t1360 252.552
R99 VDD.t2953 VDD.t1361 252.552
R100 VDD.t2526 VDD.t1355 252.552
R101 VDD.t2032 VDD.t1347 252.552
R102 VDD.t2002 VDD.t1354 252.552
R103 VDD.t1763 VDD.t1352 239.797
R104 VDD.t1353 VDD.t1268 239.797
R105 VDD.t1362 VDD.t1293 239.797
R106 VDD.t1359 VDD.t691 239.797
R107 VDD.t1356 VDD.t150 239.797
R108 VDD.t1350 VDD.t1730 239.797
R109 VDD.t1351 VDD.t1318 239.797
R110 VDD.t1357 VDD.t1786 239.797
R111 VDD.t1358 VDD.t975 239.797
R112 VDD.t1348 VDD.t946 239.797
R113 VDD.t1349 VDD.t2098 239.797
R114 VDD.t1360 VDD.t167 239.797
R115 VDD.t1361 VDD.t1122 239.797
R116 VDD.t1355 VDD.t1587 239.797
R117 VDD.t1347 VDD.t1201 239.797
R118 VDD.t1354 VDD.t234 239.797
R119 VDD.t2206 VDD.t2810 234.695
R120 VDD.t2809 VDD.t3437 234.695
R121 VDD.t2019 VDD.t2042 234.695
R122 VDD.t3351 VDD.t3062 234.695
R123 VDD.t2137 VDD.t2866 234.695
R124 VDD.t2405 VDD.t2628 234.695
R125 VDD.t2547 VDD.t2603 234.695
R126 VDD.t2146 VDD.t3177 234.695
R127 VDD.t2971 VDD.t2018 234.695
R128 VDD.t2051 VDD.t3048 234.695
R129 VDD.t2007 VDD.t2065 234.695
R130 VDD.t2041 VDD.t2560 234.695
R131 VDD.t2490 VDD.t2309 234.695
R132 VDD.t3049 VDD.t2467 234.695
R133 VDD.t2400 VDD.t3360 234.695
R134 VDD.t3204 VDD.t2954 234.695
R135 VDD.t2554 VDD.t2552 209.185
R136 VDD.t2452 VDD.t2450 209.185
R137 VDD.t2761 VDD.t2759 209.185
R138 VDD.t3159 VDD.t3161 209.185
R139 VDD.t2462 VDD.t2464 209.185
R140 VDD.t2789 VDD.t2791 209.185
R141 VDD.t2382 VDD.t2380 209.185
R142 VDD.t2370 VDD.t2368 209.185
R143 VDD.t2374 VDD.t2372 209.185
R144 VDD.t3119 VDD.t3117 209.185
R145 VDD.t3325 VDD.t3323 209.185
R146 VDD.t2773 VDD.t2771 209.185
R147 VDD.t2860 VDD.t2862 209.185
R148 VDD.t2522 VDD.t2524 209.185
R149 VDD.t2324 VDD.t2322 209.185
R150 VDD.t2677 VDD.t2675 209.185
R151 VDD.t1252 VDD.t1246 187.774
R152 VDD.t1246 VDD.t1365 174.673
R153 VDD.t1365 VDD.t1367 174.673
R154 VDD.t3244 VDD.t3141 174.673
R155 VDD.t2497 VDD.t1226 151.786
R156 VDD.t1242 VDD.t1997 151.786
R157 VDD.t1236 VDD.t2185 151.786
R158 VDD.t1218 VDD.t3047 151.786
R159 VDD.t1220 VDD.t2466 151.786
R160 VDD.t1240 VDD.t2595 151.786
R161 VDD.t1232 VDD.t2598 151.786
R162 VDD.t1248 VDD.t3026 151.786
R163 VDD.t1250 VDD.t2056 151.786
R164 VDD.t1238 VDD.t2803 151.786
R165 VDD.t1228 VDD.t2804 151.786
R166 VDD.t1230 VDD.t2819 151.786
R167 VDD.t1222 VDD.t2953 151.786
R168 VDD.t1224 VDD.t2526 151.786
R169 VDD.t1234 VDD.t2032 151.786
R170 VDD.t1244 VDD.t2002 151.786
R171 VDD.n120 VDD.n4 12.757
R172 VDD.n104 VDD.n11 12.757
R173 VDD.n88 VDD.n18 12.757
R174 VDD.n72 VDD.n25 12.757
R175 VDD.n56 VDD.n32 12.757
R176 VDD.n45 VDD.n37 12.757
R177 VDD.n43 VDD.t1227 10.3619
R178 VDD.n43 VDD.t1558 10.3619
R179 VDD.n49 VDD.t1243 10.3619
R180 VDD.n49 VDD.t1544 10.3619
R181 VDD.n54 VDD.t1237 10.3619
R182 VDD.n54 VDD.t1571 10.3619
R183 VDD.n60 VDD.t1219 10.3619
R184 VDD.n60 VDD.t1546 10.3619
R185 VDD.n65 VDD.t1221 10.3619
R186 VDD.n65 VDD.t1545 10.3619
R187 VDD.n70 VDD.t1241 10.3619
R188 VDD.n70 VDD.t1554 10.3619
R189 VDD.n76 VDD.t1233 10.3619
R190 VDD.n76 VDD.t1569 10.3619
R191 VDD.n81 VDD.t1249 10.3619
R192 VDD.n81 VDD.t1547 10.3619
R193 VDD.n86 VDD.t1251 10.3619
R194 VDD.n86 VDD.t1556 10.3619
R195 VDD.n92 VDD.t1239 10.3619
R196 VDD.n92 VDD.t1572 10.3619
R197 VDD.n97 VDD.t1229 10.3619
R198 VDD.n97 VDD.t1567 10.3619
R199 VDD.n102 VDD.t1231 10.3619
R200 VDD.n102 VDD.t1568 10.3619
R201 VDD.n108 VDD.t1223 10.3619
R202 VDD.n108 VDD.t1548 10.3619
R203 VDD.n113 VDD.t1225 10.3619
R204 VDD.n113 VDD.t1503 10.3619
R205 VDD.n118 VDD.t1235 10.3619
R206 VDD.n118 VDD.t1570 10.3619
R207 VDD.n124 VDD.t1245 10.3619
R208 VDD.n124 VDD.t1553 10.3619
R209 VDD.n41 VDD.t460 8.0286
R210 VDD.n41 VDD.t1086 8.0286
R211 VDD.n47 VDD.t454 8.0286
R212 VDD.n47 VDD.t1083 8.0286
R213 VDD.n52 VDD.t456 8.0286
R214 VDD.n52 VDD.t1084 8.0286
R215 VDD.n58 VDD.t444 8.0286
R216 VDD.n58 VDD.t1078 8.0286
R217 VDD.n63 VDD.t438 8.0286
R218 VDD.n63 VDD.t1090 8.0286
R219 VDD.n68 VDD.t450 8.0286
R220 VDD.n68 VDD.t1081 8.0286
R221 VDD.n74 VDD.t452 8.0286
R222 VDD.n74 VDD.t1082 8.0286
R223 VDD.n79 VDD.t442 8.0286
R224 VDD.n79 VDD.t396 8.0286
R225 VDD.n84 VDD.t436 8.0286
R226 VDD.n84 VDD.t1089 8.0286
R227 VDD.n90 VDD.t458 8.0286
R228 VDD.n90 VDD.t1085 8.0286
R229 VDD.n95 VDD.t448 8.0286
R230 VDD.n95 VDD.t1080 8.0286
R231 VDD.n100 VDD.t441 8.0286
R232 VDD.n100 VDD.t434 8.0286
R233 VDD.n106 VDD.t440 8.0286
R234 VDD.n106 VDD.t1091 8.0286
R235 VDD.n111 VDD.t462 8.0286
R236 VDD.n111 VDD.t1087 8.0286
R237 VDD.n116 VDD.t464 8.0286
R238 VDD.n116 VDD.t1088 8.0286
R239 VDD.n122 VDD.t446 8.0286
R240 VDD.n122 VDD.t1079 8.0286
R241 VDD.n44 VDD.t1779 7.8848
R242 VDD.n44 VDD.t1764 7.8848
R243 VDD.n50 VDD.t1278 7.8848
R244 VDD.n50 VDD.t1269 7.8848
R245 VDD.n55 VDD.t1294 7.8848
R246 VDD.n55 VDD.t1315 7.8848
R247 VDD.n61 VDD.t692 7.8848
R248 VDD.n61 VDD.t713 7.8848
R249 VDD.n66 VDD.t160 7.8848
R250 VDD.n66 VDD.t151 7.8848
R251 VDD.n71 VDD.t1738 7.8848
R252 VDD.n71 VDD.t1731 7.8848
R253 VDD.n77 VDD.t1319 7.8848
R254 VDD.n77 VDD.t1336 7.8848
R255 VDD.n82 VDD.t1787 7.8848
R256 VDD.n82 VDD.t1808 7.8848
R257 VDD.n87 VDD.t985 7.8848
R258 VDD.n87 VDD.t976 7.8848
R259 VDD.n93 VDD.t956 7.8848
R260 VDD.n93 VDD.t947 7.8848
R261 VDD.n98 VDD.t2099 7.8848
R262 VDD.n98 VDD.t2116 7.8848
R263 VDD.n103 VDD.t168 7.8848
R264 VDD.n103 VDD.t189 7.8848
R265 VDD.n109 VDD.t1123 7.8848
R266 VDD.n109 VDD.t1140 7.8848
R267 VDD.n114 VDD.t1645 7.8848
R268 VDD.n114 VDD.t1588 7.8848
R269 VDD.n119 VDD.t1211 7.8848
R270 VDD.n119 VDD.t1202 7.8848
R271 VDD.n125 VDD.t244 7.8848
R272 VDD.n125 VDD.t235 7.8848
R273 VDD.n129 VDD.t3264 7.8848
R274 VDD.n129 VDD.t3245 7.8848
R275 VDD.n130 VDD.t3217 7.8848
R276 VDD.n130 VDD.t3142 7.8848
R277 VDD.n40 VDD.t737 7.83416
R278 VDD.n40 VDD.t1488 7.83416
R279 VDD.n46 VDD.t733 7.83416
R280 VDD.n46 VDD.t1486 7.83416
R281 VDD.n51 VDD.t721 7.83416
R282 VDD.n51 VDD.t1496 7.83416
R283 VDD.n57 VDD.t743 7.83416
R284 VDD.n57 VDD.t1491 7.83416
R285 VDD.n62 VDD.t735 7.83416
R286 VDD.n62 VDD.t1487 7.83416
R287 VDD.n67 VDD.t727 7.83416
R288 VDD.n67 VDD.t1483 7.83416
R289 VDD.n73 VDD.t749 7.83416
R290 VDD.n73 VDD.t1494 7.83416
R291 VDD.n78 VDD.t751 7.83416
R292 VDD.n78 VDD.t1495 7.83416
R293 VDD.n83 VDD.t739 7.83416
R294 VDD.n83 VDD.t1489 7.83416
R295 VDD.n89 VDD.t723 7.83416
R296 VDD.n89 VDD.t1481 7.83416
R297 VDD.n94 VDD.t725 7.83416
R298 VDD.n94 VDD.t1482 7.83416
R299 VDD.n99 VDD.t747 7.83416
R300 VDD.n99 VDD.t1493 7.83416
R301 VDD.n105 VDD.t745 7.83416
R302 VDD.n105 VDD.t1492 7.83416
R303 VDD.n110 VDD.t729 7.83416
R304 VDD.n110 VDD.t1484 7.83416
R305 VDD.n115 VDD.t731 7.83416
R306 VDD.n115 VDD.t1485 7.83416
R307 VDD.n121 VDD.t741 7.83416
R308 VDD.n121 VDD.t1490 7.83416
R309 VDD.n42 VDD.n38 5.30638
R310 VDD.n42 VDD.n39 5.30638
R311 VDD.n48 VDD.n35 5.30638
R312 VDD.n48 VDD.n36 5.30638
R313 VDD.n53 VDD.n33 5.30638
R314 VDD.n53 VDD.n34 5.30638
R315 VDD.n59 VDD.n30 5.30638
R316 VDD.n59 VDD.n31 5.30638
R317 VDD.n64 VDD.n28 5.30638
R318 VDD.n64 VDD.n29 5.30638
R319 VDD.n69 VDD.n26 5.30638
R320 VDD.n69 VDD.n27 5.30638
R321 VDD.n75 VDD.n23 5.30638
R322 VDD.n75 VDD.n24 5.30638
R323 VDD.n80 VDD.n21 5.30638
R324 VDD.n80 VDD.n22 5.30638
R325 VDD.n85 VDD.n19 5.30638
R326 VDD.n85 VDD.n20 5.30638
R327 VDD.n91 VDD.n16 5.30638
R328 VDD.n91 VDD.n17 5.30638
R329 VDD.n96 VDD.n14 5.30638
R330 VDD.n96 VDD.n15 5.30638
R331 VDD.n101 VDD.n12 5.30638
R332 VDD.n101 VDD.n13 5.30638
R333 VDD.n107 VDD.n9 5.30638
R334 VDD.n107 VDD.n10 5.30638
R335 VDD.n112 VDD.n7 5.30638
R336 VDD.n112 VDD.n8 5.30638
R337 VDD.n117 VDD.n5 5.30638
R338 VDD.n117 VDD.n6 5.30638
R339 VDD.n123 VDD.n2 5.30638
R340 VDD.n123 VDD.n3 5.30638
R341 VDD.n128 VDD.t1368 4.28205
R342 VDD.n128 VDD.t3171 4.28205
R343 VDD.n126 VDD.t1253 4.20719
R344 VDD.n126 VDD.t1557 4.20719
R345 VDD.n38 VDD.t2633 3.5005
R346 VDD.n35 VDD.t2512 3.5005
R347 VDD.n33 VDD.t3305 3.5005
R348 VDD.n30 VDD.t3331 3.5005
R349 VDD.n28 VDD.t2988 3.5005
R350 VDD.n26 VDD.t2842 3.5005
R351 VDD.n23 VDD.t2565 3.5005
R352 VDD.n21 VDD.t2802 3.5005
R353 VDD.n19 VDD.t2373 3.5005
R354 VDD.n16 VDD.t3118 3.5005
R355 VDD.n14 VDD.t3429 3.5005
R356 VDD.n12 VDD.t3076 3.5005
R357 VDD.n9 VDD.t2863 3.5005
R358 VDD.n7 VDD.t3194 3.5005
R359 VDD.n5 VDD.t2533 3.5005
R360 VDD.n2 VDD.t2788 3.5005
R361 VDD.n39 VDD.t2553 2.86414
R362 VDD.n36 VDD.t2453 2.86414
R363 VDD.n34 VDD.t2762 2.86414
R364 VDD.n31 VDD.t3160 2.86414
R365 VDD.n29 VDD.t2463 2.86414
R366 VDD.n27 VDD.t2790 2.86414
R367 VDD.n24 VDD.t2383 2.86414
R368 VDD.n22 VDD.t2371 2.86414
R369 VDD.n20 VDD.t3196 2.86414
R370 VDD.n17 VDD.t3238 2.86414
R371 VDD.n15 VDD.t3326 2.86414
R372 VDD.n13 VDD.t2774 2.86414
R373 VDD.n10 VDD.t2961 2.86414
R374 VDD.n8 VDD.t2523 2.86414
R375 VDD.n6 VDD.t2325 2.86414
R376 VDD.n3 VDD.t2678 2.86414
R377 VDD.n127 VDD.n0 2.84898
R378 VDD.n127 VDD.n1 2.84898
R379 VDD.n38 VDD.t2634 2.72272
R380 VDD.n35 VDD.t2513 2.72272
R381 VDD.n33 VDD.t3306 2.72272
R382 VDD.n30 VDD.t3332 2.72272
R383 VDD.n28 VDD.t2989 2.72272
R384 VDD.n26 VDD.t2843 2.72272
R385 VDD.n23 VDD.t2566 2.72272
R386 VDD.n21 VDD.t2801 2.72272
R387 VDD.n19 VDD.t2375 2.72272
R388 VDD.n16 VDD.t3120 2.72272
R389 VDD.n14 VDD.t3430 2.72272
R390 VDD.n12 VDD.t3075 2.72272
R391 VDD.n9 VDD.t2861 2.72272
R392 VDD.n7 VDD.t3195 2.72272
R393 VDD.n5 VDD.t2534 2.72272
R394 VDD.n2 VDD.t2787 2.72272
R395 VDD.n39 VDD.t2555 1.94494
R396 VDD.n36 VDD.t2451 1.94494
R397 VDD.n34 VDD.t2760 1.94494
R398 VDD.n31 VDD.t3162 1.94494
R399 VDD.n29 VDD.t2465 1.94494
R400 VDD.n27 VDD.t2792 1.94494
R401 VDD.n24 VDD.t2381 1.94494
R402 VDD.n22 VDD.t2369 1.94494
R403 VDD.n20 VDD.t3197 1.94494
R404 VDD.n17 VDD.t3239 1.94494
R405 VDD.n15 VDD.t3324 1.94494
R406 VDD.n13 VDD.t2772 1.94494
R407 VDD.n10 VDD.t2962 1.94494
R408 VDD.n8 VDD.t2525 1.94494
R409 VDD.n6 VDD.t2323 1.94494
R410 VDD.n3 VDD.t2676 1.94494
R411 VDD.n1 VDD.t1366 1.43357
R412 VDD.n0 VDD.t3172 1.43357
R413 VDD.n1 VDD.t1247 1.40948
R414 VDD.n0 VDD.t1555 1.40948
R415 VDD.n41 VDD.n40 0.71975
R416 VDD.n47 VDD.n46 0.71975
R417 VDD.n52 VDD.n51 0.71975
R418 VDD.n58 VDD.n57 0.71975
R419 VDD.n63 VDD.n62 0.71975
R420 VDD.n68 VDD.n67 0.71975
R421 VDD.n74 VDD.n73 0.71975
R422 VDD.n79 VDD.n78 0.71975
R423 VDD.n84 VDD.n83 0.71975
R424 VDD.n90 VDD.n89 0.71975
R425 VDD.n95 VDD.n94 0.71975
R426 VDD.n100 VDD.n99 0.71975
R427 VDD.n106 VDD.n105 0.71975
R428 VDD.n111 VDD.n110 0.71975
R429 VDD.n116 VDD.n115 0.71975
R430 VDD.n122 VDD.n121 0.71975
R431 VDD.n44 VDD.n43 0.49925
R432 VDD.n50 VDD.n49 0.49925
R433 VDD.n55 VDD.n54 0.49925
R434 VDD.n61 VDD.n60 0.49925
R435 VDD.n66 VDD.n65 0.49925
R436 VDD.n71 VDD.n70 0.49925
R437 VDD.n77 VDD.n76 0.49925
R438 VDD.n82 VDD.n81 0.49925
R439 VDD.n87 VDD.n86 0.49925
R440 VDD.n93 VDD.n92 0.49925
R441 VDD.n98 VDD.n97 0.49925
R442 VDD.n103 VDD.n102 0.49925
R443 VDD.n109 VDD.n108 0.49925
R444 VDD.n114 VDD.n113 0.49925
R445 VDD.n119 VDD.n118 0.49925
R446 VDD.n125 VDD.n124 0.49925
R447 VDD.n127 VDD.n126 0.2495
R448 VDD.n128 VDD.n127 0.2405
R449 VDD.n130 VDD.n129 0.2405
R450 VDD.n42 VDD.n41 0.2285
R451 VDD.n48 VDD.n47 0.2285
R452 VDD.n53 VDD.n52 0.2285
R453 VDD.n59 VDD.n58 0.2285
R454 VDD.n64 VDD.n63 0.2285
R455 VDD.n69 VDD.n68 0.2285
R456 VDD.n75 VDD.n74 0.2285
R457 VDD.n80 VDD.n79 0.2285
R458 VDD.n85 VDD.n84 0.2285
R459 VDD.n91 VDD.n90 0.2285
R460 VDD.n96 VDD.n95 0.2285
R461 VDD.n101 VDD.n100 0.2285
R462 VDD.n107 VDD.n106 0.2285
R463 VDD.n112 VDD.n111 0.2285
R464 VDD.n117 VDD.n116 0.2285
R465 VDD.n123 VDD.n122 0.2285
R466 VDD.n43 VDD.n42 0.2165
R467 VDD.n49 VDD.n48 0.2165
R468 VDD.n54 VDD.n53 0.2165
R469 VDD.n60 VDD.n59 0.2165
R470 VDD.n65 VDD.n64 0.2165
R471 VDD.n70 VDD.n69 0.2165
R472 VDD.n76 VDD.n75 0.2165
R473 VDD.n81 VDD.n80 0.2165
R474 VDD.n86 VDD.n85 0.2165
R475 VDD.n92 VDD.n91 0.2165
R476 VDD.n97 VDD.n96 0.2165
R477 VDD.n102 VDD.n101 0.2165
R478 VDD.n108 VDD.n107 0.2165
R479 VDD.n113 VDD.n112 0.2165
R480 VDD.n118 VDD.n117 0.2165
R481 VDD.n124 VDD.n123 0.2165
R482 VDD.n51 VDD.n50 0.1925
R483 VDD.n62 VDD.n61 0.1925
R484 VDD.n67 VDD.n66 0.1925
R485 VDD.n78 VDD.n77 0.1925
R486 VDD.n83 VDD.n82 0.1925
R487 VDD.n94 VDD.n93 0.1925
R488 VDD.n99 VDD.n98 0.1925
R489 VDD.n110 VDD.n109 0.1925
R490 VDD.n115 VDD.n114 0.1925
R491 VDD.n126 VDD.n125 0.1925
R492 VDD.n45 VDD.n44 0.0965
R493 VDD.n46 VDD.n45 0.0965
R494 VDD.n56 VDD.n55 0.0965
R495 VDD.n57 VDD.n56 0.0965
R496 VDD.n72 VDD.n71 0.0965
R497 VDD.n73 VDD.n72 0.0965
R498 VDD.n88 VDD.n87 0.0965
R499 VDD.n89 VDD.n88 0.0965
R500 VDD.n104 VDD.n103 0.0965
R501 VDD.n105 VDD.n104 0.0965
R502 VDD.n120 VDD.n119 0.0965
R503 VDD.n121 VDD.n120 0.0965
R504 VDD.n129 VDD.n128 0.0965
R505 VDD VDD.n130 0.07925
R506 a_23377_n862.n22 a_23377_n862.t32 18.9023
R507 a_23377_n862.n0 a_23377_n862.t4 16.1132
R508 a_23377_n862.n22 a_23377_n862.t33 15.6434
R509 a_23377_n862.n2 a_23377_n862.t11 15.4511
R510 a_23377_n862.n3 a_23377_n862.t3 15.4511
R511 a_23377_n862.n6 a_23377_n862.t7 15.4511
R512 a_23377_n862.n7 a_23377_n862.t15 15.4511
R513 a_23377_n862.n10 a_23377_n862.t24 15.4511
R514 a_23377_n862.n11 a_23377_n862.t17 15.4511
R515 a_23377_n862.n14 a_23377_n862.t6 15.4511
R516 a_23377_n862.n15 a_23377_n862.t10 15.4511
R517 a_23377_n862.n18 a_23377_n862.t2 15.4511
R518 a_23377_n862.n19 a_23377_n862.t8 15.4511
R519 a_23377_n862.n30 a_23377_n862.t12 15.4511
R520 a_23377_n862.n27 a_23377_n862.t1 15.4511
R521 a_23377_n862.n26 a_23377_n862.t9 15.4511
R522 a_23377_n862.n23 a_23377_n862.t5 15.4511
R523 a_23377_n862.t0 a_23377_n862.n31 15.4511
R524 a_23377_n862.n0 a_23377_n862.t18 14.8566
R525 a_23377_n862.n1 a_23377_n862.t14 14.8566
R526 a_23377_n862.n4 a_23377_n862.t16 14.8566
R527 a_23377_n862.n5 a_23377_n862.t28 14.8566
R528 a_23377_n862.n8 a_23377_n862.t31 14.8566
R529 a_23377_n862.n9 a_23377_n862.t19 14.8566
R530 a_23377_n862.n12 a_23377_n862.t13 14.8566
R531 a_23377_n862.n13 a_23377_n862.t26 14.8566
R532 a_23377_n862.n16 a_23377_n862.t30 14.8566
R533 a_23377_n862.n17 a_23377_n862.t29 14.8566
R534 a_23377_n862.n20 a_23377_n862.t25 14.8566
R535 a_23377_n862.n21 a_23377_n862.t20 14.8566
R536 a_23377_n862.n29 a_23377_n862.t21 14.8566
R537 a_23377_n862.n28 a_23377_n862.t27 14.8566
R538 a_23377_n862.n25 a_23377_n862.t23 14.8566
R539 a_23377_n862.n24 a_23377_n862.t22 14.8566
R540 a_23377_n862.n23 a_23377_n862.n22 14.5641
R541 a_23377_n862.n3 a_23377_n862.n2 0.746214
R542 a_23377_n862.n7 a_23377_n862.n6 0.746214
R543 a_23377_n862.n11 a_23377_n862.n10 0.746214
R544 a_23377_n862.n15 a_23377_n862.n14 0.746214
R545 a_23377_n862.n19 a_23377_n862.n18 0.746214
R546 a_23377_n862.n31 a_23377_n862.n30 0.746214
R547 a_23377_n862.n27 a_23377_n862.n26 0.746214
R548 a_23377_n862.n2 a_23377_n862.n1 0.662643
R549 a_23377_n862.n4 a_23377_n862.n3 0.662643
R550 a_23377_n862.n6 a_23377_n862.n5 0.662643
R551 a_23377_n862.n8 a_23377_n862.n7 0.662643
R552 a_23377_n862.n10 a_23377_n862.n9 0.662643
R553 a_23377_n862.n12 a_23377_n862.n11 0.662643
R554 a_23377_n862.n14 a_23377_n862.n13 0.662643
R555 a_23377_n862.n16 a_23377_n862.n15 0.662643
R556 a_23377_n862.n18 a_23377_n862.n17 0.662643
R557 a_23377_n862.n20 a_23377_n862.n19 0.662643
R558 a_23377_n862.n31 a_23377_n862.n21 0.662643
R559 a_23377_n862.n30 a_23377_n862.n29 0.662643
R560 a_23377_n862.n28 a_23377_n862.n27 0.662643
R561 a_23377_n862.n26 a_23377_n862.n25 0.662643
R562 a_23377_n862.n24 a_23377_n862.n23 0.662643
R563 a_23377_n862.n1 a_23377_n862.n0 0.4505
R564 a_23377_n862.n5 a_23377_n862.n4 0.4505
R565 a_23377_n862.n9 a_23377_n862.n8 0.4505
R566 a_23377_n862.n13 a_23377_n862.n12 0.4505
R567 a_23377_n862.n17 a_23377_n862.n16 0.4505
R568 a_23377_n862.n21 a_23377_n862.n20 0.4505
R569 a_23377_n862.n29 a_23377_n862.n28 0.4505
R570 a_23377_n862.n25 a_23377_n862.n24 0.4505
R571 a_n884_9238.n1 a_n884_9238.t15 29.9245
R572 a_n884_9238.n30 a_n884_9238.t6 29.3395
R573 a_n884_9238.n28 a_n884_9238.t27 29.3395
R574 a_n884_9238.n26 a_n884_9238.t14 29.3395
R575 a_n884_9238.n24 a_n884_9238.t13 29.3395
R576 a_n884_9238.n22 a_n884_9238.t24 29.3395
R577 a_n884_9238.n20 a_n884_9238.t23 29.3395
R578 a_n884_9238.n18 a_n884_9238.t30 29.3395
R579 a_n884_9238.n16 a_n884_9238.t10 29.3395
R580 a_n884_9238.n14 a_n884_9238.t9 29.3395
R581 a_n884_9238.n12 a_n884_9238.t26 29.3395
R582 a_n884_9238.n10 a_n884_9238.t31 29.3395
R583 a_n884_9238.n8 a_n884_9238.t12 29.3395
R584 a_n884_9238.n6 a_n884_9238.t11 29.3395
R585 a_n884_9238.n4 a_n884_9238.t28 29.3395
R586 a_n884_9238.n2 a_n884_9238.t34 29.3395
R587 a_n884_9238.n31 a_n884_9238.t22 27.973
R588 a_n884_9238.n29 a_n884_9238.t8 27.973
R589 a_n884_9238.n27 a_n884_9238.t25 27.973
R590 a_n884_9238.n25 a_n884_9238.t5 27.973
R591 a_n884_9238.n23 a_n884_9238.t4 27.973
R592 a_n884_9238.n21 a_n884_9238.t17 27.973
R593 a_n884_9238.n19 a_n884_9238.t16 27.973
R594 a_n884_9238.n17 a_n884_9238.t33 27.973
R595 a_n884_9238.n15 a_n884_9238.t32 27.973
R596 a_n884_9238.n13 a_n884_9238.t19 27.973
R597 a_n884_9238.n11 a_n884_9238.t18 27.973
R598 a_n884_9238.n9 a_n884_9238.t29 27.973
R599 a_n884_9238.n7 a_n884_9238.t35 27.973
R600 a_n884_9238.n5 a_n884_9238.t7 27.973
R601 a_n884_9238.n3 a_n884_9238.t21 27.973
R602 a_n884_9238.n1 a_n884_9238.t20 27.973
R603 a_n884_9238.n32 a_n884_9238.n31 10.1914
R604 a_n884_9238.n32 a_n884_9238.n0 7.10204
R605 a_n884_9238.n2 a_n884_9238.n1 3.38836
R606 a_n884_9238.n4 a_n884_9238.n3 3.38836
R607 a_n884_9238.n6 a_n884_9238.n5 3.38836
R608 a_n884_9238.n8 a_n884_9238.n7 3.38836
R609 a_n884_9238.n10 a_n884_9238.n9 3.38836
R610 a_n884_9238.n12 a_n884_9238.n11 3.38836
R611 a_n884_9238.n14 a_n884_9238.n13 3.38836
R612 a_n884_9238.n16 a_n884_9238.n15 3.38836
R613 a_n884_9238.n18 a_n884_9238.n17 3.38836
R614 a_n884_9238.n20 a_n884_9238.n19 3.38836
R615 a_n884_9238.n22 a_n884_9238.n21 3.38836
R616 a_n884_9238.n24 a_n884_9238.n23 3.38836
R617 a_n884_9238.n26 a_n884_9238.n25 3.38836
R618 a_n884_9238.n28 a_n884_9238.n27 3.38836
R619 a_n884_9238.n30 a_n884_9238.n29 3.38836
R620 a_n884_9238.n0 a_n884_9238.t2 3.00946
R621 a_n884_9238.n33 a_n884_9238.n32 2.63313
R622 a_n884_9238.n0 a_n884_9238.t3 2.44528
R623 a_n884_9238.t0 a_n884_9238.n33 1.67214
R624 a_n884_9238.n33 a_n884_9238.t1 1.35871
R625 a_n884_9238.n3 a_n884_9238.n2 0.5855
R626 a_n884_9238.n5 a_n884_9238.n4 0.5855
R627 a_n884_9238.n7 a_n884_9238.n6 0.5855
R628 a_n884_9238.n9 a_n884_9238.n8 0.5855
R629 a_n884_9238.n11 a_n884_9238.n10 0.5855
R630 a_n884_9238.n13 a_n884_9238.n12 0.5855
R631 a_n884_9238.n15 a_n884_9238.n14 0.5855
R632 a_n884_9238.n17 a_n884_9238.n16 0.5855
R633 a_n884_9238.n19 a_n884_9238.n18 0.5855
R634 a_n884_9238.n21 a_n884_9238.n20 0.5855
R635 a_n884_9238.n23 a_n884_9238.n22 0.5855
R636 a_n884_9238.n25 a_n884_9238.n24 0.5855
R637 a_n884_9238.n27 a_n884_9238.n26 0.5855
R638 a_n884_9238.n29 a_n884_9238.n28 0.5855
R639 a_n884_9238.n31 a_n884_9238.n30 0.5855
R640 a_36720_n708.n1 a_36720_n708.t29 31.0255
R641 a_36720_n708.n2 a_36720_n708.t34 31.0255
R642 a_36720_n708.n4 a_36720_n708.t14 31.0255
R643 a_36720_n708.n6 a_36720_n708.t26 31.0255
R644 a_36720_n708.n8 a_36720_n708.t32 31.0255
R645 a_36720_n708.n10 a_36720_n708.t12 31.0255
R646 a_36720_n708.n12 a_36720_n708.t15 31.0255
R647 a_36720_n708.n14 a_36720_n708.t27 31.0255
R648 a_36720_n708.n16 a_36720_n708.t33 31.0255
R649 a_36720_n708.n18 a_36720_n708.t22 31.0255
R650 a_36720_n708.n20 a_36720_n708.t31 31.0255
R651 a_36720_n708.n22 a_36720_n708.t8 31.0255
R652 a_36720_n708.n24 a_36720_n708.t10 31.0255
R653 a_36720_n708.n26 a_36720_n708.t13 31.0255
R654 a_36720_n708.n28 a_36720_n708.t24 31.0255
R655 a_36720_n708.n30 a_36720_n708.t7 31.0255
R656 a_36720_n708.n1 a_36720_n708.t21 27.8969
R657 a_36720_n708.n2 a_36720_n708.t23 27.8969
R658 a_36720_n708.n4 a_36720_n708.t11 27.8969
R659 a_36720_n708.n6 a_36720_n708.t9 27.8969
R660 a_36720_n708.n8 a_36720_n708.t35 27.8969
R661 a_36720_n708.n10 a_36720_n708.t25 27.8969
R662 a_36720_n708.n12 a_36720_n708.t20 27.8969
R663 a_36720_n708.n14 a_36720_n708.t18 27.8969
R664 a_36720_n708.n16 a_36720_n708.t4 27.8969
R665 a_36720_n708.n18 a_36720_n708.t5 27.8969
R666 a_36720_n708.n20 a_36720_n708.t30 27.8969
R667 a_36720_n708.n22 a_36720_n708.t19 27.8969
R668 a_36720_n708.n24 a_36720_n708.t16 27.8969
R669 a_36720_n708.n26 a_36720_n708.t6 27.8969
R670 a_36720_n708.n28 a_36720_n708.t17 27.8969
R671 a_36720_n708.n30 a_36720_n708.t28 27.8969
R672 a_36720_n708.n3 a_36720_n708.n1 13.8288
R673 a_36720_n708.n3 a_36720_n708.n2 12.5495
R674 a_36720_n708.n5 a_36720_n708.n4 12.5495
R675 a_36720_n708.n7 a_36720_n708.n6 12.5495
R676 a_36720_n708.n9 a_36720_n708.n8 12.5495
R677 a_36720_n708.n11 a_36720_n708.n10 12.5495
R678 a_36720_n708.n13 a_36720_n708.n12 12.5495
R679 a_36720_n708.n15 a_36720_n708.n14 12.5495
R680 a_36720_n708.n17 a_36720_n708.n16 12.5495
R681 a_36720_n708.n19 a_36720_n708.n18 12.5495
R682 a_36720_n708.n21 a_36720_n708.n20 12.5495
R683 a_36720_n708.n23 a_36720_n708.n22 12.5495
R684 a_36720_n708.n25 a_36720_n708.n24 12.5495
R685 a_36720_n708.n27 a_36720_n708.n26 12.5495
R686 a_36720_n708.n29 a_36720_n708.n28 12.5495
R687 a_36720_n708.n31 a_36720_n708.n30 12.5495
R688 a_36720_n708.n33 a_36720_n708.n32 6.45898
R689 a_36720_n708.n32 a_36720_n708.n31 5.79746
R690 a_36720_n708.n32 a_36720_n708.n0 2.99572
R691 a_36720_n708.n33 a_36720_n708.t1 2.64244
R692 a_36720_n708.t0 a_36720_n708.n33 2.64244
R693 a_36720_n708.n0 a_36720_n708.t2 1.46824
R694 a_36720_n708.n0 a_36720_n708.t3 1.46824
R695 a_36720_n708.n7 a_36720_n708.n5 1.27979
R696 a_36720_n708.n11 a_36720_n708.n9 1.27979
R697 a_36720_n708.n15 a_36720_n708.n13 1.27979
R698 a_36720_n708.n19 a_36720_n708.n17 1.27979
R699 a_36720_n708.n23 a_36720_n708.n21 1.27979
R700 a_36720_n708.n27 a_36720_n708.n25 1.27979
R701 a_36720_n708.n31 a_36720_n708.n29 1.27979
R702 a_36720_n708.n5 a_36720_n708.n3 1.24121
R703 a_36720_n708.n9 a_36720_n708.n7 1.24121
R704 a_36720_n708.n13 a_36720_n708.n11 1.24121
R705 a_36720_n708.n17 a_36720_n708.n15 1.24121
R706 a_36720_n708.n21 a_36720_n708.n19 1.24121
R707 a_36720_n708.n25 a_36720_n708.n23 1.24121
R708 a_36720_n708.n29 a_36720_n708.n27 1.24121
R709 a_n884_8454.n1 a_n884_8454.t26 29.9245
R710 a_n884_8454.n30 a_n884_8454.t18 29.3395
R711 a_n884_8454.n28 a_n884_8454.t7 29.3395
R712 a_n884_8454.n26 a_n884_8454.t25 29.3395
R713 a_n884_8454.n24 a_n884_8454.t24 29.3395
R714 a_n884_8454.n22 a_n884_8454.t5 29.3395
R715 a_n884_8454.n20 a_n884_8454.t35 29.3395
R716 a_n884_8454.n18 a_n884_8454.t11 29.3395
R717 a_n884_8454.n16 a_n884_8454.t21 29.3395
R718 a_n884_8454.n14 a_n884_8454.t20 29.3395
R719 a_n884_8454.n12 a_n884_8454.t6 29.3395
R720 a_n884_8454.n10 a_n884_8454.t14 29.3395
R721 a_n884_8454.n8 a_n884_8454.t23 29.3395
R722 a_n884_8454.n6 a_n884_8454.t22 29.3395
R723 a_n884_8454.n4 a_n884_8454.t8 29.3395
R724 a_n884_8454.n2 a_n884_8454.t16 29.3395
R725 a_n884_8454.n31 a_n884_8454.t33 27.973
R726 a_n884_8454.n29 a_n884_8454.t19 27.973
R727 a_n884_8454.n27 a_n884_8454.t34 27.973
R728 a_n884_8454.n25 a_n884_8454.t15 27.973
R729 a_n884_8454.n23 a_n884_8454.t13 27.973
R730 a_n884_8454.n21 a_n884_8454.t28 27.973
R731 a_n884_8454.n19 a_n884_8454.t27 27.973
R732 a_n884_8454.n17 a_n884_8454.t10 27.973
R733 a_n884_8454.n15 a_n884_8454.t9 27.973
R734 a_n884_8454.n13 a_n884_8454.t30 27.973
R735 a_n884_8454.n11 a_n884_8454.t29 27.973
R736 a_n884_8454.n9 a_n884_8454.t4 27.973
R737 a_n884_8454.n7 a_n884_8454.t12 27.973
R738 a_n884_8454.n5 a_n884_8454.t17 27.973
R739 a_n884_8454.n3 a_n884_8454.t32 27.973
R740 a_n884_8454.n1 a_n884_8454.t31 27.973
R741 a_n884_8454.n32 a_n884_8454.n31 10.1914
R742 a_n884_8454.n33 a_n884_8454.n32 7.10205
R743 a_n884_8454.n2 a_n884_8454.n1 3.38836
R744 a_n884_8454.n4 a_n884_8454.n3 3.38836
R745 a_n884_8454.n6 a_n884_8454.n5 3.38836
R746 a_n884_8454.n8 a_n884_8454.n7 3.38836
R747 a_n884_8454.n10 a_n884_8454.n9 3.38836
R748 a_n884_8454.n12 a_n884_8454.n11 3.38836
R749 a_n884_8454.n14 a_n884_8454.n13 3.38836
R750 a_n884_8454.n16 a_n884_8454.n15 3.38836
R751 a_n884_8454.n18 a_n884_8454.n17 3.38836
R752 a_n884_8454.n20 a_n884_8454.n19 3.38836
R753 a_n884_8454.n22 a_n884_8454.n21 3.38836
R754 a_n884_8454.n24 a_n884_8454.n23 3.38836
R755 a_n884_8454.n26 a_n884_8454.n25 3.38836
R756 a_n884_8454.n28 a_n884_8454.n27 3.38836
R757 a_n884_8454.n30 a_n884_8454.n29 3.38836
R758 a_n884_8454.t0 a_n884_8454.n33 3.00946
R759 a_n884_8454.n32 a_n884_8454.n0 2.63313
R760 a_n884_8454.n33 a_n884_8454.t1 2.44528
R761 a_n884_8454.n0 a_n884_8454.t2 1.67214
R762 a_n884_8454.n0 a_n884_8454.t3 1.35871
R763 a_n884_8454.n3 a_n884_8454.n2 0.5855
R764 a_n884_8454.n5 a_n884_8454.n4 0.5855
R765 a_n884_8454.n7 a_n884_8454.n6 0.5855
R766 a_n884_8454.n9 a_n884_8454.n8 0.5855
R767 a_n884_8454.n11 a_n884_8454.n10 0.5855
R768 a_n884_8454.n13 a_n884_8454.n12 0.5855
R769 a_n884_8454.n15 a_n884_8454.n14 0.5855
R770 a_n884_8454.n17 a_n884_8454.n16 0.5855
R771 a_n884_8454.n19 a_n884_8454.n18 0.5855
R772 a_n884_8454.n21 a_n884_8454.n20 0.5855
R773 a_n884_8454.n23 a_n884_8454.n22 0.5855
R774 a_n884_8454.n25 a_n884_8454.n24 0.5855
R775 a_n884_8454.n27 a_n884_8454.n26 0.5855
R776 a_n884_8454.n29 a_n884_8454.n28 0.5855
R777 a_n884_8454.n31 a_n884_8454.n30 0.5855
R778 a_24360_n708.n1 a_24360_n708.t30 31.0255
R779 a_24360_n708.n2 a_24360_n708.t12 31.0255
R780 a_24360_n708.n4 a_24360_n708.t13 31.0255
R781 a_24360_n708.n6 a_24360_n708.t23 31.0255
R782 a_24360_n708.n8 a_24360_n708.t31 31.0255
R783 a_24360_n708.n10 a_24360_n708.t11 31.0255
R784 a_24360_n708.n12 a_24360_n708.t14 31.0255
R785 a_24360_n708.n14 a_24360_n708.t24 31.0255
R786 a_24360_n708.n16 a_24360_n708.t32 31.0255
R787 a_24360_n708.n18 a_24360_n708.t21 31.0255
R788 a_24360_n708.n20 a_24360_n708.t29 31.0255
R789 a_24360_n708.n22 a_24360_n708.t7 31.0255
R790 a_24360_n708.n24 a_24360_n708.t9 31.0255
R791 a_24360_n708.n26 a_24360_n708.t33 31.0255
R792 a_24360_n708.n28 a_24360_n708.t15 31.0255
R793 a_24360_n708.n30 a_24360_n708.t6 31.0255
R794 a_24360_n708.n1 a_24360_n708.t27 27.8969
R795 a_24360_n708.n2 a_24360_n708.t28 27.8969
R796 a_24360_n708.n4 a_24360_n708.t10 27.8969
R797 a_24360_n708.n6 a_24360_n708.t8 27.8969
R798 a_24360_n708.n8 a_24360_n708.t34 27.8969
R799 a_24360_n708.n10 a_24360_n708.t22 27.8969
R800 a_24360_n708.n12 a_24360_n708.t20 27.8969
R801 a_24360_n708.n14 a_24360_n708.t18 27.8969
R802 a_24360_n708.n16 a_24360_n708.t35 27.8969
R803 a_24360_n708.n18 a_24360_n708.t4 27.8969
R804 a_24360_n708.n20 a_24360_n708.t26 27.8969
R805 a_24360_n708.n22 a_24360_n708.t19 27.8969
R806 a_24360_n708.n24 a_24360_n708.t16 27.8969
R807 a_24360_n708.n26 a_24360_n708.t5 27.8969
R808 a_24360_n708.n28 a_24360_n708.t17 27.8969
R809 a_24360_n708.n30 a_24360_n708.t25 27.8969
R810 a_24360_n708.n3 a_24360_n708.n1 13.8288
R811 a_24360_n708.n3 a_24360_n708.n2 12.5495
R812 a_24360_n708.n5 a_24360_n708.n4 12.5495
R813 a_24360_n708.n7 a_24360_n708.n6 12.5495
R814 a_24360_n708.n9 a_24360_n708.n8 12.5495
R815 a_24360_n708.n11 a_24360_n708.n10 12.5495
R816 a_24360_n708.n13 a_24360_n708.n12 12.5495
R817 a_24360_n708.n15 a_24360_n708.n14 12.5495
R818 a_24360_n708.n17 a_24360_n708.n16 12.5495
R819 a_24360_n708.n19 a_24360_n708.n18 12.5495
R820 a_24360_n708.n21 a_24360_n708.n20 12.5495
R821 a_24360_n708.n23 a_24360_n708.n22 12.5495
R822 a_24360_n708.n25 a_24360_n708.n24 12.5495
R823 a_24360_n708.n27 a_24360_n708.n26 12.5495
R824 a_24360_n708.n29 a_24360_n708.n28 12.5495
R825 a_24360_n708.n31 a_24360_n708.n30 12.5495
R826 a_24360_n708.n33 a_24360_n708.n32 6.45898
R827 a_24360_n708.n32 a_24360_n708.n31 5.79746
R828 a_24360_n708.n32 a_24360_n708.n0 2.99572
R829 a_24360_n708.n33 a_24360_n708.t1 2.64244
R830 a_24360_n708.t0 a_24360_n708.n33 2.64244
R831 a_24360_n708.n0 a_24360_n708.t3 1.46824
R832 a_24360_n708.n0 a_24360_n708.t2 1.46824
R833 a_24360_n708.n7 a_24360_n708.n5 1.27979
R834 a_24360_n708.n11 a_24360_n708.n9 1.27979
R835 a_24360_n708.n15 a_24360_n708.n13 1.27979
R836 a_24360_n708.n19 a_24360_n708.n17 1.27979
R837 a_24360_n708.n23 a_24360_n708.n21 1.27979
R838 a_24360_n708.n27 a_24360_n708.n25 1.27979
R839 a_24360_n708.n31 a_24360_n708.n29 1.27979
R840 a_24360_n708.n5 a_24360_n708.n3 1.24121
R841 a_24360_n708.n9 a_24360_n708.n7 1.24121
R842 a_24360_n708.n13 a_24360_n708.n11 1.24121
R843 a_24360_n708.n17 a_24360_n708.n15 1.24121
R844 a_24360_n708.n21 a_24360_n708.n19 1.24121
R845 a_24360_n708.n25 a_24360_n708.n23 1.24121
R846 a_24360_n708.n29 a_24360_n708.n27 1.24121
R847 a_4584_n708.n1 a_4584_n708.t23 31.0255
R848 a_4584_n708.n2 a_4584_n708.t33 31.0255
R849 a_4584_n708.n4 a_4584_n708.t20 31.0255
R850 a_4584_n708.n6 a_4584_n708.t30 31.0255
R851 a_4584_n708.n8 a_4584_n708.t5 31.0255
R852 a_4584_n708.n10 a_4584_n708.t18 31.0255
R853 a_4584_n708.n12 a_4584_n708.t21 31.0255
R854 a_4584_n708.n14 a_4584_n708.t31 31.0255
R855 a_4584_n708.n16 a_4584_n708.t6 31.0255
R856 a_4584_n708.n18 a_4584_n708.t28 31.0255
R857 a_4584_n708.n20 a_4584_n708.t35 31.0255
R858 a_4584_n708.n22 a_4584_n708.t13 31.0255
R859 a_4584_n708.n24 a_4584_n708.t15 31.0255
R860 a_4584_n708.n26 a_4584_n708.t4 31.0255
R861 a_4584_n708.n28 a_4584_n708.t12 31.0255
R862 a_4584_n708.n30 a_4584_n708.t11 31.0255
R863 a_4584_n708.n1 a_4584_n708.t17 27.8969
R864 a_4584_n708.n2 a_4584_n708.t19 27.8969
R865 a_4584_n708.n4 a_4584_n708.t16 27.8969
R866 a_4584_n708.n6 a_4584_n708.t14 27.8969
R867 a_4584_n708.n8 a_4584_n708.t7 27.8969
R868 a_4584_n708.n10 a_4584_n708.t29 27.8969
R869 a_4584_n708.n12 a_4584_n708.t27 27.8969
R870 a_4584_n708.n14 a_4584_n708.t25 27.8969
R871 a_4584_n708.n16 a_4584_n708.t8 27.8969
R872 a_4584_n708.n18 a_4584_n708.t9 27.8969
R873 a_4584_n708.n20 a_4584_n708.t34 27.8969
R874 a_4584_n708.n22 a_4584_n708.t26 27.8969
R875 a_4584_n708.n24 a_4584_n708.t22 27.8969
R876 a_4584_n708.n26 a_4584_n708.t10 27.8969
R877 a_4584_n708.n28 a_4584_n708.t24 27.8969
R878 a_4584_n708.n30 a_4584_n708.t32 27.8969
R879 a_4584_n708.n3 a_4584_n708.n1 13.8288
R880 a_4584_n708.n3 a_4584_n708.n2 12.5495
R881 a_4584_n708.n5 a_4584_n708.n4 12.5495
R882 a_4584_n708.n7 a_4584_n708.n6 12.5495
R883 a_4584_n708.n9 a_4584_n708.n8 12.5495
R884 a_4584_n708.n11 a_4584_n708.n10 12.5495
R885 a_4584_n708.n13 a_4584_n708.n12 12.5495
R886 a_4584_n708.n15 a_4584_n708.n14 12.5495
R887 a_4584_n708.n17 a_4584_n708.n16 12.5495
R888 a_4584_n708.n19 a_4584_n708.n18 12.5495
R889 a_4584_n708.n21 a_4584_n708.n20 12.5495
R890 a_4584_n708.n23 a_4584_n708.n22 12.5495
R891 a_4584_n708.n25 a_4584_n708.n24 12.5495
R892 a_4584_n708.n27 a_4584_n708.n26 12.5495
R893 a_4584_n708.n29 a_4584_n708.n28 12.5495
R894 a_4584_n708.n31 a_4584_n708.n30 12.5495
R895 a_4584_n708.n33 a_4584_n708.n32 6.45898
R896 a_4584_n708.n32 a_4584_n708.n31 5.79746
R897 a_4584_n708.n32 a_4584_n708.n0 2.99572
R898 a_4584_n708.n33 a_4584_n708.t1 2.64244
R899 a_4584_n708.t0 a_4584_n708.n33 2.64244
R900 a_4584_n708.n0 a_4584_n708.t3 1.46824
R901 a_4584_n708.n0 a_4584_n708.t2 1.46824
R902 a_4584_n708.n7 a_4584_n708.n5 1.27979
R903 a_4584_n708.n11 a_4584_n708.n9 1.27979
R904 a_4584_n708.n15 a_4584_n708.n13 1.27979
R905 a_4584_n708.n19 a_4584_n708.n17 1.27979
R906 a_4584_n708.n23 a_4584_n708.n21 1.27979
R907 a_4584_n708.n27 a_4584_n708.n25 1.27979
R908 a_4584_n708.n31 a_4584_n708.n29 1.27979
R909 a_4584_n708.n5 a_4584_n708.n3 1.24121
R910 a_4584_n708.n9 a_4584_n708.n7 1.24121
R911 a_4584_n708.n13 a_4584_n708.n11 1.24121
R912 a_4584_n708.n17 a_4584_n708.n15 1.24121
R913 a_4584_n708.n21 a_4584_n708.n19 1.24121
R914 a_4584_n708.n25 a_4584_n708.n23 1.24121
R915 a_4584_n708.n29 a_4584_n708.n27 1.24121
R916 VSS.n17 VSS.t748 11.7983
R917 VSS.n18 VSS.t497 11.537
R918 VSS.n27 VSS.t494 11.537
R919 VSS.n36 VSS.t495 11.537
R920 VSS.n45 VSS.t489 11.537
R921 VSS.n54 VSS.t485 11.537
R922 VSS.n63 VSS.t492 11.537
R923 VSS.n72 VSS.t493 11.537
R924 VSS.n81 VSS.t488 11.537
R925 VSS.n90 VSS.t484 11.537
R926 VSS.n99 VSS.t496 11.537
R927 VSS.n108 VSS.t491 11.537
R928 VSS.n117 VSS.t487 11.537
R929 VSS.n126 VSS.t486 11.537
R930 VSS.n135 VSS.t498 11.537
R931 VSS.n144 VSS.t499 11.537
R932 VSS.n153 VSS.t490 11.537
R933 VSS.n25 VSS.t746 11.187
R934 VSS.n34 VSS.t756 11.187
R935 VSS.n43 VSS.t751 11.187
R936 VSS.n52 VSS.t747 11.187
R937 VSS.n61 VSS.t743 11.187
R938 VSS.n70 VSS.t754 11.187
R939 VSS.n79 VSS.t755 11.187
R940 VSS.n88 VSS.t749 11.187
R941 VSS.n97 VSS.t741 11.187
R942 VSS.n106 VSS.t742 11.187
R943 VSS.n115 VSS.t753 11.187
R944 VSS.n124 VSS.t752 11.187
R945 VSS.n133 VSS.t744 11.187
R946 VSS.n142 VSS.t745 11.187
R947 VSS.n151 VSS.t750 11.187
R948 VSS.n24 VSS.t2055 11.007
R949 VSS.n33 VSS.t1121 11.007
R950 VSS.n42 VSS.t1202 11.007
R951 VSS.n51 VSS.t724 11.007
R952 VSS.n60 VSS.t160 11.007
R953 VSS.n69 VSS.t2992 11.007
R954 VSS.n78 VSS.t1231 11.007
R955 VSS.n87 VSS.t1566 11.007
R956 VSS.n96 VSS.t924 11.007
R957 VSS.n105 VSS.t891 11.007
R958 VSS.n114 VSS.t1859 11.007
R959 VSS.n123 VSS.t201 11.007
R960 VSS.n132 VSS.t1041 11.007
R961 VSS.n141 VSS.t1750 11.007
R962 VSS.n150 VSS.t1088 11.007
R963 VSS.n159 VSS.t246 11.007
R964 VSS.n152 VSS.t2667 11.007
R965 VSS.n143 VSS.t3234 11.007
R966 VSS.n134 VSS.t2807 11.007
R967 VSS.n125 VSS.t3262 11.007
R968 VSS.n116 VSS.t2945 11.007
R969 VSS.n107 VSS.t2806 11.007
R970 VSS.n98 VSS.t2139 11.007
R971 VSS.n89 VSS.t2808 11.007
R972 VSS.n80 VSS.t3233 11.007
R973 VSS.n71 VSS.t321 11.007
R974 VSS.n62 VSS.t3047 11.007
R975 VSS.n53 VSS.t3153 11.007
R976 VSS.n44 VSS.t2360 11.007
R977 VSS.n35 VSS.t2632 11.007
R978 VSS.n26 VSS.t3237 11.007
R979 VSS.n17 VSS.t1946 11.007
R980 VSS.n21 VSS.t1254 10.9564
R981 VSS.n30 VSS.t1262 10.9564
R982 VSS.n39 VSS.t1259 10.9564
R983 VSS.n48 VSS.t1250 10.9564
R984 VSS.n57 VSS.t1251 10.9564
R985 VSS.n66 VSS.t1261 10.9564
R986 VSS.n75 VSS.t1257 10.9564
R987 VSS.n84 VSS.t1248 10.9564
R988 VSS.n93 VSS.t1249 10.9564
R989 VSS.n102 VSS.t1260 10.9564
R990 VSS.n111 VSS.t1255 10.9564
R991 VSS.n120 VSS.t1256 10.9564
R992 VSS.n129 VSS.t1252 10.9564
R993 VSS.n138 VSS.t1253 10.9564
R994 VSS.n147 VSS.t1258 10.9564
R995 VSS.n156 VSS.t1263 10.9564
R996 VSS.n157 VSS.t2711 10.9564
R997 VSS.n155 VSS.t11 10.9564
R998 VSS.n148 VSS.t3191 10.9564
R999 VSS.n146 VSS.t5 10.9564
R1000 VSS.n139 VSS.t2783 10.9564
R1001 VSS.n137 VSS.t13 10.9564
R1002 VSS.n130 VSS.t2129 10.9564
R1003 VSS.n128 VSS.t18 10.9564
R1004 VSS.n121 VSS.t2853 10.9564
R1005 VSS.n119 VSS.t8 10.9564
R1006 VSS.n112 VSS.t2658 10.9564
R1007 VSS.n110 VSS.t19 10.9564
R1008 VSS.n103 VSS.t1717 10.9564
R1009 VSS.n101 VSS.t10 10.9564
R1010 VSS.n94 VSS.t2590 10.9564
R1011 VSS.n92 VSS.t15 10.9564
R1012 VSS.n85 VSS.t2810 10.9564
R1013 VSS.n83 VSS.t9 10.9564
R1014 VSS.n76 VSS.t2312 10.9564
R1015 VSS.n74 VSS.t6 10.9564
R1016 VSS.n67 VSS.t2635 10.9564
R1017 VSS.n65 VSS.t14 10.9564
R1018 VSS.n58 VSS.t2019 10.9564
R1019 VSS.n56 VSS.t17 10.9564
R1020 VSS.n49 VSS.t3032 10.9564
R1021 VSS.n47 VSS.t16 10.9564
R1022 VSS.n40 VSS.t3148 10.9564
R1023 VSS.n38 VSS.t7 10.9564
R1024 VSS.n31 VSS.t2346 10.9564
R1025 VSS.n29 VSS.t12 10.9564
R1026 VSS.n22 VSS.t1978 10.9564
R1027 VSS.n20 VSS.t4 10.9564
R1028 VSS.n160 VSS.t535 9.05702
R1029 VSS.n161 VSS.t534 9.05702
R1030 VSS.n24 VSS.t1977 9.04832
R1031 VSS.n33 VSS.t2347 9.04832
R1032 VSS.n42 VSS.t3149 9.04832
R1033 VSS.n51 VSS.t3031 9.04832
R1034 VSS.n60 VSS.t2020 9.04832
R1035 VSS.n69 VSS.t2633 9.04832
R1036 VSS.n78 VSS.t2313 9.04832
R1037 VSS.n87 VSS.t2809 9.04832
R1038 VSS.n96 VSS.t2591 9.04832
R1039 VSS.n105 VSS.t1715 9.04832
R1040 VSS.n114 VSS.t2657 9.04832
R1041 VSS.n123 VSS.t2852 9.04832
R1042 VSS.n132 VSS.t2130 9.04832
R1043 VSS.n141 VSS.t2784 9.04832
R1044 VSS.n150 VSS.t3192 9.04832
R1045 VSS.n159 VSS.t2712 9.04832
R1046 VSS.n158 VSS.t2710 9.04832
R1047 VSS.n149 VSS.t3190 9.04832
R1048 VSS.n140 VSS.t2785 9.04832
R1049 VSS.n131 VSS.t2128 9.04832
R1050 VSS.n122 VSS.t2854 9.04832
R1051 VSS.n113 VSS.t2656 9.04832
R1052 VSS.n104 VSS.t1716 9.04832
R1053 VSS.n95 VSS.t2589 9.04832
R1054 VSS.n86 VSS.t2811 9.04832
R1055 VSS.n77 VSS.t2314 9.04832
R1056 VSS.n68 VSS.t2634 9.04832
R1057 VSS.n59 VSS.t2018 9.04832
R1058 VSS.n50 VSS.t3033 9.04832
R1059 VSS.n41 VSS.t3150 9.04832
R1060 VSS.n32 VSS.t2345 9.04832
R1061 VSS.n23 VSS.t1979 9.04832
R1062 VSS.n162 VSS.t1267 9.03655
R1063 VSS.n160 VSS.t1119 8.9018
R1064 VSS.n163 VSS.t3046 8.71637
R1065 VSS.n161 VSS.n0 6.45702
R1066 VSS.n19 VSS.n16 6.40638
R1067 VSS.n28 VSS.n15 6.40638
R1068 VSS.n37 VSS.n14 6.40638
R1069 VSS.n46 VSS.n13 6.40638
R1070 VSS.n55 VSS.n12 6.40638
R1071 VSS.n64 VSS.n11 6.40638
R1072 VSS.n73 VSS.n10 6.40638
R1073 VSS.n82 VSS.n9 6.40638
R1074 VSS.n91 VSS.n8 6.40638
R1075 VSS.n100 VSS.n7 6.40638
R1076 VSS.n109 VSS.n6 6.40638
R1077 VSS.n118 VSS.n5 6.40638
R1078 VSS.n127 VSS.n4 6.40638
R1079 VSS.n136 VSS.n3 6.40638
R1080 VSS.n145 VSS.n2 6.40638
R1081 VSS.n154 VSS.n1 6.40638
R1082 VSS.n16 VSS.t2366 4.9005
R1083 VSS.n15 VSS.t2285 4.9005
R1084 VSS.n14 VSS.t2532 4.9005
R1085 VSS.n13 VSS.t2961 4.9005
R1086 VSS.n12 VSS.t2295 4.9005
R1087 VSS.n11 VSS.t2559 4.9005
R1088 VSS.n10 VSS.t2193 4.9005
R1089 VSS.n9 VSS.t2182 4.9005
R1090 VSS.n8 VSS.t3029 4.9005
R1091 VSS.n7 VSS.t3068 4.9005
R1092 VSS.n6 VSS.t3155 4.9005
R1093 VSS.n5 VSS.t2541 4.9005
R1094 VSS.n4 VSS.t2713 4.9005
R1095 VSS.n3 VSS.t2343 4.9005
R1096 VSS.n2 VSS.t2144 4.9005
R1097 VSS.n1 VSS.t2483 4.9005
R1098 VSS.n16 VSS.t2365 4.5505
R1099 VSS.n15 VSS.t2284 4.5505
R1100 VSS.n14 VSS.t2531 4.5505
R1101 VSS.n13 VSS.t2960 4.5505
R1102 VSS.n12 VSS.t2294 4.5505
R1103 VSS.n11 VSS.t2560 4.5505
R1104 VSS.n10 VSS.t2192 4.5505
R1105 VSS.n9 VSS.t2183 4.5505
R1106 VSS.n8 VSS.t3030 4.5505
R1107 VSS.n7 VSS.t3069 4.5505
R1108 VSS.n6 VSS.t3154 4.5505
R1109 VSS.n5 VSS.t2542 4.5505
R1110 VSS.n4 VSS.t2714 4.5505
R1111 VSS.n3 VSS.t2344 4.5505
R1112 VSS.n2 VSS.t2145 4.5505
R1113 VSS.n1 VSS.t2484 4.5505
R1114 VSS.n0 VSS.t1266 2.58003
R1115 VSS.n0 VSS.t1120 2.42368
R1116 VSS.n26 VSS.n25 0.61175
R1117 VSS.n35 VSS.n34 0.61175
R1118 VSS.n44 VSS.n43 0.61175
R1119 VSS.n53 VSS.n52 0.61175
R1120 VSS.n62 VSS.n61 0.61175
R1121 VSS.n71 VSS.n70 0.61175
R1122 VSS.n80 VSS.n79 0.61175
R1123 VSS.n89 VSS.n88 0.61175
R1124 VSS.n98 VSS.n97 0.61175
R1125 VSS.n107 VSS.n106 0.61175
R1126 VSS.n116 VSS.n115 0.61175
R1127 VSS.n125 VSS.n124 0.61175
R1128 VSS.n134 VSS.n133 0.61175
R1129 VSS.n143 VSS.n142 0.61175
R1130 VSS.n152 VSS.n151 0.61175
R1131 VSS.n163 VSS.n162 0.3365
R1132 VSS.n161 VSS.n160 0.2495
R1133 VSS.n24 VSS.n23 0.2405
R1134 VSS.n33 VSS.n32 0.2405
R1135 VSS.n42 VSS.n41 0.2405
R1136 VSS.n51 VSS.n50 0.2405
R1137 VSS.n60 VSS.n59 0.2405
R1138 VSS.n69 VSS.n68 0.2405
R1139 VSS.n78 VSS.n77 0.2405
R1140 VSS.n87 VSS.n86 0.2405
R1141 VSS.n96 VSS.n95 0.2405
R1142 VSS.n105 VSS.n104 0.2405
R1143 VSS.n114 VSS.n113 0.2405
R1144 VSS.n123 VSS.n122 0.2405
R1145 VSS.n132 VSS.n131 0.2405
R1146 VSS.n141 VSS.n140 0.2405
R1147 VSS.n150 VSS.n149 0.2405
R1148 VSS.n159 VSS.n158 0.2405
R1149 VSS.n162 VSS.n161 0.2405
R1150 VSS.n19 VSS.n18 0.2285
R1151 VSS.n28 VSS.n27 0.2285
R1152 VSS.n37 VSS.n36 0.2285
R1153 VSS.n46 VSS.n45 0.2285
R1154 VSS.n55 VSS.n54 0.2285
R1155 VSS.n64 VSS.n63 0.2285
R1156 VSS.n73 VSS.n72 0.2285
R1157 VSS.n82 VSS.n81 0.2285
R1158 VSS.n91 VSS.n90 0.2285
R1159 VSS.n100 VSS.n99 0.2285
R1160 VSS.n109 VSS.n108 0.2285
R1161 VSS.n118 VSS.n117 0.2285
R1162 VSS.n127 VSS.n126 0.2285
R1163 VSS.n136 VSS.n135 0.2285
R1164 VSS.n145 VSS.n144 0.2285
R1165 VSS.n154 VSS.n153 0.2285
R1166 VSS.n25 VSS.n24 0.1925
R1167 VSS.n34 VSS.n33 0.1925
R1168 VSS.n43 VSS.n42 0.1925
R1169 VSS.n52 VSS.n51 0.1925
R1170 VSS.n61 VSS.n60 0.1925
R1171 VSS.n70 VSS.n69 0.1925
R1172 VSS.n79 VSS.n78 0.1925
R1173 VSS.n88 VSS.n87 0.1925
R1174 VSS.n97 VSS.n96 0.1925
R1175 VSS.n106 VSS.n105 0.1925
R1176 VSS.n115 VSS.n114 0.1925
R1177 VSS.n124 VSS.n123 0.1925
R1178 VSS.n133 VSS.n132 0.1925
R1179 VSS.n142 VSS.n141 0.1925
R1180 VSS.n151 VSS.n150 0.1925
R1181 VSS.n160 VSS.n159 0.1925
R1182 VSS.n20 VSS.n19 0.16325
R1183 VSS.n22 VSS.n21 0.16325
R1184 VSS.n29 VSS.n28 0.16325
R1185 VSS.n31 VSS.n30 0.16325
R1186 VSS.n38 VSS.n37 0.16325
R1187 VSS.n40 VSS.n39 0.16325
R1188 VSS.n47 VSS.n46 0.16325
R1189 VSS.n49 VSS.n48 0.16325
R1190 VSS.n56 VSS.n55 0.16325
R1191 VSS.n58 VSS.n57 0.16325
R1192 VSS.n65 VSS.n64 0.16325
R1193 VSS.n67 VSS.n66 0.16325
R1194 VSS.n74 VSS.n73 0.16325
R1195 VSS.n76 VSS.n75 0.16325
R1196 VSS.n83 VSS.n82 0.16325
R1197 VSS.n85 VSS.n84 0.16325
R1198 VSS.n92 VSS.n91 0.16325
R1199 VSS.n94 VSS.n93 0.16325
R1200 VSS.n101 VSS.n100 0.16325
R1201 VSS.n103 VSS.n102 0.16325
R1202 VSS.n110 VSS.n109 0.16325
R1203 VSS.n112 VSS.n111 0.16325
R1204 VSS.n119 VSS.n118 0.16325
R1205 VSS.n121 VSS.n120 0.16325
R1206 VSS.n128 VSS.n127 0.16325
R1207 VSS.n130 VSS.n129 0.16325
R1208 VSS.n137 VSS.n136 0.16325
R1209 VSS.n139 VSS.n138 0.16325
R1210 VSS.n146 VSS.n145 0.16325
R1211 VSS.n148 VSS.n147 0.16325
R1212 VSS.n155 VSS.n154 0.16325
R1213 VSS.n157 VSS.n156 0.16325
R1214 VSS.n18 VSS.n17 0.1085
R1215 VSS.n27 VSS.n26 0.1085
R1216 VSS.n36 VSS.n35 0.1085
R1217 VSS.n45 VSS.n44 0.1085
R1218 VSS.n54 VSS.n53 0.1085
R1219 VSS.n63 VSS.n62 0.1085
R1220 VSS.n72 VSS.n71 0.1085
R1221 VSS.n81 VSS.n80 0.1085
R1222 VSS.n90 VSS.n89 0.1085
R1223 VSS.n99 VSS.n98 0.1085
R1224 VSS.n108 VSS.n107 0.1085
R1225 VSS.n117 VSS.n116 0.1085
R1226 VSS.n126 VSS.n125 0.1085
R1227 VSS.n135 VSS.n134 0.1085
R1228 VSS.n144 VSS.n143 0.1085
R1229 VSS.n153 VSS.n152 0.1085
R1230 VSS.n23 VSS.n22 0.0965
R1231 VSS.n32 VSS.n31 0.0965
R1232 VSS.n41 VSS.n40 0.0965
R1233 VSS.n50 VSS.n49 0.0965
R1234 VSS.n59 VSS.n58 0.0965
R1235 VSS.n68 VSS.n67 0.0965
R1236 VSS.n77 VSS.n76 0.0965
R1237 VSS.n86 VSS.n85 0.0965
R1238 VSS.n95 VSS.n94 0.0965
R1239 VSS.n104 VSS.n103 0.0965
R1240 VSS.n113 VSS.n112 0.0965
R1241 VSS.n122 VSS.n121 0.0965
R1242 VSS.n131 VSS.n130 0.0965
R1243 VSS.n140 VSS.n139 0.0965
R1244 VSS.n149 VSS.n148 0.0965
R1245 VSS.n158 VSS.n157 0.0965
R1246 VSS VSS.n163 0.07925
R1247 VSS.n21 VSS.n20 0.05375
R1248 VSS.n30 VSS.n29 0.05375
R1249 VSS.n39 VSS.n38 0.05375
R1250 VSS.n48 VSS.n47 0.05375
R1251 VSS.n57 VSS.n56 0.05375
R1252 VSS.n66 VSS.n65 0.05375
R1253 VSS.n75 VSS.n74 0.05375
R1254 VSS.n84 VSS.n83 0.05375
R1255 VSS.n93 VSS.n92 0.05375
R1256 VSS.n102 VSS.n101 0.05375
R1257 VSS.n111 VSS.n110 0.05375
R1258 VSS.n120 VSS.n119 0.05375
R1259 VSS.n129 VSS.n128 0.05375
R1260 VSS.n138 VSS.n137 0.05375
R1261 VSS.n147 VSS.n146 0.05375
R1262 VSS.n156 VSS.n155 0.05375
R1263 a_n1204_9238.n1 a_n1204_9238.t19 29.7679
R1264 a_n1204_9238.n30 a_n1204_9238.t4 29.4079
R1265 a_n1204_9238.n28 a_n1204_9238.t32 29.4079
R1266 a_n1204_9238.n26 a_n1204_9238.t18 29.4079
R1267 a_n1204_9238.n24 a_n1204_9238.t16 29.4079
R1268 a_n1204_9238.n22 a_n1204_9238.t29 29.4079
R1269 a_n1204_9238.n20 a_n1204_9238.t28 29.4079
R1270 a_n1204_9238.n18 a_n1204_9238.t36 29.4079
R1271 a_n1204_9238.n16 a_n1204_9238.t13 29.4079
R1272 a_n1204_9238.n14 a_n1204_9238.t12 29.4079
R1273 a_n1204_9238.n12 a_n1204_9238.t30 29.4079
R1274 a_n1204_9238.n10 a_n1204_9238.t38 29.4079
R1275 a_n1204_9238.n8 a_n1204_9238.t15 29.4079
R1276 a_n1204_9238.n6 a_n1204_9238.t14 29.4079
R1277 a_n1204_9238.n4 a_n1204_9238.t33 29.4079
R1278 a_n1204_9238.n2 a_n1204_9238.t39 29.4079
R1279 a_n1204_9238.n31 a_n1204_9238.t34 29.1445
R1280 a_n1204_9238.n29 a_n1204_9238.t20 29.1445
R1281 a_n1204_9238.n27 a_n1204_9238.t35 29.1445
R1282 a_n1204_9238.n25 a_n1204_9238.t10 29.1445
R1283 a_n1204_9238.n23 a_n1204_9238.t9 29.1445
R1284 a_n1204_9238.n21 a_n1204_9238.t22 29.1445
R1285 a_n1204_9238.n19 a_n1204_9238.t21 29.1445
R1286 a_n1204_9238.n17 a_n1204_9238.t7 29.1445
R1287 a_n1204_9238.n15 a_n1204_9238.t6 29.1445
R1288 a_n1204_9238.n13 a_n1204_9238.t24 29.1445
R1289 a_n1204_9238.n11 a_n1204_9238.t23 29.1445
R1290 a_n1204_9238.n9 a_n1204_9238.t37 29.1445
R1291 a_n1204_9238.n7 a_n1204_9238.t8 29.1445
R1292 a_n1204_9238.n5 a_n1204_9238.t17 29.1445
R1293 a_n1204_9238.n3 a_n1204_9238.t27 29.1445
R1294 a_n1204_9238.n1 a_n1204_9238.t26 29.1445
R1295 a_n1204_9238.n33 a_n1204_9238.t11 24.7684
R1296 a_n1204_9238.n33 a_n1204_9238.t31 24.1166
R1297 a_n1204_9238.n34 a_n1204_9238.t5 23.7255
R1298 a_n1204_9238.n34 a_n1204_9238.t25 23.0737
R1299 a_n1204_9238.n34 a_n1204_9238.n33 17.1396
R1300 a_n1204_9238.n32 a_n1204_9238.n31 10.2862
R1301 a_n1204_9238.n35 a_n1204_9238.n34 8.0005
R1302 a_n1204_9238.n32 a_n1204_9238.n0 6.86767
R1303 a_n1204_9238.n2 a_n1204_9238.n1 3.61336
R1304 a_n1204_9238.n4 a_n1204_9238.n3 3.61336
R1305 a_n1204_9238.n6 a_n1204_9238.n5 3.61336
R1306 a_n1204_9238.n8 a_n1204_9238.n7 3.61336
R1307 a_n1204_9238.n10 a_n1204_9238.n9 3.61336
R1308 a_n1204_9238.n12 a_n1204_9238.n11 3.61336
R1309 a_n1204_9238.n14 a_n1204_9238.n13 3.61336
R1310 a_n1204_9238.n16 a_n1204_9238.n15 3.61336
R1311 a_n1204_9238.n18 a_n1204_9238.n17 3.61336
R1312 a_n1204_9238.n20 a_n1204_9238.n19 3.61336
R1313 a_n1204_9238.n22 a_n1204_9238.n21 3.61336
R1314 a_n1204_9238.n24 a_n1204_9238.n23 3.61336
R1315 a_n1204_9238.n26 a_n1204_9238.n25 3.61336
R1316 a_n1204_9238.n28 a_n1204_9238.n27 3.61336
R1317 a_n1204_9238.n30 a_n1204_9238.n29 3.61336
R1318 a_n1204_9238.n36 a_n1204_9238.n35 3.45159
R1319 a_n1204_9238.n0 a_n1204_9238.t2 2.58003
R1320 a_n1204_9238.n0 a_n1204_9238.t3 2.58003
R1321 a_n1204_9238.t1 a_n1204_9238.n36 1.43357
R1322 a_n1204_9238.n36 a_n1204_9238.t0 1.43357
R1323 a_n1204_9238.n3 a_n1204_9238.n2 0.3605
R1324 a_n1204_9238.n5 a_n1204_9238.n4 0.3605
R1325 a_n1204_9238.n7 a_n1204_9238.n6 0.3605
R1326 a_n1204_9238.n9 a_n1204_9238.n8 0.3605
R1327 a_n1204_9238.n11 a_n1204_9238.n10 0.3605
R1328 a_n1204_9238.n13 a_n1204_9238.n12 0.3605
R1329 a_n1204_9238.n15 a_n1204_9238.n14 0.3605
R1330 a_n1204_9238.n17 a_n1204_9238.n16 0.3605
R1331 a_n1204_9238.n19 a_n1204_9238.n18 0.3605
R1332 a_n1204_9238.n21 a_n1204_9238.n20 0.3605
R1333 a_n1204_9238.n23 a_n1204_9238.n22 0.3605
R1334 a_n1204_9238.n25 a_n1204_9238.n24 0.3605
R1335 a_n1204_9238.n27 a_n1204_9238.n26 0.3605
R1336 a_n1204_9238.n29 a_n1204_9238.n28 0.3605
R1337 a_n1204_9238.n31 a_n1204_9238.n30 0.3605
R1338 a_n1204_9238.n35 a_n1204_9238.n32 0.169589
R1339 a_n1204_6886.n1 a_n1204_6886.t25 29.7679
R1340 a_n1204_6886.n30 a_n1204_6886.t14 29.4079
R1341 a_n1204_6886.n28 a_n1204_6886.t36 29.4079
R1342 a_n1204_6886.n26 a_n1204_6886.t24 29.4079
R1343 a_n1204_6886.n24 a_n1204_6886.t22 29.4079
R1344 a_n1204_6886.n22 a_n1204_6886.t34 29.4079
R1345 a_n1204_6886.n20 a_n1204_6886.t33 29.4079
R1346 a_n1204_6886.n18 a_n1204_6886.t6 29.4079
R1347 a_n1204_6886.n16 a_n1204_6886.t18 29.4079
R1348 a_n1204_6886.n14 a_n1204_6886.t17 29.4079
R1349 a_n1204_6886.n12 a_n1204_6886.t35 29.4079
R1350 a_n1204_6886.n10 a_n1204_6886.t9 29.4079
R1351 a_n1204_6886.n8 a_n1204_6886.t20 29.4079
R1352 a_n1204_6886.n6 a_n1204_6886.t19 29.4079
R1353 a_n1204_6886.n4 a_n1204_6886.t37 29.4079
R1354 a_n1204_6886.n2 a_n1204_6886.t10 29.4079
R1355 a_n1204_6886.n31 a_n1204_6886.t30 29.1445
R1356 a_n1204_6886.n29 a_n1204_6886.t13 29.1445
R1357 a_n1204_6886.n27 a_n1204_6886.t31 29.1445
R1358 a_n1204_6886.n25 a_n1204_6886.t7 29.1445
R1359 a_n1204_6886.n23 a_n1204_6886.t5 29.1445
R1360 a_n1204_6886.n21 a_n1204_6886.t23 29.1445
R1361 a_n1204_6886.n19 a_n1204_6886.t21 29.1445
R1362 a_n1204_6886.n17 a_n1204_6886.t39 29.1445
R1363 a_n1204_6886.n15 a_n1204_6886.t38 29.1445
R1364 a_n1204_6886.n13 a_n1204_6886.t27 29.1445
R1365 a_n1204_6886.n11 a_n1204_6886.t26 29.1445
R1366 a_n1204_6886.n9 a_n1204_6886.t32 29.1445
R1367 a_n1204_6886.n7 a_n1204_6886.t4 29.1445
R1368 a_n1204_6886.n5 a_n1204_6886.t11 29.1445
R1369 a_n1204_6886.n3 a_n1204_6886.t29 29.1445
R1370 a_n1204_6886.n1 a_n1204_6886.t28 29.1445
R1371 a_n1204_6886.n33 a_n1204_6886.t16 24.7684
R1372 a_n1204_6886.n33 a_n1204_6886.t12 24.1166
R1373 a_n1204_6886.n34 a_n1204_6886.t15 23.7255
R1374 a_n1204_6886.n34 a_n1204_6886.t8 23.0737
R1375 a_n1204_6886.n34 a_n1204_6886.n33 17.1396
R1376 a_n1204_6886.n32 a_n1204_6886.n31 10.2862
R1377 a_n1204_6886.n35 a_n1204_6886.n34 8.0005
R1378 a_n1204_6886.n32 a_n1204_6886.n0 6.86767
R1379 a_n1204_6886.n2 a_n1204_6886.n1 3.61336
R1380 a_n1204_6886.n4 a_n1204_6886.n3 3.61336
R1381 a_n1204_6886.n6 a_n1204_6886.n5 3.61336
R1382 a_n1204_6886.n8 a_n1204_6886.n7 3.61336
R1383 a_n1204_6886.n10 a_n1204_6886.n9 3.61336
R1384 a_n1204_6886.n12 a_n1204_6886.n11 3.61336
R1385 a_n1204_6886.n14 a_n1204_6886.n13 3.61336
R1386 a_n1204_6886.n16 a_n1204_6886.n15 3.61336
R1387 a_n1204_6886.n18 a_n1204_6886.n17 3.61336
R1388 a_n1204_6886.n20 a_n1204_6886.n19 3.61336
R1389 a_n1204_6886.n22 a_n1204_6886.n21 3.61336
R1390 a_n1204_6886.n24 a_n1204_6886.n23 3.61336
R1391 a_n1204_6886.n26 a_n1204_6886.n25 3.61336
R1392 a_n1204_6886.n28 a_n1204_6886.n27 3.61336
R1393 a_n1204_6886.n30 a_n1204_6886.n29 3.61336
R1394 a_n1204_6886.n36 a_n1204_6886.n35 3.45159
R1395 a_n1204_6886.n0 a_n1204_6886.t3 2.58003
R1396 a_n1204_6886.n0 a_n1204_6886.t2 2.58003
R1397 a_n1204_6886.t1 a_n1204_6886.n36 1.43357
R1398 a_n1204_6886.n36 a_n1204_6886.t0 1.43357
R1399 a_n1204_6886.n3 a_n1204_6886.n2 0.3605
R1400 a_n1204_6886.n5 a_n1204_6886.n4 0.3605
R1401 a_n1204_6886.n7 a_n1204_6886.n6 0.3605
R1402 a_n1204_6886.n9 a_n1204_6886.n8 0.3605
R1403 a_n1204_6886.n11 a_n1204_6886.n10 0.3605
R1404 a_n1204_6886.n13 a_n1204_6886.n12 0.3605
R1405 a_n1204_6886.n15 a_n1204_6886.n14 0.3605
R1406 a_n1204_6886.n17 a_n1204_6886.n16 0.3605
R1407 a_n1204_6886.n19 a_n1204_6886.n18 0.3605
R1408 a_n1204_6886.n21 a_n1204_6886.n20 0.3605
R1409 a_n1204_6886.n23 a_n1204_6886.n22 0.3605
R1410 a_n1204_6886.n25 a_n1204_6886.n24 0.3605
R1411 a_n1204_6886.n27 a_n1204_6886.n26 0.3605
R1412 a_n1204_6886.n29 a_n1204_6886.n28 0.3605
R1413 a_n1204_6886.n31 a_n1204_6886.n30 0.3605
R1414 a_n1204_6886.n35 a_n1204_6886.n32 0.169589
R1415 a_31063_n2146.n18 a_31063_n2146.t32 18.9023
R1416 a_31063_n2146.n0 a_31063_n2146.t11 16.1106
R1417 a_31063_n2146.n18 a_31063_n2146.t33 15.6434
R1418 a_31063_n2146.n2 a_31063_n2146.t5 15.4484
R1419 a_31063_n2146.n3 a_31063_n2146.t9 15.4484
R1420 a_31063_n2146.n6 a_31063_n2146.t14 15.4484
R1421 a_31063_n2146.n7 a_31063_n2146.t3 15.4484
R1422 a_31063_n2146.n10 a_31063_n2146.t1 15.4484
R1423 a_31063_n2146.n11 a_31063_n2146.t8 15.4484
R1424 a_31063_n2146.n14 a_31063_n2146.t10 15.4484
R1425 a_31063_n2146.n15 a_31063_n2146.t2 15.4484
R1426 a_31063_n2146.n30 a_31063_n2146.t12 15.4484
R1427 a_31063_n2146.n27 a_31063_n2146.t4 15.4484
R1428 a_31063_n2146.n26 a_31063_n2146.t6 15.4484
R1429 a_31063_n2146.n23 a_31063_n2146.t15 15.4484
R1430 a_31063_n2146.n22 a_31063_n2146.t13 15.4484
R1431 a_31063_n2146.n19 a_31063_n2146.t7 15.4484
R1432 a_31063_n2146.t0 a_31063_n2146.n31 15.4484
R1433 a_31063_n2146.n0 a_31063_n2146.t25 14.854
R1434 a_31063_n2146.n1 a_31063_n2146.t29 14.854
R1435 a_31063_n2146.n4 a_31063_n2146.t20 14.854
R1436 a_31063_n2146.n5 a_31063_n2146.t16 14.854
R1437 a_31063_n2146.n8 a_31063_n2146.t22 14.854
R1438 a_31063_n2146.n9 a_31063_n2146.t17 14.854
R1439 a_31063_n2146.n12 a_31063_n2146.t21 14.854
R1440 a_31063_n2146.n13 a_31063_n2146.t31 14.854
R1441 a_31063_n2146.n16 a_31063_n2146.t24 14.854
R1442 a_31063_n2146.n17 a_31063_n2146.t27 14.854
R1443 a_31063_n2146.n29 a_31063_n2146.t26 14.854
R1444 a_31063_n2146.n28 a_31063_n2146.t23 14.854
R1445 a_31063_n2146.n25 a_31063_n2146.t19 14.854
R1446 a_31063_n2146.n24 a_31063_n2146.t18 14.854
R1447 a_31063_n2146.n21 a_31063_n2146.t28 14.854
R1448 a_31063_n2146.n20 a_31063_n2146.t30 14.854
R1449 a_31063_n2146.n19 a_31063_n2146.n18 14.5641
R1450 a_31063_n2146.n3 a_31063_n2146.n2 0.746214
R1451 a_31063_n2146.n7 a_31063_n2146.n6 0.746214
R1452 a_31063_n2146.n11 a_31063_n2146.n10 0.746214
R1453 a_31063_n2146.n15 a_31063_n2146.n14 0.746214
R1454 a_31063_n2146.n31 a_31063_n2146.n30 0.746214
R1455 a_31063_n2146.n27 a_31063_n2146.n26 0.746214
R1456 a_31063_n2146.n23 a_31063_n2146.n22 0.746214
R1457 a_31063_n2146.n2 a_31063_n2146.n1 0.662643
R1458 a_31063_n2146.n4 a_31063_n2146.n3 0.662643
R1459 a_31063_n2146.n6 a_31063_n2146.n5 0.662643
R1460 a_31063_n2146.n8 a_31063_n2146.n7 0.662643
R1461 a_31063_n2146.n10 a_31063_n2146.n9 0.662643
R1462 a_31063_n2146.n12 a_31063_n2146.n11 0.662643
R1463 a_31063_n2146.n14 a_31063_n2146.n13 0.662643
R1464 a_31063_n2146.n16 a_31063_n2146.n15 0.662643
R1465 a_31063_n2146.n31 a_31063_n2146.n17 0.662643
R1466 a_31063_n2146.n30 a_31063_n2146.n29 0.662643
R1467 a_31063_n2146.n28 a_31063_n2146.n27 0.662643
R1468 a_31063_n2146.n26 a_31063_n2146.n25 0.662643
R1469 a_31063_n2146.n24 a_31063_n2146.n23 0.662643
R1470 a_31063_n2146.n22 a_31063_n2146.n21 0.662643
R1471 a_31063_n2146.n20 a_31063_n2146.n19 0.662643
R1472 a_31063_n2146.n1 a_31063_n2146.n0 0.4505
R1473 a_31063_n2146.n5 a_31063_n2146.n4 0.4505
R1474 a_31063_n2146.n9 a_31063_n2146.n8 0.4505
R1475 a_31063_n2146.n13 a_31063_n2146.n12 0.4505
R1476 a_31063_n2146.n17 a_31063_n2146.n16 0.4505
R1477 a_31063_n2146.n29 a_31063_n2146.n28 0.4505
R1478 a_31063_n2146.n25 a_31063_n2146.n24 0.4505
R1479 a_31063_n2146.n21 a_31063_n2146.n20 0.4505
R1480 QB12b.n0 QB12b.t1 13.1454
R1481 QB12b.n0 QB12b.t0 9.29658
R1482 QB12b QB12b.n0 4.69014
R1483 RB3.t13 RB3.t42 69.3795
R1484 RB3.t0 RB3.t6 69.3795
R1485 RB3.t47 RB3.t20 69.3795
R1486 RB3.t25 RB3.t19 69.3795
R1487 RB3.t26 RB3.t36 69.3795
R1488 RB3.t45 RB3.t3 69.3795
R1489 RB3.t44 RB3.t16 69.3795
R1490 RB3.t10 RB3.t14 69.3795
R1491 RB3.t28 RB3.t40 69.3795
R1492 RB3.t27 RB3.t39 69.3795
R1493 RB3.t46 RB3.t18 69.3795
R1494 RB3.t7 RB3.t30 69.3795
R1495 RB3.t15 RB3.t43 69.3795
R1496 RB3.t29 RB3.t41 69.3795
R1497 RB3.t1 RB3.t8 69.3795
R1498 RB3.t9 RB3.t31 69.3795
R1499 RB3.n29 RB3.t11 30.2434
R1500 RB3.n27 RB3.t37 30.2434
R1501 RB3.n25 RB3.t35 30.2434
R1502 RB3.n23 RB3.t17 30.2434
R1503 RB3.n21 RB3.t21 30.2434
R1504 RB3.n19 RB3.t33 30.2434
R1505 RB3.n17 RB3.t32 30.2434
R1506 RB3.n15 RB3.t5 30.2434
R1507 RB3.n13 RB3.t23 30.2434
R1508 RB3.n11 RB3.t22 30.2434
R1509 RB3.n9 RB3.t34 30.2434
R1510 RB3.n7 RB3.t2 30.2434
R1511 RB3.n5 RB3.t12 30.2434
R1512 RB3.n3 RB3.t24 30.2434
R1513 RB3.n1 RB3.t38 30.2434
R1514 RB3.n0 RB3.t4 30.2434
R1515 RB3.n2 RB3.n0 21.0176
R1516 RB3.n30 RB3.n29 17.0448
R1517 RB3.n28 RB3.n27 17.0448
R1518 RB3.n26 RB3.n25 17.0448
R1519 RB3.n24 RB3.n23 17.0448
R1520 RB3.n22 RB3.n21 17.0448
R1521 RB3.n20 RB3.n19 17.0448
R1522 RB3.n18 RB3.n17 17.0448
R1523 RB3.n16 RB3.n15 17.0448
R1524 RB3.n14 RB3.n13 17.0448
R1525 RB3.n12 RB3.n11 17.0448
R1526 RB3.n10 RB3.n9 17.0448
R1527 RB3.n8 RB3.n7 17.0448
R1528 RB3.n6 RB3.n5 17.0448
R1529 RB3.n4 RB3.n3 17.0448
R1530 RB3.n2 RB3.n1 17.0448
R1531 RB3.n29 RB3.t13 16.6862
R1532 RB3.n27 RB3.t0 16.6862
R1533 RB3.n25 RB3.t47 16.6862
R1534 RB3.n23 RB3.t25 16.6862
R1535 RB3.n21 RB3.t26 16.6862
R1536 RB3.n19 RB3.t45 16.6862
R1537 RB3.n17 RB3.t44 16.6862
R1538 RB3.n15 RB3.t10 16.6862
R1539 RB3.n13 RB3.t28 16.6862
R1540 RB3.n11 RB3.t27 16.6862
R1541 RB3.n9 RB3.t46 16.6862
R1542 RB3.n7 RB3.t7 16.6862
R1543 RB3.n5 RB3.t15 16.6862
R1544 RB3.n3 RB3.t29 16.6862
R1545 RB3.n1 RB3.t1 16.6862
R1546 RB3.n0 RB3.t9 16.6862
R1547 RB3 RB3.n30 5.77818
R1548 RB3.n4 RB3.n2 3.97336
R1549 RB3.n6 RB3.n4 3.97336
R1550 RB3.n8 RB3.n6 3.97336
R1551 RB3.n10 RB3.n8 3.97336
R1552 RB3.n12 RB3.n10 3.97336
R1553 RB3.n14 RB3.n12 3.97336
R1554 RB3.n16 RB3.n14 3.97336
R1555 RB3.n18 RB3.n16 3.97336
R1556 RB3.n20 RB3.n18 3.97336
R1557 RB3.n22 RB3.n20 3.97336
R1558 RB3.n24 RB3.n22 3.97336
R1559 RB3.n26 RB3.n24 3.97336
R1560 RB3.n28 RB3.n26 3.97336
R1561 RB3.n30 RB3.n28 3.97336
R1562 RA8.t1 RA8.t25 70.3934
R1563 RA8.t28 RA8.t35 70.3934
R1564 RA8.t27 RA8.t16 70.3934
R1565 RA8.t42 RA8.t14 70.3934
R1566 RA8.t44 RA8.t23 70.3934
R1567 RA8.t8 RA8.t30 70.3934
R1568 RA8.t24 RA8.t0 70.3934
R1569 RA8.t39 RA8.t12 70.3934
R1570 RA8.t45 RA8.t20 70.3934
R1571 RA8.t10 RA8.t34 70.3934
R1572 RA8.t9 RA8.t32 70.3934
R1573 RA8.t41 RA8.t2 70.3934
R1574 RA8.t47 RA8.t22 70.3934
R1575 RA8.t13 RA8.t37 70.3934
R1576 RA8.t11 RA8.t36 70.3934
R1577 RA8.t26 RA8.t15 70.3934
R1578 RA8.n29 RA8.t1 31.2862
R1579 RA8.n27 RA8.t28 31.2862
R1580 RA8.n25 RA8.t27 31.2862
R1581 RA8.n23 RA8.t42 31.2862
R1582 RA8.n21 RA8.t44 31.2862
R1583 RA8.n19 RA8.t8 31.2862
R1584 RA8.n17 RA8.t24 31.2862
R1585 RA8.n15 RA8.t39 31.2862
R1586 RA8.n13 RA8.t45 31.2862
R1587 RA8.n11 RA8.t10 31.2862
R1588 RA8.n9 RA8.t9 31.2862
R1589 RA8.n7 RA8.t41 31.2862
R1590 RA8.n5 RA8.t47 31.2862
R1591 RA8.n3 RA8.t13 31.2862
R1592 RA8.n1 RA8.t11 31.2862
R1593 RA8.n0 RA8.t26 31.2862
R1594 RA8.n2 RA8.n0 21.0181
R1595 RA8.n30 RA8.n29 17.0453
R1596 RA8.n28 RA8.n27 17.0453
R1597 RA8.n26 RA8.n25 17.0453
R1598 RA8.n24 RA8.n23 17.0453
R1599 RA8.n22 RA8.n21 17.0453
R1600 RA8.n20 RA8.n19 17.0453
R1601 RA8.n18 RA8.n17 17.0453
R1602 RA8.n16 RA8.n15 17.0453
R1603 RA8.n14 RA8.n13 17.0453
R1604 RA8.n12 RA8.n11 17.0453
R1605 RA8.n10 RA8.n9 17.0453
R1606 RA8.n8 RA8.n7 17.0453
R1607 RA8.n6 RA8.n5 17.0453
R1608 RA8.n4 RA8.n3 17.0453
R1609 RA8.n2 RA8.n1 17.0453
R1610 RA8.n29 RA8.t46 15.6434
R1611 RA8.n27 RA8.t21 15.6434
R1612 RA8.n25 RA8.t19 15.6434
R1613 RA8.n23 RA8.t33 15.6434
R1614 RA8.n21 RA8.t38 15.6434
R1615 RA8.n19 RA8.t3 15.6434
R1616 RA8.n17 RA8.t17 15.6434
R1617 RA8.n15 RA8.t29 15.6434
R1618 RA8.n13 RA8.t40 15.6434
R1619 RA8.n11 RA8.t5 15.6434
R1620 RA8.n9 RA8.t4 15.6434
R1621 RA8.n7 RA8.t31 15.6434
R1622 RA8.n5 RA8.t43 15.6434
R1623 RA8.n3 RA8.t7 15.6434
R1624 RA8.n1 RA8.t6 15.6434
R1625 RA8.n0 RA8.t18 15.6434
R1626 RA8 RA8.n30 4.49729
R1627 RA8.n4 RA8.n2 3.97336
R1628 RA8.n6 RA8.n4 3.97336
R1629 RA8.n8 RA8.n6 3.97336
R1630 RA8.n10 RA8.n8 3.97336
R1631 RA8.n12 RA8.n10 3.97336
R1632 RA8.n14 RA8.n12 3.97336
R1633 RA8.n16 RA8.n14 3.97336
R1634 RA8.n18 RA8.n16 3.97336
R1635 RA8.n20 RA8.n18 3.97336
R1636 RA8.n22 RA8.n20 3.97336
R1637 RA8.n24 RA8.n22 3.97336
R1638 RA8.n26 RA8.n24 3.97336
R1639 RA8.n28 RA8.n26 3.97336
R1640 RA8.n30 RA8.n28 3.97336
R1641 a_15961_n862.n22 a_15961_n862.t32 18.9023
R1642 a_15961_n862.n0 a_15961_n862.t5 16.1132
R1643 a_15961_n862.n22 a_15961_n862.t33 15.6434
R1644 a_15961_n862.n2 a_15961_n862.t10 15.4511
R1645 a_15961_n862.n3 a_15961_n862.t4 15.4511
R1646 a_15961_n862.n6 a_15961_n862.t3 15.4511
R1647 a_15961_n862.n7 a_15961_n862.t15 15.4511
R1648 a_15961_n862.n10 a_15961_n862.t20 15.4511
R1649 a_15961_n862.n11 a_15961_n862.t16 15.4511
R1650 a_15961_n862.n14 a_15961_n862.t8 15.4511
R1651 a_15961_n862.n15 a_15961_n862.t12 15.4511
R1652 a_15961_n862.n18 a_15961_n862.t2 15.4511
R1653 a_15961_n862.n19 a_15961_n862.t7 15.4511
R1654 a_15961_n862.n30 a_15961_n862.t11 15.4511
R1655 a_15961_n862.n27 a_15961_n862.t1 15.4511
R1656 a_15961_n862.n26 a_15961_n862.t9 15.4511
R1657 a_15961_n862.n23 a_15961_n862.t6 15.4511
R1658 a_15961_n862.t0 a_15961_n862.n31 15.4511
R1659 a_15961_n862.n0 a_15961_n862.t13 14.8566
R1660 a_15961_n862.n1 a_15961_n862.t19 14.8566
R1661 a_15961_n862.n4 a_15961_n862.t17 14.8566
R1662 a_15961_n862.n5 a_15961_n862.t18 14.8566
R1663 a_15961_n862.n8 a_15961_n862.t21 14.8566
R1664 a_15961_n862.n9 a_15961_n862.t28 14.8566
R1665 a_15961_n862.n12 a_15961_n862.t24 14.8566
R1666 a_15961_n862.n13 a_15961_n862.t31 14.8566
R1667 a_15961_n862.n16 a_15961_n862.t25 14.8566
R1668 a_15961_n862.n17 a_15961_n862.t27 14.8566
R1669 a_15961_n862.n20 a_15961_n862.t29 14.8566
R1670 a_15961_n862.n21 a_15961_n862.t14 14.8566
R1671 a_15961_n862.n29 a_15961_n862.t22 14.8566
R1672 a_15961_n862.n28 a_15961_n862.t23 14.8566
R1673 a_15961_n862.n25 a_15961_n862.t26 14.8566
R1674 a_15961_n862.n24 a_15961_n862.t30 14.8566
R1675 a_15961_n862.n23 a_15961_n862.n22 14.5641
R1676 a_15961_n862.n3 a_15961_n862.n2 0.746214
R1677 a_15961_n862.n7 a_15961_n862.n6 0.746214
R1678 a_15961_n862.n11 a_15961_n862.n10 0.746214
R1679 a_15961_n862.n15 a_15961_n862.n14 0.746214
R1680 a_15961_n862.n19 a_15961_n862.n18 0.746214
R1681 a_15961_n862.n31 a_15961_n862.n30 0.746214
R1682 a_15961_n862.n27 a_15961_n862.n26 0.746214
R1683 a_15961_n862.n2 a_15961_n862.n1 0.662643
R1684 a_15961_n862.n4 a_15961_n862.n3 0.662643
R1685 a_15961_n862.n6 a_15961_n862.n5 0.662643
R1686 a_15961_n862.n8 a_15961_n862.n7 0.662643
R1687 a_15961_n862.n10 a_15961_n862.n9 0.662643
R1688 a_15961_n862.n12 a_15961_n862.n11 0.662643
R1689 a_15961_n862.n14 a_15961_n862.n13 0.662643
R1690 a_15961_n862.n16 a_15961_n862.n15 0.662643
R1691 a_15961_n862.n18 a_15961_n862.n17 0.662643
R1692 a_15961_n862.n20 a_15961_n862.n19 0.662643
R1693 a_15961_n862.n31 a_15961_n862.n21 0.662643
R1694 a_15961_n862.n30 a_15961_n862.n29 0.662643
R1695 a_15961_n862.n28 a_15961_n862.n27 0.662643
R1696 a_15961_n862.n26 a_15961_n862.n25 0.662643
R1697 a_15961_n862.n24 a_15961_n862.n23 0.662643
R1698 a_15961_n862.n1 a_15961_n862.n0 0.4505
R1699 a_15961_n862.n5 a_15961_n862.n4 0.4505
R1700 a_15961_n862.n9 a_15961_n862.n8 0.4505
R1701 a_15961_n862.n13 a_15961_n862.n12 0.4505
R1702 a_15961_n862.n17 a_15961_n862.n16 0.4505
R1703 a_15961_n862.n21 a_15961_n862.n20 0.4505
R1704 a_15961_n862.n29 a_15961_n862.n28 0.4505
R1705 a_15961_n862.n25 a_15961_n862.n24 0.4505
R1706 a_n884_5318.n1 a_n884_5318.t27 29.9245
R1707 a_n884_5318.n30 a_n884_5318.t15 29.3395
R1708 a_n884_5318.n28 a_n884_5318.t7 29.3395
R1709 a_n884_5318.n26 a_n884_5318.t26 29.3395
R1710 a_n884_5318.n24 a_n884_5318.t25 29.3395
R1711 a_n884_5318.n22 a_n884_5318.t5 29.3395
R1712 a_n884_5318.n20 a_n884_5318.t35 29.3395
R1713 a_n884_5318.n18 a_n884_5318.t10 29.3395
R1714 a_n884_5318.n16 a_n884_5318.t21 29.3395
R1715 a_n884_5318.n14 a_n884_5318.t19 29.3395
R1716 a_n884_5318.n12 a_n884_5318.t6 29.3395
R1717 a_n884_5318.n10 a_n884_5318.t12 29.3395
R1718 a_n884_5318.n8 a_n884_5318.t24 29.3395
R1719 a_n884_5318.n6 a_n884_5318.t23 29.3395
R1720 a_n884_5318.n4 a_n884_5318.t8 29.3395
R1721 a_n884_5318.n2 a_n884_5318.t14 29.3395
R1722 a_n884_5318.n31 a_n884_5318.t9 27.973
R1723 a_n884_5318.n29 a_n884_5318.t29 27.973
R1724 a_n884_5318.n27 a_n884_5318.t11 27.973
R1725 a_n884_5318.n25 a_n884_5318.t22 27.973
R1726 a_n884_5318.n23 a_n884_5318.t20 27.973
R1727 a_n884_5318.n21 a_n884_5318.t31 27.973
R1728 a_n884_5318.n19 a_n884_5318.t30 27.973
R1729 a_n884_5318.n17 a_n884_5318.t17 27.973
R1730 a_n884_5318.n15 a_n884_5318.t16 27.973
R1731 a_n884_5318.n13 a_n884_5318.t33 27.973
R1732 a_n884_5318.n11 a_n884_5318.t32 27.973
R1733 a_n884_5318.n9 a_n884_5318.t13 27.973
R1734 a_n884_5318.n7 a_n884_5318.t18 27.973
R1735 a_n884_5318.n5 a_n884_5318.t28 27.973
R1736 a_n884_5318.n3 a_n884_5318.t4 27.973
R1737 a_n884_5318.n1 a_n884_5318.t34 27.973
R1738 a_n884_5318.n32 a_n884_5318.n31 10.1914
R1739 a_n884_5318.n33 a_n884_5318.n32 7.10205
R1740 a_n884_5318.n2 a_n884_5318.n1 3.38836
R1741 a_n884_5318.n4 a_n884_5318.n3 3.38836
R1742 a_n884_5318.n6 a_n884_5318.n5 3.38836
R1743 a_n884_5318.n8 a_n884_5318.n7 3.38836
R1744 a_n884_5318.n10 a_n884_5318.n9 3.38836
R1745 a_n884_5318.n12 a_n884_5318.n11 3.38836
R1746 a_n884_5318.n14 a_n884_5318.n13 3.38836
R1747 a_n884_5318.n16 a_n884_5318.n15 3.38836
R1748 a_n884_5318.n18 a_n884_5318.n17 3.38836
R1749 a_n884_5318.n20 a_n884_5318.n19 3.38836
R1750 a_n884_5318.n22 a_n884_5318.n21 3.38836
R1751 a_n884_5318.n24 a_n884_5318.n23 3.38836
R1752 a_n884_5318.n26 a_n884_5318.n25 3.38836
R1753 a_n884_5318.n28 a_n884_5318.n27 3.38836
R1754 a_n884_5318.n30 a_n884_5318.n29 3.38836
R1755 a_n884_5318.t0 a_n884_5318.n33 3.00946
R1756 a_n884_5318.n32 a_n884_5318.n0 2.63313
R1757 a_n884_5318.n33 a_n884_5318.t1 2.44528
R1758 a_n884_5318.n0 a_n884_5318.t2 1.67214
R1759 a_n884_5318.n0 a_n884_5318.t3 1.35871
R1760 a_n884_5318.n3 a_n884_5318.n2 0.5855
R1761 a_n884_5318.n5 a_n884_5318.n4 0.5855
R1762 a_n884_5318.n7 a_n884_5318.n6 0.5855
R1763 a_n884_5318.n9 a_n884_5318.n8 0.5855
R1764 a_n884_5318.n11 a_n884_5318.n10 0.5855
R1765 a_n884_5318.n13 a_n884_5318.n12 0.5855
R1766 a_n884_5318.n15 a_n884_5318.n14 0.5855
R1767 a_n884_5318.n17 a_n884_5318.n16 0.5855
R1768 a_n884_5318.n19 a_n884_5318.n18 0.5855
R1769 a_n884_5318.n21 a_n884_5318.n20 0.5855
R1770 a_n884_5318.n23 a_n884_5318.n22 0.5855
R1771 a_n884_5318.n25 a_n884_5318.n24 0.5855
R1772 a_n884_5318.n27 a_n884_5318.n26 0.5855
R1773 a_n884_5318.n29 a_n884_5318.n28 0.5855
R1774 a_n884_5318.n31 a_n884_5318.n30 0.5855
R1775 a_n1204_n170.n1 a_n1204_n170.t20 29.7679
R1776 a_n1204_n170.n30 a_n1204_n170.t7 29.4079
R1777 a_n1204_n170.n28 a_n1204_n170.t37 29.4079
R1778 a_n1204_n170.n26 a_n1204_n170.t18 29.4079
R1779 a_n1204_n170.n24 a_n1204_n170.t17 29.4079
R1780 a_n1204_n170.n22 a_n1204_n170.t33 29.4079
R1781 a_n1204_n170.n20 a_n1204_n170.t32 29.4079
R1782 a_n1204_n170.n18 a_n1204_n170.t39 29.4079
R1783 a_n1204_n170.n16 a_n1204_n170.t14 29.4079
R1784 a_n1204_n170.n14 a_n1204_n170.t13 29.4079
R1785 a_n1204_n170.n12 a_n1204_n170.t35 29.4079
R1786 a_n1204_n170.n10 a_n1204_n170.t5 29.4079
R1787 a_n1204_n170.n8 a_n1204_n170.t16 29.4079
R1788 a_n1204_n170.n6 a_n1204_n170.t15 29.4079
R1789 a_n1204_n170.n4 a_n1204_n170.t38 29.4079
R1790 a_n1204_n170.n2 a_n1204_n170.t6 29.4079
R1791 a_n1204_n170.n31 a_n1204_n170.t8 29.1445
R1792 a_n1204_n170.n29 a_n1204_n170.t36 29.1445
R1793 a_n1204_n170.n27 a_n1204_n170.t29 29.1445
R1794 a_n1204_n170.n25 a_n1204_n170.t27 29.1445
R1795 a_n1204_n170.n23 a_n1204_n170.t30 29.1445
R1796 a_n1204_n170.n21 a_n1204_n170.t11 29.1445
R1797 a_n1204_n170.n19 a_n1204_n170.t23 29.1445
R1798 a_n1204_n170.n17 a_n1204_n170.t10 29.1445
R1799 a_n1204_n170.n15 a_n1204_n170.t21 29.1445
R1800 a_n1204_n170.n13 a_n1204_n170.t19 29.1445
R1801 a_n1204_n170.n11 a_n1204_n170.t26 29.1445
R1802 a_n1204_n170.n9 a_n1204_n170.t22 29.1445
R1803 a_n1204_n170.n7 a_n1204_n170.t25 29.1445
R1804 a_n1204_n170.n5 a_n1204_n170.t31 29.1445
R1805 a_n1204_n170.n3 a_n1204_n170.t28 29.1445
R1806 a_n1204_n170.n1 a_n1204_n170.t34 29.1445
R1807 a_n1204_n170.n33 a_n1204_n170.t12 24.7684
R1808 a_n1204_n170.n33 a_n1204_n170.t24 24.1166
R1809 a_n1204_n170.n34 a_n1204_n170.t9 23.7255
R1810 a_n1204_n170.n34 a_n1204_n170.t4 23.0737
R1811 a_n1204_n170.n34 a_n1204_n170.n33 17.1396
R1812 a_n1204_n170.n32 a_n1204_n170.n31 10.2862
R1813 a_n1204_n170.n35 a_n1204_n170.n34 8.0005
R1814 a_n1204_n170.n32 a_n1204_n170.n0 6.86767
R1815 a_n1204_n170.n2 a_n1204_n170.n1 3.61336
R1816 a_n1204_n170.n4 a_n1204_n170.n3 3.61336
R1817 a_n1204_n170.n6 a_n1204_n170.n5 3.61336
R1818 a_n1204_n170.n8 a_n1204_n170.n7 3.61336
R1819 a_n1204_n170.n10 a_n1204_n170.n9 3.61336
R1820 a_n1204_n170.n12 a_n1204_n170.n11 3.61336
R1821 a_n1204_n170.n14 a_n1204_n170.n13 3.61336
R1822 a_n1204_n170.n16 a_n1204_n170.n15 3.61336
R1823 a_n1204_n170.n18 a_n1204_n170.n17 3.61336
R1824 a_n1204_n170.n20 a_n1204_n170.n19 3.61336
R1825 a_n1204_n170.n22 a_n1204_n170.n21 3.61336
R1826 a_n1204_n170.n24 a_n1204_n170.n23 3.61336
R1827 a_n1204_n170.n26 a_n1204_n170.n25 3.61336
R1828 a_n1204_n170.n28 a_n1204_n170.n27 3.61336
R1829 a_n1204_n170.n30 a_n1204_n170.n29 3.61336
R1830 a_n1204_n170.n36 a_n1204_n170.n35 3.45159
R1831 a_n1204_n170.n0 a_n1204_n170.t3 2.58003
R1832 a_n1204_n170.n0 a_n1204_n170.t2 2.58003
R1833 a_n1204_n170.t1 a_n1204_n170.n36 1.43357
R1834 a_n1204_n170.n36 a_n1204_n170.t0 1.43357
R1835 a_n1204_n170.n3 a_n1204_n170.n2 0.3605
R1836 a_n1204_n170.n5 a_n1204_n170.n4 0.3605
R1837 a_n1204_n170.n7 a_n1204_n170.n6 0.3605
R1838 a_n1204_n170.n9 a_n1204_n170.n8 0.3605
R1839 a_n1204_n170.n11 a_n1204_n170.n10 0.3605
R1840 a_n1204_n170.n13 a_n1204_n170.n12 0.3605
R1841 a_n1204_n170.n15 a_n1204_n170.n14 0.3605
R1842 a_n1204_n170.n17 a_n1204_n170.n16 0.3605
R1843 a_n1204_n170.n19 a_n1204_n170.n18 0.3605
R1844 a_n1204_n170.n21 a_n1204_n170.n20 0.3605
R1845 a_n1204_n170.n23 a_n1204_n170.n22 0.3605
R1846 a_n1204_n170.n25 a_n1204_n170.n24 0.3605
R1847 a_n1204_n170.n27 a_n1204_n170.n26 0.3605
R1848 a_n1204_n170.n29 a_n1204_n170.n28 0.3605
R1849 a_n1204_n170.n31 a_n1204_n170.n30 0.3605
R1850 a_n1204_n170.n35 a_n1204_n170.n32 0.169589
R1851 a_n884_n170.n1 a_n884_n170.t20 29.9245
R1852 a_n884_n170.n30 a_n884_n170.t12 29.3395
R1853 a_n884_n170.n28 a_n884_n170.t33 29.3395
R1854 a_n884_n170.n26 a_n884_n170.t16 29.3395
R1855 a_n884_n170.n24 a_n884_n170.t29 29.3395
R1856 a_n884_n170.n22 a_n884_n170.t13 29.3395
R1857 a_n884_n170.n20 a_n884_n170.t24 29.3395
R1858 a_n884_n170.n18 a_n884_n170.t15 29.3395
R1859 a_n884_n170.n16 a_n884_n170.t11 29.3395
R1860 a_n884_n170.n14 a_n884_n170.t17 29.3395
R1861 a_n884_n170.n12 a_n884_n170.t31 29.3395
R1862 a_n884_n170.n10 a_n884_n170.t21 29.3395
R1863 a_n884_n170.n8 a_n884_n170.t14 29.3395
R1864 a_n884_n170.n6 a_n884_n170.t27 29.3395
R1865 a_n884_n170.n4 a_n884_n170.t22 29.3395
R1866 a_n884_n170.n2 a_n884_n170.t30 29.3395
R1867 a_n884_n170.n31 a_n884_n170.t32 27.973
R1868 a_n884_n170.n29 a_n884_n170.t10 27.973
R1869 a_n884_n170.n27 a_n884_n170.t34 27.973
R1870 a_n884_n170.n25 a_n884_n170.t8 27.973
R1871 a_n884_n170.n23 a_n884_n170.t7 27.973
R1872 a_n884_n170.n21 a_n884_n170.t19 27.973
R1873 a_n884_n170.n19 a_n884_n170.t18 27.973
R1874 a_n884_n170.n17 a_n884_n170.t5 27.973
R1875 a_n884_n170.n15 a_n884_n170.t4 27.973
R1876 a_n884_n170.n13 a_n884_n170.t25 27.973
R1877 a_n884_n170.n11 a_n884_n170.t23 27.973
R1878 a_n884_n170.n9 a_n884_n170.t35 27.973
R1879 a_n884_n170.n7 a_n884_n170.t6 27.973
R1880 a_n884_n170.n5 a_n884_n170.t9 27.973
R1881 a_n884_n170.n3 a_n884_n170.t28 27.973
R1882 a_n884_n170.n1 a_n884_n170.t26 27.973
R1883 a_n884_n170.n32 a_n884_n170.n31 10.1914
R1884 a_n884_n170.n32 a_n884_n170.n0 7.10204
R1885 a_n884_n170.n2 a_n884_n170.n1 3.38836
R1886 a_n884_n170.n4 a_n884_n170.n3 3.38836
R1887 a_n884_n170.n6 a_n884_n170.n5 3.38836
R1888 a_n884_n170.n8 a_n884_n170.n7 3.38836
R1889 a_n884_n170.n10 a_n884_n170.n9 3.38836
R1890 a_n884_n170.n12 a_n884_n170.n11 3.38836
R1891 a_n884_n170.n14 a_n884_n170.n13 3.38836
R1892 a_n884_n170.n16 a_n884_n170.n15 3.38836
R1893 a_n884_n170.n18 a_n884_n170.n17 3.38836
R1894 a_n884_n170.n20 a_n884_n170.n19 3.38836
R1895 a_n884_n170.n22 a_n884_n170.n21 3.38836
R1896 a_n884_n170.n24 a_n884_n170.n23 3.38836
R1897 a_n884_n170.n26 a_n884_n170.n25 3.38836
R1898 a_n884_n170.n28 a_n884_n170.n27 3.38836
R1899 a_n884_n170.n30 a_n884_n170.n29 3.38836
R1900 a_n884_n170.n0 a_n884_n170.t3 3.00946
R1901 a_n884_n170.n33 a_n884_n170.n32 2.63313
R1902 a_n884_n170.n0 a_n884_n170.t2 2.44528
R1903 a_n884_n170.t1 a_n884_n170.n33 1.67214
R1904 a_n884_n170.n33 a_n884_n170.t0 1.35871
R1905 a_n884_n170.n3 a_n884_n170.n2 0.5855
R1906 a_n884_n170.n5 a_n884_n170.n4 0.5855
R1907 a_n884_n170.n7 a_n884_n170.n6 0.5855
R1908 a_n884_n170.n9 a_n884_n170.n8 0.5855
R1909 a_n884_n170.n11 a_n884_n170.n10 0.5855
R1910 a_n884_n170.n13 a_n884_n170.n12 0.5855
R1911 a_n884_n170.n15 a_n884_n170.n14 0.5855
R1912 a_n884_n170.n17 a_n884_n170.n16 0.5855
R1913 a_n884_n170.n19 a_n884_n170.n18 0.5855
R1914 a_n884_n170.n21 a_n884_n170.n20 0.5855
R1915 a_n884_n170.n23 a_n884_n170.n22 0.5855
R1916 a_n884_n170.n25 a_n884_n170.n24 0.5855
R1917 a_n884_n170.n27 a_n884_n170.n26 0.5855
R1918 a_n884_n170.n29 a_n884_n170.n28 0.5855
R1919 a_n884_n170.n31 a_n884_n170.n30 0.5855
R1920 a_1399_n2146.n18 a_1399_n2146.t32 18.9023
R1921 a_1399_n2146.n0 a_1399_n2146.t11 16.1106
R1922 a_1399_n2146.n18 a_1399_n2146.t33 15.6434
R1923 a_1399_n2146.n2 a_1399_n2146.t5 15.4484
R1924 a_1399_n2146.n3 a_1399_n2146.t9 15.4484
R1925 a_1399_n2146.n6 a_1399_n2146.t21 15.4484
R1926 a_1399_n2146.n7 a_1399_n2146.t3 15.4484
R1927 a_1399_n2146.n10 a_1399_n2146.t1 15.4484
R1928 a_1399_n2146.n11 a_1399_n2146.t8 15.4484
R1929 a_1399_n2146.n14 a_1399_n2146.t10 15.4484
R1930 a_1399_n2146.n15 a_1399_n2146.t2 15.4484
R1931 a_1399_n2146.n30 a_1399_n2146.t12 15.4484
R1932 a_1399_n2146.n27 a_1399_n2146.t4 15.4484
R1933 a_1399_n2146.n26 a_1399_n2146.t6 15.4484
R1934 a_1399_n2146.n23 a_1399_n2146.t14 15.4484
R1935 a_1399_n2146.n22 a_1399_n2146.t13 15.4484
R1936 a_1399_n2146.n19 a_1399_n2146.t7 15.4484
R1937 a_1399_n2146.t0 a_1399_n2146.n31 15.4484
R1938 a_1399_n2146.n0 a_1399_n2146.t20 14.854
R1939 a_1399_n2146.n1 a_1399_n2146.t18 14.854
R1940 a_1399_n2146.n4 a_1399_n2146.t24 14.854
R1941 a_1399_n2146.n5 a_1399_n2146.t31 14.854
R1942 a_1399_n2146.n8 a_1399_n2146.t29 14.854
R1943 a_1399_n2146.n9 a_1399_n2146.t16 14.854
R1944 a_1399_n2146.n12 a_1399_n2146.t25 14.854
R1945 a_1399_n2146.n13 a_1399_n2146.t22 14.854
R1946 a_1399_n2146.n16 a_1399_n2146.t26 14.854
R1947 a_1399_n2146.n17 a_1399_n2146.t15 14.854
R1948 a_1399_n2146.n29 a_1399_n2146.t17 14.854
R1949 a_1399_n2146.n28 a_1399_n2146.t19 14.854
R1950 a_1399_n2146.n25 a_1399_n2146.t23 14.854
R1951 a_1399_n2146.n24 a_1399_n2146.t30 14.854
R1952 a_1399_n2146.n21 a_1399_n2146.t27 14.854
R1953 a_1399_n2146.n20 a_1399_n2146.t28 14.854
R1954 a_1399_n2146.n19 a_1399_n2146.n18 14.5641
R1955 a_1399_n2146.n3 a_1399_n2146.n2 0.746214
R1956 a_1399_n2146.n7 a_1399_n2146.n6 0.746214
R1957 a_1399_n2146.n11 a_1399_n2146.n10 0.746214
R1958 a_1399_n2146.n15 a_1399_n2146.n14 0.746214
R1959 a_1399_n2146.n31 a_1399_n2146.n30 0.746214
R1960 a_1399_n2146.n27 a_1399_n2146.n26 0.746214
R1961 a_1399_n2146.n23 a_1399_n2146.n22 0.746214
R1962 a_1399_n2146.n2 a_1399_n2146.n1 0.662643
R1963 a_1399_n2146.n4 a_1399_n2146.n3 0.662643
R1964 a_1399_n2146.n6 a_1399_n2146.n5 0.662643
R1965 a_1399_n2146.n8 a_1399_n2146.n7 0.662643
R1966 a_1399_n2146.n10 a_1399_n2146.n9 0.662643
R1967 a_1399_n2146.n12 a_1399_n2146.n11 0.662643
R1968 a_1399_n2146.n14 a_1399_n2146.n13 0.662643
R1969 a_1399_n2146.n16 a_1399_n2146.n15 0.662643
R1970 a_1399_n2146.n31 a_1399_n2146.n17 0.662643
R1971 a_1399_n2146.n30 a_1399_n2146.n29 0.662643
R1972 a_1399_n2146.n28 a_1399_n2146.n27 0.662643
R1973 a_1399_n2146.n26 a_1399_n2146.n25 0.662643
R1974 a_1399_n2146.n24 a_1399_n2146.n23 0.662643
R1975 a_1399_n2146.n22 a_1399_n2146.n21 0.662643
R1976 a_1399_n2146.n20 a_1399_n2146.n19 0.662643
R1977 a_1399_n2146.n1 a_1399_n2146.n0 0.4505
R1978 a_1399_n2146.n5 a_1399_n2146.n4 0.4505
R1979 a_1399_n2146.n9 a_1399_n2146.n8 0.4505
R1980 a_1399_n2146.n13 a_1399_n2146.n12 0.4505
R1981 a_1399_n2146.n17 a_1399_n2146.n16 0.4505
R1982 a_1399_n2146.n29 a_1399_n2146.n28 0.4505
R1983 a_1399_n2146.n25 a_1399_n2146.n24 0.4505
R1984 a_1399_n2146.n21 a_1399_n2146.n20 0.4505
R1985 a_n1204_2966.n1 a_n1204_2966.t37 29.7679
R1986 a_n1204_2966.n30 a_n1204_2966.t21 29.4079
R1987 a_n1204_2966.n28 a_n1204_2966.t13 29.4079
R1988 a_n1204_2966.n26 a_n1204_2966.t36 29.4079
R1989 a_n1204_2966.n24 a_n1204_2966.t35 29.4079
R1990 a_n1204_2966.n22 a_n1204_2966.t11 29.4079
R1991 a_n1204_2966.n20 a_n1204_2966.t10 29.4079
R1992 a_n1204_2966.n18 a_n1204_2966.t17 29.4079
R1993 a_n1204_2966.n16 a_n1204_2966.t32 29.4079
R1994 a_n1204_2966.n14 a_n1204_2966.t30 29.4079
R1995 a_n1204_2966.n12 a_n1204_2966.t12 29.4079
R1996 a_n1204_2966.n10 a_n1204_2966.t18 29.4079
R1997 a_n1204_2966.n8 a_n1204_2966.t34 29.4079
R1998 a_n1204_2966.n6 a_n1204_2966.t33 29.4079
R1999 a_n1204_2966.n4 a_n1204_2966.t14 29.4079
R2000 a_n1204_2966.n2 a_n1204_2966.t20 29.4079
R2001 a_n1204_2966.n31 a_n1204_2966.t15 29.1445
R2002 a_n1204_2966.n29 a_n1204_2966.t39 29.1445
R2003 a_n1204_2966.n27 a_n1204_2966.t16 29.1445
R2004 a_n1204_2966.n25 a_n1204_2966.t31 29.1445
R2005 a_n1204_2966.n23 a_n1204_2966.t29 29.1445
R2006 a_n1204_2966.n21 a_n1204_2966.t5 29.1445
R2007 a_n1204_2966.n19 a_n1204_2966.t4 29.1445
R2008 a_n1204_2966.n17 a_n1204_2966.t25 29.1445
R2009 a_n1204_2966.n15 a_n1204_2966.t24 29.1445
R2010 a_n1204_2966.n13 a_n1204_2966.t7 29.1445
R2011 a_n1204_2966.n11 a_n1204_2966.t6 29.1445
R2012 a_n1204_2966.n9 a_n1204_2966.t19 29.1445
R2013 a_n1204_2966.n7 a_n1204_2966.t26 29.1445
R2014 a_n1204_2966.n5 a_n1204_2966.t38 29.1445
R2015 a_n1204_2966.n3 a_n1204_2966.t9 29.1445
R2016 a_n1204_2966.n1 a_n1204_2966.t8 29.1445
R2017 a_n1204_2966.n33 a_n1204_2966.t28 24.7684
R2018 a_n1204_2966.n33 a_n1204_2966.t27 24.1166
R2019 a_n1204_2966.n34 a_n1204_2966.t23 23.7255
R2020 a_n1204_2966.n34 a_n1204_2966.t22 23.0737
R2021 a_n1204_2966.n34 a_n1204_2966.n33 17.1396
R2022 a_n1204_2966.n32 a_n1204_2966.n31 10.2862
R2023 a_n1204_2966.n35 a_n1204_2966.n34 8.0005
R2024 a_n1204_2966.n32 a_n1204_2966.n0 6.86767
R2025 a_n1204_2966.n2 a_n1204_2966.n1 3.61336
R2026 a_n1204_2966.n4 a_n1204_2966.n3 3.61336
R2027 a_n1204_2966.n6 a_n1204_2966.n5 3.61336
R2028 a_n1204_2966.n8 a_n1204_2966.n7 3.61336
R2029 a_n1204_2966.n10 a_n1204_2966.n9 3.61336
R2030 a_n1204_2966.n12 a_n1204_2966.n11 3.61336
R2031 a_n1204_2966.n14 a_n1204_2966.n13 3.61336
R2032 a_n1204_2966.n16 a_n1204_2966.n15 3.61336
R2033 a_n1204_2966.n18 a_n1204_2966.n17 3.61336
R2034 a_n1204_2966.n20 a_n1204_2966.n19 3.61336
R2035 a_n1204_2966.n22 a_n1204_2966.n21 3.61336
R2036 a_n1204_2966.n24 a_n1204_2966.n23 3.61336
R2037 a_n1204_2966.n26 a_n1204_2966.n25 3.61336
R2038 a_n1204_2966.n28 a_n1204_2966.n27 3.61336
R2039 a_n1204_2966.n30 a_n1204_2966.n29 3.61336
R2040 a_n1204_2966.n36 a_n1204_2966.n35 3.45159
R2041 a_n1204_2966.n0 a_n1204_2966.t3 2.58003
R2042 a_n1204_2966.n0 a_n1204_2966.t2 2.58003
R2043 a_n1204_2966.n36 a_n1204_2966.t0 1.43357
R2044 a_n1204_2966.t1 a_n1204_2966.n36 1.43357
R2045 a_n1204_2966.n3 a_n1204_2966.n2 0.3605
R2046 a_n1204_2966.n5 a_n1204_2966.n4 0.3605
R2047 a_n1204_2966.n7 a_n1204_2966.n6 0.3605
R2048 a_n1204_2966.n9 a_n1204_2966.n8 0.3605
R2049 a_n1204_2966.n11 a_n1204_2966.n10 0.3605
R2050 a_n1204_2966.n13 a_n1204_2966.n12 0.3605
R2051 a_n1204_2966.n15 a_n1204_2966.n14 0.3605
R2052 a_n1204_2966.n17 a_n1204_2966.n16 0.3605
R2053 a_n1204_2966.n19 a_n1204_2966.n18 0.3605
R2054 a_n1204_2966.n21 a_n1204_2966.n20 0.3605
R2055 a_n1204_2966.n23 a_n1204_2966.n22 0.3605
R2056 a_n1204_2966.n25 a_n1204_2966.n24 0.3605
R2057 a_n1204_2966.n27 a_n1204_2966.n26 0.3605
R2058 a_n1204_2966.n29 a_n1204_2966.n28 0.3605
R2059 a_n1204_2966.n31 a_n1204_2966.n30 0.3605
R2060 a_n1204_2966.n35 a_n1204_2966.n32 0.169589
R2061 RB14.t26 RB14.t42 69.3795
R2062 RB14.t8 RB14.t36 69.3795
R2063 RB14.t14 RB14.t33 69.3795
R2064 RB14.t7 RB14.t38 69.3795
R2065 RB14.t45 RB14.t20 69.3795
R2066 RB14.t43 RB14.t24 69.3795
R2067 RB14.t47 RB14.t18 69.3795
R2068 RB14.t44 RB14.t27 69.3795
R2069 RB14.t1 RB14.t25 69.3795
R2070 RB14.t12 RB14.t32 69.3795
R2071 RB14.t5 RB14.t23 69.3795
R2072 RB14.t46 RB14.t17 69.3795
R2073 RB14.t13 RB14.t30 69.3795
R2074 RB14.t15 RB14.t35 69.3795
R2075 RB14.t11 RB14.t31 69.3795
R2076 RB14.t4 RB14.t22 69.3795
R2077 RB14.n29 RB14.t28 30.2434
R2078 RB14.n27 RB14.t9 30.2434
R2079 RB14.n25 RB14.t6 30.2434
R2080 RB14.n23 RB14.t34 30.2434
R2081 RB14.n21 RB14.t37 30.2434
R2082 RB14.n19 RB14.t2 30.2434
R2083 RB14.n17 RB14.t0 30.2434
R2084 RB14.n15 RB14.t21 30.2434
R2085 RB14.n13 RB14.t40 30.2434
R2086 RB14.n11 RB14.t39 30.2434
R2087 RB14.n9 RB14.t3 30.2434
R2088 RB14.n7 RB14.t16 30.2434
R2089 RB14.n5 RB14.t29 30.2434
R2090 RB14.n3 RB14.t41 30.2434
R2091 RB14.n1 RB14.t10 30.2434
R2092 RB14.n0 RB14.t19 30.2434
R2093 RB14.n2 RB14.n0 21.0176
R2094 RB14.n30 RB14.n29 17.0448
R2095 RB14.n28 RB14.n27 17.0448
R2096 RB14.n26 RB14.n25 17.0448
R2097 RB14.n24 RB14.n23 17.0448
R2098 RB14.n22 RB14.n21 17.0448
R2099 RB14.n20 RB14.n19 17.0448
R2100 RB14.n18 RB14.n17 17.0448
R2101 RB14.n16 RB14.n15 17.0448
R2102 RB14.n14 RB14.n13 17.0448
R2103 RB14.n12 RB14.n11 17.0448
R2104 RB14.n10 RB14.n9 17.0448
R2105 RB14.n8 RB14.n7 17.0448
R2106 RB14.n6 RB14.n5 17.0448
R2107 RB14.n4 RB14.n3 17.0448
R2108 RB14.n2 RB14.n1 17.0448
R2109 RB14.n29 RB14.t26 16.6862
R2110 RB14.n27 RB14.t8 16.6862
R2111 RB14.n25 RB14.t14 16.6862
R2112 RB14.n23 RB14.t7 16.6862
R2113 RB14.n21 RB14.t45 16.6862
R2114 RB14.n19 RB14.t43 16.6862
R2115 RB14.n17 RB14.t47 16.6862
R2116 RB14.n15 RB14.t44 16.6862
R2117 RB14.n13 RB14.t1 16.6862
R2118 RB14.n11 RB14.t12 16.6862
R2119 RB14.n9 RB14.t5 16.6862
R2120 RB14.n7 RB14.t46 16.6862
R2121 RB14.n5 RB14.t13 16.6862
R2122 RB14.n3 RB14.t15 16.6862
R2123 RB14.n1 RB14.t11 16.6862
R2124 RB14.n0 RB14.t4 16.6862
R2125 RB14 RB14.n30 5.77657
R2126 RB14.n4 RB14.n2 3.97336
R2127 RB14.n6 RB14.n4 3.97336
R2128 RB14.n8 RB14.n6 3.97336
R2129 RB14.n10 RB14.n8 3.97336
R2130 RB14.n12 RB14.n10 3.97336
R2131 RB14.n14 RB14.n12 3.97336
R2132 RB14.n16 RB14.n14 3.97336
R2133 RB14.n18 RB14.n16 3.97336
R2134 RB14.n20 RB14.n18 3.97336
R2135 RB14.n22 RB14.n20 3.97336
R2136 RB14.n24 RB14.n22 3.97336
R2137 RB14.n26 RB14.n24 3.97336
R2138 RB14.n28 RB14.n26 3.97336
R2139 RB14.n30 RB14.n28 3.97336
R2140 RA12.t14 RA12.t38 70.3934
R2141 RA12.t41 RA12.t1 70.3934
R2142 RA12.t40 RA12.t30 70.3934
R2143 RA12.t8 RA12.t28 70.3934
R2144 RA12.t10 RA12.t36 70.3934
R2145 RA12.t21 RA12.t45 70.3934
R2146 RA12.t37 RA12.t13 70.3934
R2147 RA12.t6 RA12.t25 70.3934
R2148 RA12.t11 RA12.t34 70.3934
R2149 RA12.t23 RA12.t0 70.3934
R2150 RA12.t22 RA12.t46 70.3934
R2151 RA12.t7 RA12.t15 70.3934
R2152 RA12.t12 RA12.t35 70.3934
R2153 RA12.t26 RA12.t4 70.3934
R2154 RA12.t24 RA12.t2 70.3934
R2155 RA12.t39 RA12.t29 70.3934
R2156 RA12.n29 RA12.t14 31.2862
R2157 RA12.n27 RA12.t41 31.2862
R2158 RA12.n25 RA12.t40 31.2862
R2159 RA12.n23 RA12.t8 31.2862
R2160 RA12.n21 RA12.t10 31.2862
R2161 RA12.n19 RA12.t21 31.2862
R2162 RA12.n17 RA12.t37 31.2862
R2163 RA12.n15 RA12.t6 31.2862
R2164 RA12.n13 RA12.t11 31.2862
R2165 RA12.n11 RA12.t23 31.2862
R2166 RA12.n9 RA12.t22 31.2862
R2167 RA12.n7 RA12.t7 31.2862
R2168 RA12.n5 RA12.t12 31.2862
R2169 RA12.n3 RA12.t26 31.2862
R2170 RA12.n1 RA12.t24 31.2862
R2171 RA12.n0 RA12.t39 31.2862
R2172 RA12.n2 RA12.n0 21.0181
R2173 RA12.n30 RA12.n29 17.0453
R2174 RA12.n28 RA12.n27 17.0453
R2175 RA12.n26 RA12.n25 17.0453
R2176 RA12.n24 RA12.n23 17.0453
R2177 RA12.n22 RA12.n21 17.0453
R2178 RA12.n20 RA12.n19 17.0453
R2179 RA12.n18 RA12.n17 17.0453
R2180 RA12.n16 RA12.n15 17.0453
R2181 RA12.n14 RA12.n13 17.0453
R2182 RA12.n12 RA12.n11 17.0453
R2183 RA12.n10 RA12.n9 17.0453
R2184 RA12.n8 RA12.n7 17.0453
R2185 RA12.n6 RA12.n5 17.0453
R2186 RA12.n4 RA12.n3 17.0453
R2187 RA12.n2 RA12.n1 17.0453
R2188 RA12.n29 RA12.t9 15.6434
R2189 RA12.n27 RA12.t33 15.6434
R2190 RA12.n25 RA12.t32 15.6434
R2191 RA12.n23 RA12.t44 15.6434
R2192 RA12.n21 RA12.t47 15.6434
R2193 RA12.n19 RA12.t16 15.6434
R2194 RA12.n17 RA12.t27 15.6434
R2195 RA12.n15 RA12.t42 15.6434
R2196 RA12.n13 RA12.t3 15.6434
R2197 RA12.n11 RA12.t18 15.6434
R2198 RA12.n9 RA12.t17 15.6434
R2199 RA12.n7 RA12.t43 15.6434
R2200 RA12.n5 RA12.t5 15.6434
R2201 RA12.n3 RA12.t20 15.6434
R2202 RA12.n1 RA12.t19 15.6434
R2203 RA12.n0 RA12.t31 15.6434
R2204 RA12 RA12.n30 4.50532
R2205 RA12.n4 RA12.n2 3.97336
R2206 RA12.n6 RA12.n4 3.97336
R2207 RA12.n8 RA12.n6 3.97336
R2208 RA12.n10 RA12.n8 3.97336
R2209 RA12.n12 RA12.n10 3.97336
R2210 RA12.n14 RA12.n12 3.97336
R2211 RA12.n16 RA12.n14 3.97336
R2212 RA12.n18 RA12.n16 3.97336
R2213 RA12.n20 RA12.n18 3.97336
R2214 RA12.n22 RA12.n20 3.97336
R2215 RA12.n24 RA12.n22 3.97336
R2216 RA12.n26 RA12.n24 3.97336
R2217 RA12.n28 RA12.n26 3.97336
R2218 RA12.n30 RA12.n28 3.97336
R2219 a_n1204_2182.n1 a_n1204_2182.t5 29.7679
R2220 a_n1204_2182.n30 a_n1204_2182.t28 29.4079
R2221 a_n1204_2182.n28 a_n1204_2182.t20 29.4079
R2222 a_n1204_2182.n26 a_n1204_2182.t4 29.4079
R2223 a_n1204_2182.n24 a_n1204_2182.t39 29.4079
R2224 a_n1204_2182.n22 a_n1204_2182.t17 29.4079
R2225 a_n1204_2182.n20 a_n1204_2182.t15 29.4079
R2226 a_n1204_2182.n18 a_n1204_2182.t23 29.4079
R2227 a_n1204_2182.n16 a_n1204_2182.t33 29.4079
R2228 a_n1204_2182.n14 a_n1204_2182.t31 29.4079
R2229 a_n1204_2182.n12 a_n1204_2182.t19 29.4079
R2230 a_n1204_2182.n10 a_n1204_2182.t25 29.4079
R2231 a_n1204_2182.n8 a_n1204_2182.t37 29.4079
R2232 a_n1204_2182.n6 a_n1204_2182.t36 29.4079
R2233 a_n1204_2182.n4 a_n1204_2182.t21 29.4079
R2234 a_n1204_2182.n2 a_n1204_2182.t26 29.4079
R2235 a_n1204_2182.n31 a_n1204_2182.t22 29.1445
R2236 a_n1204_2182.n29 a_n1204_2182.t9 29.1445
R2237 a_n1204_2182.n27 a_n1204_2182.t24 29.1445
R2238 a_n1204_2182.n25 a_n1204_2182.t35 29.1445
R2239 a_n1204_2182.n23 a_n1204_2182.t34 29.1445
R2240 a_n1204_2182.n21 a_n1204_2182.t12 29.1445
R2241 a_n1204_2182.n19 a_n1204_2182.t11 29.1445
R2242 a_n1204_2182.n17 a_n1204_2182.t30 29.1445
R2243 a_n1204_2182.n15 a_n1204_2182.t29 29.1445
R2244 a_n1204_2182.n13 a_n1204_2182.t14 29.1445
R2245 a_n1204_2182.n11 a_n1204_2182.t13 29.1445
R2246 a_n1204_2182.n9 a_n1204_2182.t27 29.1445
R2247 a_n1204_2182.n7 a_n1204_2182.t32 29.1445
R2248 a_n1204_2182.n5 a_n1204_2182.t6 29.1445
R2249 a_n1204_2182.n3 a_n1204_2182.t18 29.1445
R2250 a_n1204_2182.n1 a_n1204_2182.t16 29.1445
R2251 a_n1204_2182.n33 a_n1204_2182.t10 24.7684
R2252 a_n1204_2182.n33 a_n1204_2182.t7 24.1166
R2253 a_n1204_2182.n34 a_n1204_2182.t8 23.7255
R2254 a_n1204_2182.n34 a_n1204_2182.t38 23.0737
R2255 a_n1204_2182.n34 a_n1204_2182.n33 17.1396
R2256 a_n1204_2182.n32 a_n1204_2182.n31 10.2862
R2257 a_n1204_2182.n35 a_n1204_2182.n34 8.0005
R2258 a_n1204_2182.n32 a_n1204_2182.n0 6.86767
R2259 a_n1204_2182.n2 a_n1204_2182.n1 3.61336
R2260 a_n1204_2182.n4 a_n1204_2182.n3 3.61336
R2261 a_n1204_2182.n6 a_n1204_2182.n5 3.61336
R2262 a_n1204_2182.n8 a_n1204_2182.n7 3.61336
R2263 a_n1204_2182.n10 a_n1204_2182.n9 3.61336
R2264 a_n1204_2182.n12 a_n1204_2182.n11 3.61336
R2265 a_n1204_2182.n14 a_n1204_2182.n13 3.61336
R2266 a_n1204_2182.n16 a_n1204_2182.n15 3.61336
R2267 a_n1204_2182.n18 a_n1204_2182.n17 3.61336
R2268 a_n1204_2182.n20 a_n1204_2182.n19 3.61336
R2269 a_n1204_2182.n22 a_n1204_2182.n21 3.61336
R2270 a_n1204_2182.n24 a_n1204_2182.n23 3.61336
R2271 a_n1204_2182.n26 a_n1204_2182.n25 3.61336
R2272 a_n1204_2182.n28 a_n1204_2182.n27 3.61336
R2273 a_n1204_2182.n30 a_n1204_2182.n29 3.61336
R2274 a_n1204_2182.n36 a_n1204_2182.n35 3.45159
R2275 a_n1204_2182.n0 a_n1204_2182.t3 2.58003
R2276 a_n1204_2182.n0 a_n1204_2182.t2 2.58003
R2277 a_n1204_2182.n36 a_n1204_2182.t0 1.43357
R2278 a_n1204_2182.t1 a_n1204_2182.n36 1.43357
R2279 a_n1204_2182.n3 a_n1204_2182.n2 0.3605
R2280 a_n1204_2182.n5 a_n1204_2182.n4 0.3605
R2281 a_n1204_2182.n7 a_n1204_2182.n6 0.3605
R2282 a_n1204_2182.n9 a_n1204_2182.n8 0.3605
R2283 a_n1204_2182.n11 a_n1204_2182.n10 0.3605
R2284 a_n1204_2182.n13 a_n1204_2182.n12 0.3605
R2285 a_n1204_2182.n15 a_n1204_2182.n14 0.3605
R2286 a_n1204_2182.n17 a_n1204_2182.n16 0.3605
R2287 a_n1204_2182.n19 a_n1204_2182.n18 0.3605
R2288 a_n1204_2182.n21 a_n1204_2182.n20 0.3605
R2289 a_n1204_2182.n23 a_n1204_2182.n22 0.3605
R2290 a_n1204_2182.n25 a_n1204_2182.n24 0.3605
R2291 a_n1204_2182.n27 a_n1204_2182.n26 0.3605
R2292 a_n1204_2182.n29 a_n1204_2182.n28 0.3605
R2293 a_n1204_2182.n31 a_n1204_2182.n30 0.3605
R2294 a_n1204_2182.n35 a_n1204_2182.n32 0.169589
R2295 a_n1204_10022.n1 a_n1204_10022.t16 29.7679
R2296 a_n1204_10022.n30 a_n1204_10022.t34 29.4079
R2297 a_n1204_10022.n28 a_n1204_10022.t17 29.4079
R2298 a_n1204_10022.n26 a_n1204_10022.t24 29.4079
R2299 a_n1204_10022.n24 a_n1204_10022.t11 29.4079
R2300 a_n1204_10022.n22 a_n1204_10022.t29 29.4079
R2301 a_n1204_10022.n20 a_n1204_10022.t14 29.4079
R2302 a_n1204_10022.n18 a_n1204_10022.t25 29.4079
R2303 a_n1204_10022.n16 a_n1204_10022.t8 29.4079
R2304 a_n1204_10022.n14 a_n1204_10022.t31 29.4079
R2305 a_n1204_10022.n12 a_n1204_10022.t19 29.4079
R2306 a_n1204_10022.n10 a_n1204_10022.t30 29.4079
R2307 a_n1204_10022.n8 a_n1204_10022.t12 29.4079
R2308 a_n1204_10022.n6 a_n1204_10022.t36 29.4079
R2309 a_n1204_10022.n4 a_n1204_10022.t21 29.4079
R2310 a_n1204_10022.n2 a_n1204_10022.t35 29.4079
R2311 a_n1204_10022.n31 a_n1204_10022.t32 29.1445
R2312 a_n1204_10022.n29 a_n1204_10022.t18 29.1445
R2313 a_n1204_10022.n27 a_n1204_10022.t20 29.1445
R2314 a_n1204_10022.n25 a_n1204_10022.t4 29.1445
R2315 a_n1204_10022.n23 a_n1204_10022.t26 29.1445
R2316 a_n1204_10022.n21 a_n1204_10022.t5 29.1445
R2317 a_n1204_10022.n19 a_n1204_10022.t27 29.1445
R2318 a_n1204_10022.n17 a_n1204_10022.t37 29.1445
R2319 a_n1204_10022.n15 a_n1204_10022.t22 29.1445
R2320 a_n1204_10022.n13 a_n1204_10022.t9 29.1445
R2321 a_n1204_10022.n11 a_n1204_10022.t33 29.1445
R2322 a_n1204_10022.n9 a_n1204_10022.t13 29.1445
R2323 a_n1204_10022.n7 a_n1204_10022.t28 29.1445
R2324 a_n1204_10022.n5 a_n1204_10022.t15 29.1445
R2325 a_n1204_10022.n3 a_n1204_10022.t38 29.1445
R2326 a_n1204_10022.n1 a_n1204_10022.t23 29.1445
R2327 a_n1204_10022.n33 a_n1204_10022.t10 24.7684
R2328 a_n1204_10022.n33 a_n1204_10022.t6 24.1166
R2329 a_n1204_10022.n34 a_n1204_10022.t7 23.7255
R2330 a_n1204_10022.n34 a_n1204_10022.t39 23.0737
R2331 a_n1204_10022.n34 a_n1204_10022.n33 17.1396
R2332 a_n1204_10022.n32 a_n1204_10022.n31 10.2862
R2333 a_n1204_10022.n35 a_n1204_10022.n34 8.0005
R2334 a_n1204_10022.n32 a_n1204_10022.n0 6.86767
R2335 a_n1204_10022.n2 a_n1204_10022.n1 3.61336
R2336 a_n1204_10022.n4 a_n1204_10022.n3 3.61336
R2337 a_n1204_10022.n6 a_n1204_10022.n5 3.61336
R2338 a_n1204_10022.n8 a_n1204_10022.n7 3.61336
R2339 a_n1204_10022.n10 a_n1204_10022.n9 3.61336
R2340 a_n1204_10022.n12 a_n1204_10022.n11 3.61336
R2341 a_n1204_10022.n14 a_n1204_10022.n13 3.61336
R2342 a_n1204_10022.n16 a_n1204_10022.n15 3.61336
R2343 a_n1204_10022.n18 a_n1204_10022.n17 3.61336
R2344 a_n1204_10022.n20 a_n1204_10022.n19 3.61336
R2345 a_n1204_10022.n22 a_n1204_10022.n21 3.61336
R2346 a_n1204_10022.n24 a_n1204_10022.n23 3.61336
R2347 a_n1204_10022.n26 a_n1204_10022.n25 3.61336
R2348 a_n1204_10022.n28 a_n1204_10022.n27 3.61336
R2349 a_n1204_10022.n30 a_n1204_10022.n29 3.61336
R2350 a_n1204_10022.n36 a_n1204_10022.n35 3.45159
R2351 a_n1204_10022.n0 a_n1204_10022.t2 2.58003
R2352 a_n1204_10022.n0 a_n1204_10022.t3 2.58003
R2353 a_n1204_10022.n36 a_n1204_10022.t0 1.43357
R2354 a_n1204_10022.t1 a_n1204_10022.n36 1.43357
R2355 a_n1204_10022.n3 a_n1204_10022.n2 0.3605
R2356 a_n1204_10022.n5 a_n1204_10022.n4 0.3605
R2357 a_n1204_10022.n7 a_n1204_10022.n6 0.3605
R2358 a_n1204_10022.n9 a_n1204_10022.n8 0.3605
R2359 a_n1204_10022.n11 a_n1204_10022.n10 0.3605
R2360 a_n1204_10022.n13 a_n1204_10022.n12 0.3605
R2361 a_n1204_10022.n15 a_n1204_10022.n14 0.3605
R2362 a_n1204_10022.n17 a_n1204_10022.n16 0.3605
R2363 a_n1204_10022.n19 a_n1204_10022.n18 0.3605
R2364 a_n1204_10022.n21 a_n1204_10022.n20 0.3605
R2365 a_n1204_10022.n23 a_n1204_10022.n22 0.3605
R2366 a_n1204_10022.n25 a_n1204_10022.n24 0.3605
R2367 a_n1204_10022.n27 a_n1204_10022.n26 0.3605
R2368 a_n1204_10022.n29 a_n1204_10022.n28 0.3605
R2369 a_n1204_10022.n31 a_n1204_10022.n30 0.3605
R2370 a_n1204_10022.n35 a_n1204_10022.n32 0.169589
R2371 a_21175_n2146.n18 a_21175_n2146.t33 18.9023
R2372 a_21175_n2146.n0 a_21175_n2146.t11 16.1106
R2373 a_21175_n2146.n18 a_21175_n2146.t32 15.6434
R2374 a_21175_n2146.n2 a_21175_n2146.t5 15.4484
R2375 a_21175_n2146.n3 a_21175_n2146.t9 15.4484
R2376 a_21175_n2146.n6 a_21175_n2146.t18 15.4484
R2377 a_21175_n2146.n7 a_21175_n2146.t3 15.4484
R2378 a_21175_n2146.n10 a_21175_n2146.t1 15.4484
R2379 a_21175_n2146.n11 a_21175_n2146.t8 15.4484
R2380 a_21175_n2146.n14 a_21175_n2146.t10 15.4484
R2381 a_21175_n2146.n15 a_21175_n2146.t2 15.4484
R2382 a_21175_n2146.n30 a_21175_n2146.t12 15.4484
R2383 a_21175_n2146.n27 a_21175_n2146.t4 15.4484
R2384 a_21175_n2146.n26 a_21175_n2146.t6 15.4484
R2385 a_21175_n2146.n23 a_21175_n2146.t13 15.4484
R2386 a_21175_n2146.n22 a_21175_n2146.t16 15.4484
R2387 a_21175_n2146.n19 a_21175_n2146.t7 15.4484
R2388 a_21175_n2146.t0 a_21175_n2146.n31 15.4484
R2389 a_21175_n2146.n0 a_21175_n2146.t29 14.854
R2390 a_21175_n2146.n1 a_21175_n2146.t28 14.854
R2391 a_21175_n2146.n4 a_21175_n2146.t26 14.854
R2392 a_21175_n2146.n5 a_21175_n2146.t19 14.854
R2393 a_21175_n2146.n8 a_21175_n2146.t31 14.854
R2394 a_21175_n2146.n9 a_21175_n2146.t17 14.854
R2395 a_21175_n2146.n12 a_21175_n2146.t22 14.854
R2396 a_21175_n2146.n13 a_21175_n2146.t30 14.854
R2397 a_21175_n2146.n16 a_21175_n2146.t25 14.854
R2398 a_21175_n2146.n17 a_21175_n2146.t20 14.854
R2399 a_21175_n2146.n29 a_21175_n2146.t27 14.854
R2400 a_21175_n2146.n28 a_21175_n2146.t23 14.854
R2401 a_21175_n2146.n25 a_21175_n2146.t21 14.854
R2402 a_21175_n2146.n24 a_21175_n2146.t24 14.854
R2403 a_21175_n2146.n21 a_21175_n2146.t14 14.854
R2404 a_21175_n2146.n20 a_21175_n2146.t15 14.854
R2405 a_21175_n2146.n19 a_21175_n2146.n18 14.5641
R2406 a_21175_n2146.n3 a_21175_n2146.n2 0.746214
R2407 a_21175_n2146.n7 a_21175_n2146.n6 0.746214
R2408 a_21175_n2146.n11 a_21175_n2146.n10 0.746214
R2409 a_21175_n2146.n15 a_21175_n2146.n14 0.746214
R2410 a_21175_n2146.n31 a_21175_n2146.n30 0.746214
R2411 a_21175_n2146.n27 a_21175_n2146.n26 0.746214
R2412 a_21175_n2146.n23 a_21175_n2146.n22 0.746214
R2413 a_21175_n2146.n2 a_21175_n2146.n1 0.662643
R2414 a_21175_n2146.n4 a_21175_n2146.n3 0.662643
R2415 a_21175_n2146.n6 a_21175_n2146.n5 0.662643
R2416 a_21175_n2146.n8 a_21175_n2146.n7 0.662643
R2417 a_21175_n2146.n10 a_21175_n2146.n9 0.662643
R2418 a_21175_n2146.n12 a_21175_n2146.n11 0.662643
R2419 a_21175_n2146.n14 a_21175_n2146.n13 0.662643
R2420 a_21175_n2146.n16 a_21175_n2146.n15 0.662643
R2421 a_21175_n2146.n31 a_21175_n2146.n17 0.662643
R2422 a_21175_n2146.n30 a_21175_n2146.n29 0.662643
R2423 a_21175_n2146.n28 a_21175_n2146.n27 0.662643
R2424 a_21175_n2146.n26 a_21175_n2146.n25 0.662643
R2425 a_21175_n2146.n24 a_21175_n2146.n23 0.662643
R2426 a_21175_n2146.n22 a_21175_n2146.n21 0.662643
R2427 a_21175_n2146.n20 a_21175_n2146.n19 0.662643
R2428 a_21175_n2146.n1 a_21175_n2146.n0 0.4505
R2429 a_21175_n2146.n5 a_21175_n2146.n4 0.4505
R2430 a_21175_n2146.n9 a_21175_n2146.n8 0.4505
R2431 a_21175_n2146.n13 a_21175_n2146.n12 0.4505
R2432 a_21175_n2146.n17 a_21175_n2146.n16 0.4505
R2433 a_21175_n2146.n29 a_21175_n2146.n28 0.4505
R2434 a_21175_n2146.n25 a_21175_n2146.n24 0.4505
R2435 a_21175_n2146.n21 a_21175_n2146.n20 0.4505
R2436 RA1.t23 RA1.t17 70.3934
R2437 RA1.t12 RA1.t34 70.3934
R2438 RA1.t45 RA1.t44 70.3934
R2439 RA1.t24 RA1.t29 70.3934
R2440 RA1.t46 RA1.t10 70.3934
R2441 RA1.t25 RA1.t30 70.3934
R2442 RA1.t43 RA1.t0 70.3934
R2443 RA1.t18 RA1.t21 70.3934
R2444 RA1.t1 RA1.t4 70.3934
R2445 RA1.t31 RA1.t36 70.3934
R2446 RA1.t7 RA1.t13 70.3934
R2447 RA1.t27 RA1.t42 70.3934
R2448 RA1.t6 RA1.t11 70.3934
R2449 RA1.t38 RA1.t40 70.3934
R2450 RA1.t19 RA1.t22 70.3934
R2451 RA1.t35 RA1.t33 70.3934
R2452 RA1.n29 RA1.t23 31.2862
R2453 RA1.n27 RA1.t12 31.2862
R2454 RA1.n25 RA1.t45 31.2862
R2455 RA1.n23 RA1.t24 31.2862
R2456 RA1.n21 RA1.t46 31.2862
R2457 RA1.n19 RA1.t25 31.2862
R2458 RA1.n17 RA1.t43 31.2862
R2459 RA1.n15 RA1.t18 31.2862
R2460 RA1.n13 RA1.t1 31.2862
R2461 RA1.n11 RA1.t31 31.2862
R2462 RA1.n9 RA1.t7 31.2862
R2463 RA1.n7 RA1.t27 31.2862
R2464 RA1.n5 RA1.t6 31.2862
R2465 RA1.n3 RA1.t38 31.2862
R2466 RA1.n1 RA1.t19 31.2862
R2467 RA1.n0 RA1.t35 31.2862
R2468 RA1.n2 RA1.n0 21.0181
R2469 RA1.n30 RA1.n29 17.0453
R2470 RA1.n28 RA1.n27 17.0453
R2471 RA1.n26 RA1.n25 17.0453
R2472 RA1.n24 RA1.n23 17.0453
R2473 RA1.n22 RA1.n21 17.0453
R2474 RA1.n20 RA1.n19 17.0453
R2475 RA1.n18 RA1.n17 17.0453
R2476 RA1.n16 RA1.n15 17.0453
R2477 RA1.n14 RA1.n13 17.0453
R2478 RA1.n12 RA1.n11 17.0453
R2479 RA1.n10 RA1.n9 17.0453
R2480 RA1.n8 RA1.n7 17.0453
R2481 RA1.n6 RA1.n5 17.0453
R2482 RA1.n4 RA1.n3 17.0453
R2483 RA1.n2 RA1.n1 17.0453
R2484 RA1.n29 RA1.t14 15.6434
R2485 RA1.n27 RA1.t5 15.6434
R2486 RA1.n25 RA1.t39 15.6434
R2487 RA1.n23 RA1.t15 15.6434
R2488 RA1.n21 RA1.t41 15.6434
R2489 RA1.n19 RA1.t16 15.6434
R2490 RA1.n17 RA1.t37 15.6434
R2491 RA1.n15 RA1.t8 15.6434
R2492 RA1.n13 RA1.t47 15.6434
R2493 RA1.n11 RA1.t26 15.6434
R2494 RA1.n9 RA1.t3 15.6434
R2495 RA1.n7 RA1.t20 15.6434
R2496 RA1.n5 RA1.t2 15.6434
R2497 RA1.n3 RA1.t32 15.6434
R2498 RA1.n1 RA1.t9 15.6434
R2499 RA1.n0 RA1.t28 15.6434
R2500 RA1 RA1.n30 4.50693
R2501 RA1.n4 RA1.n2 3.97336
R2502 RA1.n6 RA1.n4 3.97336
R2503 RA1.n8 RA1.n6 3.97336
R2504 RA1.n10 RA1.n8 3.97336
R2505 RA1.n12 RA1.n10 3.97336
R2506 RA1.n14 RA1.n12 3.97336
R2507 RA1.n16 RA1.n14 3.97336
R2508 RA1.n18 RA1.n16 3.97336
R2509 RA1.n20 RA1.n18 3.97336
R2510 RA1.n22 RA1.n20 3.97336
R2511 RA1.n24 RA1.n22 3.97336
R2512 RA1.n26 RA1.n24 3.97336
R2513 RA1.n28 RA1.n26 3.97336
R2514 RA1.n30 RA1.n28 3.97336
R2515 a_19416_n708.n1 a_19416_n708.t19 31.0255
R2516 a_19416_n708.n2 a_19416_n708.t31 31.0255
R2517 a_19416_n708.n4 a_19416_n708.t26 31.0255
R2518 a_19416_n708.n6 a_19416_n708.t5 31.0255
R2519 a_19416_n708.n8 a_19416_n708.t11 31.0255
R2520 a_19416_n708.n10 a_19416_n708.t25 31.0255
R2521 a_19416_n708.n12 a_19416_n708.t27 31.0255
R2522 a_19416_n708.n14 a_19416_n708.t6 31.0255
R2523 a_19416_n708.n16 a_19416_n708.t12 31.0255
R2524 a_19416_n708.n18 a_19416_n708.t35 31.0255
R2525 a_19416_n708.n20 a_19416_n708.t10 31.0255
R2526 a_19416_n708.n22 a_19416_n708.t21 31.0255
R2527 a_19416_n708.n24 a_19416_n708.t23 31.0255
R2528 a_19416_n708.n26 a_19416_n708.t29 31.0255
R2529 a_19416_n708.n28 a_19416_n708.t8 31.0255
R2530 a_19416_n708.n30 a_19416_n708.t20 31.0255
R2531 a_19416_n708.n1 a_19416_n708.t13 27.8969
R2532 a_19416_n708.n2 a_19416_n708.t14 27.8969
R2533 a_19416_n708.n4 a_19416_n708.t24 27.8969
R2534 a_19416_n708.n6 a_19416_n708.t22 27.8969
R2535 a_19416_n708.n8 a_19416_n708.t15 27.8969
R2536 a_19416_n708.n10 a_19416_n708.t4 27.8969
R2537 a_19416_n708.n12 a_19416_n708.t34 27.8969
R2538 a_19416_n708.n14 a_19416_n708.t32 27.8969
R2539 a_19416_n708.n16 a_19416_n708.t16 27.8969
R2540 a_19416_n708.n18 a_19416_n708.t17 27.8969
R2541 a_19416_n708.n20 a_19416_n708.t9 27.8969
R2542 a_19416_n708.n22 a_19416_n708.t33 27.8969
R2543 a_19416_n708.n24 a_19416_n708.t28 27.8969
R2544 a_19416_n708.n26 a_19416_n708.t18 27.8969
R2545 a_19416_n708.n28 a_19416_n708.t30 27.8969
R2546 a_19416_n708.n30 a_19416_n708.t7 27.8969
R2547 a_19416_n708.n3 a_19416_n708.n1 13.8288
R2548 a_19416_n708.n3 a_19416_n708.n2 12.5495
R2549 a_19416_n708.n5 a_19416_n708.n4 12.5495
R2550 a_19416_n708.n7 a_19416_n708.n6 12.5495
R2551 a_19416_n708.n9 a_19416_n708.n8 12.5495
R2552 a_19416_n708.n11 a_19416_n708.n10 12.5495
R2553 a_19416_n708.n13 a_19416_n708.n12 12.5495
R2554 a_19416_n708.n15 a_19416_n708.n14 12.5495
R2555 a_19416_n708.n17 a_19416_n708.n16 12.5495
R2556 a_19416_n708.n19 a_19416_n708.n18 12.5495
R2557 a_19416_n708.n21 a_19416_n708.n20 12.5495
R2558 a_19416_n708.n23 a_19416_n708.n22 12.5495
R2559 a_19416_n708.n25 a_19416_n708.n24 12.5495
R2560 a_19416_n708.n27 a_19416_n708.n26 12.5495
R2561 a_19416_n708.n29 a_19416_n708.n28 12.5495
R2562 a_19416_n708.n31 a_19416_n708.n30 12.5495
R2563 a_19416_n708.n32 a_19416_n708.n0 6.45898
R2564 a_19416_n708.n32 a_19416_n708.n31 5.79746
R2565 a_19416_n708.n33 a_19416_n708.n32 2.99572
R2566 a_19416_n708.n0 a_19416_n708.t3 2.64244
R2567 a_19416_n708.n0 a_19416_n708.t2 2.64244
R2568 a_19416_n708.n33 a_19416_n708.t0 1.46824
R2569 a_19416_n708.t1 a_19416_n708.n33 1.46824
R2570 a_19416_n708.n7 a_19416_n708.n5 1.27979
R2571 a_19416_n708.n11 a_19416_n708.n9 1.27979
R2572 a_19416_n708.n15 a_19416_n708.n13 1.27979
R2573 a_19416_n708.n19 a_19416_n708.n17 1.27979
R2574 a_19416_n708.n23 a_19416_n708.n21 1.27979
R2575 a_19416_n708.n27 a_19416_n708.n25 1.27979
R2576 a_19416_n708.n31 a_19416_n708.n29 1.27979
R2577 a_19416_n708.n5 a_19416_n708.n3 1.24121
R2578 a_19416_n708.n9 a_19416_n708.n7 1.24121
R2579 a_19416_n708.n13 a_19416_n708.n11 1.24121
R2580 a_19416_n708.n17 a_19416_n708.n15 1.24121
R2581 a_19416_n708.n21 a_19416_n708.n19 1.24121
R2582 a_19416_n708.n25 a_19416_n708.n23 1.24121
R2583 a_19416_n708.n29 a_19416_n708.n27 1.24121
R2584 a_n884_7670.n1 a_n884_7670.t35 29.9245
R2585 a_n884_7670.n30 a_n884_7670.t23 29.3395
R2586 a_n884_7670.n28 a_n884_7670.t15 29.3395
R2587 a_n884_7670.n26 a_n884_7670.t34 29.3395
R2588 a_n884_7670.n24 a_n884_7670.t33 29.3395
R2589 a_n884_7670.n22 a_n884_7670.t11 29.3395
R2590 a_n884_7670.n20 a_n884_7670.t9 29.3395
R2591 a_n884_7670.n18 a_n884_7670.t18 29.3395
R2592 a_n884_7670.n16 a_n884_7670.t27 29.3395
R2593 a_n884_7670.n14 a_n884_7670.t26 29.3395
R2594 a_n884_7670.n12 a_n884_7670.t14 29.3395
R2595 a_n884_7670.n10 a_n884_7670.t20 29.3395
R2596 a_n884_7670.n8 a_n884_7670.t32 29.3395
R2597 a_n884_7670.n6 a_n884_7670.t30 29.3395
R2598 a_n884_7670.n4 a_n884_7670.t16 29.3395
R2599 a_n884_7670.n2 a_n884_7670.t21 29.3395
R2600 a_n884_7670.n31 a_n884_7670.t17 27.973
R2601 a_n884_7670.n29 a_n884_7670.t5 27.973
R2602 a_n884_7670.n27 a_n884_7670.t19 27.973
R2603 a_n884_7670.n25 a_n884_7670.t31 27.973
R2604 a_n884_7670.n23 a_n884_7670.t29 27.973
R2605 a_n884_7670.n21 a_n884_7670.t7 27.973
R2606 a_n884_7670.n19 a_n884_7670.t6 27.973
R2607 a_n884_7670.n17 a_n884_7670.t25 27.973
R2608 a_n884_7670.n15 a_n884_7670.t24 27.973
R2609 a_n884_7670.n13 a_n884_7670.t10 27.973
R2610 a_n884_7670.n11 a_n884_7670.t8 27.973
R2611 a_n884_7670.n9 a_n884_7670.t22 27.973
R2612 a_n884_7670.n7 a_n884_7670.t28 27.973
R2613 a_n884_7670.n5 a_n884_7670.t4 27.973
R2614 a_n884_7670.n3 a_n884_7670.t13 27.973
R2615 a_n884_7670.n1 a_n884_7670.t12 27.973
R2616 a_n884_7670.n32 a_n884_7670.n31 10.1914
R2617 a_n884_7670.n33 a_n884_7670.n32 7.10205
R2618 a_n884_7670.n2 a_n884_7670.n1 3.38836
R2619 a_n884_7670.n4 a_n884_7670.n3 3.38836
R2620 a_n884_7670.n6 a_n884_7670.n5 3.38836
R2621 a_n884_7670.n8 a_n884_7670.n7 3.38836
R2622 a_n884_7670.n10 a_n884_7670.n9 3.38836
R2623 a_n884_7670.n12 a_n884_7670.n11 3.38836
R2624 a_n884_7670.n14 a_n884_7670.n13 3.38836
R2625 a_n884_7670.n16 a_n884_7670.n15 3.38836
R2626 a_n884_7670.n18 a_n884_7670.n17 3.38836
R2627 a_n884_7670.n20 a_n884_7670.n19 3.38836
R2628 a_n884_7670.n22 a_n884_7670.n21 3.38836
R2629 a_n884_7670.n24 a_n884_7670.n23 3.38836
R2630 a_n884_7670.n26 a_n884_7670.n25 3.38836
R2631 a_n884_7670.n28 a_n884_7670.n27 3.38836
R2632 a_n884_7670.n30 a_n884_7670.n29 3.38836
R2633 a_n884_7670.n33 a_n884_7670.t2 3.00946
R2634 a_n884_7670.n32 a_n884_7670.n0 2.63313
R2635 a_n884_7670.t0 a_n884_7670.n33 2.44528
R2636 a_n884_7670.n0 a_n884_7670.t3 1.67214
R2637 a_n884_7670.n0 a_n884_7670.t1 1.35871
R2638 a_n884_7670.n3 a_n884_7670.n2 0.5855
R2639 a_n884_7670.n5 a_n884_7670.n4 0.5855
R2640 a_n884_7670.n7 a_n884_7670.n6 0.5855
R2641 a_n884_7670.n9 a_n884_7670.n8 0.5855
R2642 a_n884_7670.n11 a_n884_7670.n10 0.5855
R2643 a_n884_7670.n13 a_n884_7670.n12 0.5855
R2644 a_n884_7670.n15 a_n884_7670.n14 0.5855
R2645 a_n884_7670.n17 a_n884_7670.n16 0.5855
R2646 a_n884_7670.n19 a_n884_7670.n18 0.5855
R2647 a_n884_7670.n21 a_n884_7670.n20 0.5855
R2648 a_n884_7670.n23 a_n884_7670.n22 0.5855
R2649 a_n884_7670.n25 a_n884_7670.n24 0.5855
R2650 a_n884_7670.n27 a_n884_7670.n26 0.5855
R2651 a_n884_7670.n29 a_n884_7670.n28 0.5855
R2652 a_n884_7670.n31 a_n884_7670.n30 0.5855
R2653 a_n884_4534.n1 a_n884_4534.t35 29.9245
R2654 a_n884_4534.n30 a_n884_4534.t23 29.3395
R2655 a_n884_4534.n28 a_n884_4534.t15 29.3395
R2656 a_n884_4534.n26 a_n884_4534.t34 29.3395
R2657 a_n884_4534.n24 a_n884_4534.t33 29.3395
R2658 a_n884_4534.n22 a_n884_4534.t11 29.3395
R2659 a_n884_4534.n20 a_n884_4534.t9 29.3395
R2660 a_n884_4534.n18 a_n884_4534.t18 29.3395
R2661 a_n884_4534.n16 a_n884_4534.t27 29.3395
R2662 a_n884_4534.n14 a_n884_4534.t26 29.3395
R2663 a_n884_4534.n12 a_n884_4534.t14 29.3395
R2664 a_n884_4534.n10 a_n884_4534.t20 29.3395
R2665 a_n884_4534.n8 a_n884_4534.t32 29.3395
R2666 a_n884_4534.n6 a_n884_4534.t30 29.3395
R2667 a_n884_4534.n4 a_n884_4534.t16 29.3395
R2668 a_n884_4534.n2 a_n884_4534.t21 29.3395
R2669 a_n884_4534.n31 a_n884_4534.t17 27.973
R2670 a_n884_4534.n29 a_n884_4534.t5 27.973
R2671 a_n884_4534.n27 a_n884_4534.t19 27.973
R2672 a_n884_4534.n25 a_n884_4534.t31 27.973
R2673 a_n884_4534.n23 a_n884_4534.t29 27.973
R2674 a_n884_4534.n21 a_n884_4534.t7 27.973
R2675 a_n884_4534.n19 a_n884_4534.t6 27.973
R2676 a_n884_4534.n17 a_n884_4534.t25 27.973
R2677 a_n884_4534.n15 a_n884_4534.t24 27.973
R2678 a_n884_4534.n13 a_n884_4534.t10 27.973
R2679 a_n884_4534.n11 a_n884_4534.t8 27.973
R2680 a_n884_4534.n9 a_n884_4534.t22 27.973
R2681 a_n884_4534.n7 a_n884_4534.t28 27.973
R2682 a_n884_4534.n5 a_n884_4534.t4 27.973
R2683 a_n884_4534.n3 a_n884_4534.t13 27.973
R2684 a_n884_4534.n1 a_n884_4534.t12 27.973
R2685 a_n884_4534.n32 a_n884_4534.n31 10.1914
R2686 a_n884_4534.n32 a_n884_4534.n0 7.10204
R2687 a_n884_4534.n2 a_n884_4534.n1 3.38836
R2688 a_n884_4534.n4 a_n884_4534.n3 3.38836
R2689 a_n884_4534.n6 a_n884_4534.n5 3.38836
R2690 a_n884_4534.n8 a_n884_4534.n7 3.38836
R2691 a_n884_4534.n10 a_n884_4534.n9 3.38836
R2692 a_n884_4534.n12 a_n884_4534.n11 3.38836
R2693 a_n884_4534.n14 a_n884_4534.n13 3.38836
R2694 a_n884_4534.n16 a_n884_4534.n15 3.38836
R2695 a_n884_4534.n18 a_n884_4534.n17 3.38836
R2696 a_n884_4534.n20 a_n884_4534.n19 3.38836
R2697 a_n884_4534.n22 a_n884_4534.n21 3.38836
R2698 a_n884_4534.n24 a_n884_4534.n23 3.38836
R2699 a_n884_4534.n26 a_n884_4534.n25 3.38836
R2700 a_n884_4534.n28 a_n884_4534.n27 3.38836
R2701 a_n884_4534.n30 a_n884_4534.n29 3.38836
R2702 a_n884_4534.n0 a_n884_4534.t1 3.00946
R2703 a_n884_4534.n33 a_n884_4534.n32 2.63313
R2704 a_n884_4534.n0 a_n884_4534.t2 2.44528
R2705 a_n884_4534.n33 a_n884_4534.t3 1.67214
R2706 a_n884_4534.t0 a_n884_4534.n33 1.35871
R2707 a_n884_4534.n3 a_n884_4534.n2 0.5855
R2708 a_n884_4534.n5 a_n884_4534.n4 0.5855
R2709 a_n884_4534.n7 a_n884_4534.n6 0.5855
R2710 a_n884_4534.n9 a_n884_4534.n8 0.5855
R2711 a_n884_4534.n11 a_n884_4534.n10 0.5855
R2712 a_n884_4534.n13 a_n884_4534.n12 0.5855
R2713 a_n884_4534.n15 a_n884_4534.n14 0.5855
R2714 a_n884_4534.n17 a_n884_4534.n16 0.5855
R2715 a_n884_4534.n19 a_n884_4534.n18 0.5855
R2716 a_n884_4534.n21 a_n884_4534.n20 0.5855
R2717 a_n884_4534.n23 a_n884_4534.n22 0.5855
R2718 a_n884_4534.n25 a_n884_4534.n24 0.5855
R2719 a_n884_4534.n27 a_n884_4534.n26 0.5855
R2720 a_n884_4534.n29 a_n884_4534.n28 0.5855
R2721 a_n884_4534.n31 a_n884_4534.n30 0.5855
R2722 a_26832_n708.n1 a_26832_n708.t8 31.0255
R2723 a_26832_n708.n2 a_26832_n708.t24 31.0255
R2724 a_26832_n708.n4 a_26832_n708.t20 31.0255
R2725 a_26832_n708.n6 a_26832_n708.t30 31.0255
R2726 a_26832_n708.n8 a_26832_n708.t6 31.0255
R2727 a_26832_n708.n10 a_26832_n708.t19 31.0255
R2728 a_26832_n708.n12 a_26832_n708.t21 31.0255
R2729 a_26832_n708.n14 a_26832_n708.t31 31.0255
R2730 a_26832_n708.n16 a_26832_n708.t7 31.0255
R2731 a_26832_n708.n18 a_26832_n708.t28 31.0255
R2732 a_26832_n708.n20 a_26832_n708.t34 31.0255
R2733 a_26832_n708.n22 a_26832_n708.t14 31.0255
R2734 a_26832_n708.n24 a_26832_n708.t17 31.0255
R2735 a_26832_n708.n26 a_26832_n708.t35 31.0255
R2736 a_26832_n708.n28 a_26832_n708.t15 31.0255
R2737 a_26832_n708.n30 a_26832_n708.t13 31.0255
R2738 a_26832_n708.n1 a_26832_n708.t4 27.8969
R2739 a_26832_n708.n2 a_26832_n708.t5 27.8969
R2740 a_26832_n708.n4 a_26832_n708.t18 27.8969
R2741 a_26832_n708.n6 a_26832_n708.t16 27.8969
R2742 a_26832_n708.n8 a_26832_n708.t9 27.8969
R2743 a_26832_n708.n10 a_26832_n708.t29 27.8969
R2744 a_26832_n708.n12 a_26832_n708.t27 27.8969
R2745 a_26832_n708.n14 a_26832_n708.t25 27.8969
R2746 a_26832_n708.n16 a_26832_n708.t10 27.8969
R2747 a_26832_n708.n18 a_26832_n708.t11 27.8969
R2748 a_26832_n708.n20 a_26832_n708.t33 27.8969
R2749 a_26832_n708.n22 a_26832_n708.t26 27.8969
R2750 a_26832_n708.n24 a_26832_n708.t22 27.8969
R2751 a_26832_n708.n26 a_26832_n708.t12 27.8969
R2752 a_26832_n708.n28 a_26832_n708.t23 27.8969
R2753 a_26832_n708.n30 a_26832_n708.t32 27.8969
R2754 a_26832_n708.n3 a_26832_n708.n1 13.8288
R2755 a_26832_n708.n3 a_26832_n708.n2 12.5495
R2756 a_26832_n708.n5 a_26832_n708.n4 12.5495
R2757 a_26832_n708.n7 a_26832_n708.n6 12.5495
R2758 a_26832_n708.n9 a_26832_n708.n8 12.5495
R2759 a_26832_n708.n11 a_26832_n708.n10 12.5495
R2760 a_26832_n708.n13 a_26832_n708.n12 12.5495
R2761 a_26832_n708.n15 a_26832_n708.n14 12.5495
R2762 a_26832_n708.n17 a_26832_n708.n16 12.5495
R2763 a_26832_n708.n19 a_26832_n708.n18 12.5495
R2764 a_26832_n708.n21 a_26832_n708.n20 12.5495
R2765 a_26832_n708.n23 a_26832_n708.n22 12.5495
R2766 a_26832_n708.n25 a_26832_n708.n24 12.5495
R2767 a_26832_n708.n27 a_26832_n708.n26 12.5495
R2768 a_26832_n708.n29 a_26832_n708.n28 12.5495
R2769 a_26832_n708.n31 a_26832_n708.n30 12.5495
R2770 a_26832_n708.n32 a_26832_n708.n0 6.45898
R2771 a_26832_n708.n32 a_26832_n708.n31 5.79746
R2772 a_26832_n708.n33 a_26832_n708.n32 2.99572
R2773 a_26832_n708.n0 a_26832_n708.t2 2.64244
R2774 a_26832_n708.n0 a_26832_n708.t3 2.64244
R2775 a_26832_n708.n33 a_26832_n708.t0 1.46824
R2776 a_26832_n708.t1 a_26832_n708.n33 1.46824
R2777 a_26832_n708.n7 a_26832_n708.n5 1.27979
R2778 a_26832_n708.n11 a_26832_n708.n9 1.27979
R2779 a_26832_n708.n15 a_26832_n708.n13 1.27979
R2780 a_26832_n708.n19 a_26832_n708.n17 1.27979
R2781 a_26832_n708.n23 a_26832_n708.n21 1.27979
R2782 a_26832_n708.n27 a_26832_n708.n25 1.27979
R2783 a_26832_n708.n31 a_26832_n708.n29 1.27979
R2784 a_26832_n708.n5 a_26832_n708.n3 1.24121
R2785 a_26832_n708.n9 a_26832_n708.n7 1.24121
R2786 a_26832_n708.n13 a_26832_n708.n11 1.24121
R2787 a_26832_n708.n17 a_26832_n708.n15 1.24121
R2788 a_26832_n708.n21 a_26832_n708.n19 1.24121
R2789 a_26832_n708.n25 a_26832_n708.n23 1.24121
R2790 a_26832_n708.n29 a_26832_n708.n27 1.24121
R2791 RA9.t0 RA9.t24 70.3934
R2792 RA9.t27 RA9.t32 70.3934
R2793 RA9.t26 RA9.t15 70.3934
R2794 RA9.t40 RA9.t13 70.3934
R2795 RA9.t43 RA9.t22 70.3934
R2796 RA9.t7 RA9.t28 70.3934
R2797 RA9.t23 RA9.t47 70.3934
R2798 RA9.t37 RA9.t11 70.3934
R2799 RA9.t44 RA9.t17 70.3934
R2800 RA9.t9 RA9.t31 70.3934
R2801 RA9.t8 RA9.t30 70.3934
R2802 RA9.t39 RA9.t1 70.3934
R2803 RA9.t45 RA9.t20 70.3934
R2804 RA9.t12 RA9.t36 70.3934
R2805 RA9.t10 RA9.t34 70.3934
R2806 RA9.t25 RA9.t14 70.3934
R2807 RA9.n29 RA9.t0 31.2862
R2808 RA9.n27 RA9.t27 31.2862
R2809 RA9.n25 RA9.t26 31.2862
R2810 RA9.n23 RA9.t40 31.2862
R2811 RA9.n21 RA9.t43 31.2862
R2812 RA9.n19 RA9.t7 31.2862
R2813 RA9.n17 RA9.t23 31.2862
R2814 RA9.n15 RA9.t37 31.2862
R2815 RA9.n13 RA9.t44 31.2862
R2816 RA9.n11 RA9.t9 31.2862
R2817 RA9.n9 RA9.t8 31.2862
R2818 RA9.n7 RA9.t39 31.2862
R2819 RA9.n5 RA9.t45 31.2862
R2820 RA9.n3 RA9.t12 31.2862
R2821 RA9.n1 RA9.t10 31.2862
R2822 RA9.n0 RA9.t25 31.2862
R2823 RA9.n2 RA9.n0 21.0181
R2824 RA9.n30 RA9.n29 17.0453
R2825 RA9.n28 RA9.n27 17.0453
R2826 RA9.n26 RA9.n25 17.0453
R2827 RA9.n24 RA9.n23 17.0453
R2828 RA9.n22 RA9.n21 17.0453
R2829 RA9.n20 RA9.n19 17.0453
R2830 RA9.n18 RA9.n17 17.0453
R2831 RA9.n16 RA9.n15 17.0453
R2832 RA9.n14 RA9.n13 17.0453
R2833 RA9.n12 RA9.n11 17.0453
R2834 RA9.n10 RA9.n9 17.0453
R2835 RA9.n8 RA9.n7 17.0453
R2836 RA9.n6 RA9.n5 17.0453
R2837 RA9.n4 RA9.n3 17.0453
R2838 RA9.n2 RA9.n1 17.0453
R2839 RA9.n29 RA9.t46 15.6434
R2840 RA9.n27 RA9.t21 15.6434
R2841 RA9.n25 RA9.t19 15.6434
R2842 RA9.n23 RA9.t35 15.6434
R2843 RA9.n21 RA9.t38 15.6434
R2844 RA9.n19 RA9.t2 15.6434
R2845 RA9.n17 RA9.t16 15.6434
R2846 RA9.n15 RA9.t29 15.6434
R2847 RA9.n13 RA9.t41 15.6434
R2848 RA9.n11 RA9.t4 15.6434
R2849 RA9.n9 RA9.t3 15.6434
R2850 RA9.n7 RA9.t33 15.6434
R2851 RA9.n5 RA9.t42 15.6434
R2852 RA9.n3 RA9.t6 15.6434
R2853 RA9.n1 RA9.t5 15.6434
R2854 RA9.n0 RA9.t18 15.6434
R2855 RA9 RA9.n30 4.49889
R2856 RA9.n4 RA9.n2 3.97336
R2857 RA9.n6 RA9.n4 3.97336
R2858 RA9.n8 RA9.n6 3.97336
R2859 RA9.n10 RA9.n8 3.97336
R2860 RA9.n12 RA9.n10 3.97336
R2861 RA9.n14 RA9.n12 3.97336
R2862 RA9.n16 RA9.n14 3.97336
R2863 RA9.n18 RA9.n16 3.97336
R2864 RA9.n20 RA9.n18 3.97336
R2865 RA9.n22 RA9.n20 3.97336
R2866 RA9.n24 RA9.n22 3.97336
R2867 RA9.n26 RA9.n24 3.97336
R2868 RA9.n28 RA9.n26 3.97336
R2869 RA9.n30 RA9.n28 3.97336
R2870 RB9.t11 RB9.t38 69.3795
R2871 RB9.t46 RB9.t2 69.3795
R2872 RB9.t45 RB9.t17 69.3795
R2873 RB9.t21 RB9.t16 69.3795
R2874 RB9.t24 RB9.t30 69.3795
R2875 RB9.t43 RB9.t0 69.3795
R2876 RB9.t42 RB9.t14 69.3795
R2877 RB9.t8 RB9.t12 69.3795
R2878 RB9.t26 RB9.t34 69.3795
R2879 RB9.t25 RB9.t33 69.3795
R2880 RB9.t44 RB9.t15 69.3795
R2881 RB9.t5 RB9.t28 69.3795
R2882 RB9.t13 RB9.t40 69.3795
R2883 RB9.t27 RB9.t37 69.3795
R2884 RB9.t47 RB9.t6 69.3795
R2885 RB9.t7 RB9.t29 69.3795
R2886 RB9.n29 RB9.t9 30.2434
R2887 RB9.n27 RB9.t39 30.2434
R2888 RB9.n25 RB9.t36 30.2434
R2889 RB9.n23 RB9.t18 30.2434
R2890 RB9.n21 RB9.t19 30.2434
R2891 RB9.n19 RB9.t32 30.2434
R2892 RB9.n17 RB9.t31 30.2434
R2893 RB9.n15 RB9.t4 30.2434
R2894 RB9.n13 RB9.t22 30.2434
R2895 RB9.n11 RB9.t20 30.2434
R2896 RB9.n9 RB9.t35 30.2434
R2897 RB9.n7 RB9.t1 30.2434
R2898 RB9.n5 RB9.t10 30.2434
R2899 RB9.n3 RB9.t23 30.2434
R2900 RB9.n1 RB9.t41 30.2434
R2901 RB9.n0 RB9.t3 30.2434
R2902 RB9.n2 RB9.n0 21.0176
R2903 RB9.n30 RB9.n29 17.0448
R2904 RB9.n28 RB9.n27 17.0448
R2905 RB9.n26 RB9.n25 17.0448
R2906 RB9.n24 RB9.n23 17.0448
R2907 RB9.n22 RB9.n21 17.0448
R2908 RB9.n20 RB9.n19 17.0448
R2909 RB9.n18 RB9.n17 17.0448
R2910 RB9.n16 RB9.n15 17.0448
R2911 RB9.n14 RB9.n13 17.0448
R2912 RB9.n12 RB9.n11 17.0448
R2913 RB9.n10 RB9.n9 17.0448
R2914 RB9.n8 RB9.n7 17.0448
R2915 RB9.n6 RB9.n5 17.0448
R2916 RB9.n4 RB9.n3 17.0448
R2917 RB9.n2 RB9.n1 17.0448
R2918 RB9.n29 RB9.t11 16.6862
R2919 RB9.n27 RB9.t46 16.6862
R2920 RB9.n25 RB9.t45 16.6862
R2921 RB9.n23 RB9.t21 16.6862
R2922 RB9.n21 RB9.t24 16.6862
R2923 RB9.n19 RB9.t43 16.6862
R2924 RB9.n17 RB9.t42 16.6862
R2925 RB9.n15 RB9.t8 16.6862
R2926 RB9.n13 RB9.t26 16.6862
R2927 RB9.n11 RB9.t25 16.6862
R2928 RB9.n9 RB9.t44 16.6862
R2929 RB9.n7 RB9.t5 16.6862
R2930 RB9.n5 RB9.t13 16.6862
R2931 RB9.n3 RB9.t27 16.6862
R2932 RB9.n1 RB9.t47 16.6862
R2933 RB9.n0 RB9.t7 16.6862
R2934 RB9 RB9.n30 5.77657
R2935 RB9.n4 RB9.n2 3.97336
R2936 RB9.n6 RB9.n4 3.97336
R2937 RB9.n8 RB9.n6 3.97336
R2938 RB9.n10 RB9.n8 3.97336
R2939 RB9.n12 RB9.n10 3.97336
R2940 RB9.n14 RB9.n12 3.97336
R2941 RB9.n16 RB9.n14 3.97336
R2942 RB9.n18 RB9.n16 3.97336
R2943 RB9.n20 RB9.n18 3.97336
R2944 RB9.n22 RB9.n20 3.97336
R2945 RB9.n24 RB9.n22 3.97336
R2946 RB9.n26 RB9.n24 3.97336
R2947 RB9.n28 RB9.n26 3.97336
R2948 RB9.n30 RB9.n28 3.97336
R2949 a_13759_n2146.n10 a_13759_n2146.t32 18.9023
R2950 a_13759_n2146.n0 a_13759_n2146.t10 16.1106
R2951 a_13759_n2146.n10 a_13759_n2146.t33 15.6434
R2952 a_13759_n2146.n2 a_13759_n2146.t4 15.4484
R2953 a_13759_n2146.n3 a_13759_n2146.t8 15.4484
R2954 a_13759_n2146.n6 a_13759_n2146.t16 15.4484
R2955 a_13759_n2146.n7 a_13759_n2146.t2 15.4484
R2956 a_13759_n2146.n30 a_13759_n2146.t7 15.4484
R2957 a_13759_n2146.n27 a_13759_n2146.t9 15.4484
R2958 a_13759_n2146.n26 a_13759_n2146.t1 15.4484
R2959 a_13759_n2146.n23 a_13759_n2146.t17 15.4484
R2960 a_13759_n2146.n22 a_13759_n2146.t11 15.4484
R2961 a_13759_n2146.n19 a_13759_n2146.t3 15.4484
R2962 a_13759_n2146.n18 a_13759_n2146.t5 15.4484
R2963 a_13759_n2146.n15 a_13759_n2146.t12 15.4484
R2964 a_13759_n2146.n14 a_13759_n2146.t15 15.4484
R2965 a_13759_n2146.n11 a_13759_n2146.t6 15.4484
R2966 a_13759_n2146.t0 a_13759_n2146.n31 15.4484
R2967 a_13759_n2146.n0 a_13759_n2146.t24 14.854
R2968 a_13759_n2146.n1 a_13759_n2146.t31 14.854
R2969 a_13759_n2146.n4 a_13759_n2146.t23 14.854
R2970 a_13759_n2146.n5 a_13759_n2146.t14 14.854
R2971 a_13759_n2146.n8 a_13759_n2146.t29 14.854
R2972 a_13759_n2146.n9 a_13759_n2146.t25 14.854
R2973 a_13759_n2146.n29 a_13759_n2146.t22 14.854
R2974 a_13759_n2146.n28 a_13759_n2146.t27 14.854
R2975 a_13759_n2146.n25 a_13759_n2146.t18 14.854
R2976 a_13759_n2146.n24 a_13759_n2146.t28 14.854
R2977 a_13759_n2146.n21 a_13759_n2146.t21 14.854
R2978 a_13759_n2146.n20 a_13759_n2146.t19 14.854
R2979 a_13759_n2146.n17 a_13759_n2146.t20 14.854
R2980 a_13759_n2146.n16 a_13759_n2146.t26 14.854
R2981 a_13759_n2146.n13 a_13759_n2146.t13 14.854
R2982 a_13759_n2146.n12 a_13759_n2146.t30 14.854
R2983 a_13759_n2146.n11 a_13759_n2146.n10 14.5641
R2984 a_13759_n2146.n3 a_13759_n2146.n2 0.746214
R2985 a_13759_n2146.n7 a_13759_n2146.n6 0.746214
R2986 a_13759_n2146.n31 a_13759_n2146.n30 0.746214
R2987 a_13759_n2146.n27 a_13759_n2146.n26 0.746214
R2988 a_13759_n2146.n23 a_13759_n2146.n22 0.746214
R2989 a_13759_n2146.n19 a_13759_n2146.n18 0.746214
R2990 a_13759_n2146.n15 a_13759_n2146.n14 0.746214
R2991 a_13759_n2146.n2 a_13759_n2146.n1 0.662643
R2992 a_13759_n2146.n4 a_13759_n2146.n3 0.662643
R2993 a_13759_n2146.n6 a_13759_n2146.n5 0.662643
R2994 a_13759_n2146.n8 a_13759_n2146.n7 0.662643
R2995 a_13759_n2146.n31 a_13759_n2146.n9 0.662643
R2996 a_13759_n2146.n30 a_13759_n2146.n29 0.662643
R2997 a_13759_n2146.n28 a_13759_n2146.n27 0.662643
R2998 a_13759_n2146.n26 a_13759_n2146.n25 0.662643
R2999 a_13759_n2146.n24 a_13759_n2146.n23 0.662643
R3000 a_13759_n2146.n22 a_13759_n2146.n21 0.662643
R3001 a_13759_n2146.n20 a_13759_n2146.n19 0.662643
R3002 a_13759_n2146.n18 a_13759_n2146.n17 0.662643
R3003 a_13759_n2146.n16 a_13759_n2146.n15 0.662643
R3004 a_13759_n2146.n14 a_13759_n2146.n13 0.662643
R3005 a_13759_n2146.n12 a_13759_n2146.n11 0.662643
R3006 a_13759_n2146.n1 a_13759_n2146.n0 0.4505
R3007 a_13759_n2146.n5 a_13759_n2146.n4 0.4505
R3008 a_13759_n2146.n9 a_13759_n2146.n8 0.4505
R3009 a_13759_n2146.n29 a_13759_n2146.n28 0.4505
R3010 a_13759_n2146.n25 a_13759_n2146.n24 0.4505
R3011 a_13759_n2146.n21 a_13759_n2146.n20 0.4505
R3012 a_13759_n2146.n17 a_13759_n2146.n16 0.4505
R3013 a_13759_n2146.n13 a_13759_n2146.n12 0.4505
R3014 a_28321_n862.n26 a_28321_n862.t32 18.9023
R3015 a_28321_n862.n0 a_28321_n862.t3 16.1132
R3016 a_28321_n862.n26 a_28321_n862.t33 15.6434
R3017 a_28321_n862.n2 a_28321_n862.t9 15.4511
R3018 a_28321_n862.n3 a_28321_n862.t2 15.4511
R3019 a_28321_n862.n6 a_28321_n862.t5 15.4511
R3020 a_28321_n862.n7 a_28321_n862.t15 15.4511
R3021 a_28321_n862.n10 a_28321_n862.t21 15.4511
R3022 a_28321_n862.n11 a_28321_n862.t18 15.4511
R3023 a_28321_n862.n14 a_28321_n862.t7 15.4511
R3024 a_28321_n862.n15 a_28321_n862.t12 15.4511
R3025 a_28321_n862.n18 a_28321_n862.t17 15.4511
R3026 a_28321_n862.n19 a_28321_n862.t6 15.4511
R3027 a_28321_n862.n22 a_28321_n862.t1 15.4511
R3028 a_28321_n862.n23 a_28321_n862.t11 15.4511
R3029 a_28321_n862.n30 a_28321_n862.t8 15.4511
R3030 a_28321_n862.n27 a_28321_n862.t4 15.4511
R3031 a_28321_n862.t0 a_28321_n862.n31 15.4511
R3032 a_28321_n862.n0 a_28321_n862.t22 14.8566
R3033 a_28321_n862.n1 a_28321_n862.t10 14.8566
R3034 a_28321_n862.n4 a_28321_n862.t20 14.8566
R3035 a_28321_n862.n5 a_28321_n862.t28 14.8566
R3036 a_28321_n862.n8 a_28321_n862.t29 14.8566
R3037 a_28321_n862.n9 a_28321_n862.t25 14.8566
R3038 a_28321_n862.n12 a_28321_n862.t14 14.8566
R3039 a_28321_n862.n13 a_28321_n862.t31 14.8566
R3040 a_28321_n862.n16 a_28321_n862.t19 14.8566
R3041 a_28321_n862.n17 a_28321_n862.t26 14.8566
R3042 a_28321_n862.n20 a_28321_n862.t13 14.8566
R3043 a_28321_n862.n21 a_28321_n862.t16 14.8566
R3044 a_28321_n862.n24 a_28321_n862.t27 14.8566
R3045 a_28321_n862.n25 a_28321_n862.t23 14.8566
R3046 a_28321_n862.n29 a_28321_n862.t24 14.8566
R3047 a_28321_n862.n28 a_28321_n862.t30 14.8566
R3048 a_28321_n862.n27 a_28321_n862.n26 14.5641
R3049 a_28321_n862.n3 a_28321_n862.n2 0.746214
R3050 a_28321_n862.n7 a_28321_n862.n6 0.746214
R3051 a_28321_n862.n11 a_28321_n862.n10 0.746214
R3052 a_28321_n862.n15 a_28321_n862.n14 0.746214
R3053 a_28321_n862.n19 a_28321_n862.n18 0.746214
R3054 a_28321_n862.n23 a_28321_n862.n22 0.746214
R3055 a_28321_n862.n31 a_28321_n862.n30 0.746214
R3056 a_28321_n862.n2 a_28321_n862.n1 0.662643
R3057 a_28321_n862.n4 a_28321_n862.n3 0.662643
R3058 a_28321_n862.n6 a_28321_n862.n5 0.662643
R3059 a_28321_n862.n8 a_28321_n862.n7 0.662643
R3060 a_28321_n862.n10 a_28321_n862.n9 0.662643
R3061 a_28321_n862.n12 a_28321_n862.n11 0.662643
R3062 a_28321_n862.n14 a_28321_n862.n13 0.662643
R3063 a_28321_n862.n16 a_28321_n862.n15 0.662643
R3064 a_28321_n862.n18 a_28321_n862.n17 0.662643
R3065 a_28321_n862.n20 a_28321_n862.n19 0.662643
R3066 a_28321_n862.n22 a_28321_n862.n21 0.662643
R3067 a_28321_n862.n24 a_28321_n862.n23 0.662643
R3068 a_28321_n862.n31 a_28321_n862.n25 0.662643
R3069 a_28321_n862.n30 a_28321_n862.n29 0.662643
R3070 a_28321_n862.n28 a_28321_n862.n27 0.662643
R3071 a_28321_n862.n1 a_28321_n862.n0 0.4505
R3072 a_28321_n862.n5 a_28321_n862.n4 0.4505
R3073 a_28321_n862.n9 a_28321_n862.n8 0.4505
R3074 a_28321_n862.n13 a_28321_n862.n12 0.4505
R3075 a_28321_n862.n17 a_28321_n862.n16 0.4505
R3076 a_28321_n862.n21 a_28321_n862.n20 0.4505
R3077 a_28321_n862.n25 a_28321_n862.n24 0.4505
R3078 a_28321_n862.n29 a_28321_n862.n28 0.4505
R3079 RA13.t30 RA13.t13 70.3934
R3080 RA13.t26 RA13.t7 70.3934
R3081 RA13.t36 RA13.t46 70.3934
R3082 RA13.t29 RA13.t5 70.3934
R3083 RA13.t23 RA13.t47 70.3934
R3084 RA13.t16 RA13.t43 70.3934
R3085 RA13.t21 RA13.t37 70.3934
R3086 RA13.t15 RA13.t42 70.3934
R3087 RA13.t25 RA13.t2 70.3934
R3088 RA13.t22 RA13.t45 70.3934
R3089 RA13.t28 RA13.t4 70.3934
R3090 RA13.t20 RA13.t0 70.3934
R3091 RA13.t32 RA13.t11 70.3934
R3092 RA13.t24 RA13.t1 70.3934
R3093 RA13.t35 RA13.t12 70.3934
R3094 RA13.t27 RA13.t41 70.3934
R3095 RA13.n29 RA13.t30 31.2862
R3096 RA13.n27 RA13.t26 31.2862
R3097 RA13.n25 RA13.t36 31.2862
R3098 RA13.n23 RA13.t29 31.2862
R3099 RA13.n21 RA13.t23 31.2862
R3100 RA13.n19 RA13.t16 31.2862
R3101 RA13.n17 RA13.t21 31.2862
R3102 RA13.n15 RA13.t15 31.2862
R3103 RA13.n13 RA13.t25 31.2862
R3104 RA13.n11 RA13.t22 31.2862
R3105 RA13.n9 RA13.t28 31.2862
R3106 RA13.n7 RA13.t20 31.2862
R3107 RA13.n5 RA13.t32 31.2862
R3108 RA13.n3 RA13.t24 31.2862
R3109 RA13.n1 RA13.t35 31.2862
R3110 RA13.n0 RA13.t27 31.2862
R3111 RA13.n2 RA13.n0 21.0181
R3112 RA13.n30 RA13.n29 17.0453
R3113 RA13.n28 RA13.n27 17.0453
R3114 RA13.n26 RA13.n25 17.0453
R3115 RA13.n24 RA13.n23 17.0453
R3116 RA13.n22 RA13.n21 17.0453
R3117 RA13.n20 RA13.n19 17.0453
R3118 RA13.n18 RA13.n17 17.0453
R3119 RA13.n16 RA13.n15 17.0453
R3120 RA13.n14 RA13.n13 17.0453
R3121 RA13.n12 RA13.n11 17.0453
R3122 RA13.n10 RA13.n9 17.0453
R3123 RA13.n8 RA13.n7 17.0453
R3124 RA13.n6 RA13.n5 17.0453
R3125 RA13.n4 RA13.n3 17.0453
R3126 RA13.n2 RA13.n1 17.0453
R3127 RA13.n29 RA13.t44 15.6434
R3128 RA13.n27 RA13.t19 15.6434
R3129 RA13.n25 RA13.t18 15.6434
R3130 RA13.n23 RA13.t34 15.6434
R3131 RA13.n21 RA13.t38 15.6434
R3132 RA13.n19 RA13.t3 15.6434
R3133 RA13.n17 RA13.t14 15.6434
R3134 RA13.n15 RA13.t31 15.6434
R3135 RA13.n13 RA13.t39 15.6434
R3136 RA13.n11 RA13.t8 15.6434
R3137 RA13.n9 RA13.t6 15.6434
R3138 RA13.n7 RA13.t33 15.6434
R3139 RA13.n5 RA13.t40 15.6434
R3140 RA13.n3 RA13.t10 15.6434
R3141 RA13.n1 RA13.t9 15.6434
R3142 RA13.n0 RA13.t17 15.6434
R3143 RA13 RA13.n30 4.50854
R3144 RA13.n4 RA13.n2 3.97336
R3145 RA13.n6 RA13.n4 3.97336
R3146 RA13.n8 RA13.n6 3.97336
R3147 RA13.n10 RA13.n8 3.97336
R3148 RA13.n12 RA13.n10 3.97336
R3149 RA13.n14 RA13.n12 3.97336
R3150 RA13.n16 RA13.n14 3.97336
R3151 RA13.n18 RA13.n16 3.97336
R3152 RA13.n20 RA13.n18 3.97336
R3153 RA13.n22 RA13.n20 3.97336
R3154 RA13.n24 RA13.n22 3.97336
R3155 RA13.n26 RA13.n24 3.97336
R3156 RA13.n28 RA13.n26 3.97336
R3157 RA13.n30 RA13.n28 3.97336
R3158 RA11.t33 RA11.t7 70.3934
R3159 RA11.t10 RA11.t18 70.3934
R3160 RA11.t9 RA11.t47 70.3934
R3161 RA11.t23 RA11.t45 70.3934
R3162 RA11.t27 RA11.t4 70.3934
R3163 RA11.t39 RA11.t15 70.3934
R3164 RA11.t5 RA11.t32 70.3934
R3165 RA11.t21 RA11.t43 70.3934
R3166 RA11.t30 RA11.t0 70.3934
R3167 RA11.t41 RA11.t17 70.3934
R3168 RA11.t40 RA11.t16 70.3934
R3169 RA11.t22 RA11.t34 70.3934
R3170 RA11.t31 RA11.t2 70.3934
R3171 RA11.t44 RA11.t20 70.3934
R3172 RA11.t42 RA11.t19 70.3934
R3173 RA11.t8 RA11.t46 70.3934
R3174 RA11.n29 RA11.t33 31.2862
R3175 RA11.n27 RA11.t10 31.2862
R3176 RA11.n25 RA11.t9 31.2862
R3177 RA11.n23 RA11.t23 31.2862
R3178 RA11.n21 RA11.t27 31.2862
R3179 RA11.n19 RA11.t39 31.2862
R3180 RA11.n17 RA11.t5 31.2862
R3181 RA11.n15 RA11.t21 31.2862
R3182 RA11.n13 RA11.t30 31.2862
R3183 RA11.n11 RA11.t41 31.2862
R3184 RA11.n9 RA11.t40 31.2862
R3185 RA11.n7 RA11.t22 31.2862
R3186 RA11.n5 RA11.t31 31.2862
R3187 RA11.n3 RA11.t44 31.2862
R3188 RA11.n1 RA11.t42 31.2862
R3189 RA11.n0 RA11.t8 31.2862
R3190 RA11.n2 RA11.n0 21.0181
R3191 RA11.n30 RA11.n29 17.0453
R3192 RA11.n28 RA11.n27 17.0453
R3193 RA11.n26 RA11.n25 17.0453
R3194 RA11.n24 RA11.n23 17.0453
R3195 RA11.n22 RA11.n21 17.0453
R3196 RA11.n20 RA11.n19 17.0453
R3197 RA11.n18 RA11.n17 17.0453
R3198 RA11.n16 RA11.n15 17.0453
R3199 RA11.n14 RA11.n13 17.0453
R3200 RA11.n12 RA11.n11 17.0453
R3201 RA11.n10 RA11.n9 17.0453
R3202 RA11.n8 RA11.n7 17.0453
R3203 RA11.n6 RA11.n5 17.0453
R3204 RA11.n4 RA11.n3 17.0453
R3205 RA11.n2 RA11.n1 17.0453
R3206 RA11.n29 RA11.t14 15.6434
R3207 RA11.n27 RA11.t38 15.6434
R3208 RA11.n25 RA11.t37 15.6434
R3209 RA11.n23 RA11.t6 15.6434
R3210 RA11.n21 RA11.t11 15.6434
R3211 RA11.n19 RA11.t24 15.6434
R3212 RA11.n17 RA11.t35 15.6434
R3213 RA11.n15 RA11.t1 15.6434
R3214 RA11.n13 RA11.t12 15.6434
R3215 RA11.n11 RA11.t26 15.6434
R3216 RA11.n9 RA11.t25 15.6434
R3217 RA11.n7 RA11.t3 15.6434
R3218 RA11.n5 RA11.t13 15.6434
R3219 RA11.n3 RA11.t29 15.6434
R3220 RA11.n1 RA11.t28 15.6434
R3221 RA11.n0 RA11.t36 15.6434
R3222 RA11 RA11.n30 4.50532
R3223 RA11.n4 RA11.n2 3.97336
R3224 RA11.n6 RA11.n4 3.97336
R3225 RA11.n8 RA11.n6 3.97336
R3226 RA11.n10 RA11.n8 3.97336
R3227 RA11.n12 RA11.n10 3.97336
R3228 RA11.n14 RA11.n12 3.97336
R3229 RA11.n16 RA11.n14 3.97336
R3230 RA11.n18 RA11.n16 3.97336
R3231 RA11.n20 RA11.n18 3.97336
R3232 RA11.n22 RA11.n20 3.97336
R3233 RA11.n24 RA11.n22 3.97336
R3234 RA11.n26 RA11.n24 3.97336
R3235 RA11.n28 RA11.n26 3.97336
R3236 RA11.n30 RA11.n28 3.97336
R3237 a_20905_n862.n3 a_20905_n862.t32 18.9023
R3238 a_20905_n862.n0 a_20905_n862.t2 16.1132
R3239 a_20905_n862.n3 a_20905_n862.t33 15.6434
R3240 a_20905_n862.n2 a_20905_n862.t8 15.4511
R3241 a_20905_n862.n28 a_20905_n862.t4 15.4511
R3242 a_20905_n862.n27 a_20905_n862.t16 15.4511
R3243 a_20905_n862.n24 a_20905_n862.t12 15.4511
R3244 a_20905_n862.n23 a_20905_n862.t18 15.4511
R3245 a_20905_n862.n20 a_20905_n862.t6 15.4511
R3246 a_20905_n862.n19 a_20905_n862.t10 15.4511
R3247 a_20905_n862.n16 a_20905_n862.t17 15.4511
R3248 a_20905_n862.n15 a_20905_n862.t5 15.4511
R3249 a_20905_n862.n12 a_20905_n862.t14 15.4511
R3250 a_20905_n862.n11 a_20905_n862.t9 15.4511
R3251 a_20905_n862.n8 a_20905_n862.t11 15.4511
R3252 a_20905_n862.n7 a_20905_n862.t1 15.4511
R3253 a_20905_n862.n4 a_20905_n862.t3 15.4511
R3254 a_20905_n862.t0 a_20905_n862.n31 15.4511
R3255 a_20905_n862.n0 a_20905_n862.t24 14.8566
R3256 a_20905_n862.n1 a_20905_n862.t7 14.8566
R3257 a_20905_n862.n30 a_20905_n862.t25 14.8566
R3258 a_20905_n862.n29 a_20905_n862.t13 14.8566
R3259 a_20905_n862.n26 a_20905_n862.t30 14.8566
R3260 a_20905_n862.n25 a_20905_n862.t26 14.8566
R3261 a_20905_n862.n22 a_20905_n862.t31 14.8566
R3262 a_20905_n862.n21 a_20905_n862.t23 14.8566
R3263 a_20905_n862.n18 a_20905_n862.t28 14.8566
R3264 a_20905_n862.n17 a_20905_n862.t22 14.8566
R3265 a_20905_n862.n14 a_20905_n862.t19 14.8566
R3266 a_20905_n862.n13 a_20905_n862.t21 14.8566
R3267 a_20905_n862.n10 a_20905_n862.t15 14.8566
R3268 a_20905_n862.n9 a_20905_n862.t20 14.8566
R3269 a_20905_n862.n6 a_20905_n862.t29 14.8566
R3270 a_20905_n862.n5 a_20905_n862.t27 14.8566
R3271 a_20905_n862.n4 a_20905_n862.n3 14.5641
R3272 a_20905_n862.n31 a_20905_n862.n2 0.746214
R3273 a_20905_n862.n28 a_20905_n862.n27 0.746214
R3274 a_20905_n862.n24 a_20905_n862.n23 0.746214
R3275 a_20905_n862.n20 a_20905_n862.n19 0.746214
R3276 a_20905_n862.n16 a_20905_n862.n15 0.746214
R3277 a_20905_n862.n12 a_20905_n862.n11 0.746214
R3278 a_20905_n862.n8 a_20905_n862.n7 0.746214
R3279 a_20905_n862.n2 a_20905_n862.n1 0.662643
R3280 a_20905_n862.n31 a_20905_n862.n30 0.662643
R3281 a_20905_n862.n29 a_20905_n862.n28 0.662643
R3282 a_20905_n862.n27 a_20905_n862.n26 0.662643
R3283 a_20905_n862.n25 a_20905_n862.n24 0.662643
R3284 a_20905_n862.n23 a_20905_n862.n22 0.662643
R3285 a_20905_n862.n21 a_20905_n862.n20 0.662643
R3286 a_20905_n862.n19 a_20905_n862.n18 0.662643
R3287 a_20905_n862.n17 a_20905_n862.n16 0.662643
R3288 a_20905_n862.n15 a_20905_n862.n14 0.662643
R3289 a_20905_n862.n13 a_20905_n862.n12 0.662643
R3290 a_20905_n862.n11 a_20905_n862.n10 0.662643
R3291 a_20905_n862.n9 a_20905_n862.n8 0.662643
R3292 a_20905_n862.n7 a_20905_n862.n6 0.662643
R3293 a_20905_n862.n5 a_20905_n862.n4 0.662643
R3294 a_20905_n862.n1 a_20905_n862.n0 0.4505
R3295 a_20905_n862.n30 a_20905_n862.n29 0.4505
R3296 a_20905_n862.n26 a_20905_n862.n25 0.4505
R3297 a_20905_n862.n22 a_20905_n862.n21 0.4505
R3298 a_20905_n862.n18 a_20905_n862.n17 0.4505
R3299 a_20905_n862.n14 a_20905_n862.n13 0.4505
R3300 a_20905_n862.n10 a_20905_n862.n9 0.4505
R3301 a_20905_n862.n6 a_20905_n862.n5 0.4505
R3302 a_n884_n1738.n30 a_n884_n1738.t16 29.3395
R3303 a_n884_n1738.n28 a_n884_n1738.t6 29.3395
R3304 a_n884_n1738.n26 a_n884_n1738.t20 29.3395
R3305 a_n884_n1738.n24 a_n884_n1738.t32 29.3395
R3306 a_n884_n1738.n22 a_n884_n1738.t11 29.3395
R3307 a_n884_n1738.n20 a_n884_n1738.t33 29.3395
R3308 a_n884_n1738.n18 a_n884_n1738.t15 29.3395
R3309 a_n884_n1738.n16 a_n884_n1738.t24 29.3395
R3310 a_n884_n1738.n14 a_n884_n1738.t13 29.3395
R3311 a_n884_n1738.n12 a_n884_n1738.t8 29.3395
R3312 a_n884_n1738.n10 a_n884_n1738.t22 29.3395
R3313 a_n884_n1738.n8 a_n884_n1738.t30 29.3395
R3314 a_n884_n1738.n6 a_n884_n1738.t28 29.3395
R3315 a_n884_n1738.n4 a_n884_n1738.t9 29.3395
R3316 a_n884_n1738.n2 a_n884_n1738.t17 29.3395
R3317 a_n884_n1738.n0 a_n884_n1738.t5 29.3395
R3318 a_n884_n1738.n0 a_n884_n1738.t4 28.558
R3319 a_n884_n1738.n29 a_n884_n1738.t25 27.973
R3320 a_n884_n1738.n27 a_n884_n1738.t31 27.973
R3321 a_n884_n1738.n25 a_n884_n1738.t18 27.973
R3322 a_n884_n1738.n23 a_n884_n1738.t7 27.973
R3323 a_n884_n1738.n21 a_n884_n1738.t19 27.973
R3324 a_n884_n1738.n19 a_n884_n1738.t26 27.973
R3325 a_n884_n1738.n17 a_n884_n1738.t12 27.973
R3326 a_n884_n1738.n15 a_n884_n1738.t34 27.973
R3327 a_n884_n1738.n13 a_n884_n1738.t23 27.973
R3328 a_n884_n1738.n11 a_n884_n1738.t10 27.973
R3329 a_n884_n1738.n9 a_n884_n1738.t21 27.973
R3330 a_n884_n1738.n7 a_n884_n1738.t29 27.973
R3331 a_n884_n1738.n5 a_n884_n1738.t27 27.973
R3332 a_n884_n1738.n3 a_n884_n1738.t14 27.973
R3333 a_n884_n1738.n1 a_n884_n1738.t35 27.973
R3334 a_n884_n1738.n32 a_n884_n1738.n30 10.9275
R3335 a_n884_n1738.n33 a_n884_n1738.n32 6.98762
R3336 a_n884_n1738.n32 a_n884_n1738.n31 5.2005
R3337 a_n884_n1738.n1 a_n884_n1738.n0 3.38836
R3338 a_n884_n1738.n3 a_n884_n1738.n2 3.38836
R3339 a_n884_n1738.n5 a_n884_n1738.n4 3.38836
R3340 a_n884_n1738.n7 a_n884_n1738.n6 3.38836
R3341 a_n884_n1738.n9 a_n884_n1738.n8 3.38836
R3342 a_n884_n1738.n11 a_n884_n1738.n10 3.38836
R3343 a_n884_n1738.n13 a_n884_n1738.n12 3.38836
R3344 a_n884_n1738.n15 a_n884_n1738.n14 3.38836
R3345 a_n884_n1738.n17 a_n884_n1738.n16 3.38836
R3346 a_n884_n1738.n19 a_n884_n1738.n18 3.38836
R3347 a_n884_n1738.n21 a_n884_n1738.n20 3.38836
R3348 a_n884_n1738.n23 a_n884_n1738.n22 3.38836
R3349 a_n884_n1738.n25 a_n884_n1738.n24 3.38836
R3350 a_n884_n1738.n27 a_n884_n1738.n26 3.38836
R3351 a_n884_n1738.n29 a_n884_n1738.n28 3.38836
R3352 a_n884_n1738.t0 a_n884_n1738.n33 3.2005
R3353 a_n884_n1738.n33 a_n884_n1738.t2 2.6005
R3354 a_n884_n1738.n31 a_n884_n1738.t1 1.77828
R3355 a_n884_n1738.n31 a_n884_n1738.t3 1.44494
R3356 a_n884_n1738.n2 a_n884_n1738.n1 0.5855
R3357 a_n884_n1738.n4 a_n884_n1738.n3 0.5855
R3358 a_n884_n1738.n6 a_n884_n1738.n5 0.5855
R3359 a_n884_n1738.n8 a_n884_n1738.n7 0.5855
R3360 a_n884_n1738.n10 a_n884_n1738.n9 0.5855
R3361 a_n884_n1738.n12 a_n884_n1738.n11 0.5855
R3362 a_n884_n1738.n14 a_n884_n1738.n13 0.5855
R3363 a_n884_n1738.n16 a_n884_n1738.n15 0.5855
R3364 a_n884_n1738.n18 a_n884_n1738.n17 0.5855
R3365 a_n884_n1738.n20 a_n884_n1738.n19 0.5855
R3366 a_n884_n1738.n22 a_n884_n1738.n21 0.5855
R3367 a_n884_n1738.n24 a_n884_n1738.n23 0.5855
R3368 a_n884_n1738.n26 a_n884_n1738.n25 0.5855
R3369 a_n884_n1738.n28 a_n884_n1738.n27 0.5855
R3370 a_n884_n1738.n30 a_n884_n1738.n29 0.5855
R3371 a_34248_n708.n1 a_34248_n708.t34 31.0255
R3372 a_34248_n708.n2 a_34248_n708.t17 31.0255
R3373 a_34248_n708.n4 a_34248_n708.t14 31.0255
R3374 a_34248_n708.n6 a_34248_n708.t25 31.0255
R3375 a_34248_n708.n8 a_34248_n708.t32 31.0255
R3376 a_34248_n708.n10 a_34248_n708.t13 31.0255
R3377 a_34248_n708.n12 a_34248_n708.t15 31.0255
R3378 a_34248_n708.n14 a_34248_n708.t26 31.0255
R3379 a_34248_n708.n16 a_34248_n708.t33 31.0255
R3380 a_34248_n708.n18 a_34248_n708.t23 31.0255
R3381 a_34248_n708.n20 a_34248_n708.t29 31.0255
R3382 a_34248_n708.n22 a_34248_n708.t9 31.0255
R3383 a_34248_n708.n24 a_34248_n708.t11 31.0255
R3384 a_34248_n708.n26 a_34248_n708.t35 31.0255
R3385 a_34248_n708.n28 a_34248_n708.t19 31.0255
R3386 a_34248_n708.n30 a_34248_n708.t8 31.0255
R3387 a_34248_n708.n1 a_34248_n708.t30 27.8969
R3388 a_34248_n708.n2 a_34248_n708.t31 27.8969
R3389 a_34248_n708.n4 a_34248_n708.t12 27.8969
R3390 a_34248_n708.n6 a_34248_n708.t10 27.8969
R3391 a_34248_n708.n8 a_34248_n708.t4 27.8969
R3392 a_34248_n708.n10 a_34248_n708.t24 27.8969
R3393 a_34248_n708.n12 a_34248_n708.t22 27.8969
R3394 a_34248_n708.n14 a_34248_n708.t20 27.8969
R3395 a_34248_n708.n16 a_34248_n708.t5 27.8969
R3396 a_34248_n708.n18 a_34248_n708.t6 27.8969
R3397 a_34248_n708.n20 a_34248_n708.t28 27.8969
R3398 a_34248_n708.n22 a_34248_n708.t21 27.8969
R3399 a_34248_n708.n24 a_34248_n708.t16 27.8969
R3400 a_34248_n708.n26 a_34248_n708.t7 27.8969
R3401 a_34248_n708.n28 a_34248_n708.t18 27.8969
R3402 a_34248_n708.n30 a_34248_n708.t27 27.8969
R3403 a_34248_n708.n3 a_34248_n708.n1 13.8288
R3404 a_34248_n708.n3 a_34248_n708.n2 12.5495
R3405 a_34248_n708.n5 a_34248_n708.n4 12.5495
R3406 a_34248_n708.n7 a_34248_n708.n6 12.5495
R3407 a_34248_n708.n9 a_34248_n708.n8 12.5495
R3408 a_34248_n708.n11 a_34248_n708.n10 12.5495
R3409 a_34248_n708.n13 a_34248_n708.n12 12.5495
R3410 a_34248_n708.n15 a_34248_n708.n14 12.5495
R3411 a_34248_n708.n17 a_34248_n708.n16 12.5495
R3412 a_34248_n708.n19 a_34248_n708.n18 12.5495
R3413 a_34248_n708.n21 a_34248_n708.n20 12.5495
R3414 a_34248_n708.n23 a_34248_n708.n22 12.5495
R3415 a_34248_n708.n25 a_34248_n708.n24 12.5495
R3416 a_34248_n708.n27 a_34248_n708.n26 12.5495
R3417 a_34248_n708.n29 a_34248_n708.n28 12.5495
R3418 a_34248_n708.n31 a_34248_n708.n30 12.5495
R3419 a_34248_n708.n32 a_34248_n708.n0 6.45898
R3420 a_34248_n708.n32 a_34248_n708.n31 5.79746
R3421 a_34248_n708.n33 a_34248_n708.n32 2.99572
R3422 a_34248_n708.n0 a_34248_n708.t2 2.64244
R3423 a_34248_n708.n0 a_34248_n708.t3 2.64244
R3424 a_34248_n708.t1 a_34248_n708.n33 1.46824
R3425 a_34248_n708.n33 a_34248_n708.t0 1.46824
R3426 a_34248_n708.n7 a_34248_n708.n5 1.27979
R3427 a_34248_n708.n11 a_34248_n708.n9 1.27979
R3428 a_34248_n708.n15 a_34248_n708.n13 1.27979
R3429 a_34248_n708.n19 a_34248_n708.n17 1.27979
R3430 a_34248_n708.n23 a_34248_n708.n21 1.27979
R3431 a_34248_n708.n27 a_34248_n708.n25 1.27979
R3432 a_34248_n708.n31 a_34248_n708.n29 1.27979
R3433 a_34248_n708.n5 a_34248_n708.n3 1.24121
R3434 a_34248_n708.n9 a_34248_n708.n7 1.24121
R3435 a_34248_n708.n13 a_34248_n708.n11 1.24121
R3436 a_34248_n708.n17 a_34248_n708.n15 1.24121
R3437 a_34248_n708.n21 a_34248_n708.n19 1.24121
R3438 a_34248_n708.n25 a_34248_n708.n23 1.24121
R3439 a_34248_n708.n29 a_34248_n708.n27 1.24121
R3440 a_n1204_n954.n1 a_n1204_n954.t9 29.7679
R3441 a_n1204_n954.n30 a_n1204_n954.t29 29.4079
R3442 a_n1204_n954.n28 a_n1204_n954.t21 29.4079
R3443 a_n1204_n954.n26 a_n1204_n954.t8 29.4079
R3444 a_n1204_n954.n24 a_n1204_n954.t6 29.4079
R3445 a_n1204_n954.n22 a_n1204_n954.t19 29.4079
R3446 a_n1204_n954.n20 a_n1204_n954.t18 29.4079
R3447 a_n1204_n954.n18 a_n1204_n954.t25 29.4079
R3448 a_n1204_n954.n16 a_n1204_n954.t38 29.4079
R3449 a_n1204_n954.n14 a_n1204_n954.t37 29.4079
R3450 a_n1204_n954.n12 a_n1204_n954.t20 29.4079
R3451 a_n1204_n954.n10 a_n1204_n954.t27 29.4079
R3452 a_n1204_n954.n8 a_n1204_n954.t5 29.4079
R3453 a_n1204_n954.n6 a_n1204_n954.t4 29.4079
R3454 a_n1204_n954.n4 a_n1204_n954.t22 29.4079
R3455 a_n1204_n954.n2 a_n1204_n954.t28 29.4079
R3456 a_n1204_n954.n31 a_n1204_n954.t23 29.1445
R3457 a_n1204_n954.n29 a_n1204_n954.t11 29.1445
R3458 a_n1204_n954.n27 a_n1204_n954.t24 29.1445
R3459 a_n1204_n954.n25 a_n1204_n954.t35 29.1445
R3460 a_n1204_n954.n23 a_n1204_n954.t34 29.1445
R3461 a_n1204_n954.n21 a_n1204_n954.t13 29.1445
R3462 a_n1204_n954.n19 a_n1204_n954.t12 29.1445
R3463 a_n1204_n954.n17 a_n1204_n954.t31 29.1445
R3464 a_n1204_n954.n15 a_n1204_n954.t30 29.1445
R3465 a_n1204_n954.n13 a_n1204_n954.t15 29.1445
R3466 a_n1204_n954.n11 a_n1204_n954.t14 29.1445
R3467 a_n1204_n954.n9 a_n1204_n954.t26 29.1445
R3468 a_n1204_n954.n7 a_n1204_n954.t33 29.1445
R3469 a_n1204_n954.n5 a_n1204_n954.t7 29.1445
R3470 a_n1204_n954.n3 a_n1204_n954.t17 29.1445
R3471 a_n1204_n954.n1 a_n1204_n954.t16 29.1445
R3472 a_n1204_n954.n33 a_n1204_n954.t39 24.7684
R3473 a_n1204_n954.n33 a_n1204_n954.t10 24.1166
R3474 a_n1204_n954.n34 a_n1204_n954.t32 23.7255
R3475 a_n1204_n954.n34 a_n1204_n954.t36 23.0737
R3476 a_n1204_n954.n34 a_n1204_n954.n33 17.1396
R3477 a_n1204_n954.n32 a_n1204_n954.n31 10.2862
R3478 a_n1204_n954.n35 a_n1204_n954.n34 8.0005
R3479 a_n1204_n954.n32 a_n1204_n954.n0 6.86767
R3480 a_n1204_n954.n2 a_n1204_n954.n1 3.61336
R3481 a_n1204_n954.n4 a_n1204_n954.n3 3.61336
R3482 a_n1204_n954.n6 a_n1204_n954.n5 3.61336
R3483 a_n1204_n954.n8 a_n1204_n954.n7 3.61336
R3484 a_n1204_n954.n10 a_n1204_n954.n9 3.61336
R3485 a_n1204_n954.n12 a_n1204_n954.n11 3.61336
R3486 a_n1204_n954.n14 a_n1204_n954.n13 3.61336
R3487 a_n1204_n954.n16 a_n1204_n954.n15 3.61336
R3488 a_n1204_n954.n18 a_n1204_n954.n17 3.61336
R3489 a_n1204_n954.n20 a_n1204_n954.n19 3.61336
R3490 a_n1204_n954.n22 a_n1204_n954.n21 3.61336
R3491 a_n1204_n954.n24 a_n1204_n954.n23 3.61336
R3492 a_n1204_n954.n26 a_n1204_n954.n25 3.61336
R3493 a_n1204_n954.n28 a_n1204_n954.n27 3.61336
R3494 a_n1204_n954.n30 a_n1204_n954.n29 3.61336
R3495 a_n1204_n954.n36 a_n1204_n954.n35 3.45159
R3496 a_n1204_n954.n0 a_n1204_n954.t2 2.58003
R3497 a_n1204_n954.n0 a_n1204_n954.t3 2.58003
R3498 a_n1204_n954.n36 a_n1204_n954.t0 1.43357
R3499 a_n1204_n954.t1 a_n1204_n954.n36 1.43357
R3500 a_n1204_n954.n3 a_n1204_n954.n2 0.3605
R3501 a_n1204_n954.n5 a_n1204_n954.n4 0.3605
R3502 a_n1204_n954.n7 a_n1204_n954.n6 0.3605
R3503 a_n1204_n954.n9 a_n1204_n954.n8 0.3605
R3504 a_n1204_n954.n11 a_n1204_n954.n10 0.3605
R3505 a_n1204_n954.n13 a_n1204_n954.n12 0.3605
R3506 a_n1204_n954.n15 a_n1204_n954.n14 0.3605
R3507 a_n1204_n954.n17 a_n1204_n954.n16 0.3605
R3508 a_n1204_n954.n19 a_n1204_n954.n18 0.3605
R3509 a_n1204_n954.n21 a_n1204_n954.n20 0.3605
R3510 a_n1204_n954.n23 a_n1204_n954.n22 0.3605
R3511 a_n1204_n954.n25 a_n1204_n954.n24 0.3605
R3512 a_n1204_n954.n27 a_n1204_n954.n26 0.3605
R3513 a_n1204_n954.n29 a_n1204_n954.n28 0.3605
R3514 a_n1204_n954.n31 a_n1204_n954.n30 0.3605
R3515 a_n1204_n954.n35 a_n1204_n954.n32 0.169589
R3516 a_2112_n708.n1 a_2112_n708.t17 31.0255
R3517 a_2112_n708.n2 a_2112_n708.t28 31.0255
R3518 a_2112_n708.n4 a_2112_n708.t18 31.0255
R3519 a_2112_n708.n6 a_2112_n708.t29 31.0255
R3520 a_2112_n708.n8 a_2112_n708.t34 31.0255
R3521 a_2112_n708.n10 a_2112_n708.t16 31.0255
R3522 a_2112_n708.n12 a_2112_n708.t19 31.0255
R3523 a_2112_n708.n14 a_2112_n708.t30 31.0255
R3524 a_2112_n708.n16 a_2112_n708.t35 31.0255
R3525 a_2112_n708.n18 a_2112_n708.t26 31.0255
R3526 a_2112_n708.n20 a_2112_n708.t33 31.0255
R3527 a_2112_n708.n22 a_2112_n708.t10 31.0255
R3528 a_2112_n708.n24 a_2112_n708.t13 31.0255
R3529 a_2112_n708.n26 a_2112_n708.t14 31.0255
R3530 a_2112_n708.n28 a_2112_n708.t25 31.0255
R3531 a_2112_n708.n30 a_2112_n708.t8 31.0255
R3532 a_2112_n708.n1 a_2112_n708.t9 27.8969
R3533 a_2112_n708.n2 a_2112_n708.t11 27.8969
R3534 a_2112_n708.n4 a_2112_n708.t15 27.8969
R3535 a_2112_n708.n6 a_2112_n708.t12 27.8969
R3536 a_2112_n708.n8 a_2112_n708.t4 27.8969
R3537 a_2112_n708.n10 a_2112_n708.t27 27.8969
R3538 a_2112_n708.n12 a_2112_n708.t24 27.8969
R3539 a_2112_n708.n14 a_2112_n708.t22 27.8969
R3540 a_2112_n708.n16 a_2112_n708.t5 27.8969
R3541 a_2112_n708.n18 a_2112_n708.t6 27.8969
R3542 a_2112_n708.n20 a_2112_n708.t32 27.8969
R3543 a_2112_n708.n22 a_2112_n708.t23 27.8969
R3544 a_2112_n708.n24 a_2112_n708.t20 27.8969
R3545 a_2112_n708.n26 a_2112_n708.t7 27.8969
R3546 a_2112_n708.n28 a_2112_n708.t21 27.8969
R3547 a_2112_n708.n30 a_2112_n708.t31 27.8969
R3548 a_2112_n708.n3 a_2112_n708.n1 13.8288
R3549 a_2112_n708.n3 a_2112_n708.n2 12.5495
R3550 a_2112_n708.n5 a_2112_n708.n4 12.5495
R3551 a_2112_n708.n7 a_2112_n708.n6 12.5495
R3552 a_2112_n708.n9 a_2112_n708.n8 12.5495
R3553 a_2112_n708.n11 a_2112_n708.n10 12.5495
R3554 a_2112_n708.n13 a_2112_n708.n12 12.5495
R3555 a_2112_n708.n15 a_2112_n708.n14 12.5495
R3556 a_2112_n708.n17 a_2112_n708.n16 12.5495
R3557 a_2112_n708.n19 a_2112_n708.n18 12.5495
R3558 a_2112_n708.n21 a_2112_n708.n20 12.5495
R3559 a_2112_n708.n23 a_2112_n708.n22 12.5495
R3560 a_2112_n708.n25 a_2112_n708.n24 12.5495
R3561 a_2112_n708.n27 a_2112_n708.n26 12.5495
R3562 a_2112_n708.n29 a_2112_n708.n28 12.5495
R3563 a_2112_n708.n31 a_2112_n708.n30 12.5495
R3564 a_2112_n708.n32 a_2112_n708.n0 6.45898
R3565 a_2112_n708.n32 a_2112_n708.n31 5.79746
R3566 a_2112_n708.n33 a_2112_n708.n32 2.99572
R3567 a_2112_n708.n0 a_2112_n708.t2 2.64244
R3568 a_2112_n708.n0 a_2112_n708.t3 2.64244
R3569 a_2112_n708.n33 a_2112_n708.t0 1.46824
R3570 a_2112_n708.t1 a_2112_n708.n33 1.46824
R3571 a_2112_n708.n7 a_2112_n708.n5 1.27979
R3572 a_2112_n708.n11 a_2112_n708.n9 1.27979
R3573 a_2112_n708.n15 a_2112_n708.n13 1.27979
R3574 a_2112_n708.n19 a_2112_n708.n17 1.27979
R3575 a_2112_n708.n23 a_2112_n708.n21 1.27979
R3576 a_2112_n708.n27 a_2112_n708.n25 1.27979
R3577 a_2112_n708.n31 a_2112_n708.n29 1.27979
R3578 a_2112_n708.n5 a_2112_n708.n3 1.24121
R3579 a_2112_n708.n9 a_2112_n708.n7 1.24121
R3580 a_2112_n708.n13 a_2112_n708.n11 1.24121
R3581 a_2112_n708.n17 a_2112_n708.n15 1.24121
R3582 a_2112_n708.n21 a_2112_n708.n19 1.24121
R3583 a_2112_n708.n25 a_2112_n708.n23 1.24121
R3584 a_2112_n708.n29 a_2112_n708.n27 1.24121
R3585 RB0.t47 RB0.t9 69.3795
R3586 RB0.t11 RB0.t22 69.3795
R3587 RB0.t34 RB0.t43 69.3795
R3588 RB0.t3 RB0.t28 69.3795
R3589 RB0.t27 RB0.t46 69.3795
R3590 RB0.t4 RB0.t18 69.3795
R3591 RB0.t32 RB0.t38 69.3795
R3592 RB0.t12 RB0.t24 69.3795
R3593 RB0.t31 RB0.t7 69.3795
R3594 RB0.t17 RB0.t33 69.3795
R3595 RB0.t37 RB0.t1 69.3795
R3596 RB0.t8 RB0.t16 69.3795
R3597 RB0.t5 RB0.t13 69.3795
R3598 RB0.t23 RB0.t39 69.3795
R3599 RB0.t45 RB0.t20 69.3795
R3600 RB0.t14 RB0.t21 69.3795
R3601 RB0.n29 RB0.t36 30.2434
R3602 RB0.n27 RB0.t0 30.2434
R3603 RB0.n25 RB0.t29 30.2434
R3604 RB0.n23 RB0.t40 30.2434
R3605 RB0.n21 RB0.t19 30.2434
R3606 RB0.n19 RB0.t41 30.2434
R3607 RB0.n17 RB0.t26 30.2434
R3608 RB0.n15 RB0.t2 30.2434
R3609 RB0.n13 RB0.t25 30.2434
R3610 RB0.n11 RB0.t10 30.2434
R3611 RB0.n9 RB0.t30 30.2434
R3612 RB0.n7 RB0.t44 30.2434
R3613 RB0.n5 RB0.t42 30.2434
R3614 RB0.n3 RB0.t15 30.2434
R3615 RB0.n1 RB0.t35 30.2434
R3616 RB0.n0 RB0.t6 30.2434
R3617 RB0.n2 RB0.n0 21.0176
R3618 RB0.n30 RB0.n29 17.0448
R3619 RB0.n28 RB0.n27 17.0448
R3620 RB0.n26 RB0.n25 17.0448
R3621 RB0.n24 RB0.n23 17.0448
R3622 RB0.n22 RB0.n21 17.0448
R3623 RB0.n20 RB0.n19 17.0448
R3624 RB0.n18 RB0.n17 17.0448
R3625 RB0.n16 RB0.n15 17.0448
R3626 RB0.n14 RB0.n13 17.0448
R3627 RB0.n12 RB0.n11 17.0448
R3628 RB0.n10 RB0.n9 17.0448
R3629 RB0.n8 RB0.n7 17.0448
R3630 RB0.n6 RB0.n5 17.0448
R3631 RB0.n4 RB0.n3 17.0448
R3632 RB0.n2 RB0.n1 17.0448
R3633 RB0.n29 RB0.t47 16.6862
R3634 RB0.n27 RB0.t11 16.6862
R3635 RB0.n25 RB0.t34 16.6862
R3636 RB0.n23 RB0.t3 16.6862
R3637 RB0.n21 RB0.t27 16.6862
R3638 RB0.n19 RB0.t4 16.6862
R3639 RB0.n17 RB0.t32 16.6862
R3640 RB0.n15 RB0.t12 16.6862
R3641 RB0.n13 RB0.t31 16.6862
R3642 RB0.n11 RB0.t17 16.6862
R3643 RB0.n9 RB0.t37 16.6862
R3644 RB0.n7 RB0.t8 16.6862
R3645 RB0.n5 RB0.t5 16.6862
R3646 RB0.n3 RB0.t23 16.6862
R3647 RB0.n1 RB0.t45 16.6862
R3648 RB0.n0 RB0.t14 16.6862
R3649 RB0 RB0.n30 5.78461
R3650 RB0.n4 RB0.n2 3.97336
R3651 RB0.n6 RB0.n4 3.97336
R3652 RB0.n8 RB0.n6 3.97336
R3653 RB0.n10 RB0.n8 3.97336
R3654 RB0.n12 RB0.n10 3.97336
R3655 RB0.n14 RB0.n12 3.97336
R3656 RB0.n16 RB0.n14 3.97336
R3657 RB0.n18 RB0.n16 3.97336
R3658 RB0.n20 RB0.n18 3.97336
R3659 RB0.n22 RB0.n20 3.97336
R3660 RB0.n24 RB0.n22 3.97336
R3661 RB0.n26 RB0.n24 3.97336
R3662 RB0.n28 RB0.n26 3.97336
R3663 RB0.n30 RB0.n28 3.97336
R3664 a_7056_n708.n1 a_7056_n708.t4 31.0255
R3665 a_7056_n708.n2 a_7056_n708.t12 31.0255
R3666 a_7056_n708.n4 a_7056_n708.t25 31.0255
R3667 a_7056_n708.n6 a_7056_n708.t6 31.0255
R3668 a_7056_n708.n8 a_7056_n708.t13 31.0255
R3669 a_7056_n708.n10 a_7056_n708.t24 31.0255
R3670 a_7056_n708.n12 a_7056_n708.t26 31.0255
R3671 a_7056_n708.n14 a_7056_n708.t7 31.0255
R3672 a_7056_n708.n16 a_7056_n708.t14 31.0255
R3673 a_7056_n708.n18 a_7056_n708.t35 31.0255
R3674 a_7056_n708.n20 a_7056_n708.t11 31.0255
R3675 a_7056_n708.n22 a_7056_n708.t20 31.0255
R3676 a_7056_n708.n24 a_7056_n708.t22 31.0255
R3677 a_7056_n708.n26 a_7056_n708.t30 31.0255
R3678 a_7056_n708.n28 a_7056_n708.t10 31.0255
R3679 a_7056_n708.n30 a_7056_n708.t19 31.0255
R3680 a_7056_n708.n1 a_7056_n708.t29 27.8969
R3681 a_7056_n708.n2 a_7056_n708.t31 27.8969
R3682 a_7056_n708.n4 a_7056_n708.t23 27.8969
R3683 a_7056_n708.n6 a_7056_n708.t21 27.8969
R3684 a_7056_n708.n8 a_7056_n708.t15 27.8969
R3685 a_7056_n708.n10 a_7056_n708.t5 27.8969
R3686 a_7056_n708.n12 a_7056_n708.t34 27.8969
R3687 a_7056_n708.n14 a_7056_n708.t32 27.8969
R3688 a_7056_n708.n16 a_7056_n708.t16 27.8969
R3689 a_7056_n708.n18 a_7056_n708.t17 27.8969
R3690 a_7056_n708.n20 a_7056_n708.t9 27.8969
R3691 a_7056_n708.n22 a_7056_n708.t33 27.8969
R3692 a_7056_n708.n24 a_7056_n708.t27 27.8969
R3693 a_7056_n708.n26 a_7056_n708.t18 27.8969
R3694 a_7056_n708.n28 a_7056_n708.t28 27.8969
R3695 a_7056_n708.n30 a_7056_n708.t8 27.8969
R3696 a_7056_n708.n3 a_7056_n708.n1 13.8288
R3697 a_7056_n708.n3 a_7056_n708.n2 12.5495
R3698 a_7056_n708.n5 a_7056_n708.n4 12.5495
R3699 a_7056_n708.n7 a_7056_n708.n6 12.5495
R3700 a_7056_n708.n9 a_7056_n708.n8 12.5495
R3701 a_7056_n708.n11 a_7056_n708.n10 12.5495
R3702 a_7056_n708.n13 a_7056_n708.n12 12.5495
R3703 a_7056_n708.n15 a_7056_n708.n14 12.5495
R3704 a_7056_n708.n17 a_7056_n708.n16 12.5495
R3705 a_7056_n708.n19 a_7056_n708.n18 12.5495
R3706 a_7056_n708.n21 a_7056_n708.n20 12.5495
R3707 a_7056_n708.n23 a_7056_n708.n22 12.5495
R3708 a_7056_n708.n25 a_7056_n708.n24 12.5495
R3709 a_7056_n708.n27 a_7056_n708.n26 12.5495
R3710 a_7056_n708.n29 a_7056_n708.n28 12.5495
R3711 a_7056_n708.n31 a_7056_n708.n30 12.5495
R3712 a_7056_n708.n32 a_7056_n708.n0 6.45898
R3713 a_7056_n708.n32 a_7056_n708.n31 5.79746
R3714 a_7056_n708.n33 a_7056_n708.n32 2.99572
R3715 a_7056_n708.n0 a_7056_n708.t2 2.64244
R3716 a_7056_n708.n0 a_7056_n708.t3 2.64244
R3717 a_7056_n708.t1 a_7056_n708.n33 1.46824
R3718 a_7056_n708.n33 a_7056_n708.t0 1.46824
R3719 a_7056_n708.n7 a_7056_n708.n5 1.27979
R3720 a_7056_n708.n11 a_7056_n708.n9 1.27979
R3721 a_7056_n708.n15 a_7056_n708.n13 1.27979
R3722 a_7056_n708.n19 a_7056_n708.n17 1.27979
R3723 a_7056_n708.n23 a_7056_n708.n21 1.27979
R3724 a_7056_n708.n27 a_7056_n708.n25 1.27979
R3725 a_7056_n708.n31 a_7056_n708.n29 1.27979
R3726 a_7056_n708.n5 a_7056_n708.n3 1.24121
R3727 a_7056_n708.n9 a_7056_n708.n7 1.24121
R3728 a_7056_n708.n13 a_7056_n708.n11 1.24121
R3729 a_7056_n708.n17 a_7056_n708.n15 1.24121
R3730 a_7056_n708.n21 a_7056_n708.n19 1.24121
R3731 a_7056_n708.n25 a_7056_n708.n23 1.24121
R3732 a_7056_n708.n29 a_7056_n708.n27 1.24121
R3733 RB7.t31 RB7.t12 69.3795
R3734 RB7.t18 RB7.t24 69.3795
R3735 RB7.t17 RB7.t38 69.3795
R3736 RB7.t43 RB7.t37 69.3795
R3737 RB7.t44 RB7.t6 69.3795
R3738 RB7.t15 RB7.t21 69.3795
R3739 RB7.t14 RB7.t34 69.3795
R3740 RB7.t28 RB7.t32 69.3795
R3741 RB7.t46 RB7.t10 69.3795
R3742 RB7.t45 RB7.t9 69.3795
R3743 RB7.t16 RB7.t36 69.3795
R3744 RB7.t25 RB7.t0 69.3795
R3745 RB7.t33 RB7.t13 69.3795
R3746 RB7.t47 RB7.t11 69.3795
R3747 RB7.t19 RB7.t26 69.3795
R3748 RB7.t27 RB7.t1 69.3795
R3749 RB7.n29 RB7.t29 30.2434
R3750 RB7.n27 RB7.t7 30.2434
R3751 RB7.n25 RB7.t5 30.2434
R3752 RB7.n23 RB7.t35 30.2434
R3753 RB7.n21 RB7.t39 30.2434
R3754 RB7.n19 RB7.t3 30.2434
R3755 RB7.n17 RB7.t2 30.2434
R3756 RB7.n15 RB7.t23 30.2434
R3757 RB7.n13 RB7.t41 30.2434
R3758 RB7.n11 RB7.t40 30.2434
R3759 RB7.n9 RB7.t4 30.2434
R3760 RB7.n7 RB7.t20 30.2434
R3761 RB7.n5 RB7.t30 30.2434
R3762 RB7.n3 RB7.t42 30.2434
R3763 RB7.n1 RB7.t8 30.2434
R3764 RB7.n0 RB7.t22 30.2434
R3765 RB7.n2 RB7.n0 21.0176
R3766 RB7.n30 RB7.n29 17.0448
R3767 RB7.n28 RB7.n27 17.0448
R3768 RB7.n26 RB7.n25 17.0448
R3769 RB7.n24 RB7.n23 17.0448
R3770 RB7.n22 RB7.n21 17.0448
R3771 RB7.n20 RB7.n19 17.0448
R3772 RB7.n18 RB7.n17 17.0448
R3773 RB7.n16 RB7.n15 17.0448
R3774 RB7.n14 RB7.n13 17.0448
R3775 RB7.n12 RB7.n11 17.0448
R3776 RB7.n10 RB7.n9 17.0448
R3777 RB7.n8 RB7.n7 17.0448
R3778 RB7.n6 RB7.n5 17.0448
R3779 RB7.n4 RB7.n3 17.0448
R3780 RB7.n2 RB7.n1 17.0448
R3781 RB7.n29 RB7.t31 16.6862
R3782 RB7.n27 RB7.t18 16.6862
R3783 RB7.n25 RB7.t17 16.6862
R3784 RB7.n23 RB7.t43 16.6862
R3785 RB7.n21 RB7.t44 16.6862
R3786 RB7.n19 RB7.t15 16.6862
R3787 RB7.n17 RB7.t14 16.6862
R3788 RB7.n15 RB7.t28 16.6862
R3789 RB7.n13 RB7.t46 16.6862
R3790 RB7.n11 RB7.t45 16.6862
R3791 RB7.n9 RB7.t16 16.6862
R3792 RB7.n7 RB7.t25 16.6862
R3793 RB7.n5 RB7.t33 16.6862
R3794 RB7.n3 RB7.t47 16.6862
R3795 RB7.n1 RB7.t19 16.6862
R3796 RB7.n0 RB7.t27 16.6862
R3797 RB7 RB7.n30 5.78139
R3798 RB7.n4 RB7.n2 3.97336
R3799 RB7.n6 RB7.n4 3.97336
R3800 RB7.n8 RB7.n6 3.97336
R3801 RB7.n10 RB7.n8 3.97336
R3802 RB7.n12 RB7.n10 3.97336
R3803 RB7.n14 RB7.n12 3.97336
R3804 RB7.n16 RB7.n14 3.97336
R3805 RB7.n18 RB7.n16 3.97336
R3806 RB7.n20 RB7.n18 3.97336
R3807 RB7.n22 RB7.n20 3.97336
R3808 RB7.n24 RB7.n22 3.97336
R3809 RB7.n26 RB7.n24 3.97336
R3810 RB7.n28 RB7.n26 3.97336
R3811 RB7.n30 RB7.n28 3.97336
R3812 a_28591_n2146.n10 a_28591_n2146.t32 18.9023
R3813 a_28591_n2146.n0 a_28591_n2146.t21 16.1106
R3814 a_28591_n2146.n10 a_28591_n2146.t33 15.6434
R3815 a_28591_n2146.n2 a_28591_n2146.t4 15.4484
R3816 a_28591_n2146.n3 a_28591_n2146.t7 15.4484
R3817 a_28591_n2146.n6 a_28591_n2146.t14 15.4484
R3818 a_28591_n2146.n7 a_28591_n2146.t2 15.4484
R3819 a_28591_n2146.n30 a_28591_n2146.t8 15.4484
R3820 a_28591_n2146.n27 a_28591_n2146.t17 15.4484
R3821 a_28591_n2146.n26 a_28591_n2146.t1 15.4484
R3822 a_28591_n2146.n23 a_28591_n2146.t15 15.4484
R3823 a_28591_n2146.n22 a_28591_n2146.t9 15.4484
R3824 a_28591_n2146.n19 a_28591_n2146.t3 15.4484
R3825 a_28591_n2146.n18 a_28591_n2146.t5 15.4484
R3826 a_28591_n2146.n15 a_28591_n2146.t10 15.4484
R3827 a_28591_n2146.n14 a_28591_n2146.t13 15.4484
R3828 a_28591_n2146.n11 a_28591_n2146.t6 15.4484
R3829 a_28591_n2146.t0 a_28591_n2146.n31 15.4484
R3830 a_28591_n2146.n0 a_28591_n2146.t25 14.854
R3831 a_28591_n2146.n1 a_28591_n2146.t31 14.854
R3832 a_28591_n2146.n4 a_28591_n2146.t22 14.854
R3833 a_28591_n2146.n5 a_28591_n2146.t19 14.854
R3834 a_28591_n2146.n8 a_28591_n2146.t18 14.854
R3835 a_28591_n2146.n9 a_28591_n2146.t28 14.854
R3836 a_28591_n2146.n29 a_28591_n2146.t16 14.854
R3837 a_28591_n2146.n28 a_28591_n2146.t29 14.854
R3838 a_28591_n2146.n25 a_28591_n2146.t11 14.854
R3839 a_28591_n2146.n24 a_28591_n2146.t30 14.854
R3840 a_28591_n2146.n21 a_28591_n2146.t24 14.854
R3841 a_28591_n2146.n20 a_28591_n2146.t23 14.854
R3842 a_28591_n2146.n17 a_28591_n2146.t20 14.854
R3843 a_28591_n2146.n16 a_28591_n2146.t26 14.854
R3844 a_28591_n2146.n13 a_28591_n2146.t12 14.854
R3845 a_28591_n2146.n12 a_28591_n2146.t27 14.854
R3846 a_28591_n2146.n11 a_28591_n2146.n10 14.5641
R3847 a_28591_n2146.n3 a_28591_n2146.n2 0.746214
R3848 a_28591_n2146.n7 a_28591_n2146.n6 0.746214
R3849 a_28591_n2146.n31 a_28591_n2146.n30 0.746214
R3850 a_28591_n2146.n27 a_28591_n2146.n26 0.746214
R3851 a_28591_n2146.n23 a_28591_n2146.n22 0.746214
R3852 a_28591_n2146.n19 a_28591_n2146.n18 0.746214
R3853 a_28591_n2146.n15 a_28591_n2146.n14 0.746214
R3854 a_28591_n2146.n2 a_28591_n2146.n1 0.662643
R3855 a_28591_n2146.n4 a_28591_n2146.n3 0.662643
R3856 a_28591_n2146.n6 a_28591_n2146.n5 0.662643
R3857 a_28591_n2146.n8 a_28591_n2146.n7 0.662643
R3858 a_28591_n2146.n31 a_28591_n2146.n9 0.662643
R3859 a_28591_n2146.n30 a_28591_n2146.n29 0.662643
R3860 a_28591_n2146.n28 a_28591_n2146.n27 0.662643
R3861 a_28591_n2146.n26 a_28591_n2146.n25 0.662643
R3862 a_28591_n2146.n24 a_28591_n2146.n23 0.662643
R3863 a_28591_n2146.n22 a_28591_n2146.n21 0.662643
R3864 a_28591_n2146.n20 a_28591_n2146.n19 0.662643
R3865 a_28591_n2146.n18 a_28591_n2146.n17 0.662643
R3866 a_28591_n2146.n16 a_28591_n2146.n15 0.662643
R3867 a_28591_n2146.n14 a_28591_n2146.n13 0.662643
R3868 a_28591_n2146.n12 a_28591_n2146.n11 0.662643
R3869 a_28591_n2146.n1 a_28591_n2146.n0 0.4505
R3870 a_28591_n2146.n5 a_28591_n2146.n4 0.4505
R3871 a_28591_n2146.n9 a_28591_n2146.n8 0.4505
R3872 a_28591_n2146.n29 a_28591_n2146.n28 0.4505
R3873 a_28591_n2146.n25 a_28591_n2146.n24 0.4505
R3874 a_28591_n2146.n21 a_28591_n2146.n20 0.4505
R3875 a_28591_n2146.n17 a_28591_n2146.n16 0.4505
R3876 a_28591_n2146.n13 a_28591_n2146.n12 0.4505
R3877 a_3601_n862.n3 a_3601_n862.t32 18.9023
R3878 a_3601_n862.n0 a_3601_n862.t1 16.1132
R3879 a_3601_n862.n3 a_3601_n862.t33 15.6434
R3880 a_3601_n862.n2 a_3601_n862.t7 15.4511
R3881 a_3601_n862.n28 a_3601_n862.t4 15.4511
R3882 a_3601_n862.n27 a_3601_n862.t15 15.4511
R3883 a_3601_n862.n24 a_3601_n862.t23 15.4511
R3884 a_3601_n862.n23 a_3601_n862.t18 15.4511
R3885 a_3601_n862.n20 a_3601_n862.t3 15.4511
R3886 a_3601_n862.n19 a_3601_n862.t11 15.4511
R3887 a_3601_n862.n16 a_3601_n862.t17 15.4511
R3888 a_3601_n862.n15 a_3601_n862.t5 15.4511
R3889 a_3601_n862.n12 a_3601_n862.t14 15.4511
R3890 a_3601_n862.n11 a_3601_n862.t10 15.4511
R3891 a_3601_n862.n8 a_3601_n862.t12 15.4511
R3892 a_3601_n862.n7 a_3601_n862.t6 15.4511
R3893 a_3601_n862.n4 a_3601_n862.t2 15.4511
R3894 a_3601_n862.t0 a_3601_n862.n31 15.4511
R3895 a_3601_n862.n0 a_3601_n862.t26 14.8566
R3896 a_3601_n862.n1 a_3601_n862.t28 14.8566
R3897 a_3601_n862.n30 a_3601_n862.t24 14.8566
R3898 a_3601_n862.n29 a_3601_n862.t21 14.8566
R3899 a_3601_n862.n26 a_3601_n862.t22 14.8566
R3900 a_3601_n862.n25 a_3601_n862.t29 14.8566
R3901 a_3601_n862.n22 a_3601_n862.t8 14.8566
R3902 a_3601_n862.n21 a_3601_n862.t9 14.8566
R3903 a_3601_n862.n18 a_3601_n862.t16 14.8566
R3904 a_3601_n862.n17 a_3601_n862.t19 14.8566
R3905 a_3601_n862.n14 a_3601_n862.t27 14.8566
R3906 a_3601_n862.n13 a_3601_n862.t25 14.8566
R3907 a_3601_n862.n10 a_3601_n862.t13 14.8566
R3908 a_3601_n862.n9 a_3601_n862.t20 14.8566
R3909 a_3601_n862.n6 a_3601_n862.t30 14.8566
R3910 a_3601_n862.n5 a_3601_n862.t31 14.8566
R3911 a_3601_n862.n4 a_3601_n862.n3 14.5641
R3912 a_3601_n862.n31 a_3601_n862.n2 0.746214
R3913 a_3601_n862.n28 a_3601_n862.n27 0.746214
R3914 a_3601_n862.n24 a_3601_n862.n23 0.746214
R3915 a_3601_n862.n20 a_3601_n862.n19 0.746214
R3916 a_3601_n862.n16 a_3601_n862.n15 0.746214
R3917 a_3601_n862.n12 a_3601_n862.n11 0.746214
R3918 a_3601_n862.n8 a_3601_n862.n7 0.746214
R3919 a_3601_n862.n2 a_3601_n862.n1 0.662643
R3920 a_3601_n862.n31 a_3601_n862.n30 0.662643
R3921 a_3601_n862.n29 a_3601_n862.n28 0.662643
R3922 a_3601_n862.n27 a_3601_n862.n26 0.662643
R3923 a_3601_n862.n25 a_3601_n862.n24 0.662643
R3924 a_3601_n862.n23 a_3601_n862.n22 0.662643
R3925 a_3601_n862.n21 a_3601_n862.n20 0.662643
R3926 a_3601_n862.n19 a_3601_n862.n18 0.662643
R3927 a_3601_n862.n17 a_3601_n862.n16 0.662643
R3928 a_3601_n862.n15 a_3601_n862.n14 0.662643
R3929 a_3601_n862.n13 a_3601_n862.n12 0.662643
R3930 a_3601_n862.n11 a_3601_n862.n10 0.662643
R3931 a_3601_n862.n9 a_3601_n862.n8 0.662643
R3932 a_3601_n862.n7 a_3601_n862.n6 0.662643
R3933 a_3601_n862.n5 a_3601_n862.n4 0.662643
R3934 a_3601_n862.n1 a_3601_n862.n0 0.4505
R3935 a_3601_n862.n30 a_3601_n862.n29 0.4505
R3936 a_3601_n862.n26 a_3601_n862.n25 0.4505
R3937 a_3601_n862.n22 a_3601_n862.n21 0.4505
R3938 a_3601_n862.n18 a_3601_n862.n17 0.4505
R3939 a_3601_n862.n14 a_3601_n862.n13 0.4505
R3940 a_3601_n862.n10 a_3601_n862.n9 0.4505
R3941 a_3601_n862.n6 a_3601_n862.n5 0.4505
R3942 RA14.t30 RA14.t11 70.3934
R3943 RA14.t25 RA14.t7 70.3934
R3944 RA14.t36 RA14.t43 70.3934
R3945 RA14.t28 RA14.t6 70.3934
R3946 RA14.t22 RA14.t44 70.3934
R3947 RA14.t13 RA14.t40 70.3934
R3948 RA14.t20 RA14.t37 70.3934
R3949 RA14.t12 RA14.t39 70.3934
R3950 RA14.t24 RA14.t2 70.3934
R3951 RA14.t21 RA14.t42 70.3934
R3952 RA14.t27 RA14.t4 70.3934
R3953 RA14.t19 RA14.t47 70.3934
R3954 RA14.t34 RA14.t8 70.3934
R3955 RA14.t23 RA14.t1 70.3934
R3956 RA14.t35 RA14.t10 70.3934
R3957 RA14.t26 RA14.t38 70.3934
R3958 RA14.n29 RA14.t30 31.2862
R3959 RA14.n27 RA14.t25 31.2862
R3960 RA14.n25 RA14.t36 31.2862
R3961 RA14.n23 RA14.t28 31.2862
R3962 RA14.n21 RA14.t22 31.2862
R3963 RA14.n19 RA14.t13 31.2862
R3964 RA14.n17 RA14.t20 31.2862
R3965 RA14.n15 RA14.t12 31.2862
R3966 RA14.n13 RA14.t24 31.2862
R3967 RA14.n11 RA14.t21 31.2862
R3968 RA14.n9 RA14.t27 31.2862
R3969 RA14.n7 RA14.t19 31.2862
R3970 RA14.n5 RA14.t34 31.2862
R3971 RA14.n3 RA14.t23 31.2862
R3972 RA14.n1 RA14.t35 31.2862
R3973 RA14.n0 RA14.t26 31.2862
R3974 RA14.n2 RA14.n0 21.0181
R3975 RA14.n30 RA14.n29 17.0453
R3976 RA14.n28 RA14.n27 17.0453
R3977 RA14.n26 RA14.n25 17.0453
R3978 RA14.n24 RA14.n23 17.0453
R3979 RA14.n22 RA14.n21 17.0453
R3980 RA14.n20 RA14.n19 17.0453
R3981 RA14.n18 RA14.n17 17.0453
R3982 RA14.n16 RA14.n15 17.0453
R3983 RA14.n14 RA14.n13 17.0453
R3984 RA14.n12 RA14.n11 17.0453
R3985 RA14.n10 RA14.n9 17.0453
R3986 RA14.n8 RA14.n7 17.0453
R3987 RA14.n6 RA14.n5 17.0453
R3988 RA14.n4 RA14.n3 17.0453
R3989 RA14.n2 RA14.n1 17.0453
R3990 RA14.n29 RA14.t9 15.6434
R3991 RA14.n27 RA14.t33 15.6434
R3992 RA14.n25 RA14.t32 15.6434
R3993 RA14.n23 RA14.t46 15.6434
R3994 RA14.n21 RA14.t0 15.6434
R3995 RA14.n19 RA14.t14 15.6434
R3996 RA14.n17 RA14.t29 15.6434
R3997 RA14.n15 RA14.t41 15.6434
R3998 RA14.n13 RA14.t3 15.6434
R3999 RA14.n11 RA14.t16 15.6434
R4000 RA14.n9 RA14.t15 15.6434
R4001 RA14.n7 RA14.t45 15.6434
R4002 RA14.n5 RA14.t5 15.6434
R4003 RA14.n3 RA14.t18 15.6434
R4004 RA14.n1 RA14.t17 15.6434
R4005 RA14.n0 RA14.t31 15.6434
R4006 RA14 RA14.n30 4.5005
R4007 RA14.n4 RA14.n2 3.97336
R4008 RA14.n6 RA14.n4 3.97336
R4009 RA14.n8 RA14.n6 3.97336
R4010 RA14.n10 RA14.n8 3.97336
R4011 RA14.n12 RA14.n10 3.97336
R4012 RA14.n14 RA14.n12 3.97336
R4013 RA14.n16 RA14.n14 3.97336
R4014 RA14.n18 RA14.n16 3.97336
R4015 RA14.n20 RA14.n18 3.97336
R4016 RA14.n22 RA14.n20 3.97336
R4017 RA14.n24 RA14.n22 3.97336
R4018 RA14.n26 RA14.n24 3.97336
R4019 RA14.n28 RA14.n26 3.97336
R4020 RA14.n30 RA14.n28 3.97336
R4021 a_26119_n2146.n10 a_26119_n2146.t32 18.9023
R4022 a_26119_n2146.n0 a_26119_n2146.t25 16.1106
R4023 a_26119_n2146.n10 a_26119_n2146.t33 15.6434
R4024 a_26119_n2146.n2 a_26119_n2146.t4 15.4484
R4025 a_26119_n2146.n3 a_26119_n2146.t8 15.4484
R4026 a_26119_n2146.n6 a_26119_n2146.t15 15.4484
R4027 a_26119_n2146.n7 a_26119_n2146.t2 15.4484
R4028 a_26119_n2146.n30 a_26119_n2146.t7 15.4484
R4029 a_26119_n2146.n27 a_26119_n2146.t20 15.4484
R4030 a_26119_n2146.n26 a_26119_n2146.t1 15.4484
R4031 a_26119_n2146.n23 a_26119_n2146.t16 15.4484
R4032 a_26119_n2146.n22 a_26119_n2146.t9 15.4484
R4033 a_26119_n2146.n19 a_26119_n2146.t3 15.4484
R4034 a_26119_n2146.n18 a_26119_n2146.t5 15.4484
R4035 a_26119_n2146.n15 a_26119_n2146.t10 15.4484
R4036 a_26119_n2146.n14 a_26119_n2146.t14 15.4484
R4037 a_26119_n2146.n11 a_26119_n2146.t6 15.4484
R4038 a_26119_n2146.t0 a_26119_n2146.n31 15.4484
R4039 a_26119_n2146.n0 a_26119_n2146.t13 14.854
R4040 a_26119_n2146.n1 a_26119_n2146.t26 14.854
R4041 a_26119_n2146.n4 a_26119_n2146.t11 14.854
R4042 a_26119_n2146.n5 a_26119_n2146.t24 14.854
R4043 a_26119_n2146.n8 a_26119_n2146.t30 14.854
R4044 a_26119_n2146.n9 a_26119_n2146.t27 14.854
R4045 a_26119_n2146.n29 a_26119_n2146.t18 14.854
R4046 a_26119_n2146.n28 a_26119_n2146.t31 14.854
R4047 a_26119_n2146.n25 a_26119_n2146.t29 14.854
R4048 a_26119_n2146.n24 a_26119_n2146.t22 14.854
R4049 a_26119_n2146.n21 a_26119_n2146.t23 14.854
R4050 a_26119_n2146.n20 a_26119_n2146.t21 14.854
R4051 a_26119_n2146.n17 a_26119_n2146.t12 14.854
R4052 a_26119_n2146.n16 a_26119_n2146.t17 14.854
R4053 a_26119_n2146.n13 a_26119_n2146.t28 14.854
R4054 a_26119_n2146.n12 a_26119_n2146.t19 14.854
R4055 a_26119_n2146.n11 a_26119_n2146.n10 14.5641
R4056 a_26119_n2146.n3 a_26119_n2146.n2 0.746214
R4057 a_26119_n2146.n7 a_26119_n2146.n6 0.746214
R4058 a_26119_n2146.n31 a_26119_n2146.n30 0.746214
R4059 a_26119_n2146.n27 a_26119_n2146.n26 0.746214
R4060 a_26119_n2146.n23 a_26119_n2146.n22 0.746214
R4061 a_26119_n2146.n19 a_26119_n2146.n18 0.746214
R4062 a_26119_n2146.n15 a_26119_n2146.n14 0.746214
R4063 a_26119_n2146.n2 a_26119_n2146.n1 0.662643
R4064 a_26119_n2146.n4 a_26119_n2146.n3 0.662643
R4065 a_26119_n2146.n6 a_26119_n2146.n5 0.662643
R4066 a_26119_n2146.n8 a_26119_n2146.n7 0.662643
R4067 a_26119_n2146.n31 a_26119_n2146.n9 0.662643
R4068 a_26119_n2146.n30 a_26119_n2146.n29 0.662643
R4069 a_26119_n2146.n28 a_26119_n2146.n27 0.662643
R4070 a_26119_n2146.n26 a_26119_n2146.n25 0.662643
R4071 a_26119_n2146.n24 a_26119_n2146.n23 0.662643
R4072 a_26119_n2146.n22 a_26119_n2146.n21 0.662643
R4073 a_26119_n2146.n20 a_26119_n2146.n19 0.662643
R4074 a_26119_n2146.n18 a_26119_n2146.n17 0.662643
R4075 a_26119_n2146.n16 a_26119_n2146.n15 0.662643
R4076 a_26119_n2146.n14 a_26119_n2146.n13 0.662643
R4077 a_26119_n2146.n12 a_26119_n2146.n11 0.662643
R4078 a_26119_n2146.n1 a_26119_n2146.n0 0.4505
R4079 a_26119_n2146.n5 a_26119_n2146.n4 0.4505
R4080 a_26119_n2146.n9 a_26119_n2146.n8 0.4505
R4081 a_26119_n2146.n29 a_26119_n2146.n28 0.4505
R4082 a_26119_n2146.n25 a_26119_n2146.n24 0.4505
R4083 a_26119_n2146.n21 a_26119_n2146.n20 0.4505
R4084 a_26119_n2146.n17 a_26119_n2146.n16 0.4505
R4085 a_26119_n2146.n13 a_26119_n2146.n12 0.4505
R4086 RB11.t44 RB11.t23 69.3795
R4087 RB11.t29 RB11.t34 69.3795
R4088 RB11.t28 RB11.t2 69.3795
R4089 RB11.t3 RB11.t1 69.3795
R4090 RB11.t8 RB11.t17 69.3795
R4091 RB11.t26 RB11.t33 69.3795
R4092 RB11.t25 RB11.t47 69.3795
R4093 RB11.t40 RB11.t45 69.3795
R4094 RB11.t12 RB11.t20 69.3795
R4095 RB11.t11 RB11.t19 69.3795
R4096 RB11.t27 RB11.t0 69.3795
R4097 RB11.t36 RB11.t14 69.3795
R4098 RB11.t46 RB11.t24 69.3795
R4099 RB11.t13 RB11.t22 69.3795
R4100 RB11.t30 RB11.t37 69.3795
R4101 RB11.t38 RB11.t15 69.3795
R4102 RB11.n29 RB11.t31 30.2434
R4103 RB11.n27 RB11.t9 30.2434
R4104 RB11.n25 RB11.t7 30.2434
R4105 RB11.n23 RB11.t35 30.2434
R4106 RB11.n21 RB11.t39 30.2434
R4107 RB11.n19 RB11.t5 30.2434
R4108 RB11.n17 RB11.t4 30.2434
R4109 RB11.n15 RB11.t21 30.2434
R4110 RB11.n13 RB11.t42 30.2434
R4111 RB11.n11 RB11.t41 30.2434
R4112 RB11.n9 RB11.t6 30.2434
R4113 RB11.n7 RB11.t16 30.2434
R4114 RB11.n5 RB11.t32 30.2434
R4115 RB11.n3 RB11.t43 30.2434
R4116 RB11.n1 RB11.t10 30.2434
R4117 RB11.n0 RB11.t18 30.2434
R4118 RB11.n2 RB11.n0 21.0176
R4119 RB11.n30 RB11.n29 17.0448
R4120 RB11.n28 RB11.n27 17.0448
R4121 RB11.n26 RB11.n25 17.0448
R4122 RB11.n24 RB11.n23 17.0448
R4123 RB11.n22 RB11.n21 17.0448
R4124 RB11.n20 RB11.n19 17.0448
R4125 RB11.n18 RB11.n17 17.0448
R4126 RB11.n16 RB11.n15 17.0448
R4127 RB11.n14 RB11.n13 17.0448
R4128 RB11.n12 RB11.n11 17.0448
R4129 RB11.n10 RB11.n9 17.0448
R4130 RB11.n8 RB11.n7 17.0448
R4131 RB11.n6 RB11.n5 17.0448
R4132 RB11.n4 RB11.n3 17.0448
R4133 RB11.n2 RB11.n1 17.0448
R4134 RB11.n29 RB11.t44 16.6862
R4135 RB11.n27 RB11.t29 16.6862
R4136 RB11.n25 RB11.t28 16.6862
R4137 RB11.n23 RB11.t3 16.6862
R4138 RB11.n21 RB11.t8 16.6862
R4139 RB11.n19 RB11.t26 16.6862
R4140 RB11.n17 RB11.t25 16.6862
R4141 RB11.n15 RB11.t40 16.6862
R4142 RB11.n13 RB11.t12 16.6862
R4143 RB11.n11 RB11.t11 16.6862
R4144 RB11.n9 RB11.t27 16.6862
R4145 RB11.n7 RB11.t36 16.6862
R4146 RB11.n5 RB11.t46 16.6862
R4147 RB11.n3 RB11.t13 16.6862
R4148 RB11.n1 RB11.t30 16.6862
R4149 RB11.n0 RB11.t38 16.6862
R4150 RB11 RB11.n30 5.783
R4151 RB11.n4 RB11.n2 3.97336
R4152 RB11.n6 RB11.n4 3.97336
R4153 RB11.n8 RB11.n6 3.97336
R4154 RB11.n10 RB11.n8 3.97336
R4155 RB11.n12 RB11.n10 3.97336
R4156 RB11.n14 RB11.n12 3.97336
R4157 RB11.n16 RB11.n14 3.97336
R4158 RB11.n18 RB11.n16 3.97336
R4159 RB11.n20 RB11.n18 3.97336
R4160 RB11.n22 RB11.n20 3.97336
R4161 RB11.n24 RB11.n22 3.97336
R4162 RB11.n26 RB11.n24 3.97336
R4163 RB11.n28 RB11.n26 3.97336
R4164 RB11.n30 RB11.n28 3.97336
R4165 RA15.t11 RA15.t34 70.3934
R4166 RA15.t37 RA15.t45 70.3934
R4167 RA15.t36 RA15.t24 70.3934
R4168 RA15.t2 RA15.t22 70.3934
R4169 RA15.t3 RA15.t31 70.3934
R4170 RA15.t15 RA15.t41 70.3934
R4171 RA15.t33 RA15.t9 70.3934
R4172 RA15.t0 RA15.t20 70.3934
R4173 RA15.t4 RA15.t26 70.3934
R4174 RA15.t18 RA15.t44 70.3934
R4175 RA15.t17 RA15.t43 70.3934
R4176 RA15.t1 RA15.t10 70.3934
R4177 RA15.t5 RA15.t29 70.3934
R4178 RA15.t21 RA15.t47 70.3934
R4179 RA15.t19 RA15.t46 70.3934
R4180 RA15.t35 RA15.t23 70.3934
R4181 RA15.n29 RA15.t11 31.2862
R4182 RA15.n27 RA15.t37 31.2862
R4183 RA15.n25 RA15.t36 31.2862
R4184 RA15.n23 RA15.t2 31.2862
R4185 RA15.n21 RA15.t3 31.2862
R4186 RA15.n19 RA15.t15 31.2862
R4187 RA15.n17 RA15.t33 31.2862
R4188 RA15.n15 RA15.t0 31.2862
R4189 RA15.n13 RA15.t4 31.2862
R4190 RA15.n11 RA15.t18 31.2862
R4191 RA15.n9 RA15.t17 31.2862
R4192 RA15.n7 RA15.t1 31.2862
R4193 RA15.n5 RA15.t5 31.2862
R4194 RA15.n3 RA15.t21 31.2862
R4195 RA15.n1 RA15.t19 31.2862
R4196 RA15.n0 RA15.t35 31.2862
R4197 RA15.n2 RA15.n0 21.0181
R4198 RA15.n30 RA15.n29 17.0453
R4199 RA15.n28 RA15.n27 17.0453
R4200 RA15.n26 RA15.n25 17.0453
R4201 RA15.n24 RA15.n23 17.0453
R4202 RA15.n22 RA15.n21 17.0453
R4203 RA15.n20 RA15.n19 17.0453
R4204 RA15.n18 RA15.n17 17.0453
R4205 RA15.n16 RA15.n15 17.0453
R4206 RA15.n14 RA15.n13 17.0453
R4207 RA15.n12 RA15.n11 17.0453
R4208 RA15.n10 RA15.n9 17.0453
R4209 RA15.n8 RA15.n7 17.0453
R4210 RA15.n6 RA15.n5 17.0453
R4211 RA15.n4 RA15.n3 17.0453
R4212 RA15.n2 RA15.n1 17.0453
R4213 RA15.n29 RA15.t16 15.6434
R4214 RA15.n27 RA15.t42 15.6434
R4215 RA15.n25 RA15.t40 15.6434
R4216 RA15.n23 RA15.t8 15.6434
R4217 RA15.n21 RA15.t12 15.6434
R4218 RA15.n19 RA15.t25 15.6434
R4219 RA15.n17 RA15.t38 15.6434
R4220 RA15.n15 RA15.t6 15.6434
R4221 RA15.n13 RA15.t13 15.6434
R4222 RA15.n11 RA15.t28 15.6434
R4223 RA15.n9 RA15.t27 15.6434
R4224 RA15.n7 RA15.t7 15.6434
R4225 RA15.n5 RA15.t14 15.6434
R4226 RA15.n3 RA15.t32 15.6434
R4227 RA15.n1 RA15.t30 15.6434
R4228 RA15.n0 RA15.t39 15.6434
R4229 RA15 RA15.n30 4.50854
R4230 RA15.n4 RA15.n2 3.97336
R4231 RA15.n6 RA15.n4 3.97336
R4232 RA15.n8 RA15.n6 3.97336
R4233 RA15.n10 RA15.n8 3.97336
R4234 RA15.n12 RA15.n10 3.97336
R4235 RA15.n14 RA15.n12 3.97336
R4236 RA15.n16 RA15.n14 3.97336
R4237 RA15.n18 RA15.n16 3.97336
R4238 RA15.n20 RA15.n18 3.97336
R4239 RA15.n22 RA15.n20 3.97336
R4240 RA15.n24 RA15.n22 3.97336
R4241 RA15.n26 RA15.n24 3.97336
R4242 RA15.n28 RA15.n26 3.97336
R4243 RA15.n30 RA15.n28 3.97336
R4244 RA0.t24 RA0.t18 70.3934
R4245 RA0.t15 RA0.t34 70.3934
R4246 RA0.t46 RA0.t44 70.3934
R4247 RA0.t25 RA0.t29 70.3934
R4248 RA0.t47 RA0.t10 70.3934
R4249 RA0.t26 RA0.t30 70.3934
R4250 RA0.t43 RA0.t1 70.3934
R4251 RA0.t19 RA0.t22 70.3934
R4252 RA0.t3 RA0.t5 70.3934
R4253 RA0.t32 RA0.t36 70.3934
R4254 RA0.t9 RA0.t16 70.3934
R4255 RA0.t27 RA0.t42 70.3934
R4256 RA0.t8 RA0.t13 70.3934
R4257 RA0.t38 RA0.t41 70.3934
R4258 RA0.t20 RA0.t23 70.3934
R4259 RA0.t35 RA0.t33 70.3934
R4260 RA0.n29 RA0.t24 31.2862
R4261 RA0.n27 RA0.t15 31.2862
R4262 RA0.n25 RA0.t46 31.2862
R4263 RA0.n23 RA0.t25 31.2862
R4264 RA0.n21 RA0.t47 31.2862
R4265 RA0.n19 RA0.t26 31.2862
R4266 RA0.n17 RA0.t43 31.2862
R4267 RA0.n15 RA0.t19 31.2862
R4268 RA0.n13 RA0.t3 31.2862
R4269 RA0.n11 RA0.t32 31.2862
R4270 RA0.n9 RA0.t9 31.2862
R4271 RA0.n7 RA0.t27 31.2862
R4272 RA0.n5 RA0.t8 31.2862
R4273 RA0.n3 RA0.t38 31.2862
R4274 RA0.n1 RA0.t20 31.2862
R4275 RA0.n0 RA0.t35 31.2862
R4276 RA0.n2 RA0.n0 21.0181
R4277 RA0.n30 RA0.n29 17.0453
R4278 RA0.n28 RA0.n27 17.0453
R4279 RA0.n26 RA0.n25 17.0453
R4280 RA0.n24 RA0.n23 17.0453
R4281 RA0.n22 RA0.n21 17.0453
R4282 RA0.n20 RA0.n19 17.0453
R4283 RA0.n18 RA0.n17 17.0453
R4284 RA0.n16 RA0.n15 17.0453
R4285 RA0.n14 RA0.n13 17.0453
R4286 RA0.n12 RA0.n11 17.0453
R4287 RA0.n10 RA0.n9 17.0453
R4288 RA0.n8 RA0.n7 17.0453
R4289 RA0.n6 RA0.n5 17.0453
R4290 RA0.n4 RA0.n3 17.0453
R4291 RA0.n2 RA0.n1 17.0453
R4292 RA0.n29 RA0.t11 15.6434
R4293 RA0.n27 RA0.t4 15.6434
R4294 RA0.n25 RA0.t39 15.6434
R4295 RA0.n23 RA0.t12 15.6434
R4296 RA0.n21 RA0.t40 15.6434
R4297 RA0.n19 RA0.t14 15.6434
R4298 RA0.n17 RA0.t37 15.6434
R4299 RA0.n15 RA0.t6 15.6434
R4300 RA0.n13 RA0.t45 15.6434
R4301 RA0.n11 RA0.t21 15.6434
R4302 RA0.n9 RA0.t2 15.6434
R4303 RA0.n7 RA0.t17 15.6434
R4304 RA0.n5 RA0.t0 15.6434
R4305 RA0.n3 RA0.t31 15.6434
R4306 RA0.n1 RA0.t7 15.6434
R4307 RA0.n0 RA0.t28 15.6434
R4308 RA0 RA0.n30 4.49729
R4309 RA0.n4 RA0.n2 3.97336
R4310 RA0.n6 RA0.n4 3.97336
R4311 RA0.n8 RA0.n6 3.97336
R4312 RA0.n10 RA0.n8 3.97336
R4313 RA0.n12 RA0.n10 3.97336
R4314 RA0.n14 RA0.n12 3.97336
R4315 RA0.n16 RA0.n14 3.97336
R4316 RA0.n18 RA0.n16 3.97336
R4317 RA0.n20 RA0.n18 3.97336
R4318 RA0.n22 RA0.n20 3.97336
R4319 RA0.n24 RA0.n22 3.97336
R4320 RA0.n26 RA0.n24 3.97336
R4321 RA0.n28 RA0.n26 3.97336
R4322 RA0.n30 RA0.n28 3.97336
R4323 QA6b.n0 QA6b.t1 13.1454
R4324 QA6b.n0 QA6b.t0 9.29658
R4325 QA6b QA6b.n0 4.69014
R4326 RB4.t12 RB4.t40 69.3795
R4327 RB4.t46 RB4.t4 69.3795
R4328 RB4.t45 RB4.t19 69.3795
R4329 RB4.t23 RB4.t18 69.3795
R4330 RB4.t24 RB4.t36 69.3795
R4331 RB4.t43 RB4.t3 69.3795
R4332 RB4.t42 RB4.t15 69.3795
R4333 RB4.t10 RB4.t13 69.3795
R4334 RB4.t26 RB4.t38 69.3795
R4335 RB4.t25 RB4.t37 69.3795
R4336 RB4.t44 RB4.t17 69.3795
R4337 RB4.t5 RB4.t28 69.3795
R4338 RB4.t14 RB4.t41 69.3795
R4339 RB4.t27 RB4.t39 69.3795
R4340 RB4.t47 RB4.t6 69.3795
R4341 RB4.t7 RB4.t29 69.3795
R4342 RB4.n29 RB4.t8 30.2434
R4343 RB4.n27 RB4.t34 30.2434
R4344 RB4.n25 RB4.t33 30.2434
R4345 RB4.n23 RB4.t11 30.2434
R4346 RB4.n21 RB4.t16 30.2434
R4347 RB4.n19 RB4.t31 30.2434
R4348 RB4.n17 RB4.t30 30.2434
R4349 RB4.n15 RB4.t2 30.2434
R4350 RB4.n13 RB4.t21 30.2434
R4351 RB4.n11 RB4.t20 30.2434
R4352 RB4.n9 RB4.t32 30.2434
R4353 RB4.n7 RB4.t0 30.2434
R4354 RB4.n5 RB4.t9 30.2434
R4355 RB4.n3 RB4.t22 30.2434
R4356 RB4.n1 RB4.t35 30.2434
R4357 RB4.n0 RB4.t1 30.2434
R4358 RB4.n2 RB4.n0 21.0176
R4359 RB4.n30 RB4.n29 17.0448
R4360 RB4.n28 RB4.n27 17.0448
R4361 RB4.n26 RB4.n25 17.0448
R4362 RB4.n24 RB4.n23 17.0448
R4363 RB4.n22 RB4.n21 17.0448
R4364 RB4.n20 RB4.n19 17.0448
R4365 RB4.n18 RB4.n17 17.0448
R4366 RB4.n16 RB4.n15 17.0448
R4367 RB4.n14 RB4.n13 17.0448
R4368 RB4.n12 RB4.n11 17.0448
R4369 RB4.n10 RB4.n9 17.0448
R4370 RB4.n8 RB4.n7 17.0448
R4371 RB4.n6 RB4.n5 17.0448
R4372 RB4.n4 RB4.n3 17.0448
R4373 RB4.n2 RB4.n1 17.0448
R4374 RB4.n29 RB4.t12 16.6862
R4375 RB4.n27 RB4.t46 16.6862
R4376 RB4.n25 RB4.t45 16.6862
R4377 RB4.n23 RB4.t23 16.6862
R4378 RB4.n21 RB4.t24 16.6862
R4379 RB4.n19 RB4.t43 16.6862
R4380 RB4.n17 RB4.t42 16.6862
R4381 RB4.n15 RB4.t10 16.6862
R4382 RB4.n13 RB4.t26 16.6862
R4383 RB4.n11 RB4.t25 16.6862
R4384 RB4.n9 RB4.t44 16.6862
R4385 RB4.n7 RB4.t5 16.6862
R4386 RB4.n5 RB4.t14 16.6862
R4387 RB4.n3 RB4.t27 16.6862
R4388 RB4.n1 RB4.t47 16.6862
R4389 RB4.n0 RB4.t7 16.6862
R4390 RB4 RB4.n30 5.78139
R4391 RB4.n4 RB4.n2 3.97336
R4392 RB4.n6 RB4.n4 3.97336
R4393 RB4.n8 RB4.n6 3.97336
R4394 RB4.n10 RB4.n8 3.97336
R4395 RB4.n12 RB4.n10 3.97336
R4396 RB4.n14 RB4.n12 3.97336
R4397 RB4.n16 RB4.n14 3.97336
R4398 RB4.n18 RB4.n16 3.97336
R4399 RB4.n20 RB4.n18 3.97336
R4400 RB4.n22 RB4.n20 3.97336
R4401 RB4.n24 RB4.n22 3.97336
R4402 RB4.n26 RB4.n24 3.97336
R4403 RB4.n28 RB4.n26 3.97336
R4404 RB4.n30 RB4.n28 3.97336
R4405 QB10b.n0 QB10b.t1 13.1454
R4406 QB10b.n0 QB10b.t0 9.29658
R4407 QB10b QB10b.n0 4.69014
R4408 RB8.t11 RB8.t40 69.3795
R4409 RB8.t46 RB8.t3 69.3795
R4410 RB8.t45 RB8.t18 69.3795
R4411 RB8.t23 RB8.t17 69.3795
R4412 RB8.t24 RB8.t32 69.3795
R4413 RB8.t43 RB8.t1 69.3795
R4414 RB8.t42 RB8.t14 69.3795
R4415 RB8.t8 RB8.t12 69.3795
R4416 RB8.t26 RB8.t37 69.3795
R4417 RB8.t25 RB8.t35 69.3795
R4418 RB8.t44 RB8.t16 69.3795
R4419 RB8.t5 RB8.t28 69.3795
R4420 RB8.t13 RB8.t41 69.3795
R4421 RB8.t27 RB8.t39 69.3795
R4422 RB8.t47 RB8.t6 69.3795
R4423 RB8.t7 RB8.t29 69.3795
R4424 RB8.n29 RB8.t9 30.2434
R4425 RB8.n27 RB8.t36 30.2434
R4426 RB8.n25 RB8.t34 30.2434
R4427 RB8.n23 RB8.t15 30.2434
R4428 RB8.n21 RB8.t19 30.2434
R4429 RB8.n19 RB8.t31 30.2434
R4430 RB8.n17 RB8.t30 30.2434
R4431 RB8.n15 RB8.t4 30.2434
R4432 RB8.n13 RB8.t21 30.2434
R4433 RB8.n11 RB8.t20 30.2434
R4434 RB8.n9 RB8.t33 30.2434
R4435 RB8.n7 RB8.t0 30.2434
R4436 RB8.n5 RB8.t10 30.2434
R4437 RB8.n3 RB8.t22 30.2434
R4438 RB8.n1 RB8.t38 30.2434
R4439 RB8.n0 RB8.t2 30.2434
R4440 RB8.n2 RB8.n0 21.0176
R4441 RB8.n30 RB8.n29 17.0448
R4442 RB8.n28 RB8.n27 17.0448
R4443 RB8.n26 RB8.n25 17.0448
R4444 RB8.n24 RB8.n23 17.0448
R4445 RB8.n22 RB8.n21 17.0448
R4446 RB8.n20 RB8.n19 17.0448
R4447 RB8.n18 RB8.n17 17.0448
R4448 RB8.n16 RB8.n15 17.0448
R4449 RB8.n14 RB8.n13 17.0448
R4450 RB8.n12 RB8.n11 17.0448
R4451 RB8.n10 RB8.n9 17.0448
R4452 RB8.n8 RB8.n7 17.0448
R4453 RB8.n6 RB8.n5 17.0448
R4454 RB8.n4 RB8.n3 17.0448
R4455 RB8.n2 RB8.n1 17.0448
R4456 RB8.n29 RB8.t11 16.6862
R4457 RB8.n27 RB8.t46 16.6862
R4458 RB8.n25 RB8.t45 16.6862
R4459 RB8.n23 RB8.t23 16.6862
R4460 RB8.n21 RB8.t24 16.6862
R4461 RB8.n19 RB8.t43 16.6862
R4462 RB8.n17 RB8.t42 16.6862
R4463 RB8.n15 RB8.t8 16.6862
R4464 RB8.n13 RB8.t26 16.6862
R4465 RB8.n11 RB8.t25 16.6862
R4466 RB8.n9 RB8.t44 16.6862
R4467 RB8.n7 RB8.t5 16.6862
R4468 RB8.n5 RB8.t13 16.6862
R4469 RB8.n3 RB8.t27 16.6862
R4470 RB8.n1 RB8.t47 16.6862
R4471 RB8.n0 RB8.t7 16.6862
R4472 RB8 RB8.n30 5.77979
R4473 RB8.n4 RB8.n2 3.97336
R4474 RB8.n6 RB8.n4 3.97336
R4475 RB8.n8 RB8.n6 3.97336
R4476 RB8.n10 RB8.n8 3.97336
R4477 RB8.n12 RB8.n10 3.97336
R4478 RB8.n14 RB8.n12 3.97336
R4479 RB8.n16 RB8.n14 3.97336
R4480 RB8.n18 RB8.n16 3.97336
R4481 RB8.n20 RB8.n18 3.97336
R4482 RB8.n22 RB8.n20 3.97336
R4483 RB8.n24 RB8.n22 3.97336
R4484 RB8.n26 RB8.n24 3.97336
R4485 RB8.n28 RB8.n26 3.97336
R4486 RB8.n30 RB8.n28 3.97336
R4487 a_n884_6886.n1 a_n884_6886.t16 29.9245
R4488 a_n884_6886.n30 a_n884_6886.t4 29.3395
R4489 a_n884_6886.n28 a_n884_6886.t27 29.3395
R4490 a_n884_6886.n26 a_n884_6886.t15 29.3395
R4491 a_n884_6886.n24 a_n884_6886.t13 29.3395
R4492 a_n884_6886.n22 a_n884_6886.t22 29.3395
R4493 a_n884_6886.n20 a_n884_6886.t20 29.3395
R4494 a_n884_6886.n18 a_n884_6886.t31 29.3395
R4495 a_n884_6886.n16 a_n884_6886.t7 29.3395
R4496 a_n884_6886.n14 a_n884_6886.t5 29.3395
R4497 a_n884_6886.n12 a_n884_6886.t24 29.3395
R4498 a_n884_6886.n10 a_n884_6886.t32 29.3395
R4499 a_n884_6886.n8 a_n884_6886.t11 29.3395
R4500 a_n884_6886.n6 a_n884_6886.t9 29.3395
R4501 a_n884_6886.n4 a_n884_6886.t29 29.3395
R4502 a_n884_6886.n2 a_n884_6886.t34 29.3395
R4503 a_n884_6886.n31 a_n884_6886.t30 27.973
R4504 a_n884_6886.n29 a_n884_6886.t18 27.973
R4505 a_n884_6886.n27 a_n884_6886.t33 27.973
R4506 a_n884_6886.n25 a_n884_6886.t14 27.973
R4507 a_n884_6886.n23 a_n884_6886.t12 27.973
R4508 a_n884_6886.n21 a_n884_6886.t21 27.973
R4509 a_n884_6886.n19 a_n884_6886.t19 27.973
R4510 a_n884_6886.n17 a_n884_6886.t8 27.973
R4511 a_n884_6886.n15 a_n884_6886.t6 27.973
R4512 a_n884_6886.n13 a_n884_6886.t25 27.973
R4513 a_n884_6886.n11 a_n884_6886.t23 27.973
R4514 a_n884_6886.n9 a_n884_6886.t35 27.973
R4515 a_n884_6886.n7 a_n884_6886.t10 27.973
R4516 a_n884_6886.n5 a_n884_6886.t17 27.973
R4517 a_n884_6886.n3 a_n884_6886.t28 27.973
R4518 a_n884_6886.n1 a_n884_6886.t26 27.973
R4519 a_n884_6886.n32 a_n884_6886.n31 10.1914
R4520 a_n884_6886.n32 a_n884_6886.n0 7.10204
R4521 a_n884_6886.n2 a_n884_6886.n1 3.38836
R4522 a_n884_6886.n4 a_n884_6886.n3 3.38836
R4523 a_n884_6886.n6 a_n884_6886.n5 3.38836
R4524 a_n884_6886.n8 a_n884_6886.n7 3.38836
R4525 a_n884_6886.n10 a_n884_6886.n9 3.38836
R4526 a_n884_6886.n12 a_n884_6886.n11 3.38836
R4527 a_n884_6886.n14 a_n884_6886.n13 3.38836
R4528 a_n884_6886.n16 a_n884_6886.n15 3.38836
R4529 a_n884_6886.n18 a_n884_6886.n17 3.38836
R4530 a_n884_6886.n20 a_n884_6886.n19 3.38836
R4531 a_n884_6886.n22 a_n884_6886.n21 3.38836
R4532 a_n884_6886.n24 a_n884_6886.n23 3.38836
R4533 a_n884_6886.n26 a_n884_6886.n25 3.38836
R4534 a_n884_6886.n28 a_n884_6886.n27 3.38836
R4535 a_n884_6886.n30 a_n884_6886.n29 3.38836
R4536 a_n884_6886.n0 a_n884_6886.t3 3.00946
R4537 a_n884_6886.n33 a_n884_6886.n32 2.63313
R4538 a_n884_6886.n0 a_n884_6886.t2 2.44528
R4539 a_n884_6886.t1 a_n884_6886.n33 1.67214
R4540 a_n884_6886.n33 a_n884_6886.t0 1.35871
R4541 a_n884_6886.n3 a_n884_6886.n2 0.5855
R4542 a_n884_6886.n5 a_n884_6886.n4 0.5855
R4543 a_n884_6886.n7 a_n884_6886.n6 0.5855
R4544 a_n884_6886.n9 a_n884_6886.n8 0.5855
R4545 a_n884_6886.n11 a_n884_6886.n10 0.5855
R4546 a_n884_6886.n13 a_n884_6886.n12 0.5855
R4547 a_n884_6886.n15 a_n884_6886.n14 0.5855
R4548 a_n884_6886.n17 a_n884_6886.n16 0.5855
R4549 a_n884_6886.n19 a_n884_6886.n18 0.5855
R4550 a_n884_6886.n21 a_n884_6886.n20 0.5855
R4551 a_n884_6886.n23 a_n884_6886.n22 0.5855
R4552 a_n884_6886.n25 a_n884_6886.n24 0.5855
R4553 a_n884_6886.n27 a_n884_6886.n26 0.5855
R4554 a_n884_6886.n29 a_n884_6886.n28 0.5855
R4555 a_n884_6886.n31 a_n884_6886.n30 0.5855
R4556 a_8815_n2146.n10 a_8815_n2146.t32 18.9023
R4557 a_8815_n2146.n0 a_8815_n2146.t21 16.1106
R4558 a_8815_n2146.n10 a_8815_n2146.t33 15.6434
R4559 a_8815_n2146.n2 a_8815_n2146.t1 15.4484
R4560 a_8815_n2146.n3 a_8815_n2146.t5 15.4484
R4561 a_8815_n2146.n6 a_8815_n2146.t10 15.4484
R4562 a_8815_n2146.n7 a_8815_n2146.t12 15.4484
R4563 a_8815_n2146.n30 a_8815_n2146.t4 15.4484
R4564 a_8815_n2146.n27 a_8815_n2146.t14 15.4484
R4565 a_8815_n2146.n26 a_8815_n2146.t27 15.4484
R4566 a_8815_n2146.n23 a_8815_n2146.t11 15.4484
R4567 a_8815_n2146.n22 a_8815_n2146.t6 15.4484
R4568 a_8815_n2146.n19 a_8815_n2146.t13 15.4484
R4569 a_8815_n2146.n18 a_8815_n2146.t2 15.4484
R4570 a_8815_n2146.n15 a_8815_n2146.t7 15.4484
R4571 a_8815_n2146.n14 a_8815_n2146.t9 15.4484
R4572 a_8815_n2146.n11 a_8815_n2146.t3 15.4484
R4573 a_8815_n2146.t0 a_8815_n2146.n31 15.4484
R4574 a_8815_n2146.n0 a_8815_n2146.t26 14.854
R4575 a_8815_n2146.n1 a_8815_n2146.t30 14.854
R4576 a_8815_n2146.n4 a_8815_n2146.t19 14.854
R4577 a_8815_n2146.n5 a_8815_n2146.t20 14.854
R4578 a_8815_n2146.n8 a_8815_n2146.t29 14.854
R4579 a_8815_n2146.n9 a_8815_n2146.t22 14.854
R4580 a_8815_n2146.n29 a_8815_n2146.t24 14.854
R4581 a_8815_n2146.n28 a_8815_n2146.t16 14.854
R4582 a_8815_n2146.n25 a_8815_n2146.t28 14.854
R4583 a_8815_n2146.n24 a_8815_n2146.t25 14.854
R4584 a_8815_n2146.n21 a_8815_n2146.t23 14.854
R4585 a_8815_n2146.n20 a_8815_n2146.t18 14.854
R4586 a_8815_n2146.n17 a_8815_n2146.t17 14.854
R4587 a_8815_n2146.n16 a_8815_n2146.t8 14.854
R4588 a_8815_n2146.n13 a_8815_n2146.t31 14.854
R4589 a_8815_n2146.n12 a_8815_n2146.t15 14.854
R4590 a_8815_n2146.n11 a_8815_n2146.n10 14.5641
R4591 a_8815_n2146.n3 a_8815_n2146.n2 0.746214
R4592 a_8815_n2146.n7 a_8815_n2146.n6 0.746214
R4593 a_8815_n2146.n31 a_8815_n2146.n30 0.746214
R4594 a_8815_n2146.n27 a_8815_n2146.n26 0.746214
R4595 a_8815_n2146.n23 a_8815_n2146.n22 0.746214
R4596 a_8815_n2146.n19 a_8815_n2146.n18 0.746214
R4597 a_8815_n2146.n15 a_8815_n2146.n14 0.746214
R4598 a_8815_n2146.n2 a_8815_n2146.n1 0.662643
R4599 a_8815_n2146.n4 a_8815_n2146.n3 0.662643
R4600 a_8815_n2146.n6 a_8815_n2146.n5 0.662643
R4601 a_8815_n2146.n8 a_8815_n2146.n7 0.662643
R4602 a_8815_n2146.n31 a_8815_n2146.n9 0.662643
R4603 a_8815_n2146.n30 a_8815_n2146.n29 0.662643
R4604 a_8815_n2146.n28 a_8815_n2146.n27 0.662643
R4605 a_8815_n2146.n26 a_8815_n2146.n25 0.662643
R4606 a_8815_n2146.n24 a_8815_n2146.n23 0.662643
R4607 a_8815_n2146.n22 a_8815_n2146.n21 0.662643
R4608 a_8815_n2146.n20 a_8815_n2146.n19 0.662643
R4609 a_8815_n2146.n18 a_8815_n2146.n17 0.662643
R4610 a_8815_n2146.n16 a_8815_n2146.n15 0.662643
R4611 a_8815_n2146.n14 a_8815_n2146.n13 0.662643
R4612 a_8815_n2146.n12 a_8815_n2146.n11 0.662643
R4613 a_8815_n2146.n1 a_8815_n2146.n0 0.4505
R4614 a_8815_n2146.n5 a_8815_n2146.n4 0.4505
R4615 a_8815_n2146.n9 a_8815_n2146.n8 0.4505
R4616 a_8815_n2146.n29 a_8815_n2146.n28 0.4505
R4617 a_8815_n2146.n25 a_8815_n2146.n24 0.4505
R4618 a_8815_n2146.n21 a_8815_n2146.n20 0.4505
R4619 a_8815_n2146.n17 a_8815_n2146.n16 0.4505
R4620 a_8815_n2146.n13 a_8815_n2146.n12 0.4505
R4621 RB15.t26 RB15.t5 69.3795
R4622 RB15.t11 RB15.t17 69.3795
R4623 RB15.t10 RB15.t34 69.3795
R4624 RB15.t35 RB15.t33 69.3795
R4625 RB15.t38 RB15.t1 69.3795
R4626 RB15.t8 RB15.t13 69.3795
R4627 RB15.t7 RB15.t30 69.3795
R4628 RB15.t24 RB15.t28 69.3795
R4629 RB15.t40 RB15.t3 69.3795
R4630 RB15.t39 RB15.t2 69.3795
R4631 RB15.t9 RB15.t32 69.3795
R4632 RB15.t21 RB15.t42 69.3795
R4633 RB15.t29 RB15.t6 69.3795
R4634 RB15.t41 RB15.t4 69.3795
R4635 RB15.t12 RB15.t22 69.3795
R4636 RB15.t23 RB15.t43 69.3795
R4637 RB15.n29 RB15.t36 30.2434
R4638 RB15.n27 RB15.t19 30.2434
R4639 RB15.n25 RB15.t18 30.2434
R4640 RB15.n23 RB15.t44 30.2434
R4641 RB15.n21 RB15.t45 30.2434
R4642 RB15.n19 RB15.t15 30.2434
R4643 RB15.n17 RB15.t14 30.2434
R4644 RB15.n15 RB15.t31 30.2434
R4645 RB15.n13 RB15.t47 30.2434
R4646 RB15.n11 RB15.t46 30.2434
R4647 RB15.n9 RB15.t16 30.2434
R4648 RB15.n7 RB15.t25 30.2434
R4649 RB15.n5 RB15.t37 30.2434
R4650 RB15.n3 RB15.t0 30.2434
R4651 RB15.n1 RB15.t20 30.2434
R4652 RB15.n0 RB15.t27 30.2434
R4653 RB15.n2 RB15.n0 21.0176
R4654 RB15.n30 RB15.n29 17.0448
R4655 RB15.n28 RB15.n27 17.0448
R4656 RB15.n26 RB15.n25 17.0448
R4657 RB15.n24 RB15.n23 17.0448
R4658 RB15.n22 RB15.n21 17.0448
R4659 RB15.n20 RB15.n19 17.0448
R4660 RB15.n18 RB15.n17 17.0448
R4661 RB15.n16 RB15.n15 17.0448
R4662 RB15.n14 RB15.n13 17.0448
R4663 RB15.n12 RB15.n11 17.0448
R4664 RB15.n10 RB15.n9 17.0448
R4665 RB15.n8 RB15.n7 17.0448
R4666 RB15.n6 RB15.n5 17.0448
R4667 RB15.n4 RB15.n3 17.0448
R4668 RB15.n2 RB15.n1 17.0448
R4669 RB15.n29 RB15.t26 16.6862
R4670 RB15.n27 RB15.t11 16.6862
R4671 RB15.n25 RB15.t10 16.6862
R4672 RB15.n23 RB15.t35 16.6862
R4673 RB15.n21 RB15.t38 16.6862
R4674 RB15.n19 RB15.t8 16.6862
R4675 RB15.n17 RB15.t7 16.6862
R4676 RB15.n15 RB15.t24 16.6862
R4677 RB15.n13 RB15.t40 16.6862
R4678 RB15.n11 RB15.t39 16.6862
R4679 RB15.n9 RB15.t9 16.6862
R4680 RB15.n7 RB15.t21 16.6862
R4681 RB15.n5 RB15.t29 16.6862
R4682 RB15.n3 RB15.t41 16.6862
R4683 RB15.n1 RB15.t12 16.6862
R4684 RB15.n0 RB15.t23 16.6862
R4685 RB15 RB15.n30 5.78621
R4686 RB15.n4 RB15.n2 3.97336
R4687 RB15.n6 RB15.n4 3.97336
R4688 RB15.n8 RB15.n6 3.97336
R4689 RB15.n10 RB15.n8 3.97336
R4690 RB15.n12 RB15.n10 3.97336
R4691 RB15.n14 RB15.n12 3.97336
R4692 RB15.n16 RB15.n14 3.97336
R4693 RB15.n18 RB15.n16 3.97336
R4694 RB15.n20 RB15.n18 3.97336
R4695 RB15.n22 RB15.n20 3.97336
R4696 RB15.n24 RB15.n22 3.97336
R4697 RB15.n26 RB15.n24 3.97336
R4698 RB15.n28 RB15.n26 3.97336
R4699 RB15.n30 RB15.n28 3.97336
R4700 a_29304_n708.n1 a_29304_n708.t26 31.0255
R4701 a_29304_n708.n2 a_29304_n708.t4 31.0255
R4702 a_29304_n708.n4 a_29304_n708.t27 31.0255
R4703 a_29304_n708.n6 a_29304_n708.t6 31.0255
R4704 a_29304_n708.n8 a_29304_n708.t12 31.0255
R4705 a_29304_n708.n10 a_29304_n708.t25 31.0255
R4706 a_29304_n708.n12 a_29304_n708.t28 31.0255
R4707 a_29304_n708.n14 a_29304_n708.t7 31.0255
R4708 a_29304_n708.n16 a_29304_n708.t13 31.0255
R4709 a_29304_n708.n18 a_29304_n708.t35 31.0255
R4710 a_29304_n708.n20 a_29304_n708.t11 31.0255
R4711 a_29304_n708.n22 a_29304_n708.t21 31.0255
R4712 a_29304_n708.n24 a_29304_n708.t23 31.0255
R4713 a_29304_n708.n26 a_29304_n708.t31 31.0255
R4714 a_29304_n708.n28 a_29304_n708.t10 31.0255
R4715 a_29304_n708.n30 a_29304_n708.t20 31.0255
R4716 a_29304_n708.n1 a_29304_n708.t14 27.8969
R4717 a_29304_n708.n2 a_29304_n708.t17 27.8969
R4718 a_29304_n708.n4 a_29304_n708.t24 27.8969
R4719 a_29304_n708.n6 a_29304_n708.t22 27.8969
R4720 a_29304_n708.n8 a_29304_n708.t15 27.8969
R4721 a_29304_n708.n10 a_29304_n708.t5 27.8969
R4722 a_29304_n708.n12 a_29304_n708.t34 27.8969
R4723 a_29304_n708.n14 a_29304_n708.t32 27.8969
R4724 a_29304_n708.n16 a_29304_n708.t16 27.8969
R4725 a_29304_n708.n18 a_29304_n708.t18 27.8969
R4726 a_29304_n708.n20 a_29304_n708.t9 27.8969
R4727 a_29304_n708.n22 a_29304_n708.t33 27.8969
R4728 a_29304_n708.n24 a_29304_n708.t29 27.8969
R4729 a_29304_n708.n26 a_29304_n708.t19 27.8969
R4730 a_29304_n708.n28 a_29304_n708.t30 27.8969
R4731 a_29304_n708.n30 a_29304_n708.t8 27.8969
R4732 a_29304_n708.n3 a_29304_n708.n1 13.8288
R4733 a_29304_n708.n3 a_29304_n708.n2 12.5495
R4734 a_29304_n708.n5 a_29304_n708.n4 12.5495
R4735 a_29304_n708.n7 a_29304_n708.n6 12.5495
R4736 a_29304_n708.n9 a_29304_n708.n8 12.5495
R4737 a_29304_n708.n11 a_29304_n708.n10 12.5495
R4738 a_29304_n708.n13 a_29304_n708.n12 12.5495
R4739 a_29304_n708.n15 a_29304_n708.n14 12.5495
R4740 a_29304_n708.n17 a_29304_n708.n16 12.5495
R4741 a_29304_n708.n19 a_29304_n708.n18 12.5495
R4742 a_29304_n708.n21 a_29304_n708.n20 12.5495
R4743 a_29304_n708.n23 a_29304_n708.n22 12.5495
R4744 a_29304_n708.n25 a_29304_n708.n24 12.5495
R4745 a_29304_n708.n27 a_29304_n708.n26 12.5495
R4746 a_29304_n708.n29 a_29304_n708.n28 12.5495
R4747 a_29304_n708.n31 a_29304_n708.n30 12.5495
R4748 a_29304_n708.n32 a_29304_n708.n0 6.45898
R4749 a_29304_n708.n32 a_29304_n708.n31 5.79746
R4750 a_29304_n708.n33 a_29304_n708.n32 2.99572
R4751 a_29304_n708.n0 a_29304_n708.t3 2.64244
R4752 a_29304_n708.n0 a_29304_n708.t2 2.64244
R4753 a_29304_n708.n33 a_29304_n708.t0 1.46824
R4754 a_29304_n708.t1 a_29304_n708.n33 1.46824
R4755 a_29304_n708.n7 a_29304_n708.n5 1.27979
R4756 a_29304_n708.n11 a_29304_n708.n9 1.27979
R4757 a_29304_n708.n15 a_29304_n708.n13 1.27979
R4758 a_29304_n708.n19 a_29304_n708.n17 1.27979
R4759 a_29304_n708.n23 a_29304_n708.n21 1.27979
R4760 a_29304_n708.n27 a_29304_n708.n25 1.27979
R4761 a_29304_n708.n31 a_29304_n708.n29 1.27979
R4762 a_29304_n708.n5 a_29304_n708.n3 1.24121
R4763 a_29304_n708.n9 a_29304_n708.n7 1.24121
R4764 a_29304_n708.n13 a_29304_n708.n11 1.24121
R4765 a_29304_n708.n17 a_29304_n708.n15 1.24121
R4766 a_29304_n708.n21 a_29304_n708.n19 1.24121
R4767 a_29304_n708.n25 a_29304_n708.n23 1.24121
R4768 a_29304_n708.n29 a_29304_n708.n27 1.24121
R4769 RB12.t28 RB12.t8 69.3795
R4770 RB12.t14 RB12.t20 69.3795
R4771 RB12.t13 RB12.t36 69.3795
R4772 RB12.t39 RB12.t34 69.3795
R4773 RB12.t40 RB12.t4 69.3795
R4774 RB12.t11 RB12.t19 69.3795
R4775 RB12.t10 RB12.t31 69.3795
R4776 RB12.t26 RB12.t29 69.3795
R4777 RB12.t42 RB12.t6 69.3795
R4778 RB12.t41 RB12.t5 69.3795
R4779 RB12.t12 RB12.t33 69.3795
R4780 RB12.t21 RB12.t44 69.3795
R4781 RB12.t30 RB12.t9 69.3795
R4782 RB12.t43 RB12.t7 69.3795
R4783 RB12.t15 RB12.t22 69.3795
R4784 RB12.t23 RB12.t45 69.3795
R4785 RB12.n29 RB12.t24 30.2434
R4786 RB12.n27 RB12.t2 30.2434
R4787 RB12.n25 RB12.t1 30.2434
R4788 RB12.n23 RB12.t27 30.2434
R4789 RB12.n21 RB12.t32 30.2434
R4790 RB12.n19 RB12.t47 30.2434
R4791 RB12.n17 RB12.t46 30.2434
R4792 RB12.n15 RB12.t18 30.2434
R4793 RB12.n13 RB12.t37 30.2434
R4794 RB12.n11 RB12.t35 30.2434
R4795 RB12.n9 RB12.t0 30.2434
R4796 RB12.n7 RB12.t16 30.2434
R4797 RB12.n5 RB12.t25 30.2434
R4798 RB12.n3 RB12.t38 30.2434
R4799 RB12.n1 RB12.t3 30.2434
R4800 RB12.n0 RB12.t17 30.2434
R4801 RB12.n2 RB12.n0 21.0176
R4802 RB12.n30 RB12.n29 17.0448
R4803 RB12.n28 RB12.n27 17.0448
R4804 RB12.n26 RB12.n25 17.0448
R4805 RB12.n24 RB12.n23 17.0448
R4806 RB12.n22 RB12.n21 17.0448
R4807 RB12.n20 RB12.n19 17.0448
R4808 RB12.n18 RB12.n17 17.0448
R4809 RB12.n16 RB12.n15 17.0448
R4810 RB12.n14 RB12.n13 17.0448
R4811 RB12.n12 RB12.n11 17.0448
R4812 RB12.n10 RB12.n9 17.0448
R4813 RB12.n8 RB12.n7 17.0448
R4814 RB12.n6 RB12.n5 17.0448
R4815 RB12.n4 RB12.n3 17.0448
R4816 RB12.n2 RB12.n1 17.0448
R4817 RB12.n29 RB12.t28 16.6862
R4818 RB12.n27 RB12.t14 16.6862
R4819 RB12.n25 RB12.t13 16.6862
R4820 RB12.n23 RB12.t39 16.6862
R4821 RB12.n21 RB12.t40 16.6862
R4822 RB12.n19 RB12.t11 16.6862
R4823 RB12.n17 RB12.t10 16.6862
R4824 RB12.n15 RB12.t26 16.6862
R4825 RB12.n13 RB12.t42 16.6862
R4826 RB12.n11 RB12.t41 16.6862
R4827 RB12.n9 RB12.t12 16.6862
R4828 RB12.n7 RB12.t21 16.6862
R4829 RB12.n5 RB12.t30 16.6862
R4830 RB12.n3 RB12.t43 16.6862
R4831 RB12.n1 RB12.t15 16.6862
R4832 RB12.n0 RB12.t23 16.6862
R4833 RB12 RB12.n30 5.78621
R4834 RB12.n4 RB12.n2 3.97336
R4835 RB12.n6 RB12.n4 3.97336
R4836 RB12.n8 RB12.n6 3.97336
R4837 RB12.n10 RB12.n8 3.97336
R4838 RB12.n12 RB12.n10 3.97336
R4839 RB12.n14 RB12.n12 3.97336
R4840 RB12.n16 RB12.n14 3.97336
R4841 RB12.n18 RB12.n16 3.97336
R4842 RB12.n20 RB12.n18 3.97336
R4843 RB12.n22 RB12.n20 3.97336
R4844 RB12.n24 RB12.n22 3.97336
R4845 RB12.n26 RB12.n24 3.97336
R4846 RB12.n28 RB12.n26 3.97336
R4847 RB12.n30 RB12.n28 3.97336
R4848 RA3.t2 RA3.t26 70.3934
R4849 RA3.t29 RA3.t36 70.3934
R4850 RA3.t28 RA3.t17 70.3934
R4851 RA3.t44 RA3.t15 70.3934
R4852 RA3.t45 RA3.t24 70.3934
R4853 RA3.t9 RA3.t32 70.3934
R4854 RA3.t25 RA3.t1 70.3934
R4855 RA3.t40 RA3.t13 70.3934
R4856 RA3.t46 RA3.t22 70.3934
R4857 RA3.t11 RA3.t35 70.3934
R4858 RA3.t10 RA3.t34 70.3934
R4859 RA3.t42 RA3.t3 70.3934
R4860 RA3.t0 RA3.t23 70.3934
R4861 RA3.t14 RA3.t38 70.3934
R4862 RA3.t12 RA3.t37 70.3934
R4863 RA3.t27 RA3.t16 70.3934
R4864 RA3.n29 RA3.t2 31.2862
R4865 RA3.n27 RA3.t29 31.2862
R4866 RA3.n25 RA3.t28 31.2862
R4867 RA3.n23 RA3.t44 31.2862
R4868 RA3.n21 RA3.t45 31.2862
R4869 RA3.n19 RA3.t9 31.2862
R4870 RA3.n17 RA3.t25 31.2862
R4871 RA3.n15 RA3.t40 31.2862
R4872 RA3.n13 RA3.t46 31.2862
R4873 RA3.n11 RA3.t11 31.2862
R4874 RA3.n9 RA3.t10 31.2862
R4875 RA3.n7 RA3.t42 31.2862
R4876 RA3.n5 RA3.t0 31.2862
R4877 RA3.n3 RA3.t14 31.2862
R4878 RA3.n1 RA3.t12 31.2862
R4879 RA3.n0 RA3.t27 31.2862
R4880 RA3.n2 RA3.n0 21.0181
R4881 RA3.n30 RA3.n29 17.0453
R4882 RA3.n28 RA3.n27 17.0453
R4883 RA3.n26 RA3.n25 17.0453
R4884 RA3.n24 RA3.n23 17.0453
R4885 RA3.n22 RA3.n21 17.0453
R4886 RA3.n20 RA3.n19 17.0453
R4887 RA3.n18 RA3.n17 17.0453
R4888 RA3.n16 RA3.n15 17.0453
R4889 RA3.n14 RA3.n13 17.0453
R4890 RA3.n12 RA3.n11 17.0453
R4891 RA3.n10 RA3.n9 17.0453
R4892 RA3.n8 RA3.n7 17.0453
R4893 RA3.n6 RA3.n5 17.0453
R4894 RA3.n4 RA3.n3 17.0453
R4895 RA3.n2 RA3.n1 17.0453
R4896 RA3.n29 RA3.t47 15.6434
R4897 RA3.n27 RA3.t21 15.6434
R4898 RA3.n25 RA3.t20 15.6434
R4899 RA3.n23 RA3.t33 15.6434
R4900 RA3.n21 RA3.t39 15.6434
R4901 RA3.n19 RA3.t4 15.6434
R4902 RA3.n17 RA3.t18 15.6434
R4903 RA3.n15 RA3.t30 15.6434
R4904 RA3.n13 RA3.t41 15.6434
R4905 RA3.n11 RA3.t6 15.6434
R4906 RA3.n9 RA3.t5 15.6434
R4907 RA3.n7 RA3.t31 15.6434
R4908 RA3.n5 RA3.t43 15.6434
R4909 RA3.n3 RA3.t8 15.6434
R4910 RA3.n1 RA3.t7 15.6434
R4911 RA3.n0 RA3.t19 15.6434
R4912 RA3 RA3.n30 4.5005
R4913 RA3.n4 RA3.n2 3.97336
R4914 RA3.n6 RA3.n4 3.97336
R4915 RA3.n8 RA3.n6 3.97336
R4916 RA3.n10 RA3.n8 3.97336
R4917 RA3.n12 RA3.n10 3.97336
R4918 RA3.n14 RA3.n12 3.97336
R4919 RA3.n16 RA3.n14 3.97336
R4920 RA3.n18 RA3.n16 3.97336
R4921 RA3.n20 RA3.n18 3.97336
R4922 RA3.n22 RA3.n20 3.97336
R4923 RA3.n24 RA3.n22 3.97336
R4924 RA3.n26 RA3.n24 3.97336
R4925 RA3.n28 RA3.n26 3.97336
R4926 RA3.n30 RA3.n28 3.97336
R4927 D9.n0 D9.t0 31.0255
R4928 D9.n0 D9.t1 27.8969
R4929 D9 D9.n0 14.0473
R4930 a_n1204_1398.n1 a_n1204_1398.t16 29.7679
R4931 a_n1204_1398.n30 a_n1204_1398.t6 29.4079
R4932 a_n1204_1398.n28 a_n1204_1398.t31 29.4079
R4933 a_n1204_1398.n26 a_n1204_1398.t15 29.4079
R4934 a_n1204_1398.n24 a_n1204_1398.t14 29.4079
R4935 a_n1204_1398.n22 a_n1204_1398.t29 29.4079
R4936 a_n1204_1398.n20 a_n1204_1398.t27 29.4079
R4937 a_n1204_1398.n18 a_n1204_1398.t35 29.4079
R4938 a_n1204_1398.n16 a_n1204_1398.t11 29.4079
R4939 a_n1204_1398.n14 a_n1204_1398.t10 29.4079
R4940 a_n1204_1398.n12 a_n1204_1398.t30 29.4079
R4941 a_n1204_1398.n10 a_n1204_1398.t38 29.4079
R4942 a_n1204_1398.n8 a_n1204_1398.t13 29.4079
R4943 a_n1204_1398.n6 a_n1204_1398.t12 29.4079
R4944 a_n1204_1398.n4 a_n1204_1398.t32 29.4079
R4945 a_n1204_1398.n2 a_n1204_1398.t4 29.4079
R4946 a_n1204_1398.n31 a_n1204_1398.t25 29.1445
R4947 a_n1204_1398.n29 a_n1204_1398.t8 29.1445
R4948 a_n1204_1398.n27 a_n1204_1398.t26 29.1445
R4949 a_n1204_1398.n25 a_n1204_1398.t39 29.1445
R4950 a_n1204_1398.n23 a_n1204_1398.t37 29.1445
R4951 a_n1204_1398.n21 a_n1204_1398.t18 29.1445
R4952 a_n1204_1398.n19 a_n1204_1398.t17 29.1445
R4953 a_n1204_1398.n17 a_n1204_1398.t34 29.1445
R4954 a_n1204_1398.n15 a_n1204_1398.t33 29.1445
R4955 a_n1204_1398.n13 a_n1204_1398.t20 29.1445
R4956 a_n1204_1398.n11 a_n1204_1398.t19 29.1445
R4957 a_n1204_1398.n9 a_n1204_1398.t28 29.1445
R4958 a_n1204_1398.n7 a_n1204_1398.t36 29.1445
R4959 a_n1204_1398.n5 a_n1204_1398.t5 29.1445
R4960 a_n1204_1398.n3 a_n1204_1398.t23 29.1445
R4961 a_n1204_1398.n1 a_n1204_1398.t22 29.1445
R4962 a_n1204_1398.n33 a_n1204_1398.t9 24.7684
R4963 a_n1204_1398.n33 a_n1204_1398.t24 24.1166
R4964 a_n1204_1398.n34 a_n1204_1398.t7 23.7255
R4965 a_n1204_1398.n34 a_n1204_1398.t21 23.0737
R4966 a_n1204_1398.n34 a_n1204_1398.n33 17.1396
R4967 a_n1204_1398.n32 a_n1204_1398.n31 10.2862
R4968 a_n1204_1398.n35 a_n1204_1398.n34 8.0005
R4969 a_n1204_1398.n32 a_n1204_1398.n0 6.86767
R4970 a_n1204_1398.n2 a_n1204_1398.n1 3.61336
R4971 a_n1204_1398.n4 a_n1204_1398.n3 3.61336
R4972 a_n1204_1398.n6 a_n1204_1398.n5 3.61336
R4973 a_n1204_1398.n8 a_n1204_1398.n7 3.61336
R4974 a_n1204_1398.n10 a_n1204_1398.n9 3.61336
R4975 a_n1204_1398.n12 a_n1204_1398.n11 3.61336
R4976 a_n1204_1398.n14 a_n1204_1398.n13 3.61336
R4977 a_n1204_1398.n16 a_n1204_1398.n15 3.61336
R4978 a_n1204_1398.n18 a_n1204_1398.n17 3.61336
R4979 a_n1204_1398.n20 a_n1204_1398.n19 3.61336
R4980 a_n1204_1398.n22 a_n1204_1398.n21 3.61336
R4981 a_n1204_1398.n24 a_n1204_1398.n23 3.61336
R4982 a_n1204_1398.n26 a_n1204_1398.n25 3.61336
R4983 a_n1204_1398.n28 a_n1204_1398.n27 3.61336
R4984 a_n1204_1398.n30 a_n1204_1398.n29 3.61336
R4985 a_n1204_1398.n36 a_n1204_1398.n35 3.45159
R4986 a_n1204_1398.n0 a_n1204_1398.t2 2.58003
R4987 a_n1204_1398.n0 a_n1204_1398.t3 2.58003
R4988 a_n1204_1398.t1 a_n1204_1398.n36 1.43357
R4989 a_n1204_1398.n36 a_n1204_1398.t0 1.43357
R4990 a_n1204_1398.n3 a_n1204_1398.n2 0.3605
R4991 a_n1204_1398.n5 a_n1204_1398.n4 0.3605
R4992 a_n1204_1398.n7 a_n1204_1398.n6 0.3605
R4993 a_n1204_1398.n9 a_n1204_1398.n8 0.3605
R4994 a_n1204_1398.n11 a_n1204_1398.n10 0.3605
R4995 a_n1204_1398.n13 a_n1204_1398.n12 0.3605
R4996 a_n1204_1398.n15 a_n1204_1398.n14 0.3605
R4997 a_n1204_1398.n17 a_n1204_1398.n16 0.3605
R4998 a_n1204_1398.n19 a_n1204_1398.n18 0.3605
R4999 a_n1204_1398.n21 a_n1204_1398.n20 0.3605
R5000 a_n1204_1398.n23 a_n1204_1398.n22 0.3605
R5001 a_n1204_1398.n25 a_n1204_1398.n24 0.3605
R5002 a_n1204_1398.n27 a_n1204_1398.n26 0.3605
R5003 a_n1204_1398.n29 a_n1204_1398.n28 0.3605
R5004 a_n1204_1398.n31 a_n1204_1398.n30 0.3605
R5005 a_n1204_1398.n35 a_n1204_1398.n32 0.169589
R5006 a_6073_n862.n3 a_6073_n862.t32 18.9023
R5007 a_6073_n862.n0 a_6073_n862.t14 16.1132
R5008 a_6073_n862.n3 a_6073_n862.t33 15.6434
R5009 a_6073_n862.n2 a_6073_n862.t3 15.4511
R5010 a_6073_n862.n28 a_6073_n862.t25 15.4511
R5011 a_6073_n862.n27 a_6073_n862.t10 15.4511
R5012 a_6073_n862.n24 a_6073_n862.t21 15.4511
R5013 a_6073_n862.n23 a_6073_n862.t13 15.4511
R5014 a_6073_n862.n20 a_6073_n862.t2 15.4511
R5015 a_6073_n862.n19 a_6073_n862.t6 15.4511
R5016 a_6073_n862.n16 a_6073_n862.t11 15.4511
R5017 a_6073_n862.n15 a_6073_n862.t1 15.4511
R5018 a_6073_n862.n12 a_6073_n862.t8 15.4511
R5019 a_6073_n862.n11 a_6073_n862.t5 15.4511
R5020 a_6073_n862.n8 a_6073_n862.t7 15.4511
R5021 a_6073_n862.n7 a_6073_n862.t12 15.4511
R5022 a_6073_n862.n4 a_6073_n862.t9 15.4511
R5023 a_6073_n862.t0 a_6073_n862.n31 15.4511
R5024 a_6073_n862.n0 a_6073_n862.t29 14.8566
R5025 a_6073_n862.n1 a_6073_n862.t28 14.8566
R5026 a_6073_n862.n30 a_6073_n862.t22 14.8566
R5027 a_6073_n862.n29 a_6073_n862.t20 14.8566
R5028 a_6073_n862.n26 a_6073_n862.t30 14.8566
R5029 a_6073_n862.n25 a_6073_n862.t23 14.8566
R5030 a_6073_n862.n22 a_6073_n862.t4 14.8566
R5031 a_6073_n862.n21 a_6073_n862.t19 14.8566
R5032 a_6073_n862.n18 a_6073_n862.t24 14.8566
R5033 a_6073_n862.n17 a_6073_n862.t31 14.8566
R5034 a_6073_n862.n14 a_6073_n862.t26 14.8566
R5035 a_6073_n862.n13 a_6073_n862.t18 14.8566
R5036 a_6073_n862.n10 a_6073_n862.t17 14.8566
R5037 a_6073_n862.n9 a_6073_n862.t16 14.8566
R5038 a_6073_n862.n6 a_6073_n862.t15 14.8566
R5039 a_6073_n862.n5 a_6073_n862.t27 14.8566
R5040 a_6073_n862.n4 a_6073_n862.n3 14.5641
R5041 a_6073_n862.n31 a_6073_n862.n2 0.746214
R5042 a_6073_n862.n28 a_6073_n862.n27 0.746214
R5043 a_6073_n862.n24 a_6073_n862.n23 0.746214
R5044 a_6073_n862.n20 a_6073_n862.n19 0.746214
R5045 a_6073_n862.n16 a_6073_n862.n15 0.746214
R5046 a_6073_n862.n12 a_6073_n862.n11 0.746214
R5047 a_6073_n862.n8 a_6073_n862.n7 0.746214
R5048 a_6073_n862.n2 a_6073_n862.n1 0.662643
R5049 a_6073_n862.n31 a_6073_n862.n30 0.662643
R5050 a_6073_n862.n29 a_6073_n862.n28 0.662643
R5051 a_6073_n862.n27 a_6073_n862.n26 0.662643
R5052 a_6073_n862.n25 a_6073_n862.n24 0.662643
R5053 a_6073_n862.n23 a_6073_n862.n22 0.662643
R5054 a_6073_n862.n21 a_6073_n862.n20 0.662643
R5055 a_6073_n862.n19 a_6073_n862.n18 0.662643
R5056 a_6073_n862.n17 a_6073_n862.n16 0.662643
R5057 a_6073_n862.n15 a_6073_n862.n14 0.662643
R5058 a_6073_n862.n13 a_6073_n862.n12 0.662643
R5059 a_6073_n862.n11 a_6073_n862.n10 0.662643
R5060 a_6073_n862.n9 a_6073_n862.n8 0.662643
R5061 a_6073_n862.n7 a_6073_n862.n6 0.662643
R5062 a_6073_n862.n5 a_6073_n862.n4 0.662643
R5063 a_6073_n862.n1 a_6073_n862.n0 0.4505
R5064 a_6073_n862.n30 a_6073_n862.n29 0.4505
R5065 a_6073_n862.n26 a_6073_n862.n25 0.4505
R5066 a_6073_n862.n22 a_6073_n862.n21 0.4505
R5067 a_6073_n862.n18 a_6073_n862.n17 0.4505
R5068 a_6073_n862.n14 a_6073_n862.n13 0.4505
R5069 a_6073_n862.n10 a_6073_n862.n9 0.4505
R5070 a_6073_n862.n6 a_6073_n862.n5 0.4505
R5071 a_n884_10806.n1 a_n884_10806.t13 29.9245
R5072 a_n884_10806.n30 a_n884_10806.t29 29.3395
R5073 a_n884_10806.n28 a_n884_10806.t14 29.3395
R5074 a_n884_10806.n26 a_n884_10806.t19 29.3395
R5075 a_n884_10806.n24 a_n884_10806.t5 29.3395
R5076 a_n884_10806.n22 a_n884_10806.t23 29.3395
R5077 a_n884_10806.n20 a_n884_10806.t9 29.3395
R5078 a_n884_10806.n18 a_n884_10806.t22 29.3395
R5079 a_n884_10806.n16 a_n884_10806.t34 29.3395
R5080 a_n884_10806.n14 a_n884_10806.t27 29.3395
R5081 a_n884_10806.n12 a_n884_10806.t15 29.3395
R5082 a_n884_10806.n10 a_n884_10806.t26 29.3395
R5083 a_n884_10806.n8 a_n884_10806.t8 29.3395
R5084 a_n884_10806.n6 a_n884_10806.t31 29.3395
R5085 a_n884_10806.n4 a_n884_10806.t18 29.3395
R5086 a_n884_10806.n2 a_n884_10806.t30 29.3395
R5087 a_n884_10806.n31 a_n884_10806.t16 27.973
R5088 a_n884_10806.n29 a_n884_10806.t35 27.973
R5089 a_n884_10806.n27 a_n884_10806.t4 27.973
R5090 a_n884_10806.n25 a_n884_10806.t24 27.973
R5091 a_n884_10806.n23 a_n884_10806.t10 27.973
R5092 a_n884_10806.n21 a_n884_10806.t25 27.973
R5093 a_n884_10806.n19 a_n884_10806.t11 27.973
R5094 a_n884_10806.n17 a_n884_10806.t20 27.973
R5095 a_n884_10806.n15 a_n884_10806.t6 27.973
R5096 a_n884_10806.n13 a_n884_10806.t28 27.973
R5097 a_n884_10806.n11 a_n884_10806.t17 27.973
R5098 a_n884_10806.n9 a_n884_10806.t32 27.973
R5099 a_n884_10806.n7 a_n884_10806.t12 27.973
R5100 a_n884_10806.n5 a_n884_10806.t33 27.973
R5101 a_n884_10806.n3 a_n884_10806.t21 27.973
R5102 a_n884_10806.n1 a_n884_10806.t7 27.973
R5103 a_n884_10806.n32 a_n884_10806.n31 10.1914
R5104 a_n884_10806.n32 a_n884_10806.n0 7.10204
R5105 a_n884_10806.n2 a_n884_10806.n1 3.38836
R5106 a_n884_10806.n4 a_n884_10806.n3 3.38836
R5107 a_n884_10806.n6 a_n884_10806.n5 3.38836
R5108 a_n884_10806.n8 a_n884_10806.n7 3.38836
R5109 a_n884_10806.n10 a_n884_10806.n9 3.38836
R5110 a_n884_10806.n12 a_n884_10806.n11 3.38836
R5111 a_n884_10806.n14 a_n884_10806.n13 3.38836
R5112 a_n884_10806.n16 a_n884_10806.n15 3.38836
R5113 a_n884_10806.n18 a_n884_10806.n17 3.38836
R5114 a_n884_10806.n20 a_n884_10806.n19 3.38836
R5115 a_n884_10806.n22 a_n884_10806.n21 3.38836
R5116 a_n884_10806.n24 a_n884_10806.n23 3.38836
R5117 a_n884_10806.n26 a_n884_10806.n25 3.38836
R5118 a_n884_10806.n28 a_n884_10806.n27 3.38836
R5119 a_n884_10806.n30 a_n884_10806.n29 3.38836
R5120 a_n884_10806.n0 a_n884_10806.t2 3.00946
R5121 a_n884_10806.n33 a_n884_10806.n32 2.63313
R5122 a_n884_10806.n0 a_n884_10806.t3 2.44528
R5123 a_n884_10806.t0 a_n884_10806.n33 1.67214
R5124 a_n884_10806.n33 a_n884_10806.t1 1.35871
R5125 a_n884_10806.n3 a_n884_10806.n2 0.5855
R5126 a_n884_10806.n5 a_n884_10806.n4 0.5855
R5127 a_n884_10806.n7 a_n884_10806.n6 0.5855
R5128 a_n884_10806.n9 a_n884_10806.n8 0.5855
R5129 a_n884_10806.n11 a_n884_10806.n10 0.5855
R5130 a_n884_10806.n13 a_n884_10806.n12 0.5855
R5131 a_n884_10806.n15 a_n884_10806.n14 0.5855
R5132 a_n884_10806.n17 a_n884_10806.n16 0.5855
R5133 a_n884_10806.n19 a_n884_10806.n18 0.5855
R5134 a_n884_10806.n21 a_n884_10806.n20 0.5855
R5135 a_n884_10806.n23 a_n884_10806.n22 0.5855
R5136 a_n884_10806.n25 a_n884_10806.n24 0.5855
R5137 a_n884_10806.n27 a_n884_10806.n26 0.5855
R5138 a_n884_10806.n29 a_n884_10806.n28 0.5855
R5139 a_n884_10806.n31 a_n884_10806.n30 0.5855
R5140 RA2.t19 RA2.t42 70.3934
R5141 RA2.t46 RA2.t4 70.3934
R5142 RA2.t44 RA2.t33 70.3934
R5143 RA2.t11 RA2.t31 70.3934
R5144 RA2.t15 RA2.t39 70.3934
R5145 RA2.t25 RA2.t1 70.3934
R5146 RA2.t40 RA2.t18 70.3934
R5147 RA2.t7 RA2.t29 70.3934
R5148 RA2.t16 RA2.t35 70.3934
R5149 RA2.t27 RA2.t3 70.3934
R5150 RA2.t26 RA2.t2 70.3934
R5151 RA2.t9 RA2.t20 70.3934
R5152 RA2.t17 RA2.t38 70.3934
R5153 RA2.t30 RA2.t6 70.3934
R5154 RA2.t28 RA2.t5 70.3934
R5155 RA2.t43 RA2.t32 70.3934
R5156 RA2.n29 RA2.t19 31.2862
R5157 RA2.n27 RA2.t46 31.2862
R5158 RA2.n25 RA2.t44 31.2862
R5159 RA2.n23 RA2.t11 31.2862
R5160 RA2.n21 RA2.t15 31.2862
R5161 RA2.n19 RA2.t25 31.2862
R5162 RA2.n17 RA2.t40 31.2862
R5163 RA2.n15 RA2.t7 31.2862
R5164 RA2.n13 RA2.t16 31.2862
R5165 RA2.n11 RA2.t27 31.2862
R5166 RA2.n9 RA2.t26 31.2862
R5167 RA2.n7 RA2.t9 31.2862
R5168 RA2.n5 RA2.t17 31.2862
R5169 RA2.n3 RA2.t30 31.2862
R5170 RA2.n1 RA2.t28 31.2862
R5171 RA2.n0 RA2.t43 31.2862
R5172 RA2.n2 RA2.n0 21.0181
R5173 RA2.n30 RA2.n29 17.0453
R5174 RA2.n28 RA2.n27 17.0453
R5175 RA2.n26 RA2.n25 17.0453
R5176 RA2.n24 RA2.n23 17.0453
R5177 RA2.n22 RA2.n21 17.0453
R5178 RA2.n20 RA2.n19 17.0453
R5179 RA2.n18 RA2.n17 17.0453
R5180 RA2.n16 RA2.n15 17.0453
R5181 RA2.n14 RA2.n13 17.0453
R5182 RA2.n12 RA2.n11 17.0453
R5183 RA2.n10 RA2.n9 17.0453
R5184 RA2.n8 RA2.n7 17.0453
R5185 RA2.n6 RA2.n5 17.0453
R5186 RA2.n4 RA2.n3 17.0453
R5187 RA2.n2 RA2.n1 17.0453
R5188 RA2.n29 RA2.t0 15.6434
R5189 RA2.n27 RA2.t24 15.6434
R5190 RA2.n25 RA2.t23 15.6434
R5191 RA2.n23 RA2.t37 15.6434
R5192 RA2.n21 RA2.t41 15.6434
R5193 RA2.n19 RA2.t8 15.6434
R5194 RA2.n17 RA2.t21 15.6434
R5195 RA2.n15 RA2.t34 15.6434
R5196 RA2.n13 RA2.t45 15.6434
R5197 RA2.n11 RA2.t12 15.6434
R5198 RA2.n9 RA2.t10 15.6434
R5199 RA2.n7 RA2.t36 15.6434
R5200 RA2.n5 RA2.t47 15.6434
R5201 RA2.n3 RA2.t14 15.6434
R5202 RA2.n1 RA2.t13 15.6434
R5203 RA2.n0 RA2.t22 15.6434
R5204 RA2 RA2.n30 4.49568
R5205 RA2.n4 RA2.n2 3.97336
R5206 RA2.n6 RA2.n4 3.97336
R5207 RA2.n8 RA2.n6 3.97336
R5208 RA2.n10 RA2.n8 3.97336
R5209 RA2.n12 RA2.n10 3.97336
R5210 RA2.n14 RA2.n12 3.97336
R5211 RA2.n16 RA2.n14 3.97336
R5212 RA2.n18 RA2.n16 3.97336
R5213 RA2.n20 RA2.n18 3.97336
R5214 RA2.n22 RA2.n20 3.97336
R5215 RA2.n24 RA2.n22 3.97336
R5216 RA2.n26 RA2.n24 3.97336
R5217 RA2.n28 RA2.n26 3.97336
R5218 RA2.n30 RA2.n28 3.97336
R5219 RB5.t0 RB5.t25 69.3795
R5220 RB5.t33 RB5.t38 69.3795
R5221 RB5.t32 RB5.t6 69.3795
R5222 RB5.t7 RB5.t5 69.3795
R5223 RB5.t8 RB5.t20 69.3795
R5224 RB5.t29 RB5.t36 69.3795
R5225 RB5.t28 RB5.t3 69.3795
R5226 RB5.t43 RB5.t1 69.3795
R5227 RB5.t12 RB5.t22 69.3795
R5228 RB5.t11 RB5.t21 69.3795
R5229 RB5.t31 RB5.t4 69.3795
R5230 RB5.t39 RB5.t18 69.3795
R5231 RB5.t2 RB5.t26 69.3795
R5232 RB5.t15 RB5.t24 69.3795
R5233 RB5.t34 RB5.t40 69.3795
R5234 RB5.t41 RB5.t19 69.3795
R5235 RB5.n29 RB5.t35 30.2434
R5236 RB5.n27 RB5.t16 30.2434
R5237 RB5.n25 RB5.t14 30.2434
R5238 RB5.n23 RB5.t42 30.2434
R5239 RB5.n21 RB5.t44 30.2434
R5240 RB5.n19 RB5.t10 30.2434
R5241 RB5.n17 RB5.t9 30.2434
R5242 RB5.n15 RB5.t30 30.2434
R5243 RB5.n13 RB5.t46 30.2434
R5244 RB5.n11 RB5.t45 30.2434
R5245 RB5.n9 RB5.t13 30.2434
R5246 RB5.n7 RB5.t23 30.2434
R5247 RB5.n5 RB5.t37 30.2434
R5248 RB5.n3 RB5.t47 30.2434
R5249 RB5.n1 RB5.t17 30.2434
R5250 RB5.n0 RB5.t27 30.2434
R5251 RB5.n2 RB5.n0 21.0176
R5252 RB5.n30 RB5.n29 17.0448
R5253 RB5.n28 RB5.n27 17.0448
R5254 RB5.n26 RB5.n25 17.0448
R5255 RB5.n24 RB5.n23 17.0448
R5256 RB5.n22 RB5.n21 17.0448
R5257 RB5.n20 RB5.n19 17.0448
R5258 RB5.n18 RB5.n17 17.0448
R5259 RB5.n16 RB5.n15 17.0448
R5260 RB5.n14 RB5.n13 17.0448
R5261 RB5.n12 RB5.n11 17.0448
R5262 RB5.n10 RB5.n9 17.0448
R5263 RB5.n8 RB5.n7 17.0448
R5264 RB5.n6 RB5.n5 17.0448
R5265 RB5.n4 RB5.n3 17.0448
R5266 RB5.n2 RB5.n1 17.0448
R5267 RB5.n29 RB5.t0 16.6862
R5268 RB5.n27 RB5.t33 16.6862
R5269 RB5.n25 RB5.t32 16.6862
R5270 RB5.n23 RB5.t7 16.6862
R5271 RB5.n21 RB5.t8 16.6862
R5272 RB5.n19 RB5.t29 16.6862
R5273 RB5.n17 RB5.t28 16.6862
R5274 RB5.n15 RB5.t43 16.6862
R5275 RB5.n13 RB5.t12 16.6862
R5276 RB5.n11 RB5.t11 16.6862
R5277 RB5.n9 RB5.t31 16.6862
R5278 RB5.n7 RB5.t39 16.6862
R5279 RB5.n5 RB5.t2 16.6862
R5280 RB5.n3 RB5.t15 16.6862
R5281 RB5.n1 RB5.t34 16.6862
R5282 RB5.n0 RB5.t41 16.6862
R5283 RB5 RB5.n30 5.783
R5284 RB5.n4 RB5.n2 3.97336
R5285 RB5.n6 RB5.n4 3.97336
R5286 RB5.n8 RB5.n6 3.97336
R5287 RB5.n10 RB5.n8 3.97336
R5288 RB5.n12 RB5.n10 3.97336
R5289 RB5.n14 RB5.n12 3.97336
R5290 RB5.n16 RB5.n14 3.97336
R5291 RB5.n18 RB5.n16 3.97336
R5292 RB5.n20 RB5.n18 3.97336
R5293 RB5.n22 RB5.n20 3.97336
R5294 RB5.n24 RB5.n22 3.97336
R5295 RB5.n26 RB5.n24 3.97336
R5296 RB5.n28 RB5.n26 3.97336
R5297 RB5.n30 RB5.n28 3.97336
R5298 a_33265_n862.n14 a_33265_n862.t32 18.9023
R5299 a_33265_n862.n0 a_33265_n862.t15 16.1132
R5300 a_33265_n862.n14 a_33265_n862.t33 15.6434
R5301 a_33265_n862.n2 a_33265_n862.t3 15.4511
R5302 a_33265_n862.n3 a_33265_n862.t19 15.4511
R5303 a_33265_n862.n6 a_33265_n862.t21 15.4511
R5304 a_33265_n862.n7 a_33265_n862.t11 15.4511
R5305 a_33265_n862.n10 a_33265_n862.t18 15.4511
R5306 a_33265_n862.n11 a_33265_n862.t14 15.4511
R5307 a_33265_n862.n30 a_33265_n862.t7 15.4511
R5308 a_33265_n862.n27 a_33265_n862.t12 15.4511
R5309 a_33265_n862.n26 a_33265_n862.t1 15.4511
R5310 a_33265_n862.n23 a_33265_n862.t9 15.4511
R5311 a_33265_n862.n22 a_33265_n862.t6 15.4511
R5312 a_33265_n862.n19 a_33265_n862.t8 15.4511
R5313 a_33265_n862.n18 a_33265_n862.t13 15.4511
R5314 a_33265_n862.n15 a_33265_n862.t10 15.4511
R5315 a_33265_n862.t0 a_33265_n862.n31 15.4511
R5316 a_33265_n862.n0 a_33265_n862.t30 14.8566
R5317 a_33265_n862.n1 a_33265_n862.t28 14.8566
R5318 a_33265_n862.n4 a_33265_n862.t20 14.8566
R5319 a_33265_n862.n5 a_33265_n862.t25 14.8566
R5320 a_33265_n862.n8 a_33265_n862.t22 14.8566
R5321 a_33265_n862.n9 a_33265_n862.t4 14.8566
R5322 a_33265_n862.n12 a_33265_n862.t27 14.8566
R5323 a_33265_n862.n13 a_33265_n862.t2 14.8566
R5324 a_33265_n862.n29 a_33265_n862.t23 14.8566
R5325 a_33265_n862.n28 a_33265_n862.t16 14.8566
R5326 a_33265_n862.n25 a_33265_n862.t24 14.8566
R5327 a_33265_n862.n24 a_33265_n862.t31 14.8566
R5328 a_33265_n862.n21 a_33265_n862.t26 14.8566
R5329 a_33265_n862.n20 a_33265_n862.t29 14.8566
R5330 a_33265_n862.n17 a_33265_n862.t17 14.8566
R5331 a_33265_n862.n16 a_33265_n862.t5 14.8566
R5332 a_33265_n862.n15 a_33265_n862.n14 14.5641
R5333 a_33265_n862.n3 a_33265_n862.n2 0.746214
R5334 a_33265_n862.n7 a_33265_n862.n6 0.746214
R5335 a_33265_n862.n11 a_33265_n862.n10 0.746214
R5336 a_33265_n862.n31 a_33265_n862.n30 0.746214
R5337 a_33265_n862.n27 a_33265_n862.n26 0.746214
R5338 a_33265_n862.n23 a_33265_n862.n22 0.746214
R5339 a_33265_n862.n19 a_33265_n862.n18 0.746214
R5340 a_33265_n862.n2 a_33265_n862.n1 0.662643
R5341 a_33265_n862.n4 a_33265_n862.n3 0.662643
R5342 a_33265_n862.n6 a_33265_n862.n5 0.662643
R5343 a_33265_n862.n8 a_33265_n862.n7 0.662643
R5344 a_33265_n862.n10 a_33265_n862.n9 0.662643
R5345 a_33265_n862.n12 a_33265_n862.n11 0.662643
R5346 a_33265_n862.n31 a_33265_n862.n13 0.662643
R5347 a_33265_n862.n30 a_33265_n862.n29 0.662643
R5348 a_33265_n862.n28 a_33265_n862.n27 0.662643
R5349 a_33265_n862.n26 a_33265_n862.n25 0.662643
R5350 a_33265_n862.n24 a_33265_n862.n23 0.662643
R5351 a_33265_n862.n22 a_33265_n862.n21 0.662643
R5352 a_33265_n862.n20 a_33265_n862.n19 0.662643
R5353 a_33265_n862.n18 a_33265_n862.n17 0.662643
R5354 a_33265_n862.n16 a_33265_n862.n15 0.662643
R5355 a_33265_n862.n1 a_33265_n862.n0 0.4505
R5356 a_33265_n862.n5 a_33265_n862.n4 0.4505
R5357 a_33265_n862.n9 a_33265_n862.n8 0.4505
R5358 a_33265_n862.n13 a_33265_n862.n12 0.4505
R5359 a_33265_n862.n29 a_33265_n862.n28 0.4505
R5360 a_33265_n862.n25 a_33265_n862.n24 0.4505
R5361 a_33265_n862.n21 a_33265_n862.n20 0.4505
R5362 a_33265_n862.n17 a_33265_n862.n16 0.4505
R5363 QA13b.n0 QA13b.t1 13.1454
R5364 QA13b.n0 QA13b.t0 9.29658
R5365 QA13b QA13b.n0 4.69014
R5366 a_n360_n708.n1 a_n360_n708.t8 31.0255
R5367 a_n360_n708.n2 a_n360_n708.t19 31.0255
R5368 a_n360_n708.n4 a_n360_n708.t4 31.0255
R5369 a_n360_n708.n6 a_n360_n708.t15 31.0255
R5370 a_n360_n708.n8 a_n360_n708.t22 31.0255
R5371 a_n360_n708.n10 a_n360_n708.t33 31.0255
R5372 a_n360_n708.n12 a_n360_n708.t5 31.0255
R5373 a_n360_n708.n14 a_n360_n708.t16 31.0255
R5374 a_n360_n708.n16 a_n360_n708.t23 31.0255
R5375 a_n360_n708.n18 a_n360_n708.t13 31.0255
R5376 a_n360_n708.n20 a_n360_n708.t21 31.0255
R5377 a_n360_n708.n22 a_n360_n708.t29 31.0255
R5378 a_n360_n708.n24 a_n360_n708.t31 31.0255
R5379 a_n360_n708.n26 a_n360_n708.t9 31.0255
R5380 a_n360_n708.n28 a_n360_n708.t20 31.0255
R5381 a_n360_n708.n30 a_n360_n708.t28 31.0255
R5382 a_n360_n708.n1 a_n360_n708.t34 27.8969
R5383 a_n360_n708.n2 a_n360_n708.t35 27.8969
R5384 a_n360_n708.n4 a_n360_n708.t32 27.8969
R5385 a_n360_n708.n6 a_n360_n708.t30 27.8969
R5386 a_n360_n708.n8 a_n360_n708.t24 27.8969
R5387 a_n360_n708.n10 a_n360_n708.t14 27.8969
R5388 a_n360_n708.n12 a_n360_n708.t12 27.8969
R5389 a_n360_n708.n14 a_n360_n708.t10 27.8969
R5390 a_n360_n708.n16 a_n360_n708.t25 27.8969
R5391 a_n360_n708.n18 a_n360_n708.t26 27.8969
R5392 a_n360_n708.n20 a_n360_n708.t18 27.8969
R5393 a_n360_n708.n22 a_n360_n708.t11 27.8969
R5394 a_n360_n708.n24 a_n360_n708.t6 27.8969
R5395 a_n360_n708.n26 a_n360_n708.t27 27.8969
R5396 a_n360_n708.n28 a_n360_n708.t7 27.8969
R5397 a_n360_n708.n30 a_n360_n708.t17 27.8969
R5398 a_n360_n708.n3 a_n360_n708.n1 13.8288
R5399 a_n360_n708.n3 a_n360_n708.n2 12.5495
R5400 a_n360_n708.n5 a_n360_n708.n4 12.5495
R5401 a_n360_n708.n7 a_n360_n708.n6 12.5495
R5402 a_n360_n708.n9 a_n360_n708.n8 12.5495
R5403 a_n360_n708.n11 a_n360_n708.n10 12.5495
R5404 a_n360_n708.n13 a_n360_n708.n12 12.5495
R5405 a_n360_n708.n15 a_n360_n708.n14 12.5495
R5406 a_n360_n708.n17 a_n360_n708.n16 12.5495
R5407 a_n360_n708.n19 a_n360_n708.n18 12.5495
R5408 a_n360_n708.n21 a_n360_n708.n20 12.5495
R5409 a_n360_n708.n23 a_n360_n708.n22 12.5495
R5410 a_n360_n708.n25 a_n360_n708.n24 12.5495
R5411 a_n360_n708.n27 a_n360_n708.n26 12.5495
R5412 a_n360_n708.n29 a_n360_n708.n28 12.5495
R5413 a_n360_n708.n31 a_n360_n708.n30 12.5495
R5414 a_n360_n708.n32 a_n360_n708.n0 6.45898
R5415 a_n360_n708.n32 a_n360_n708.n31 5.79746
R5416 a_n360_n708.n33 a_n360_n708.n32 2.99572
R5417 a_n360_n708.n0 a_n360_n708.t2 2.64244
R5418 a_n360_n708.n0 a_n360_n708.t3 2.64244
R5419 a_n360_n708.t1 a_n360_n708.n33 1.46824
R5420 a_n360_n708.n33 a_n360_n708.t0 1.46824
R5421 a_n360_n708.n7 a_n360_n708.n5 1.27979
R5422 a_n360_n708.n11 a_n360_n708.n9 1.27979
R5423 a_n360_n708.n15 a_n360_n708.n13 1.27979
R5424 a_n360_n708.n19 a_n360_n708.n17 1.27979
R5425 a_n360_n708.n23 a_n360_n708.n21 1.27979
R5426 a_n360_n708.n27 a_n360_n708.n25 1.27979
R5427 a_n360_n708.n31 a_n360_n708.n29 1.27979
R5428 a_n360_n708.n5 a_n360_n708.n3 1.24121
R5429 a_n360_n708.n9 a_n360_n708.n7 1.24121
R5430 a_n360_n708.n13 a_n360_n708.n11 1.24121
R5431 a_n360_n708.n17 a_n360_n708.n15 1.24121
R5432 a_n360_n708.n21 a_n360_n708.n19 1.24121
R5433 a_n360_n708.n25 a_n360_n708.n23 1.24121
R5434 a_n360_n708.n29 a_n360_n708.n27 1.24121
R5435 WE0CLK.n1 WE0CLK.t6 29.7679
R5436 WE0CLK.n30 WE0CLK.t25 29.4079
R5437 WE0CLK.n28 WE0CLK.t8 29.4079
R5438 WE0CLK.n26 WE0CLK.t14 29.4079
R5439 WE0CLK.n24 WE0CLK.t37 29.4079
R5440 WE0CLK.n22 WE0CLK.t19 29.4079
R5441 WE0CLK.n20 WE0CLK.t4 29.4079
R5442 WE0CLK.n18 WE0CLK.t17 29.4079
R5443 WE0CLK.n16 WE0CLK.t36 29.4079
R5444 WE0CLK.n14 WE0CLK.t23 29.4079
R5445 WE0CLK.n12 WE0CLK.t10 29.4079
R5446 WE0CLK.n10 WE0CLK.t22 29.4079
R5447 WE0CLK.n8 WE0CLK.t39 29.4079
R5448 WE0CLK.n6 WE0CLK.t30 29.4079
R5449 WE0CLK.n4 WE0CLK.t11 29.4079
R5450 WE0CLK.n2 WE0CLK.t29 29.4079
R5451 WE0CLK.n31 WE0CLK.t20 29.1445
R5452 WE0CLK.n29 WE0CLK.t7 29.1445
R5453 WE0CLK.n27 WE0CLK.t9 29.1445
R5454 WE0CLK.n25 WE0CLK.t31 29.1445
R5455 WE0CLK.n23 WE0CLK.t15 29.1445
R5456 WE0CLK.n21 WE0CLK.t32 29.1445
R5457 WE0CLK.n19 WE0CLK.t16 29.1445
R5458 WE0CLK.n17 WE0CLK.t27 29.1445
R5459 WE0CLK.n15 WE0CLK.t12 29.1445
R5460 WE0CLK.n13 WE0CLK.t35 29.1445
R5461 WE0CLK.n11 WE0CLK.t21 29.1445
R5462 WE0CLK.n9 WE0CLK.t38 29.1445
R5463 WE0CLK.n7 WE0CLK.t18 29.1445
R5464 WE0CLK.n5 WE0CLK.t5 29.1445
R5465 WE0CLK.n3 WE0CLK.t28 29.1445
R5466 WE0CLK.n1 WE0CLK.t13 29.1445
R5467 WE0CLK.n33 WE0CLK.t26 24.7684
R5468 WE0CLK.n33 WE0CLK.t34 24.1166
R5469 WE0CLK.n34 WE0CLK.t24 23.7255
R5470 WE0CLK.n34 WE0CLK.t33 23.0737
R5471 WE0CLK.n34 WE0CLK.n33 17.1396
R5472 WE0CLK.n32 WE0CLK.n31 10.2862
R5473 WE0CLK WE0CLK.n34 8.0005
R5474 WE0CLK.n32 WE0CLK.n0 6.86767
R5475 WE0CLK.n2 WE0CLK.n1 3.61336
R5476 WE0CLK.n4 WE0CLK.n3 3.61336
R5477 WE0CLK.n6 WE0CLK.n5 3.61336
R5478 WE0CLK.n8 WE0CLK.n7 3.61336
R5479 WE0CLK.n10 WE0CLK.n9 3.61336
R5480 WE0CLK.n12 WE0CLK.n11 3.61336
R5481 WE0CLK.n14 WE0CLK.n13 3.61336
R5482 WE0CLK.n16 WE0CLK.n15 3.61336
R5483 WE0CLK.n18 WE0CLK.n17 3.61336
R5484 WE0CLK.n20 WE0CLK.n19 3.61336
R5485 WE0CLK.n22 WE0CLK.n21 3.61336
R5486 WE0CLK.n24 WE0CLK.n23 3.61336
R5487 WE0CLK.n26 WE0CLK.n25 3.61336
R5488 WE0CLK.n28 WE0CLK.n27 3.61336
R5489 WE0CLK.n30 WE0CLK.n29 3.61336
R5490 WE0CLK WE0CLK.n35 3.45159
R5491 WE0CLK.n0 WE0CLK.t2 2.58003
R5492 WE0CLK.n0 WE0CLK.t3 2.58003
R5493 WE0CLK.n35 WE0CLK.t0 1.43357
R5494 WE0CLK.n35 WE0CLK.t1 1.43357
R5495 WE0CLK.n3 WE0CLK.n2 0.3605
R5496 WE0CLK.n5 WE0CLK.n4 0.3605
R5497 WE0CLK.n7 WE0CLK.n6 0.3605
R5498 WE0CLK.n9 WE0CLK.n8 0.3605
R5499 WE0CLK.n11 WE0CLK.n10 0.3605
R5500 WE0CLK.n13 WE0CLK.n12 0.3605
R5501 WE0CLK.n15 WE0CLK.n14 0.3605
R5502 WE0CLK.n17 WE0CLK.n16 0.3605
R5503 WE0CLK.n19 WE0CLK.n18 0.3605
R5504 WE0CLK.n21 WE0CLK.n20 0.3605
R5505 WE0CLK.n23 WE0CLK.n22 0.3605
R5506 WE0CLK.n25 WE0CLK.n24 0.3605
R5507 WE0CLK.n27 WE0CLK.n26 0.3605
R5508 WE0CLK.n29 WE0CLK.n28 0.3605
R5509 WE0CLK.n31 WE0CLK.n30 0.3605
R5510 WE0CLK WE0CLK.n32 0.169589
R5511 a_n1204_7670.n1 a_n1204_7670.t12 29.7679
R5512 a_n1204_7670.n30 a_n1204_7670.t36 29.4079
R5513 a_n1204_7670.n28 a_n1204_7670.t25 29.4079
R5514 a_n1204_7670.n26 a_n1204_7670.t11 29.4079
R5515 a_n1204_7670.n24 a_n1204_7670.t10 29.4079
R5516 a_n1204_7670.n22 a_n1204_7670.t23 29.4079
R5517 a_n1204_7670.n20 a_n1204_7670.t22 29.4079
R5518 a_n1204_7670.n18 a_n1204_7670.t29 29.4079
R5519 a_n1204_7670.n16 a_n1204_7670.t7 29.4079
R5520 a_n1204_7670.n14 a_n1204_7670.t6 29.4079
R5521 a_n1204_7670.n12 a_n1204_7670.t24 29.4079
R5522 a_n1204_7670.n10 a_n1204_7670.t33 29.4079
R5523 a_n1204_7670.n8 a_n1204_7670.t9 29.4079
R5524 a_n1204_7670.n6 a_n1204_7670.t8 29.4079
R5525 a_n1204_7670.n4 a_n1204_7670.t26 29.4079
R5526 a_n1204_7670.n2 a_n1204_7670.t34 29.4079
R5527 a_n1204_7670.n31 a_n1204_7670.t19 29.1445
R5528 a_n1204_7670.n29 a_n1204_7670.t37 29.1445
R5529 a_n1204_7670.n27 a_n1204_7670.t20 29.1445
R5530 a_n1204_7670.n25 a_n1204_7670.t32 29.1445
R5531 a_n1204_7670.n23 a_n1204_7670.t31 29.1445
R5532 a_n1204_7670.n21 a_n1204_7670.t14 29.1445
R5533 a_n1204_7670.n19 a_n1204_7670.t13 29.1445
R5534 a_n1204_7670.n17 a_n1204_7670.t28 29.1445
R5535 a_n1204_7670.n15 a_n1204_7670.t27 29.1445
R5536 a_n1204_7670.n13 a_n1204_7670.t16 29.1445
R5537 a_n1204_7670.n11 a_n1204_7670.t15 29.1445
R5538 a_n1204_7670.n9 a_n1204_7670.t21 29.1445
R5539 a_n1204_7670.n7 a_n1204_7670.t30 29.1445
R5540 a_n1204_7670.n5 a_n1204_7670.t35 29.1445
R5541 a_n1204_7670.n3 a_n1204_7670.t18 29.1445
R5542 a_n1204_7670.n1 a_n1204_7670.t17 29.1445
R5543 a_n1204_7670.n33 a_n1204_7670.t5 24.7684
R5544 a_n1204_7670.n33 a_n1204_7670.t4 24.1166
R5545 a_n1204_7670.n34 a_n1204_7670.t39 23.7255
R5546 a_n1204_7670.n34 a_n1204_7670.t38 23.0737
R5547 a_n1204_7670.n34 a_n1204_7670.n33 17.1396
R5548 a_n1204_7670.n32 a_n1204_7670.n31 10.2862
R5549 a_n1204_7670.n35 a_n1204_7670.n34 8.0005
R5550 a_n1204_7670.n32 a_n1204_7670.n0 6.86767
R5551 a_n1204_7670.n2 a_n1204_7670.n1 3.61336
R5552 a_n1204_7670.n4 a_n1204_7670.n3 3.61336
R5553 a_n1204_7670.n6 a_n1204_7670.n5 3.61336
R5554 a_n1204_7670.n8 a_n1204_7670.n7 3.61336
R5555 a_n1204_7670.n10 a_n1204_7670.n9 3.61336
R5556 a_n1204_7670.n12 a_n1204_7670.n11 3.61336
R5557 a_n1204_7670.n14 a_n1204_7670.n13 3.61336
R5558 a_n1204_7670.n16 a_n1204_7670.n15 3.61336
R5559 a_n1204_7670.n18 a_n1204_7670.n17 3.61336
R5560 a_n1204_7670.n20 a_n1204_7670.n19 3.61336
R5561 a_n1204_7670.n22 a_n1204_7670.n21 3.61336
R5562 a_n1204_7670.n24 a_n1204_7670.n23 3.61336
R5563 a_n1204_7670.n26 a_n1204_7670.n25 3.61336
R5564 a_n1204_7670.n28 a_n1204_7670.n27 3.61336
R5565 a_n1204_7670.n30 a_n1204_7670.n29 3.61336
R5566 a_n1204_7670.n36 a_n1204_7670.n35 3.45159
R5567 a_n1204_7670.n0 a_n1204_7670.t2 2.58003
R5568 a_n1204_7670.n0 a_n1204_7670.t3 2.58003
R5569 a_n1204_7670.n36 a_n1204_7670.t0 1.43357
R5570 a_n1204_7670.t1 a_n1204_7670.n36 1.43357
R5571 a_n1204_7670.n3 a_n1204_7670.n2 0.3605
R5572 a_n1204_7670.n5 a_n1204_7670.n4 0.3605
R5573 a_n1204_7670.n7 a_n1204_7670.n6 0.3605
R5574 a_n1204_7670.n9 a_n1204_7670.n8 0.3605
R5575 a_n1204_7670.n11 a_n1204_7670.n10 0.3605
R5576 a_n1204_7670.n13 a_n1204_7670.n12 0.3605
R5577 a_n1204_7670.n15 a_n1204_7670.n14 0.3605
R5578 a_n1204_7670.n17 a_n1204_7670.n16 0.3605
R5579 a_n1204_7670.n19 a_n1204_7670.n18 0.3605
R5580 a_n1204_7670.n21 a_n1204_7670.n20 0.3605
R5581 a_n1204_7670.n23 a_n1204_7670.n22 0.3605
R5582 a_n1204_7670.n25 a_n1204_7670.n24 0.3605
R5583 a_n1204_7670.n27 a_n1204_7670.n26 0.3605
R5584 a_n1204_7670.n29 a_n1204_7670.n28 0.3605
R5585 a_n1204_7670.n31 a_n1204_7670.n30 0.3605
R5586 a_n1204_7670.n35 a_n1204_7670.n32 0.169589
R5587 a_35737_n862.n14 a_35737_n862.t32 18.9023
R5588 a_35737_n862.n0 a_35737_n862.t13 16.1132
R5589 a_35737_n862.n14 a_35737_n862.t33 15.6434
R5590 a_35737_n862.n2 a_35737_n862.t2 15.4511
R5591 a_35737_n862.n3 a_35737_n862.t17 15.4511
R5592 a_35737_n862.n6 a_35737_n862.t22 15.4511
R5593 a_35737_n862.n7 a_35737_n862.t9 15.4511
R5594 a_35737_n862.n10 a_35737_n862.t16 15.4511
R5595 a_35737_n862.n11 a_35737_n862.t12 15.4511
R5596 a_35737_n862.n30 a_35737_n862.t5 15.4511
R5597 a_35737_n862.n27 a_35737_n862.t10 15.4511
R5598 a_35737_n862.n26 a_35737_n862.t1 15.4511
R5599 a_35737_n862.n23 a_35737_n862.t7 15.4511
R5600 a_35737_n862.n22 a_35737_n862.t4 15.4511
R5601 a_35737_n862.n19 a_35737_n862.t6 15.4511
R5602 a_35737_n862.n18 a_35737_n862.t11 15.4511
R5603 a_35737_n862.n15 a_35737_n862.t8 15.4511
R5604 a_35737_n862.t0 a_35737_n862.n31 15.4511
R5605 a_35737_n862.n0 a_35737_n862.t18 14.8566
R5606 a_35737_n862.n1 a_35737_n862.t25 14.8566
R5607 a_35737_n862.n4 a_35737_n862.t23 14.8566
R5608 a_35737_n862.n5 a_35737_n862.t14 14.8566
R5609 a_35737_n862.n8 a_35737_n862.t19 14.8566
R5610 a_35737_n862.n9 a_35737_n862.t24 14.8566
R5611 a_35737_n862.n12 a_35737_n862.t3 14.8566
R5612 a_35737_n862.n13 a_35737_n862.t29 14.8566
R5613 a_35737_n862.n29 a_35737_n862.t26 14.8566
R5614 a_35737_n862.n28 a_35737_n862.t27 14.8566
R5615 a_35737_n862.n25 a_35737_n862.t21 14.8566
R5616 a_35737_n862.n24 a_35737_n862.t15 14.8566
R5617 a_35737_n862.n21 a_35737_n862.t28 14.8566
R5618 a_35737_n862.n20 a_35737_n862.t20 14.8566
R5619 a_35737_n862.n17 a_35737_n862.t31 14.8566
R5620 a_35737_n862.n16 a_35737_n862.t30 14.8566
R5621 a_35737_n862.n15 a_35737_n862.n14 14.5641
R5622 a_35737_n862.n3 a_35737_n862.n2 0.746214
R5623 a_35737_n862.n7 a_35737_n862.n6 0.746214
R5624 a_35737_n862.n11 a_35737_n862.n10 0.746214
R5625 a_35737_n862.n31 a_35737_n862.n30 0.746214
R5626 a_35737_n862.n27 a_35737_n862.n26 0.746214
R5627 a_35737_n862.n23 a_35737_n862.n22 0.746214
R5628 a_35737_n862.n19 a_35737_n862.n18 0.746214
R5629 a_35737_n862.n2 a_35737_n862.n1 0.662643
R5630 a_35737_n862.n4 a_35737_n862.n3 0.662643
R5631 a_35737_n862.n6 a_35737_n862.n5 0.662643
R5632 a_35737_n862.n8 a_35737_n862.n7 0.662643
R5633 a_35737_n862.n10 a_35737_n862.n9 0.662643
R5634 a_35737_n862.n12 a_35737_n862.n11 0.662643
R5635 a_35737_n862.n31 a_35737_n862.n13 0.662643
R5636 a_35737_n862.n30 a_35737_n862.n29 0.662643
R5637 a_35737_n862.n28 a_35737_n862.n27 0.662643
R5638 a_35737_n862.n26 a_35737_n862.n25 0.662643
R5639 a_35737_n862.n24 a_35737_n862.n23 0.662643
R5640 a_35737_n862.n22 a_35737_n862.n21 0.662643
R5641 a_35737_n862.n20 a_35737_n862.n19 0.662643
R5642 a_35737_n862.n18 a_35737_n862.n17 0.662643
R5643 a_35737_n862.n16 a_35737_n862.n15 0.662643
R5644 a_35737_n862.n1 a_35737_n862.n0 0.4505
R5645 a_35737_n862.n5 a_35737_n862.n4 0.4505
R5646 a_35737_n862.n9 a_35737_n862.n8 0.4505
R5647 a_35737_n862.n13 a_35737_n862.n12 0.4505
R5648 a_35737_n862.n29 a_35737_n862.n28 0.4505
R5649 a_35737_n862.n25 a_35737_n862.n24 0.4505
R5650 a_35737_n862.n21 a_35737_n862.n20 0.4505
R5651 a_35737_n862.n17 a_35737_n862.n16 0.4505
R5652 a_11287_n2146.n2 a_11287_n2146.t32 18.9023
R5653 a_11287_n2146.n0 a_11287_n2146.t22 16.1106
R5654 a_11287_n2146.n2 a_11287_n2146.t33 15.6434
R5655 a_11287_n2146.n30 a_11287_n2146.t1 15.4484
R5656 a_11287_n2146.n27 a_11287_n2146.t13 15.4484
R5657 a_11287_n2146.n26 a_11287_n2146.t16 15.4484
R5658 a_11287_n2146.n23 a_11287_n2146.t9 15.4484
R5659 a_11287_n2146.n22 a_11287_n2146.t2 15.4484
R5660 a_11287_n2146.n19 a_11287_n2146.t18 15.4484
R5661 a_11287_n2146.n18 a_11287_n2146.t29 15.4484
R5662 a_11287_n2146.n15 a_11287_n2146.t14 15.4484
R5663 a_11287_n2146.n14 a_11287_n2146.t3 15.4484
R5664 a_11287_n2146.n11 a_11287_n2146.t17 15.4484
R5665 a_11287_n2146.n10 a_11287_n2146.t10 15.4484
R5666 a_11287_n2146.n7 a_11287_n2146.t4 15.4484
R5667 a_11287_n2146.n6 a_11287_n2146.t12 15.4484
R5668 a_11287_n2146.n3 a_11287_n2146.t8 15.4484
R5669 a_11287_n2146.t0 a_11287_n2146.n31 15.4484
R5670 a_11287_n2146.n0 a_11287_n2146.t27 14.854
R5671 a_11287_n2146.n1 a_11287_n2146.t24 14.854
R5672 a_11287_n2146.n29 a_11287_n2146.t20 14.854
R5673 a_11287_n2146.n28 a_11287_n2146.t5 14.854
R5674 a_11287_n2146.n25 a_11287_n2146.t7 14.854
R5675 a_11287_n2146.n24 a_11287_n2146.t23 14.854
R5676 a_11287_n2146.n21 a_11287_n2146.t15 14.854
R5677 a_11287_n2146.n20 a_11287_n2146.t26 14.854
R5678 a_11287_n2146.n17 a_11287_n2146.t19 14.854
R5679 a_11287_n2146.n16 a_11287_n2146.t28 14.854
R5680 a_11287_n2146.n13 a_11287_n2146.t6 14.854
R5681 a_11287_n2146.n12 a_11287_n2146.t21 14.854
R5682 a_11287_n2146.n9 a_11287_n2146.t25 14.854
R5683 a_11287_n2146.n8 a_11287_n2146.t30 14.854
R5684 a_11287_n2146.n5 a_11287_n2146.t31 14.854
R5685 a_11287_n2146.n4 a_11287_n2146.t11 14.854
R5686 a_11287_n2146.n3 a_11287_n2146.n2 14.5641
R5687 a_11287_n2146.n31 a_11287_n2146.n30 0.746214
R5688 a_11287_n2146.n27 a_11287_n2146.n26 0.746214
R5689 a_11287_n2146.n23 a_11287_n2146.n22 0.746214
R5690 a_11287_n2146.n19 a_11287_n2146.n18 0.746214
R5691 a_11287_n2146.n15 a_11287_n2146.n14 0.746214
R5692 a_11287_n2146.n11 a_11287_n2146.n10 0.746214
R5693 a_11287_n2146.n7 a_11287_n2146.n6 0.746214
R5694 a_11287_n2146.n31 a_11287_n2146.n1 0.662643
R5695 a_11287_n2146.n30 a_11287_n2146.n29 0.662643
R5696 a_11287_n2146.n28 a_11287_n2146.n27 0.662643
R5697 a_11287_n2146.n26 a_11287_n2146.n25 0.662643
R5698 a_11287_n2146.n24 a_11287_n2146.n23 0.662643
R5699 a_11287_n2146.n22 a_11287_n2146.n21 0.662643
R5700 a_11287_n2146.n20 a_11287_n2146.n19 0.662643
R5701 a_11287_n2146.n18 a_11287_n2146.n17 0.662643
R5702 a_11287_n2146.n16 a_11287_n2146.n15 0.662643
R5703 a_11287_n2146.n14 a_11287_n2146.n13 0.662643
R5704 a_11287_n2146.n12 a_11287_n2146.n11 0.662643
R5705 a_11287_n2146.n10 a_11287_n2146.n9 0.662643
R5706 a_11287_n2146.n8 a_11287_n2146.n7 0.662643
R5707 a_11287_n2146.n6 a_11287_n2146.n5 0.662643
R5708 a_11287_n2146.n4 a_11287_n2146.n3 0.662643
R5709 a_11287_n2146.n1 a_11287_n2146.n0 0.4505
R5710 a_11287_n2146.n29 a_11287_n2146.n28 0.4505
R5711 a_11287_n2146.n25 a_11287_n2146.n24 0.4505
R5712 a_11287_n2146.n21 a_11287_n2146.n20 0.4505
R5713 a_11287_n2146.n17 a_11287_n2146.n16 0.4505
R5714 a_11287_n2146.n13 a_11287_n2146.n12 0.4505
R5715 a_11287_n2146.n9 a_11287_n2146.n8 0.4505
R5716 a_11287_n2146.n5 a_11287_n2146.n4 0.4505
R5717 a_n1204_4534.n1 a_n1204_4534.t11 29.7679
R5718 a_n1204_4534.n30 a_n1204_4534.t37 29.4079
R5719 a_n1204_4534.n28 a_n1204_4534.t26 29.4079
R5720 a_n1204_4534.n26 a_n1204_4534.t10 29.4079
R5721 a_n1204_4534.n24 a_n1204_4534.t9 29.4079
R5722 a_n1204_4534.n22 a_n1204_4534.t24 29.4079
R5723 a_n1204_4534.n20 a_n1204_4534.t23 29.4079
R5724 a_n1204_4534.n18 a_n1204_4534.t30 29.4079
R5725 a_n1204_4534.n16 a_n1204_4534.t6 29.4079
R5726 a_n1204_4534.n14 a_n1204_4534.t5 29.4079
R5727 a_n1204_4534.n12 a_n1204_4534.t25 29.4079
R5728 a_n1204_4534.n10 a_n1204_4534.t34 29.4079
R5729 a_n1204_4534.n8 a_n1204_4534.t8 29.4079
R5730 a_n1204_4534.n6 a_n1204_4534.t7 29.4079
R5731 a_n1204_4534.n4 a_n1204_4534.t27 29.4079
R5732 a_n1204_4534.n2 a_n1204_4534.t35 29.4079
R5733 a_n1204_4534.n31 a_n1204_4534.t20 29.1445
R5734 a_n1204_4534.n29 a_n1204_4534.t38 29.1445
R5735 a_n1204_4534.n27 a_n1204_4534.t21 29.1445
R5736 a_n1204_4534.n25 a_n1204_4534.t33 29.1445
R5737 a_n1204_4534.n23 a_n1204_4534.t32 29.1445
R5738 a_n1204_4534.n21 a_n1204_4534.t14 29.1445
R5739 a_n1204_4534.n19 a_n1204_4534.t13 29.1445
R5740 a_n1204_4534.n17 a_n1204_4534.t29 29.1445
R5741 a_n1204_4534.n15 a_n1204_4534.t28 29.1445
R5742 a_n1204_4534.n13 a_n1204_4534.t16 29.1445
R5743 a_n1204_4534.n11 a_n1204_4534.t15 29.1445
R5744 a_n1204_4534.n9 a_n1204_4534.t22 29.1445
R5745 a_n1204_4534.n7 a_n1204_4534.t31 29.1445
R5746 a_n1204_4534.n5 a_n1204_4534.t36 29.1445
R5747 a_n1204_4534.n3 a_n1204_4534.t18 29.1445
R5748 a_n1204_4534.n1 a_n1204_4534.t17 29.1445
R5749 a_n1204_4534.n33 a_n1204_4534.t4 24.7684
R5750 a_n1204_4534.n33 a_n1204_4534.t19 24.1166
R5751 a_n1204_4534.n34 a_n1204_4534.t39 23.7255
R5752 a_n1204_4534.n34 a_n1204_4534.t12 23.0737
R5753 a_n1204_4534.n34 a_n1204_4534.n33 17.1396
R5754 a_n1204_4534.n32 a_n1204_4534.n31 10.2862
R5755 a_n1204_4534.n35 a_n1204_4534.n34 8.0005
R5756 a_n1204_4534.n32 a_n1204_4534.n0 6.86767
R5757 a_n1204_4534.n2 a_n1204_4534.n1 3.61336
R5758 a_n1204_4534.n4 a_n1204_4534.n3 3.61336
R5759 a_n1204_4534.n6 a_n1204_4534.n5 3.61336
R5760 a_n1204_4534.n8 a_n1204_4534.n7 3.61336
R5761 a_n1204_4534.n10 a_n1204_4534.n9 3.61336
R5762 a_n1204_4534.n12 a_n1204_4534.n11 3.61336
R5763 a_n1204_4534.n14 a_n1204_4534.n13 3.61336
R5764 a_n1204_4534.n16 a_n1204_4534.n15 3.61336
R5765 a_n1204_4534.n18 a_n1204_4534.n17 3.61336
R5766 a_n1204_4534.n20 a_n1204_4534.n19 3.61336
R5767 a_n1204_4534.n22 a_n1204_4534.n21 3.61336
R5768 a_n1204_4534.n24 a_n1204_4534.n23 3.61336
R5769 a_n1204_4534.n26 a_n1204_4534.n25 3.61336
R5770 a_n1204_4534.n28 a_n1204_4534.n27 3.61336
R5771 a_n1204_4534.n30 a_n1204_4534.n29 3.61336
R5772 a_n1204_4534.n36 a_n1204_4534.n35 3.45159
R5773 a_n1204_4534.n0 a_n1204_4534.t2 2.58003
R5774 a_n1204_4534.n0 a_n1204_4534.t3 2.58003
R5775 a_n1204_4534.n36 a_n1204_4534.t0 1.43357
R5776 a_n1204_4534.t1 a_n1204_4534.n36 1.43357
R5777 a_n1204_4534.n3 a_n1204_4534.n2 0.3605
R5778 a_n1204_4534.n5 a_n1204_4534.n4 0.3605
R5779 a_n1204_4534.n7 a_n1204_4534.n6 0.3605
R5780 a_n1204_4534.n9 a_n1204_4534.n8 0.3605
R5781 a_n1204_4534.n11 a_n1204_4534.n10 0.3605
R5782 a_n1204_4534.n13 a_n1204_4534.n12 0.3605
R5783 a_n1204_4534.n15 a_n1204_4534.n14 0.3605
R5784 a_n1204_4534.n17 a_n1204_4534.n16 0.3605
R5785 a_n1204_4534.n19 a_n1204_4534.n18 0.3605
R5786 a_n1204_4534.n21 a_n1204_4534.n20 0.3605
R5787 a_n1204_4534.n23 a_n1204_4534.n22 0.3605
R5788 a_n1204_4534.n25 a_n1204_4534.n24 0.3605
R5789 a_n1204_4534.n27 a_n1204_4534.n26 0.3605
R5790 a_n1204_4534.n29 a_n1204_4534.n28 0.3605
R5791 a_n1204_4534.n31 a_n1204_4534.n30 0.3605
R5792 a_n1204_4534.n35 a_n1204_4534.n32 0.169589
R5793 RB10.t44 RB10.t24 69.3795
R5794 RB10.t30 RB10.t36 69.3795
R5795 RB10.t29 RB10.t3 69.3795
R5796 RB10.t7 RB10.t2 69.3795
R5797 RB10.t8 RB10.t20 69.3795
R5798 RB10.t27 RB10.t35 69.3795
R5799 RB10.t26 RB10.t47 69.3795
R5800 RB10.t42 RB10.t45 69.3795
R5801 RB10.t10 RB10.t22 69.3795
R5802 RB10.t9 RB10.t21 69.3795
R5803 RB10.t28 RB10.t1 69.3795
R5804 RB10.t37 RB10.t12 69.3795
R5805 RB10.t46 RB10.t25 69.3795
R5806 RB10.t11 RB10.t23 69.3795
R5807 RB10.t31 RB10.t38 69.3795
R5808 RB10.t39 RB10.t13 69.3795
R5809 RB10.n29 RB10.t40 30.2434
R5810 RB10.n27 RB10.t18 30.2434
R5811 RB10.n25 RB10.t17 30.2434
R5812 RB10.n23 RB10.t43 30.2434
R5813 RB10.n21 RB10.t0 30.2434
R5814 RB10.n19 RB10.t15 30.2434
R5815 RB10.n17 RB10.t14 30.2434
R5816 RB10.n15 RB10.t34 30.2434
R5817 RB10.n13 RB10.t5 30.2434
R5818 RB10.n11 RB10.t4 30.2434
R5819 RB10.n9 RB10.t16 30.2434
R5820 RB10.n7 RB10.t32 30.2434
R5821 RB10.n5 RB10.t41 30.2434
R5822 RB10.n3 RB10.t6 30.2434
R5823 RB10.n1 RB10.t19 30.2434
R5824 RB10.n0 RB10.t33 30.2434
R5825 RB10.n2 RB10.n0 21.0176
R5826 RB10.n30 RB10.n29 17.0448
R5827 RB10.n28 RB10.n27 17.0448
R5828 RB10.n26 RB10.n25 17.0448
R5829 RB10.n24 RB10.n23 17.0448
R5830 RB10.n22 RB10.n21 17.0448
R5831 RB10.n20 RB10.n19 17.0448
R5832 RB10.n18 RB10.n17 17.0448
R5833 RB10.n16 RB10.n15 17.0448
R5834 RB10.n14 RB10.n13 17.0448
R5835 RB10.n12 RB10.n11 17.0448
R5836 RB10.n10 RB10.n9 17.0448
R5837 RB10.n8 RB10.n7 17.0448
R5838 RB10.n6 RB10.n5 17.0448
R5839 RB10.n4 RB10.n3 17.0448
R5840 RB10.n2 RB10.n1 17.0448
R5841 RB10.n29 RB10.t44 16.6862
R5842 RB10.n27 RB10.t30 16.6862
R5843 RB10.n25 RB10.t29 16.6862
R5844 RB10.n23 RB10.t7 16.6862
R5845 RB10.n21 RB10.t8 16.6862
R5846 RB10.n19 RB10.t27 16.6862
R5847 RB10.n17 RB10.t26 16.6862
R5848 RB10.n15 RB10.t42 16.6862
R5849 RB10.n13 RB10.t10 16.6862
R5850 RB10.n11 RB10.t9 16.6862
R5851 RB10.n9 RB10.t28 16.6862
R5852 RB10.n7 RB10.t37 16.6862
R5853 RB10.n5 RB10.t46 16.6862
R5854 RB10.n3 RB10.t11 16.6862
R5855 RB10.n1 RB10.t31 16.6862
R5856 RB10.n0 RB10.t39 16.6862
R5857 RB10 RB10.n30 5.78139
R5858 RB10.n4 RB10.n2 3.97336
R5859 RB10.n6 RB10.n4 3.97336
R5860 RB10.n8 RB10.n6 3.97336
R5861 RB10.n10 RB10.n8 3.97336
R5862 RB10.n12 RB10.n10 3.97336
R5863 RB10.n14 RB10.n12 3.97336
R5864 RB10.n16 RB10.n14 3.97336
R5865 RB10.n18 RB10.n16 3.97336
R5866 RB10.n20 RB10.n18 3.97336
R5867 RB10.n22 RB10.n20 3.97336
R5868 RB10.n24 RB10.n22 3.97336
R5869 RB10.n26 RB10.n24 3.97336
R5870 RB10.n28 RB10.n26 3.97336
R5871 RB10.n30 RB10.n28 3.97336
R5872 RA10.t28 RA10.t4 70.3934
R5873 RA10.t7 RA10.t15 70.3934
R5874 RA10.t6 RA10.t44 70.3934
R5875 RA10.t22 RA10.t42 70.3934
R5876 RA10.t24 RA10.t2 70.3934
R5877 RA10.t35 RA10.t11 70.3934
R5878 RA10.t3 RA10.t27 70.3934
R5879 RA10.t20 RA10.t39 70.3934
R5880 RA10.t25 RA10.t0 70.3934
R5881 RA10.t37 RA10.t14 70.3934
R5882 RA10.t36 RA10.t12 70.3934
R5883 RA10.t21 RA10.t29 70.3934
R5884 RA10.t26 RA10.t1 70.3934
R5885 RA10.t40 RA10.t18 70.3934
R5886 RA10.t38 RA10.t16 70.3934
R5887 RA10.t5 RA10.t43 70.3934
R5888 RA10.n29 RA10.t28 31.2862
R5889 RA10.n27 RA10.t7 31.2862
R5890 RA10.n25 RA10.t6 31.2862
R5891 RA10.n23 RA10.t22 31.2862
R5892 RA10.n21 RA10.t24 31.2862
R5893 RA10.n19 RA10.t35 31.2862
R5894 RA10.n17 RA10.t3 31.2862
R5895 RA10.n15 RA10.t20 31.2862
R5896 RA10.n13 RA10.t25 31.2862
R5897 RA10.n11 RA10.t37 31.2862
R5898 RA10.n9 RA10.t36 31.2862
R5899 RA10.n7 RA10.t21 31.2862
R5900 RA10.n5 RA10.t26 31.2862
R5901 RA10.n3 RA10.t40 31.2862
R5902 RA10.n1 RA10.t38 31.2862
R5903 RA10.n0 RA10.t5 31.2862
R5904 RA10.n2 RA10.n0 21.0181
R5905 RA10.n30 RA10.n29 17.0453
R5906 RA10.n28 RA10.n27 17.0453
R5907 RA10.n26 RA10.n25 17.0453
R5908 RA10.n24 RA10.n23 17.0453
R5909 RA10.n22 RA10.n21 17.0453
R5910 RA10.n20 RA10.n19 17.0453
R5911 RA10.n18 RA10.n17 17.0453
R5912 RA10.n16 RA10.n15 17.0453
R5913 RA10.n14 RA10.n13 17.0453
R5914 RA10.n12 RA10.n11 17.0453
R5915 RA10.n10 RA10.n9 17.0453
R5916 RA10.n8 RA10.n7 17.0453
R5917 RA10.n6 RA10.n5 17.0453
R5918 RA10.n4 RA10.n3 17.0453
R5919 RA10.n2 RA10.n1 17.0453
R5920 RA10.n29 RA10.t23 15.6434
R5921 RA10.n27 RA10.t47 15.6434
R5922 RA10.n25 RA10.t46 15.6434
R5923 RA10.n23 RA10.t10 15.6434
R5924 RA10.n21 RA10.t13 15.6434
R5925 RA10.n19 RA10.t30 15.6434
R5926 RA10.n17 RA10.t41 15.6434
R5927 RA10.n15 RA10.t8 15.6434
R5928 RA10.n13 RA10.t17 15.6434
R5929 RA10.n11 RA10.t32 15.6434
R5930 RA10.n9 RA10.t31 15.6434
R5931 RA10.n7 RA10.t9 15.6434
R5932 RA10.n5 RA10.t19 15.6434
R5933 RA10.n3 RA10.t34 15.6434
R5934 RA10.n1 RA10.t33 15.6434
R5935 RA10.n0 RA10.t45 15.6434
R5936 RA10 RA10.n30 4.50532
R5937 RA10.n4 RA10.n2 3.97336
R5938 RA10.n6 RA10.n4 3.97336
R5939 RA10.n8 RA10.n6 3.97336
R5940 RA10.n10 RA10.n8 3.97336
R5941 RA10.n12 RA10.n10 3.97336
R5942 RA10.n14 RA10.n12 3.97336
R5943 RA10.n16 RA10.n14 3.97336
R5944 RA10.n18 RA10.n16 3.97336
R5945 RA10.n20 RA10.n18 3.97336
R5946 RA10.n22 RA10.n20 3.97336
R5947 RA10.n24 RA10.n22 3.97336
R5948 RA10.n26 RA10.n24 3.97336
R5949 RA10.n28 RA10.n26 3.97336
R5950 RA10.n30 RA10.n28 3.97336
R5951 RB2.t30 RB2.t9 69.3795
R5952 RB2.t15 RB2.t20 69.3795
R5953 RB2.t14 RB2.t36 69.3795
R5954 RB2.t40 RB2.t35 69.3795
R5955 RB2.t44 RB2.t5 69.3795
R5956 RB2.t12 RB2.t19 69.3795
R5957 RB2.t11 RB2.t33 69.3795
R5958 RB2.t29 RB2.t31 69.3795
R5959 RB2.t46 RB2.t7 69.3795
R5960 RB2.t45 RB2.t6 69.3795
R5961 RB2.t13 RB2.t34 69.3795
R5962 RB2.t22 RB2.t0 69.3795
R5963 RB2.t32 RB2.t10 69.3795
R5964 RB2.t47 RB2.t8 69.3795
R5965 RB2.t16 RB2.t25 69.3795
R5966 RB2.t26 RB2.t1 69.3795
R5967 RB2.n29 RB2.t17 30.2434
R5968 RB2.n27 RB2.t42 30.2434
R5969 RB2.n25 RB2.t41 30.2434
R5970 RB2.n23 RB2.t21 30.2434
R5971 RB2.n21 RB2.t23 30.2434
R5972 RB2.n19 RB2.t38 30.2434
R5973 RB2.n17 RB2.t37 30.2434
R5974 RB2.n15 RB2.t4 30.2434
R5975 RB2.n13 RB2.t27 30.2434
R5976 RB2.n11 RB2.t24 30.2434
R5977 RB2.n9 RB2.t39 30.2434
R5978 RB2.n7 RB2.t2 30.2434
R5979 RB2.n5 RB2.t18 30.2434
R5980 RB2.n3 RB2.t28 30.2434
R5981 RB2.n1 RB2.t43 30.2434
R5982 RB2.n0 RB2.t3 30.2434
R5983 RB2.n2 RB2.n0 21.0176
R5984 RB2.n30 RB2.n29 17.0448
R5985 RB2.n28 RB2.n27 17.0448
R5986 RB2.n26 RB2.n25 17.0448
R5987 RB2.n24 RB2.n23 17.0448
R5988 RB2.n22 RB2.n21 17.0448
R5989 RB2.n20 RB2.n19 17.0448
R5990 RB2.n18 RB2.n17 17.0448
R5991 RB2.n16 RB2.n15 17.0448
R5992 RB2.n14 RB2.n13 17.0448
R5993 RB2.n12 RB2.n11 17.0448
R5994 RB2.n10 RB2.n9 17.0448
R5995 RB2.n8 RB2.n7 17.0448
R5996 RB2.n6 RB2.n5 17.0448
R5997 RB2.n4 RB2.n3 17.0448
R5998 RB2.n2 RB2.n1 17.0448
R5999 RB2.n29 RB2.t30 16.6862
R6000 RB2.n27 RB2.t15 16.6862
R6001 RB2.n25 RB2.t14 16.6862
R6002 RB2.n23 RB2.t40 16.6862
R6003 RB2.n21 RB2.t44 16.6862
R6004 RB2.n19 RB2.t12 16.6862
R6005 RB2.n17 RB2.t11 16.6862
R6006 RB2.n15 RB2.t29 16.6862
R6007 RB2.n13 RB2.t46 16.6862
R6008 RB2.n11 RB2.t45 16.6862
R6009 RB2.n9 RB2.t13 16.6862
R6010 RB2.n7 RB2.t22 16.6862
R6011 RB2.n5 RB2.t32 16.6862
R6012 RB2.n3 RB2.t47 16.6862
R6013 RB2.n1 RB2.t16 16.6862
R6014 RB2.n0 RB2.t26 16.6862
R6015 RB2 RB2.n30 5.77979
R6016 RB2.n4 RB2.n2 3.97336
R6017 RB2.n6 RB2.n4 3.97336
R6018 RB2.n8 RB2.n6 3.97336
R6019 RB2.n10 RB2.n8 3.97336
R6020 RB2.n12 RB2.n10 3.97336
R6021 RB2.n14 RB2.n12 3.97336
R6022 RB2.n16 RB2.n14 3.97336
R6023 RB2.n18 RB2.n16 3.97336
R6024 RB2.n20 RB2.n18 3.97336
R6025 RB2.n22 RB2.n20 3.97336
R6026 RB2.n24 RB2.n22 3.97336
R6027 RB2.n26 RB2.n24 3.97336
R6028 RB2.n28 RB2.n26 3.97336
R6029 RB2.n30 RB2.n28 3.97336
R6030 a_n1204_3750.n1 a_n1204_3750.t23 29.7679
R6031 a_n1204_3750.n30 a_n1204_3750.t8 29.4079
R6032 a_n1204_3750.n28 a_n1204_3750.t36 29.4079
R6033 a_n1204_3750.n26 a_n1204_3750.t22 29.4079
R6034 a_n1204_3750.n24 a_n1204_3750.t21 29.4079
R6035 a_n1204_3750.n22 a_n1204_3750.t34 29.4079
R6036 a_n1204_3750.n20 a_n1204_3750.t33 29.4079
R6037 a_n1204_3750.n18 a_n1204_3750.t4 29.4079
R6038 a_n1204_3750.n16 a_n1204_3750.t18 29.4079
R6039 a_n1204_3750.n14 a_n1204_3750.t17 29.4079
R6040 a_n1204_3750.n12 a_n1204_3750.t35 29.4079
R6041 a_n1204_3750.n10 a_n1204_3750.t6 29.4079
R6042 a_n1204_3750.n8 a_n1204_3750.t20 29.4079
R6043 a_n1204_3750.n6 a_n1204_3750.t19 29.4079
R6044 a_n1204_3750.n4 a_n1204_3750.t37 29.4079
R6045 a_n1204_3750.n2 a_n1204_3750.t7 29.4079
R6046 a_n1204_3750.n31 a_n1204_3750.t38 29.1445
R6047 a_n1204_3750.n29 a_n1204_3750.t26 29.1445
R6048 a_n1204_3750.n27 a_n1204_3750.t39 29.1445
R6049 a_n1204_3750.n25 a_n1204_3750.t15 29.1445
R6050 a_n1204_3750.n23 a_n1204_3750.t14 29.1445
R6051 a_n1204_3750.n21 a_n1204_3750.t28 29.1445
R6052 a_n1204_3750.n19 a_n1204_3750.t27 29.1445
R6053 a_n1204_3750.n17 a_n1204_3750.t11 29.1445
R6054 a_n1204_3750.n15 a_n1204_3750.t10 29.1445
R6055 a_n1204_3750.n13 a_n1204_3750.t30 29.1445
R6056 a_n1204_3750.n11 a_n1204_3750.t29 29.1445
R6057 a_n1204_3750.n9 a_n1204_3750.t5 29.1445
R6058 a_n1204_3750.n7 a_n1204_3750.t12 29.1445
R6059 a_n1204_3750.n5 a_n1204_3750.t24 29.1445
R6060 a_n1204_3750.n3 a_n1204_3750.t32 29.1445
R6061 a_n1204_3750.n1 a_n1204_3750.t31 29.1445
R6062 a_n1204_3750.n33 a_n1204_3750.t13 24.7684
R6063 a_n1204_3750.n33 a_n1204_3750.t25 24.1166
R6064 a_n1204_3750.n34 a_n1204_3750.t9 23.7255
R6065 a_n1204_3750.n34 a_n1204_3750.t16 23.0737
R6066 a_n1204_3750.n34 a_n1204_3750.n33 17.1396
R6067 a_n1204_3750.n32 a_n1204_3750.n31 10.2862
R6068 a_n1204_3750.n35 a_n1204_3750.n34 8.0005
R6069 a_n1204_3750.n32 a_n1204_3750.n0 6.86767
R6070 a_n1204_3750.n2 a_n1204_3750.n1 3.61336
R6071 a_n1204_3750.n4 a_n1204_3750.n3 3.61336
R6072 a_n1204_3750.n6 a_n1204_3750.n5 3.61336
R6073 a_n1204_3750.n8 a_n1204_3750.n7 3.61336
R6074 a_n1204_3750.n10 a_n1204_3750.n9 3.61336
R6075 a_n1204_3750.n12 a_n1204_3750.n11 3.61336
R6076 a_n1204_3750.n14 a_n1204_3750.n13 3.61336
R6077 a_n1204_3750.n16 a_n1204_3750.n15 3.61336
R6078 a_n1204_3750.n18 a_n1204_3750.n17 3.61336
R6079 a_n1204_3750.n20 a_n1204_3750.n19 3.61336
R6080 a_n1204_3750.n22 a_n1204_3750.n21 3.61336
R6081 a_n1204_3750.n24 a_n1204_3750.n23 3.61336
R6082 a_n1204_3750.n26 a_n1204_3750.n25 3.61336
R6083 a_n1204_3750.n28 a_n1204_3750.n27 3.61336
R6084 a_n1204_3750.n30 a_n1204_3750.n29 3.61336
R6085 a_n1204_3750.n36 a_n1204_3750.n35 3.45159
R6086 a_n1204_3750.n0 a_n1204_3750.t2 2.58003
R6087 a_n1204_3750.n0 a_n1204_3750.t3 2.58003
R6088 a_n1204_3750.n36 a_n1204_3750.t0 1.43357
R6089 a_n1204_3750.t1 a_n1204_3750.n36 1.43357
R6090 a_n1204_3750.n3 a_n1204_3750.n2 0.3605
R6091 a_n1204_3750.n5 a_n1204_3750.n4 0.3605
R6092 a_n1204_3750.n7 a_n1204_3750.n6 0.3605
R6093 a_n1204_3750.n9 a_n1204_3750.n8 0.3605
R6094 a_n1204_3750.n11 a_n1204_3750.n10 0.3605
R6095 a_n1204_3750.n13 a_n1204_3750.n12 0.3605
R6096 a_n1204_3750.n15 a_n1204_3750.n14 0.3605
R6097 a_n1204_3750.n17 a_n1204_3750.n16 0.3605
R6098 a_n1204_3750.n19 a_n1204_3750.n18 0.3605
R6099 a_n1204_3750.n21 a_n1204_3750.n20 0.3605
R6100 a_n1204_3750.n23 a_n1204_3750.n22 0.3605
R6101 a_n1204_3750.n25 a_n1204_3750.n24 0.3605
R6102 a_n1204_3750.n27 a_n1204_3750.n26 0.3605
R6103 a_n1204_3750.n29 a_n1204_3750.n28 0.3605
R6104 a_n1204_3750.n31 a_n1204_3750.n30 0.3605
R6105 a_n1204_3750.n35 a_n1204_3750.n32 0.169589
R6106 a_n1204_614.n1 a_n1204_614.t27 29.7679
R6107 a_n1204_614.n30 a_n1204_614.t14 29.4079
R6108 a_n1204_614.n28 a_n1204_614.t34 29.4079
R6109 a_n1204_614.n26 a_n1204_614.t26 29.4079
R6110 a_n1204_614.n24 a_n1204_614.t23 29.4079
R6111 a_n1204_614.n22 a_n1204_614.t32 29.4079
R6112 a_n1204_614.n20 a_n1204_614.t31 29.4079
R6113 a_n1204_614.n18 a_n1204_614.t4 29.4079
R6114 a_n1204_614.n16 a_n1204_614.t20 29.4079
R6115 a_n1204_614.n14 a_n1204_614.t19 29.4079
R6116 a_n1204_614.n12 a_n1204_614.t33 29.4079
R6117 a_n1204_614.n10 a_n1204_614.t6 29.4079
R6118 a_n1204_614.n8 a_n1204_614.t22 29.4079
R6119 a_n1204_614.n6 a_n1204_614.t21 29.4079
R6120 a_n1204_614.n4 a_n1204_614.t35 29.4079
R6121 a_n1204_614.n2 a_n1204_614.t10 29.4079
R6122 a_n1204_614.n31 a_n1204_614.t36 29.1445
R6123 a_n1204_614.n29 a_n1204_614.t29 29.1445
R6124 a_n1204_614.n27 a_n1204_614.t17 29.1445
R6125 a_n1204_614.n25 a_n1204_614.t13 29.1445
R6126 a_n1204_614.n23 a_n1204_614.t18 29.1445
R6127 a_n1204_614.n21 a_n1204_614.t39 29.1445
R6128 a_n1204_614.n19 a_n1204_614.t9 29.1445
R6129 a_n1204_614.n17 a_n1204_614.t38 29.1445
R6130 a_n1204_614.n15 a_n1204_614.t7 29.1445
R6131 a_n1204_614.n13 a_n1204_614.t5 29.1445
R6132 a_n1204_614.n11 a_n1204_614.t12 29.1445
R6133 a_n1204_614.n9 a_n1204_614.t8 29.1445
R6134 a_n1204_614.n7 a_n1204_614.t11 29.1445
R6135 a_n1204_614.n5 a_n1204_614.t25 29.1445
R6136 a_n1204_614.n3 a_n1204_614.t16 29.1445
R6137 a_n1204_614.n1 a_n1204_614.t28 29.1445
R6138 a_n1204_614.n33 a_n1204_614.t37 24.7684
R6139 a_n1204_614.n33 a_n1204_614.t30 24.1166
R6140 a_n1204_614.n34 a_n1204_614.t24 23.7255
R6141 a_n1204_614.n34 a_n1204_614.t15 23.0737
R6142 a_n1204_614.n34 a_n1204_614.n33 17.1396
R6143 a_n1204_614.n32 a_n1204_614.n31 10.2862
R6144 a_n1204_614.n35 a_n1204_614.n34 8.0005
R6145 a_n1204_614.n32 a_n1204_614.n0 6.86767
R6146 a_n1204_614.n2 a_n1204_614.n1 3.61336
R6147 a_n1204_614.n4 a_n1204_614.n3 3.61336
R6148 a_n1204_614.n6 a_n1204_614.n5 3.61336
R6149 a_n1204_614.n8 a_n1204_614.n7 3.61336
R6150 a_n1204_614.n10 a_n1204_614.n9 3.61336
R6151 a_n1204_614.n12 a_n1204_614.n11 3.61336
R6152 a_n1204_614.n14 a_n1204_614.n13 3.61336
R6153 a_n1204_614.n16 a_n1204_614.n15 3.61336
R6154 a_n1204_614.n18 a_n1204_614.n17 3.61336
R6155 a_n1204_614.n20 a_n1204_614.n19 3.61336
R6156 a_n1204_614.n22 a_n1204_614.n21 3.61336
R6157 a_n1204_614.n24 a_n1204_614.n23 3.61336
R6158 a_n1204_614.n26 a_n1204_614.n25 3.61336
R6159 a_n1204_614.n28 a_n1204_614.n27 3.61336
R6160 a_n1204_614.n30 a_n1204_614.n29 3.61336
R6161 a_n1204_614.n36 a_n1204_614.n35 3.45159
R6162 a_n1204_614.n0 a_n1204_614.t3 2.58003
R6163 a_n1204_614.n0 a_n1204_614.t2 2.58003
R6164 a_n1204_614.t1 a_n1204_614.n36 1.43357
R6165 a_n1204_614.n36 a_n1204_614.t0 1.43357
R6166 a_n1204_614.n3 a_n1204_614.n2 0.3605
R6167 a_n1204_614.n5 a_n1204_614.n4 0.3605
R6168 a_n1204_614.n7 a_n1204_614.n6 0.3605
R6169 a_n1204_614.n9 a_n1204_614.n8 0.3605
R6170 a_n1204_614.n11 a_n1204_614.n10 0.3605
R6171 a_n1204_614.n13 a_n1204_614.n12 0.3605
R6172 a_n1204_614.n15 a_n1204_614.n14 0.3605
R6173 a_n1204_614.n17 a_n1204_614.n16 0.3605
R6174 a_n1204_614.n19 a_n1204_614.n18 0.3605
R6175 a_n1204_614.n21 a_n1204_614.n20 0.3605
R6176 a_n1204_614.n23 a_n1204_614.n22 0.3605
R6177 a_n1204_614.n25 a_n1204_614.n24 0.3605
R6178 a_n1204_614.n27 a_n1204_614.n26 0.3605
R6179 a_n1204_614.n29 a_n1204_614.n28 0.3605
R6180 a_n1204_614.n31 a_n1204_614.n30 0.3605
R6181 a_n1204_614.n35 a_n1204_614.n32 0.169589
R6182 RB6.t31 RB6.t12 69.3795
R6183 RB6.t18 RB6.t23 69.3795
R6184 RB6.t17 RB6.t38 69.3795
R6185 RB6.t43 RB6.t37 69.3795
R6186 RB6.t44 RB6.t4 69.3795
R6187 RB6.t15 RB6.t21 69.3795
R6188 RB6.t14 RB6.t34 69.3795
R6189 RB6.t28 RB6.t32 69.3795
R6190 RB6.t46 RB6.t9 69.3795
R6191 RB6.t45 RB6.t7 69.3795
R6192 RB6.t16 RB6.t36 69.3795
R6193 RB6.t25 RB6.t0 69.3795
R6194 RB6.t33 RB6.t13 69.3795
R6195 RB6.t47 RB6.t11 69.3795
R6196 RB6.t19 RB6.t26 69.3795
R6197 RB6.t27 RB6.t1 69.3795
R6198 RB6.n29 RB6.t29 30.2434
R6199 RB6.n27 RB6.t8 30.2434
R6200 RB6.n25 RB6.t6 30.2434
R6201 RB6.n23 RB6.t35 30.2434
R6202 RB6.n21 RB6.t39 30.2434
R6203 RB6.n19 RB6.t3 30.2434
R6204 RB6.n17 RB6.t2 30.2434
R6205 RB6.n15 RB6.t24 30.2434
R6206 RB6.n13 RB6.t41 30.2434
R6207 RB6.n11 RB6.t40 30.2434
R6208 RB6.n9 RB6.t5 30.2434
R6209 RB6.n7 RB6.t20 30.2434
R6210 RB6.n5 RB6.t30 30.2434
R6211 RB6.n3 RB6.t42 30.2434
R6212 RB6.n1 RB6.t10 30.2434
R6213 RB6.n0 RB6.t22 30.2434
R6214 RB6.n2 RB6.n0 21.0176
R6215 RB6.n30 RB6.n29 17.0448
R6216 RB6.n28 RB6.n27 17.0448
R6217 RB6.n26 RB6.n25 17.0448
R6218 RB6.n24 RB6.n23 17.0448
R6219 RB6.n22 RB6.n21 17.0448
R6220 RB6.n20 RB6.n19 17.0448
R6221 RB6.n18 RB6.n17 17.0448
R6222 RB6.n16 RB6.n15 17.0448
R6223 RB6.n14 RB6.n13 17.0448
R6224 RB6.n12 RB6.n11 17.0448
R6225 RB6.n10 RB6.n9 17.0448
R6226 RB6.n8 RB6.n7 17.0448
R6227 RB6.n6 RB6.n5 17.0448
R6228 RB6.n4 RB6.n3 17.0448
R6229 RB6.n2 RB6.n1 17.0448
R6230 RB6.n29 RB6.t31 16.6862
R6231 RB6.n27 RB6.t18 16.6862
R6232 RB6.n25 RB6.t17 16.6862
R6233 RB6.n23 RB6.t43 16.6862
R6234 RB6.n21 RB6.t44 16.6862
R6235 RB6.n19 RB6.t15 16.6862
R6236 RB6.n17 RB6.t14 16.6862
R6237 RB6.n15 RB6.t28 16.6862
R6238 RB6.n13 RB6.t46 16.6862
R6239 RB6.n11 RB6.t45 16.6862
R6240 RB6.n9 RB6.t16 16.6862
R6241 RB6.n7 RB6.t25 16.6862
R6242 RB6.n5 RB6.t33 16.6862
R6243 RB6.n3 RB6.t47 16.6862
R6244 RB6.n1 RB6.t19 16.6862
R6245 RB6.n0 RB6.t27 16.6862
R6246 RB6 RB6.n30 5.78461
R6247 RB6.n4 RB6.n2 3.97336
R6248 RB6.n6 RB6.n4 3.97336
R6249 RB6.n8 RB6.n6 3.97336
R6250 RB6.n10 RB6.n8 3.97336
R6251 RB6.n12 RB6.n10 3.97336
R6252 RB6.n14 RB6.n12 3.97336
R6253 RB6.n16 RB6.n14 3.97336
R6254 RB6.n18 RB6.n16 3.97336
R6255 RB6.n20 RB6.n18 3.97336
R6256 RB6.n22 RB6.n20 3.97336
R6257 RB6.n24 RB6.n22 3.97336
R6258 RB6.n26 RB6.n24 3.97336
R6259 RB6.n28 RB6.n26 3.97336
R6260 RB6.n30 RB6.n28 3.97336
R6261 a_6343_n2146.n2 a_6343_n2146.t32 18.9023
R6262 a_6343_n2146.n0 a_6343_n2146.t23 16.1106
R6263 a_6343_n2146.n2 a_6343_n2146.t33 15.6434
R6264 a_6343_n2146.n30 a_6343_n2146.t2 15.4484
R6265 a_6343_n2146.n27 a_6343_n2146.t15 15.4484
R6266 a_6343_n2146.n26 a_6343_n2146.t17 15.4484
R6267 a_6343_n2146.n23 a_6343_n2146.t5 15.4484
R6268 a_6343_n2146.n22 a_6343_n2146.t9 15.4484
R6269 a_6343_n2146.n19 a_6343_n2146.t19 15.4484
R6270 a_6343_n2146.n18 a_6343_n2146.t28 15.4484
R6271 a_6343_n2146.n15 a_6343_n2146.t16 15.4484
R6272 a_6343_n2146.n14 a_6343_n2146.t13 15.4484
R6273 a_6343_n2146.n11 a_6343_n2146.t18 15.4484
R6274 a_6343_n2146.n10 a_6343_n2146.t6 15.4484
R6275 a_6343_n2146.n7 a_6343_n2146.t1 15.4484
R6276 a_6343_n2146.n6 a_6343_n2146.t14 15.4484
R6277 a_6343_n2146.n3 a_6343_n2146.t3 15.4484
R6278 a_6343_n2146.t0 a_6343_n2146.n31 15.4484
R6279 a_6343_n2146.n0 a_6343_n2146.t11 14.854
R6280 a_6343_n2146.n1 a_6343_n2146.t31 14.854
R6281 a_6343_n2146.n29 a_6343_n2146.t20 14.854
R6282 a_6343_n2146.n28 a_6343_n2146.t26 14.854
R6283 a_6343_n2146.n25 a_6343_n2146.t29 14.854
R6284 a_6343_n2146.n24 a_6343_n2146.t4 14.854
R6285 a_6343_n2146.n21 a_6343_n2146.t21 14.854
R6286 a_6343_n2146.n20 a_6343_n2146.t22 14.854
R6287 a_6343_n2146.n17 a_6343_n2146.t10 14.854
R6288 a_6343_n2146.n16 a_6343_n2146.t7 14.854
R6289 a_6343_n2146.n13 a_6343_n2146.t8 14.854
R6290 a_6343_n2146.n12 a_6343_n2146.t27 14.854
R6291 a_6343_n2146.n9 a_6343_n2146.t12 14.854
R6292 a_6343_n2146.n8 a_6343_n2146.t24 14.854
R6293 a_6343_n2146.n5 a_6343_n2146.t30 14.854
R6294 a_6343_n2146.n4 a_6343_n2146.t25 14.854
R6295 a_6343_n2146.n3 a_6343_n2146.n2 14.5641
R6296 a_6343_n2146.n31 a_6343_n2146.n30 0.746214
R6297 a_6343_n2146.n27 a_6343_n2146.n26 0.746214
R6298 a_6343_n2146.n23 a_6343_n2146.n22 0.746214
R6299 a_6343_n2146.n19 a_6343_n2146.n18 0.746214
R6300 a_6343_n2146.n15 a_6343_n2146.n14 0.746214
R6301 a_6343_n2146.n11 a_6343_n2146.n10 0.746214
R6302 a_6343_n2146.n7 a_6343_n2146.n6 0.746214
R6303 a_6343_n2146.n31 a_6343_n2146.n1 0.662643
R6304 a_6343_n2146.n30 a_6343_n2146.n29 0.662643
R6305 a_6343_n2146.n28 a_6343_n2146.n27 0.662643
R6306 a_6343_n2146.n26 a_6343_n2146.n25 0.662643
R6307 a_6343_n2146.n24 a_6343_n2146.n23 0.662643
R6308 a_6343_n2146.n22 a_6343_n2146.n21 0.662643
R6309 a_6343_n2146.n20 a_6343_n2146.n19 0.662643
R6310 a_6343_n2146.n18 a_6343_n2146.n17 0.662643
R6311 a_6343_n2146.n16 a_6343_n2146.n15 0.662643
R6312 a_6343_n2146.n14 a_6343_n2146.n13 0.662643
R6313 a_6343_n2146.n12 a_6343_n2146.n11 0.662643
R6314 a_6343_n2146.n10 a_6343_n2146.n9 0.662643
R6315 a_6343_n2146.n8 a_6343_n2146.n7 0.662643
R6316 a_6343_n2146.n6 a_6343_n2146.n5 0.662643
R6317 a_6343_n2146.n4 a_6343_n2146.n3 0.662643
R6318 a_6343_n2146.n1 a_6343_n2146.n0 0.4505
R6319 a_6343_n2146.n29 a_6343_n2146.n28 0.4505
R6320 a_6343_n2146.n25 a_6343_n2146.n24 0.4505
R6321 a_6343_n2146.n21 a_6343_n2146.n20 0.4505
R6322 a_6343_n2146.n17 a_6343_n2146.n16 0.4505
R6323 a_6343_n2146.n13 a_6343_n2146.n12 0.4505
R6324 a_6343_n2146.n9 a_6343_n2146.n8 0.4505
R6325 a_6343_n2146.n5 a_6343_n2146.n4 0.4505
R6326 a_n884_n954.n1 a_n884_n954.t11 29.9245
R6327 a_n884_n954.n30 a_n884_n954.t34 29.3395
R6328 a_n884_n954.n28 a_n884_n954.t23 29.3395
R6329 a_n884_n954.n26 a_n884_n954.t10 29.3395
R6330 a_n884_n954.n24 a_n884_n954.t9 29.3395
R6331 a_n884_n954.n22 a_n884_n954.t20 29.3395
R6332 a_n884_n954.n20 a_n884_n954.t19 29.3395
R6333 a_n884_n954.n18 a_n884_n954.t26 29.3395
R6334 a_n884_n954.n16 a_n884_n954.t6 29.3395
R6335 a_n884_n954.n14 a_n884_n954.t5 29.3395
R6336 a_n884_n954.n12 a_n884_n954.t22 29.3395
R6337 a_n884_n954.n10 a_n884_n954.t27 29.3395
R6338 a_n884_n954.n8 a_n884_n954.t8 29.3395
R6339 a_n884_n954.n6 a_n884_n954.t7 29.3395
R6340 a_n884_n954.n4 a_n884_n954.t24 29.3395
R6341 a_n884_n954.n2 a_n884_n954.t30 29.3395
R6342 a_n884_n954.n31 a_n884_n954.t18 27.973
R6343 a_n884_n954.n29 a_n884_n954.t4 27.973
R6344 a_n884_n954.n27 a_n884_n954.t21 27.973
R6345 a_n884_n954.n25 a_n884_n954.t33 27.973
R6346 a_n884_n954.n23 a_n884_n954.t32 27.973
R6347 a_n884_n954.n21 a_n884_n954.t13 27.973
R6348 a_n884_n954.n19 a_n884_n954.t12 27.973
R6349 a_n884_n954.n17 a_n884_n954.t29 27.973
R6350 a_n884_n954.n15 a_n884_n954.t28 27.973
R6351 a_n884_n954.n13 a_n884_n954.t15 27.973
R6352 a_n884_n954.n11 a_n884_n954.t14 27.973
R6353 a_n884_n954.n9 a_n884_n954.t25 27.973
R6354 a_n884_n954.n7 a_n884_n954.t31 27.973
R6355 a_n884_n954.n5 a_n884_n954.t35 27.973
R6356 a_n884_n954.n3 a_n884_n954.t17 27.973
R6357 a_n884_n954.n1 a_n884_n954.t16 27.973
R6358 a_n884_n954.n32 a_n884_n954.n31 10.1914
R6359 a_n884_n954.n32 a_n884_n954.n0 7.10204
R6360 a_n884_n954.n2 a_n884_n954.n1 3.38836
R6361 a_n884_n954.n4 a_n884_n954.n3 3.38836
R6362 a_n884_n954.n6 a_n884_n954.n5 3.38836
R6363 a_n884_n954.n8 a_n884_n954.n7 3.38836
R6364 a_n884_n954.n10 a_n884_n954.n9 3.38836
R6365 a_n884_n954.n12 a_n884_n954.n11 3.38836
R6366 a_n884_n954.n14 a_n884_n954.n13 3.38836
R6367 a_n884_n954.n16 a_n884_n954.n15 3.38836
R6368 a_n884_n954.n18 a_n884_n954.n17 3.38836
R6369 a_n884_n954.n20 a_n884_n954.n19 3.38836
R6370 a_n884_n954.n22 a_n884_n954.n21 3.38836
R6371 a_n884_n954.n24 a_n884_n954.n23 3.38836
R6372 a_n884_n954.n26 a_n884_n954.n25 3.38836
R6373 a_n884_n954.n28 a_n884_n954.n27 3.38836
R6374 a_n884_n954.n30 a_n884_n954.n29 3.38836
R6375 a_n884_n954.n0 a_n884_n954.t2 3.00946
R6376 a_n884_n954.n33 a_n884_n954.n32 2.63313
R6377 a_n884_n954.n0 a_n884_n954.t3 2.44528
R6378 a_n884_n954.t1 a_n884_n954.n33 1.67214
R6379 a_n884_n954.n33 a_n884_n954.t0 1.35871
R6380 a_n884_n954.n3 a_n884_n954.n2 0.5855
R6381 a_n884_n954.n5 a_n884_n954.n4 0.5855
R6382 a_n884_n954.n7 a_n884_n954.n6 0.5855
R6383 a_n884_n954.n9 a_n884_n954.n8 0.5855
R6384 a_n884_n954.n11 a_n884_n954.n10 0.5855
R6385 a_n884_n954.n13 a_n884_n954.n12 0.5855
R6386 a_n884_n954.n15 a_n884_n954.n14 0.5855
R6387 a_n884_n954.n17 a_n884_n954.n16 0.5855
R6388 a_n884_n954.n19 a_n884_n954.n18 0.5855
R6389 a_n884_n954.n21 a_n884_n954.n20 0.5855
R6390 a_n884_n954.n23 a_n884_n954.n22 0.5855
R6391 a_n884_n954.n25 a_n884_n954.n24 0.5855
R6392 a_n884_n954.n27 a_n884_n954.n26 0.5855
R6393 a_n884_n954.n29 a_n884_n954.n28 0.5855
R6394 a_n884_n954.n31 a_n884_n954.n30 0.5855
R6395 a_18703_n2146.n2 a_18703_n2146.t32 18.9023
R6396 a_18703_n2146.n0 a_18703_n2146.t24 16.1106
R6397 a_18703_n2146.n2 a_18703_n2146.t33 15.6434
R6398 a_18703_n2146.n30 a_18703_n2146.t2 15.4484
R6399 a_18703_n2146.n27 a_18703_n2146.t12 15.4484
R6400 a_18703_n2146.n26 a_18703_n2146.t15 15.4484
R6401 a_18703_n2146.n23 a_18703_n2146.t4 15.4484
R6402 a_18703_n2146.n22 a_18703_n2146.t7 15.4484
R6403 a_18703_n2146.n19 a_18703_n2146.t17 15.4484
R6404 a_18703_n2146.n18 a_18703_n2146.t29 15.4484
R6405 a_18703_n2146.n15 a_18703_n2146.t13 15.4484
R6406 a_18703_n2146.n14 a_18703_n2146.t9 15.4484
R6407 a_18703_n2146.n11 a_18703_n2146.t16 15.4484
R6408 a_18703_n2146.n10 a_18703_n2146.t5 15.4484
R6409 a_18703_n2146.n7 a_18703_n2146.t1 15.4484
R6410 a_18703_n2146.n6 a_18703_n2146.t10 15.4484
R6411 a_18703_n2146.n3 a_18703_n2146.t3 15.4484
R6412 a_18703_n2146.t0 a_18703_n2146.n31 15.4484
R6413 a_18703_n2146.n0 a_18703_n2146.t6 14.854
R6414 a_18703_n2146.n1 a_18703_n2146.t11 14.854
R6415 a_18703_n2146.n29 a_18703_n2146.t23 14.854
R6416 a_18703_n2146.n28 a_18703_n2146.t25 14.854
R6417 a_18703_n2146.n25 a_18703_n2146.t31 14.854
R6418 a_18703_n2146.n24 a_18703_n2146.t21 14.854
R6419 a_18703_n2146.n21 a_18703_n2146.t20 14.854
R6420 a_18703_n2146.n20 a_18703_n2146.t14 14.854
R6421 a_18703_n2146.n17 a_18703_n2146.t19 14.854
R6422 a_18703_n2146.n16 a_18703_n2146.t8 14.854
R6423 a_18703_n2146.n13 a_18703_n2146.t27 14.854
R6424 a_18703_n2146.n12 a_18703_n2146.t30 14.854
R6425 a_18703_n2146.n9 a_18703_n2146.t22 14.854
R6426 a_18703_n2146.n8 a_18703_n2146.t18 14.854
R6427 a_18703_n2146.n5 a_18703_n2146.t28 14.854
R6428 a_18703_n2146.n4 a_18703_n2146.t26 14.854
R6429 a_18703_n2146.n3 a_18703_n2146.n2 14.5641
R6430 a_18703_n2146.n31 a_18703_n2146.n30 0.746214
R6431 a_18703_n2146.n27 a_18703_n2146.n26 0.746214
R6432 a_18703_n2146.n23 a_18703_n2146.n22 0.746214
R6433 a_18703_n2146.n19 a_18703_n2146.n18 0.746214
R6434 a_18703_n2146.n15 a_18703_n2146.n14 0.746214
R6435 a_18703_n2146.n11 a_18703_n2146.n10 0.746214
R6436 a_18703_n2146.n7 a_18703_n2146.n6 0.746214
R6437 a_18703_n2146.n31 a_18703_n2146.n1 0.662643
R6438 a_18703_n2146.n30 a_18703_n2146.n29 0.662643
R6439 a_18703_n2146.n28 a_18703_n2146.n27 0.662643
R6440 a_18703_n2146.n26 a_18703_n2146.n25 0.662643
R6441 a_18703_n2146.n24 a_18703_n2146.n23 0.662643
R6442 a_18703_n2146.n22 a_18703_n2146.n21 0.662643
R6443 a_18703_n2146.n20 a_18703_n2146.n19 0.662643
R6444 a_18703_n2146.n18 a_18703_n2146.n17 0.662643
R6445 a_18703_n2146.n16 a_18703_n2146.n15 0.662643
R6446 a_18703_n2146.n14 a_18703_n2146.n13 0.662643
R6447 a_18703_n2146.n12 a_18703_n2146.n11 0.662643
R6448 a_18703_n2146.n10 a_18703_n2146.n9 0.662643
R6449 a_18703_n2146.n8 a_18703_n2146.n7 0.662643
R6450 a_18703_n2146.n6 a_18703_n2146.n5 0.662643
R6451 a_18703_n2146.n4 a_18703_n2146.n3 0.662643
R6452 a_18703_n2146.n1 a_18703_n2146.n0 0.4505
R6453 a_18703_n2146.n29 a_18703_n2146.n28 0.4505
R6454 a_18703_n2146.n25 a_18703_n2146.n24 0.4505
R6455 a_18703_n2146.n21 a_18703_n2146.n20 0.4505
R6456 a_18703_n2146.n17 a_18703_n2146.n16 0.4505
R6457 a_18703_n2146.n13 a_18703_n2146.n12 0.4505
R6458 a_18703_n2146.n9 a_18703_n2146.n8 0.4505
R6459 a_18703_n2146.n5 a_18703_n2146.n4 0.4505
R6460 a_33535_n2146.n2 a_33535_n2146.t32 18.9023
R6461 a_33535_n2146.n0 a_33535_n2146.t26 16.1106
R6462 a_33535_n2146.n2 a_33535_n2146.t33 15.6434
R6463 a_33535_n2146.n30 a_33535_n2146.t4 15.4484
R6464 a_33535_n2146.n27 a_33535_n2146.t14 15.4484
R6465 a_33535_n2146.n26 a_33535_n2146.t18 15.4484
R6466 a_33535_n2146.n23 a_33535_n2146.t7 15.4484
R6467 a_33535_n2146.n22 a_33535_n2146.t10 15.4484
R6468 a_33535_n2146.n19 a_33535_n2146.t20 15.4484
R6469 a_33535_n2146.n18 a_33535_n2146.t28 15.4484
R6470 a_33535_n2146.n15 a_33535_n2146.t15 15.4484
R6471 a_33535_n2146.n14 a_33535_n2146.t11 15.4484
R6472 a_33535_n2146.n11 a_33535_n2146.t19 15.4484
R6473 a_33535_n2146.n10 a_33535_n2146.t8 15.4484
R6474 a_33535_n2146.n7 a_33535_n2146.t1 15.4484
R6475 a_33535_n2146.n6 a_33535_n2146.t12 15.4484
R6476 a_33535_n2146.n3 a_33535_n2146.t5 15.4484
R6477 a_33535_n2146.t0 a_33535_n2146.n31 15.4484
R6478 a_33535_n2146.n0 a_33535_n2146.t25 14.854
R6479 a_33535_n2146.n1 a_33535_n2146.t29 14.854
R6480 a_33535_n2146.n29 a_33535_n2146.t22 14.854
R6481 a_33535_n2146.n28 a_33535_n2146.t17 14.854
R6482 a_33535_n2146.n25 a_33535_n2146.t24 14.854
R6483 a_33535_n2146.n24 a_33535_n2146.t3 14.854
R6484 a_33535_n2146.n21 a_33535_n2146.t30 14.854
R6485 a_33535_n2146.n20 a_33535_n2146.t27 14.854
R6486 a_33535_n2146.n17 a_33535_n2146.t13 14.854
R6487 a_33535_n2146.n16 a_33535_n2146.t2 14.854
R6488 a_33535_n2146.n13 a_33535_n2146.t16 14.854
R6489 a_33535_n2146.n12 a_33535_n2146.t23 14.854
R6490 a_33535_n2146.n9 a_33535_n2146.t9 14.854
R6491 a_33535_n2146.n8 a_33535_n2146.t21 14.854
R6492 a_33535_n2146.n5 a_33535_n2146.t31 14.854
R6493 a_33535_n2146.n4 a_33535_n2146.t6 14.854
R6494 a_33535_n2146.n3 a_33535_n2146.n2 14.5641
R6495 a_33535_n2146.n31 a_33535_n2146.n30 0.746214
R6496 a_33535_n2146.n27 a_33535_n2146.n26 0.746214
R6497 a_33535_n2146.n23 a_33535_n2146.n22 0.746214
R6498 a_33535_n2146.n19 a_33535_n2146.n18 0.746214
R6499 a_33535_n2146.n15 a_33535_n2146.n14 0.746214
R6500 a_33535_n2146.n11 a_33535_n2146.n10 0.746214
R6501 a_33535_n2146.n7 a_33535_n2146.n6 0.746214
R6502 a_33535_n2146.n31 a_33535_n2146.n1 0.662643
R6503 a_33535_n2146.n30 a_33535_n2146.n29 0.662643
R6504 a_33535_n2146.n28 a_33535_n2146.n27 0.662643
R6505 a_33535_n2146.n26 a_33535_n2146.n25 0.662643
R6506 a_33535_n2146.n24 a_33535_n2146.n23 0.662643
R6507 a_33535_n2146.n22 a_33535_n2146.n21 0.662643
R6508 a_33535_n2146.n20 a_33535_n2146.n19 0.662643
R6509 a_33535_n2146.n18 a_33535_n2146.n17 0.662643
R6510 a_33535_n2146.n16 a_33535_n2146.n15 0.662643
R6511 a_33535_n2146.n14 a_33535_n2146.n13 0.662643
R6512 a_33535_n2146.n12 a_33535_n2146.n11 0.662643
R6513 a_33535_n2146.n10 a_33535_n2146.n9 0.662643
R6514 a_33535_n2146.n8 a_33535_n2146.n7 0.662643
R6515 a_33535_n2146.n6 a_33535_n2146.n5 0.662643
R6516 a_33535_n2146.n4 a_33535_n2146.n3 0.662643
R6517 a_33535_n2146.n1 a_33535_n2146.n0 0.4505
R6518 a_33535_n2146.n29 a_33535_n2146.n28 0.4505
R6519 a_33535_n2146.n25 a_33535_n2146.n24 0.4505
R6520 a_33535_n2146.n21 a_33535_n2146.n20 0.4505
R6521 a_33535_n2146.n17 a_33535_n2146.n16 0.4505
R6522 a_33535_n2146.n13 a_33535_n2146.n12 0.4505
R6523 a_33535_n2146.n9 a_33535_n2146.n8 0.4505
R6524 a_33535_n2146.n5 a_33535_n2146.n4 0.4505
R6525 a_21888_n708.n1 a_21888_n708.t15 31.0255
R6526 a_21888_n708.n2 a_21888_n708.t20 31.0255
R6527 a_21888_n708.n4 a_21888_n708.t31 31.0255
R6528 a_21888_n708.n6 a_21888_n708.t11 31.0255
R6529 a_21888_n708.n8 a_21888_n708.t18 31.0255
R6530 a_21888_n708.n10 a_21888_n708.t30 31.0255
R6531 a_21888_n708.n12 a_21888_n708.t32 31.0255
R6532 a_21888_n708.n14 a_21888_n708.t12 31.0255
R6533 a_21888_n708.n16 a_21888_n708.t19 31.0255
R6534 a_21888_n708.n18 a_21888_n708.t7 31.0255
R6535 a_21888_n708.n20 a_21888_n708.t17 31.0255
R6536 a_21888_n708.n22 a_21888_n708.t26 31.0255
R6537 a_21888_n708.n24 a_21888_n708.t28 31.0255
R6538 a_21888_n708.n26 a_21888_n708.t35 31.0255
R6539 a_21888_n708.n28 a_21888_n708.t16 31.0255
R6540 a_21888_n708.n30 a_21888_n708.t25 31.0255
R6541 a_21888_n708.n1 a_21888_n708.t8 27.8969
R6542 a_21888_n708.n2 a_21888_n708.t10 27.8969
R6543 a_21888_n708.n4 a_21888_n708.t29 27.8969
R6544 a_21888_n708.n6 a_21888_n708.t27 27.8969
R6545 a_21888_n708.n8 a_21888_n708.t21 27.8969
R6546 a_21888_n708.n10 a_21888_n708.t9 27.8969
R6547 a_21888_n708.n12 a_21888_n708.t6 27.8969
R6548 a_21888_n708.n14 a_21888_n708.t4 27.8969
R6549 a_21888_n708.n16 a_21888_n708.t22 27.8969
R6550 a_21888_n708.n18 a_21888_n708.t23 27.8969
R6551 a_21888_n708.n20 a_21888_n708.t14 27.8969
R6552 a_21888_n708.n22 a_21888_n708.t5 27.8969
R6553 a_21888_n708.n24 a_21888_n708.t33 27.8969
R6554 a_21888_n708.n26 a_21888_n708.t24 27.8969
R6555 a_21888_n708.n28 a_21888_n708.t34 27.8969
R6556 a_21888_n708.n30 a_21888_n708.t13 27.8969
R6557 a_21888_n708.n3 a_21888_n708.n1 13.8288
R6558 a_21888_n708.n3 a_21888_n708.n2 12.5495
R6559 a_21888_n708.n5 a_21888_n708.n4 12.5495
R6560 a_21888_n708.n7 a_21888_n708.n6 12.5495
R6561 a_21888_n708.n9 a_21888_n708.n8 12.5495
R6562 a_21888_n708.n11 a_21888_n708.n10 12.5495
R6563 a_21888_n708.n13 a_21888_n708.n12 12.5495
R6564 a_21888_n708.n15 a_21888_n708.n14 12.5495
R6565 a_21888_n708.n17 a_21888_n708.n16 12.5495
R6566 a_21888_n708.n19 a_21888_n708.n18 12.5495
R6567 a_21888_n708.n21 a_21888_n708.n20 12.5495
R6568 a_21888_n708.n23 a_21888_n708.n22 12.5495
R6569 a_21888_n708.n25 a_21888_n708.n24 12.5495
R6570 a_21888_n708.n27 a_21888_n708.n26 12.5495
R6571 a_21888_n708.n29 a_21888_n708.n28 12.5495
R6572 a_21888_n708.n31 a_21888_n708.n30 12.5495
R6573 a_21888_n708.n32 a_21888_n708.n0 6.45898
R6574 a_21888_n708.n32 a_21888_n708.n31 5.79746
R6575 a_21888_n708.n33 a_21888_n708.n32 2.99572
R6576 a_21888_n708.n0 a_21888_n708.t3 2.64244
R6577 a_21888_n708.n0 a_21888_n708.t2 2.64244
R6578 a_21888_n708.n33 a_21888_n708.t0 1.46824
R6579 a_21888_n708.t1 a_21888_n708.n33 1.46824
R6580 a_21888_n708.n7 a_21888_n708.n5 1.27979
R6581 a_21888_n708.n11 a_21888_n708.n9 1.27979
R6582 a_21888_n708.n15 a_21888_n708.n13 1.27979
R6583 a_21888_n708.n19 a_21888_n708.n17 1.27979
R6584 a_21888_n708.n23 a_21888_n708.n21 1.27979
R6585 a_21888_n708.n27 a_21888_n708.n25 1.27979
R6586 a_21888_n708.n31 a_21888_n708.n29 1.27979
R6587 a_21888_n708.n5 a_21888_n708.n3 1.24121
R6588 a_21888_n708.n9 a_21888_n708.n7 1.24121
R6589 a_21888_n708.n13 a_21888_n708.n11 1.24121
R6590 a_21888_n708.n17 a_21888_n708.n15 1.24121
R6591 a_21888_n708.n21 a_21888_n708.n19 1.24121
R6592 a_21888_n708.n25 a_21888_n708.n23 1.24121
R6593 a_21888_n708.n29 a_21888_n708.n27 1.24121
R6594 a_n1204_8454.n1 a_n1204_8454.t23 29.7679
R6595 a_n1204_8454.n30 a_n1204_8454.t10 29.4079
R6596 a_n1204_8454.n28 a_n1204_8454.t38 29.4079
R6597 a_n1204_8454.n26 a_n1204_8454.t22 29.4079
R6598 a_n1204_8454.n24 a_n1204_8454.t21 29.4079
R6599 a_n1204_8454.n22 a_n1204_8454.t35 29.4079
R6600 a_n1204_8454.n20 a_n1204_8454.t33 29.4079
R6601 a_n1204_8454.n18 a_n1204_8454.t5 29.4079
R6602 a_n1204_8454.n16 a_n1204_8454.t15 29.4079
R6603 a_n1204_8454.n14 a_n1204_8454.t13 29.4079
R6604 a_n1204_8454.n12 a_n1204_8454.t37 29.4079
R6605 a_n1204_8454.n10 a_n1204_8454.t7 29.4079
R6606 a_n1204_8454.n8 a_n1204_8454.t19 29.4079
R6607 a_n1204_8454.n6 a_n1204_8454.t18 29.4079
R6608 a_n1204_8454.n4 a_n1204_8454.t39 29.4079
R6609 a_n1204_8454.n2 a_n1204_8454.t8 29.4079
R6610 a_n1204_8454.n31 a_n1204_8454.t4 29.1445
R6611 a_n1204_8454.n29 a_n1204_8454.t27 29.1445
R6612 a_n1204_8454.n27 a_n1204_8454.t6 29.1445
R6613 a_n1204_8454.n25 a_n1204_8454.t17 29.1445
R6614 a_n1204_8454.n23 a_n1204_8454.t16 29.1445
R6615 a_n1204_8454.n21 a_n1204_8454.t30 29.1445
R6616 a_n1204_8454.n19 a_n1204_8454.t29 29.1445
R6617 a_n1204_8454.n17 a_n1204_8454.t12 29.1445
R6618 a_n1204_8454.n15 a_n1204_8454.t11 29.1445
R6619 a_n1204_8454.n13 a_n1204_8454.t32 29.1445
R6620 a_n1204_8454.n11 a_n1204_8454.t31 29.1445
R6621 a_n1204_8454.n9 a_n1204_8454.t9 29.1445
R6622 a_n1204_8454.n7 a_n1204_8454.t14 29.1445
R6623 a_n1204_8454.n5 a_n1204_8454.t24 29.1445
R6624 a_n1204_8454.n3 a_n1204_8454.t36 29.1445
R6625 a_n1204_8454.n1 a_n1204_8454.t34 29.1445
R6626 a_n1204_8454.n33 a_n1204_8454.t28 24.7684
R6627 a_n1204_8454.n33 a_n1204_8454.t25 24.1166
R6628 a_n1204_8454.n34 a_n1204_8454.t26 23.7255
R6629 a_n1204_8454.n34 a_n1204_8454.t20 23.0737
R6630 a_n1204_8454.n34 a_n1204_8454.n33 17.1396
R6631 a_n1204_8454.n32 a_n1204_8454.n31 10.2862
R6632 a_n1204_8454.n35 a_n1204_8454.n34 8.0005
R6633 a_n1204_8454.n32 a_n1204_8454.n0 6.86767
R6634 a_n1204_8454.n2 a_n1204_8454.n1 3.61336
R6635 a_n1204_8454.n4 a_n1204_8454.n3 3.61336
R6636 a_n1204_8454.n6 a_n1204_8454.n5 3.61336
R6637 a_n1204_8454.n8 a_n1204_8454.n7 3.61336
R6638 a_n1204_8454.n10 a_n1204_8454.n9 3.61336
R6639 a_n1204_8454.n12 a_n1204_8454.n11 3.61336
R6640 a_n1204_8454.n14 a_n1204_8454.n13 3.61336
R6641 a_n1204_8454.n16 a_n1204_8454.n15 3.61336
R6642 a_n1204_8454.n18 a_n1204_8454.n17 3.61336
R6643 a_n1204_8454.n20 a_n1204_8454.n19 3.61336
R6644 a_n1204_8454.n22 a_n1204_8454.n21 3.61336
R6645 a_n1204_8454.n24 a_n1204_8454.n23 3.61336
R6646 a_n1204_8454.n26 a_n1204_8454.n25 3.61336
R6647 a_n1204_8454.n28 a_n1204_8454.n27 3.61336
R6648 a_n1204_8454.n30 a_n1204_8454.n29 3.61336
R6649 a_n1204_8454.n36 a_n1204_8454.n35 3.45159
R6650 a_n1204_8454.n0 a_n1204_8454.t2 2.58003
R6651 a_n1204_8454.n0 a_n1204_8454.t3 2.58003
R6652 a_n1204_8454.n36 a_n1204_8454.t0 1.43357
R6653 a_n1204_8454.t1 a_n1204_8454.n36 1.43357
R6654 a_n1204_8454.n3 a_n1204_8454.n2 0.3605
R6655 a_n1204_8454.n5 a_n1204_8454.n4 0.3605
R6656 a_n1204_8454.n7 a_n1204_8454.n6 0.3605
R6657 a_n1204_8454.n9 a_n1204_8454.n8 0.3605
R6658 a_n1204_8454.n11 a_n1204_8454.n10 0.3605
R6659 a_n1204_8454.n13 a_n1204_8454.n12 0.3605
R6660 a_n1204_8454.n15 a_n1204_8454.n14 0.3605
R6661 a_n1204_8454.n17 a_n1204_8454.n16 0.3605
R6662 a_n1204_8454.n19 a_n1204_8454.n18 0.3605
R6663 a_n1204_8454.n21 a_n1204_8454.n20 0.3605
R6664 a_n1204_8454.n23 a_n1204_8454.n22 0.3605
R6665 a_n1204_8454.n25 a_n1204_8454.n24 0.3605
R6666 a_n1204_8454.n27 a_n1204_8454.n26 0.3605
R6667 a_n1204_8454.n29 a_n1204_8454.n28 0.3605
R6668 a_n1204_8454.n31 a_n1204_8454.n30 0.3605
R6669 a_n1204_8454.n35 a_n1204_8454.n32 0.169589
R6670 a_n1204_5318.n1 a_n1204_5318.t33 29.7679
R6671 a_n1204_5318.n30 a_n1204_5318.t23 29.4079
R6672 a_n1204_5318.n28 a_n1204_5318.t10 29.4079
R6673 a_n1204_5318.n26 a_n1204_5318.t32 29.4079
R6674 a_n1204_5318.n24 a_n1204_5318.t31 29.4079
R6675 a_n1204_5318.n22 a_n1204_5318.t7 29.4079
R6676 a_n1204_5318.n20 a_n1204_5318.t6 29.4079
R6677 a_n1204_5318.n18 a_n1204_5318.t13 29.4079
R6678 a_n1204_5318.n16 a_n1204_5318.t28 29.4079
R6679 a_n1204_5318.n14 a_n1204_5318.t27 29.4079
R6680 a_n1204_5318.n12 a_n1204_5318.t9 29.4079
R6681 a_n1204_5318.n10 a_n1204_5318.t16 29.4079
R6682 a_n1204_5318.n8 a_n1204_5318.t30 29.4079
R6683 a_n1204_5318.n6 a_n1204_5318.t29 29.4079
R6684 a_n1204_5318.n4 a_n1204_5318.t11 29.4079
R6685 a_n1204_5318.n2 a_n1204_5318.t19 29.4079
R6686 a_n1204_5318.n31 a_n1204_5318.t4 29.1445
R6687 a_n1204_5318.n29 a_n1204_5318.t25 29.1445
R6688 a_n1204_5318.n27 a_n1204_5318.t5 29.1445
R6689 a_n1204_5318.n25 a_n1204_5318.t18 29.1445
R6690 a_n1204_5318.n23 a_n1204_5318.t17 29.1445
R6691 a_n1204_5318.n21 a_n1204_5318.t35 29.1445
R6692 a_n1204_5318.n19 a_n1204_5318.t34 29.1445
R6693 a_n1204_5318.n17 a_n1204_5318.t14 29.1445
R6694 a_n1204_5318.n15 a_n1204_5318.t12 29.1445
R6695 a_n1204_5318.n13 a_n1204_5318.t37 29.1445
R6696 a_n1204_5318.n11 a_n1204_5318.t36 29.1445
R6697 a_n1204_5318.n9 a_n1204_5318.t8 29.1445
R6698 a_n1204_5318.n7 a_n1204_5318.t15 29.1445
R6699 a_n1204_5318.n5 a_n1204_5318.t21 29.1445
R6700 a_n1204_5318.n3 a_n1204_5318.t39 29.1445
R6701 a_n1204_5318.n1 a_n1204_5318.t38 29.1445
R6702 a_n1204_5318.n33 a_n1204_5318.t26 24.7684
R6703 a_n1204_5318.n33 a_n1204_5318.t22 24.1166
R6704 a_n1204_5318.n34 a_n1204_5318.t24 23.7255
R6705 a_n1204_5318.n34 a_n1204_5318.t20 23.0737
R6706 a_n1204_5318.n34 a_n1204_5318.n33 17.1396
R6707 a_n1204_5318.n32 a_n1204_5318.n31 10.2862
R6708 a_n1204_5318.n35 a_n1204_5318.n34 8.0005
R6709 a_n1204_5318.n32 a_n1204_5318.n0 6.86767
R6710 a_n1204_5318.n2 a_n1204_5318.n1 3.61336
R6711 a_n1204_5318.n4 a_n1204_5318.n3 3.61336
R6712 a_n1204_5318.n6 a_n1204_5318.n5 3.61336
R6713 a_n1204_5318.n8 a_n1204_5318.n7 3.61336
R6714 a_n1204_5318.n10 a_n1204_5318.n9 3.61336
R6715 a_n1204_5318.n12 a_n1204_5318.n11 3.61336
R6716 a_n1204_5318.n14 a_n1204_5318.n13 3.61336
R6717 a_n1204_5318.n16 a_n1204_5318.n15 3.61336
R6718 a_n1204_5318.n18 a_n1204_5318.n17 3.61336
R6719 a_n1204_5318.n20 a_n1204_5318.n19 3.61336
R6720 a_n1204_5318.n22 a_n1204_5318.n21 3.61336
R6721 a_n1204_5318.n24 a_n1204_5318.n23 3.61336
R6722 a_n1204_5318.n26 a_n1204_5318.n25 3.61336
R6723 a_n1204_5318.n28 a_n1204_5318.n27 3.61336
R6724 a_n1204_5318.n30 a_n1204_5318.n29 3.61336
R6725 a_n1204_5318.n36 a_n1204_5318.n35 3.45159
R6726 a_n1204_5318.n0 a_n1204_5318.t2 2.58003
R6727 a_n1204_5318.n0 a_n1204_5318.t3 2.58003
R6728 a_n1204_5318.n36 a_n1204_5318.t0 1.43357
R6729 a_n1204_5318.t1 a_n1204_5318.n36 1.43357
R6730 a_n1204_5318.n3 a_n1204_5318.n2 0.3605
R6731 a_n1204_5318.n5 a_n1204_5318.n4 0.3605
R6732 a_n1204_5318.n7 a_n1204_5318.n6 0.3605
R6733 a_n1204_5318.n9 a_n1204_5318.n8 0.3605
R6734 a_n1204_5318.n11 a_n1204_5318.n10 0.3605
R6735 a_n1204_5318.n13 a_n1204_5318.n12 0.3605
R6736 a_n1204_5318.n15 a_n1204_5318.n14 0.3605
R6737 a_n1204_5318.n17 a_n1204_5318.n16 0.3605
R6738 a_n1204_5318.n19 a_n1204_5318.n18 0.3605
R6739 a_n1204_5318.n21 a_n1204_5318.n20 0.3605
R6740 a_n1204_5318.n23 a_n1204_5318.n22 0.3605
R6741 a_n1204_5318.n25 a_n1204_5318.n24 0.3605
R6742 a_n1204_5318.n27 a_n1204_5318.n26 0.3605
R6743 a_n1204_5318.n29 a_n1204_5318.n28 0.3605
R6744 a_n1204_5318.n31 a_n1204_5318.n30 0.3605
R6745 a_n1204_5318.n35 a_n1204_5318.n32 0.169589
R6746 a_16944_n708.n1 a_16944_n708.t4 31.0255
R6747 a_16944_n708.n2 a_16944_n708.t18 31.0255
R6748 a_16944_n708.n4 a_16944_n708.t19 31.0255
R6749 a_16944_n708.n6 a_16944_n708.t28 31.0255
R6750 a_16944_n708.n8 a_16944_n708.t5 31.0255
R6751 a_16944_n708.n10 a_16944_n708.t17 31.0255
R6752 a_16944_n708.n12 a_16944_n708.t20 31.0255
R6753 a_16944_n708.n14 a_16944_n708.t29 31.0255
R6754 a_16944_n708.n16 a_16944_n708.t6 31.0255
R6755 a_16944_n708.n18 a_16944_n708.t26 31.0255
R6756 a_16944_n708.n20 a_16944_n708.t35 31.0255
R6757 a_16944_n708.n22 a_16944_n708.t13 31.0255
R6758 a_16944_n708.n24 a_16944_n708.t15 31.0255
R6759 a_16944_n708.n26 a_16944_n708.t32 31.0255
R6760 a_16944_n708.n28 a_16944_n708.t8 31.0255
R6761 a_16944_n708.n30 a_16944_n708.t12 31.0255
R6762 a_16944_n708.n1 a_16944_n708.t33 27.8969
R6763 a_16944_n708.n2 a_16944_n708.t34 27.8969
R6764 a_16944_n708.n4 a_16944_n708.t16 27.8969
R6765 a_16944_n708.n6 a_16944_n708.t14 27.8969
R6766 a_16944_n708.n8 a_16944_n708.t7 27.8969
R6767 a_16944_n708.n10 a_16944_n708.t27 27.8969
R6768 a_16944_n708.n12 a_16944_n708.t25 27.8969
R6769 a_16944_n708.n14 a_16944_n708.t23 27.8969
R6770 a_16944_n708.n16 a_16944_n708.t9 27.8969
R6771 a_16944_n708.n18 a_16944_n708.t10 27.8969
R6772 a_16944_n708.n20 a_16944_n708.t31 27.8969
R6773 a_16944_n708.n22 a_16944_n708.t24 27.8969
R6774 a_16944_n708.n24 a_16944_n708.t21 27.8969
R6775 a_16944_n708.n26 a_16944_n708.t11 27.8969
R6776 a_16944_n708.n28 a_16944_n708.t22 27.8969
R6777 a_16944_n708.n30 a_16944_n708.t30 27.8969
R6778 a_16944_n708.n3 a_16944_n708.n1 13.8288
R6779 a_16944_n708.n3 a_16944_n708.n2 12.5495
R6780 a_16944_n708.n5 a_16944_n708.n4 12.5495
R6781 a_16944_n708.n7 a_16944_n708.n6 12.5495
R6782 a_16944_n708.n9 a_16944_n708.n8 12.5495
R6783 a_16944_n708.n11 a_16944_n708.n10 12.5495
R6784 a_16944_n708.n13 a_16944_n708.n12 12.5495
R6785 a_16944_n708.n15 a_16944_n708.n14 12.5495
R6786 a_16944_n708.n17 a_16944_n708.n16 12.5495
R6787 a_16944_n708.n19 a_16944_n708.n18 12.5495
R6788 a_16944_n708.n21 a_16944_n708.n20 12.5495
R6789 a_16944_n708.n23 a_16944_n708.n22 12.5495
R6790 a_16944_n708.n25 a_16944_n708.n24 12.5495
R6791 a_16944_n708.n27 a_16944_n708.n26 12.5495
R6792 a_16944_n708.n29 a_16944_n708.n28 12.5495
R6793 a_16944_n708.n31 a_16944_n708.n30 12.5495
R6794 a_16944_n708.n32 a_16944_n708.n0 6.45898
R6795 a_16944_n708.n32 a_16944_n708.n31 5.79746
R6796 a_16944_n708.n33 a_16944_n708.n32 2.99572
R6797 a_16944_n708.n0 a_16944_n708.t2 2.64244
R6798 a_16944_n708.n0 a_16944_n708.t3 2.64244
R6799 a_16944_n708.t1 a_16944_n708.n33 1.46824
R6800 a_16944_n708.n33 a_16944_n708.t0 1.46824
R6801 a_16944_n708.n7 a_16944_n708.n5 1.27979
R6802 a_16944_n708.n11 a_16944_n708.n9 1.27979
R6803 a_16944_n708.n15 a_16944_n708.n13 1.27979
R6804 a_16944_n708.n19 a_16944_n708.n17 1.27979
R6805 a_16944_n708.n23 a_16944_n708.n21 1.27979
R6806 a_16944_n708.n27 a_16944_n708.n25 1.27979
R6807 a_16944_n708.n31 a_16944_n708.n29 1.27979
R6808 a_16944_n708.n5 a_16944_n708.n3 1.24121
R6809 a_16944_n708.n9 a_16944_n708.n7 1.24121
R6810 a_16944_n708.n13 a_16944_n708.n11 1.24121
R6811 a_16944_n708.n17 a_16944_n708.n15 1.24121
R6812 a_16944_n708.n21 a_16944_n708.n19 1.24121
R6813 a_16944_n708.n25 a_16944_n708.n23 1.24121
R6814 a_16944_n708.n29 a_16944_n708.n27 1.24121
R6815 a_16231_n2146.n2 a_16231_n2146.t33 18.9023
R6816 a_16231_n2146.n0 a_16231_n2146.t18 16.1106
R6817 a_16231_n2146.n2 a_16231_n2146.t32 15.6434
R6818 a_16231_n2146.n30 a_16231_n2146.t2 15.4484
R6819 a_16231_n2146.n27 a_16231_n2146.t11 15.4484
R6820 a_16231_n2146.n26 a_16231_n2146.t13 15.4484
R6821 a_16231_n2146.n23 a_16231_n2146.t5 15.4484
R6822 a_16231_n2146.n22 a_16231_n2146.t8 15.4484
R6823 a_16231_n2146.n19 a_16231_n2146.t15 15.4484
R6824 a_16231_n2146.n18 a_16231_n2146.t26 15.4484
R6825 a_16231_n2146.n15 a_16231_n2146.t12 15.4484
R6826 a_16231_n2146.n14 a_16231_n2146.t9 15.4484
R6827 a_16231_n2146.n11 a_16231_n2146.t14 15.4484
R6828 a_16231_n2146.n10 a_16231_n2146.t6 15.4484
R6829 a_16231_n2146.n7 a_16231_n2146.t1 15.4484
R6830 a_16231_n2146.n6 a_16231_n2146.t10 15.4484
R6831 a_16231_n2146.n3 a_16231_n2146.t3 15.4484
R6832 a_16231_n2146.t0 a_16231_n2146.n31 15.4484
R6833 a_16231_n2146.n0 a_16231_n2146.t29 14.854
R6834 a_16231_n2146.n1 a_16231_n2146.t4 14.854
R6835 a_16231_n2146.n29 a_16231_n2146.t28 14.854
R6836 a_16231_n2146.n28 a_16231_n2146.t22 14.854
R6837 a_16231_n2146.n25 a_16231_n2146.t19 14.854
R6838 a_16231_n2146.n24 a_16231_n2146.t24 14.854
R6839 a_16231_n2146.n21 a_16231_n2146.t20 14.854
R6840 a_16231_n2146.n20 a_16231_n2146.t21 14.854
R6841 a_16231_n2146.n17 a_16231_n2146.t17 14.854
R6842 a_16231_n2146.n16 a_16231_n2146.t30 14.854
R6843 a_16231_n2146.n13 a_16231_n2146.t16 14.854
R6844 a_16231_n2146.n12 a_16231_n2146.t25 14.854
R6845 a_16231_n2146.n9 a_16231_n2146.t27 14.854
R6846 a_16231_n2146.n8 a_16231_n2146.t31 14.854
R6847 a_16231_n2146.n5 a_16231_n2146.t7 14.854
R6848 a_16231_n2146.n4 a_16231_n2146.t23 14.854
R6849 a_16231_n2146.n3 a_16231_n2146.n2 14.5641
R6850 a_16231_n2146.n31 a_16231_n2146.n30 0.746214
R6851 a_16231_n2146.n27 a_16231_n2146.n26 0.746214
R6852 a_16231_n2146.n23 a_16231_n2146.n22 0.746214
R6853 a_16231_n2146.n19 a_16231_n2146.n18 0.746214
R6854 a_16231_n2146.n15 a_16231_n2146.n14 0.746214
R6855 a_16231_n2146.n11 a_16231_n2146.n10 0.746214
R6856 a_16231_n2146.n7 a_16231_n2146.n6 0.746214
R6857 a_16231_n2146.n31 a_16231_n2146.n1 0.662643
R6858 a_16231_n2146.n30 a_16231_n2146.n29 0.662643
R6859 a_16231_n2146.n28 a_16231_n2146.n27 0.662643
R6860 a_16231_n2146.n26 a_16231_n2146.n25 0.662643
R6861 a_16231_n2146.n24 a_16231_n2146.n23 0.662643
R6862 a_16231_n2146.n22 a_16231_n2146.n21 0.662643
R6863 a_16231_n2146.n20 a_16231_n2146.n19 0.662643
R6864 a_16231_n2146.n18 a_16231_n2146.n17 0.662643
R6865 a_16231_n2146.n16 a_16231_n2146.n15 0.662643
R6866 a_16231_n2146.n14 a_16231_n2146.n13 0.662643
R6867 a_16231_n2146.n12 a_16231_n2146.n11 0.662643
R6868 a_16231_n2146.n10 a_16231_n2146.n9 0.662643
R6869 a_16231_n2146.n8 a_16231_n2146.n7 0.662643
R6870 a_16231_n2146.n6 a_16231_n2146.n5 0.662643
R6871 a_16231_n2146.n4 a_16231_n2146.n3 0.662643
R6872 a_16231_n2146.n1 a_16231_n2146.n0 0.4505
R6873 a_16231_n2146.n29 a_16231_n2146.n28 0.4505
R6874 a_16231_n2146.n25 a_16231_n2146.n24 0.4505
R6875 a_16231_n2146.n21 a_16231_n2146.n20 0.4505
R6876 a_16231_n2146.n17 a_16231_n2146.n16 0.4505
R6877 a_16231_n2146.n13 a_16231_n2146.n12 0.4505
R6878 a_16231_n2146.n9 a_16231_n2146.n8 0.4505
R6879 a_16231_n2146.n5 a_16231_n2146.n4 0.4505
R6880 a_n884_614.n1 a_n884_614.t16 29.9245
R6881 a_n884_614.n30 a_n884_614.t5 29.3395
R6882 a_n884_614.n28 a_n884_614.t26 29.3395
R6883 a_n884_614.n26 a_n884_614.t9 29.3395
R6884 a_n884_614.n24 a_n884_614.t21 29.3395
R6885 a_n884_614.n22 a_n884_614.t6 29.3395
R6886 a_n884_614.n20 a_n884_614.t19 29.3395
R6887 a_n884_614.n18 a_n884_614.t8 29.3395
R6888 a_n884_614.n16 a_n884_614.t4 29.3395
R6889 a_n884_614.n14 a_n884_614.t11 29.3395
R6890 a_n884_614.n12 a_n884_614.t24 29.3395
R6891 a_n884_614.n10 a_n884_614.t17 29.3395
R6892 a_n884_614.n8 a_n884_614.t7 29.3395
R6893 a_n884_614.n6 a_n884_614.t20 29.3395
R6894 a_n884_614.n4 a_n884_614.t18 29.3395
R6895 a_n884_614.n2 a_n884_614.t23 29.3395
R6896 a_n884_614.n31 a_n884_614.t33 27.973
R6897 a_n884_614.n29 a_n884_614.t25 27.973
R6898 a_n884_614.n27 a_n884_614.t34 27.973
R6899 a_n884_614.n25 a_n884_614.t15 27.973
R6900 a_n884_614.n23 a_n884_614.t14 27.973
R6901 a_n884_614.n21 a_n884_614.t28 27.973
R6902 a_n884_614.n19 a_n884_614.t27 27.973
R6903 a_n884_614.n17 a_n884_614.t12 27.973
R6904 a_n884_614.n15 a_n884_614.t10 27.973
R6905 a_n884_614.n13 a_n884_614.t30 27.973
R6906 a_n884_614.n11 a_n884_614.t29 27.973
R6907 a_n884_614.n9 a_n884_614.t35 27.973
R6908 a_n884_614.n7 a_n884_614.t13 27.973
R6909 a_n884_614.n5 a_n884_614.t22 27.973
R6910 a_n884_614.n3 a_n884_614.t32 27.973
R6911 a_n884_614.n1 a_n884_614.t31 27.973
R6912 a_n884_614.n32 a_n884_614.n31 10.1914
R6913 a_n884_614.n32 a_n884_614.n0 7.10204
R6914 a_n884_614.n2 a_n884_614.n1 3.38836
R6915 a_n884_614.n4 a_n884_614.n3 3.38836
R6916 a_n884_614.n6 a_n884_614.n5 3.38836
R6917 a_n884_614.n8 a_n884_614.n7 3.38836
R6918 a_n884_614.n10 a_n884_614.n9 3.38836
R6919 a_n884_614.n12 a_n884_614.n11 3.38836
R6920 a_n884_614.n14 a_n884_614.n13 3.38836
R6921 a_n884_614.n16 a_n884_614.n15 3.38836
R6922 a_n884_614.n18 a_n884_614.n17 3.38836
R6923 a_n884_614.n20 a_n884_614.n19 3.38836
R6924 a_n884_614.n22 a_n884_614.n21 3.38836
R6925 a_n884_614.n24 a_n884_614.n23 3.38836
R6926 a_n884_614.n26 a_n884_614.n25 3.38836
R6927 a_n884_614.n28 a_n884_614.n27 3.38836
R6928 a_n884_614.n30 a_n884_614.n29 3.38836
R6929 a_n884_614.n0 a_n884_614.t3 3.00946
R6930 a_n884_614.n33 a_n884_614.n32 2.63313
R6931 a_n884_614.n0 a_n884_614.t2 2.44528
R6932 a_n884_614.t1 a_n884_614.n33 1.67214
R6933 a_n884_614.n33 a_n884_614.t0 1.35871
R6934 a_n884_614.n3 a_n884_614.n2 0.5855
R6935 a_n884_614.n5 a_n884_614.n4 0.5855
R6936 a_n884_614.n7 a_n884_614.n6 0.5855
R6937 a_n884_614.n9 a_n884_614.n8 0.5855
R6938 a_n884_614.n11 a_n884_614.n10 0.5855
R6939 a_n884_614.n13 a_n884_614.n12 0.5855
R6940 a_n884_614.n15 a_n884_614.n14 0.5855
R6941 a_n884_614.n17 a_n884_614.n16 0.5855
R6942 a_n884_614.n19 a_n884_614.n18 0.5855
R6943 a_n884_614.n21 a_n884_614.n20 0.5855
R6944 a_n884_614.n23 a_n884_614.n22 0.5855
R6945 a_n884_614.n25 a_n884_614.n24 0.5855
R6946 a_n884_614.n27 a_n884_614.n26 0.5855
R6947 a_n884_614.n29 a_n884_614.n28 0.5855
R6948 a_n884_614.n31 a_n884_614.n30 0.5855
R6949 a_n884_10022.n1 a_n884_10022.t20 29.9245
R6950 a_n884_10022.n30 a_n884_10022.t4 29.3395
R6951 a_n884_10022.n28 a_n884_10022.t21 29.3395
R6952 a_n884_10022.n26 a_n884_10022.t28 29.3395
R6953 a_n884_10022.n24 a_n884_10022.t14 29.3395
R6954 a_n884_10022.n22 a_n884_10022.t32 29.3395
R6955 a_n884_10022.n20 a_n884_10022.t18 29.3395
R6956 a_n884_10022.n18 a_n884_10022.t29 29.3395
R6957 a_n884_10022.n16 a_n884_10022.t10 29.3395
R6958 a_n884_10022.n14 a_n884_10022.t34 29.3395
R6959 a_n884_10022.n12 a_n884_10022.t24 29.3395
R6960 a_n884_10022.n10 a_n884_10022.t33 29.3395
R6961 a_n884_10022.n8 a_n884_10022.t15 29.3395
R6962 a_n884_10022.n6 a_n884_10022.t6 29.3395
R6963 a_n884_10022.n4 a_n884_10022.t25 29.3395
R6964 a_n884_10022.n2 a_n884_10022.t5 29.3395
R6965 a_n884_10022.n31 a_n884_10022.t23 27.973
R6966 a_n884_10022.n29 a_n884_10022.t9 27.973
R6967 a_n884_10022.n27 a_n884_10022.t11 27.973
R6968 a_n884_10022.n25 a_n884_10022.t30 27.973
R6969 a_n884_10022.n23 a_n884_10022.t16 27.973
R6970 a_n884_10022.n21 a_n884_10022.t31 27.973
R6971 a_n884_10022.n19 a_n884_10022.t17 27.973
R6972 a_n884_10022.n17 a_n884_10022.t26 27.973
R6973 a_n884_10022.n15 a_n884_10022.t12 27.973
R6974 a_n884_10022.n13 a_n884_10022.t35 27.973
R6975 a_n884_10022.n11 a_n884_10022.t22 27.973
R6976 a_n884_10022.n9 a_n884_10022.t7 27.973
R6977 a_n884_10022.n7 a_n884_10022.t19 27.973
R6978 a_n884_10022.n5 a_n884_10022.t8 27.973
R6979 a_n884_10022.n3 a_n884_10022.t27 27.973
R6980 a_n884_10022.n1 a_n884_10022.t13 27.973
R6981 a_n884_10022.n32 a_n884_10022.n31 10.1914
R6982 a_n884_10022.n32 a_n884_10022.n0 7.10204
R6983 a_n884_10022.n2 a_n884_10022.n1 3.38836
R6984 a_n884_10022.n4 a_n884_10022.n3 3.38836
R6985 a_n884_10022.n6 a_n884_10022.n5 3.38836
R6986 a_n884_10022.n8 a_n884_10022.n7 3.38836
R6987 a_n884_10022.n10 a_n884_10022.n9 3.38836
R6988 a_n884_10022.n12 a_n884_10022.n11 3.38836
R6989 a_n884_10022.n14 a_n884_10022.n13 3.38836
R6990 a_n884_10022.n16 a_n884_10022.n15 3.38836
R6991 a_n884_10022.n18 a_n884_10022.n17 3.38836
R6992 a_n884_10022.n20 a_n884_10022.n19 3.38836
R6993 a_n884_10022.n22 a_n884_10022.n21 3.38836
R6994 a_n884_10022.n24 a_n884_10022.n23 3.38836
R6995 a_n884_10022.n26 a_n884_10022.n25 3.38836
R6996 a_n884_10022.n28 a_n884_10022.n27 3.38836
R6997 a_n884_10022.n30 a_n884_10022.n29 3.38836
R6998 a_n884_10022.n0 a_n884_10022.t2 3.00946
R6999 a_n884_10022.n33 a_n884_10022.n32 2.63313
R7000 a_n884_10022.n0 a_n884_10022.t3 2.44528
R7001 a_n884_10022.t1 a_n884_10022.n33 1.67214
R7002 a_n884_10022.n33 a_n884_10022.t0 1.35871
R7003 a_n884_10022.n3 a_n884_10022.n2 0.5855
R7004 a_n884_10022.n5 a_n884_10022.n4 0.5855
R7005 a_n884_10022.n7 a_n884_10022.n6 0.5855
R7006 a_n884_10022.n9 a_n884_10022.n8 0.5855
R7007 a_n884_10022.n11 a_n884_10022.n10 0.5855
R7008 a_n884_10022.n13 a_n884_10022.n12 0.5855
R7009 a_n884_10022.n15 a_n884_10022.n14 0.5855
R7010 a_n884_10022.n17 a_n884_10022.n16 0.5855
R7011 a_n884_10022.n19 a_n884_10022.n18 0.5855
R7012 a_n884_10022.n21 a_n884_10022.n20 0.5855
R7013 a_n884_10022.n23 a_n884_10022.n22 0.5855
R7014 a_n884_10022.n25 a_n884_10022.n24 0.5855
R7015 a_n884_10022.n27 a_n884_10022.n26 0.5855
R7016 a_n884_10022.n29 a_n884_10022.n28 0.5855
R7017 a_n884_10022.n31 a_n884_10022.n30 0.5855
R7018 WEM.n0 WEM.t6 29.5045
R7019 WEM.n30 WEM.t10 29.4079
R7020 WEM.n28 WEM.t31 29.4079
R7021 WEM.n26 WEM.t12 29.4079
R7022 WEM.n24 WEM.t27 29.4079
R7023 WEM.n22 WEM.t5 29.4079
R7024 WEM.n20 WEM.t28 29.4079
R7025 WEM.n18 WEM.t9 29.4079
R7026 WEM.n16 WEM.t19 29.4079
R7027 WEM.n14 WEM.t8 29.4079
R7028 WEM.n12 WEM.t32 29.4079
R7029 WEM.n10 WEM.t13 29.4079
R7030 WEM.n8 WEM.t25 29.4079
R7031 WEM.n6 WEM.t22 29.4079
R7032 WEM.n4 WEM.t1 29.4079
R7033 WEM.n2 WEM.t11 29.4079
R7034 WEM.n0 WEM.t30 29.4079
R7035 WEM.n29 WEM.t33 29.1445
R7036 WEM.n27 WEM.t2 29.1445
R7037 WEM.n25 WEM.t23 29.1445
R7038 WEM.n23 WEM.t7 29.1445
R7039 WEM.n21 WEM.t24 29.1445
R7040 WEM.n19 WEM.t34 29.1445
R7041 WEM.n17 WEM.t20 29.1445
R7042 WEM.n15 WEM.t3 29.1445
R7043 WEM.n13 WEM.t29 29.1445
R7044 WEM.n11 WEM.t14 29.1445
R7045 WEM.n9 WEM.t26 29.1445
R7046 WEM.n7 WEM.t0 29.1445
R7047 WEM.n5 WEM.t35 29.1445
R7048 WEM.n3 WEM.t21 29.1445
R7049 WEM.n1 WEM.t4 29.1445
R7050 WEM.n31 WEM.t18 28.8094
R7051 WEM.n32 WEM.t16 27.7666
R7052 WEM.n31 WEM.t17 21.6398
R7053 WEM.n32 WEM.t15 20.5969
R7054 WEM.n33 WEM.n32 17.17
R7055 WEM.n32 WEM.n31 17.1396
R7056 WEM.n1 WEM.n0 3.61336
R7057 WEM.n3 WEM.n2 3.61336
R7058 WEM.n5 WEM.n4 3.61336
R7059 WEM.n7 WEM.n6 3.61336
R7060 WEM.n9 WEM.n8 3.61336
R7061 WEM.n11 WEM.n10 3.61336
R7062 WEM.n13 WEM.n12 3.61336
R7063 WEM.n15 WEM.n14 3.61336
R7064 WEM.n17 WEM.n16 3.61336
R7065 WEM.n19 WEM.n18 3.61336
R7066 WEM.n21 WEM.n20 3.61336
R7067 WEM.n23 WEM.n22 3.61336
R7068 WEM.n25 WEM.n24 3.61336
R7069 WEM.n27 WEM.n26 3.61336
R7070 WEM.n29 WEM.n28 3.61336
R7071 WEM.n33 WEM.n30 2.28264
R7072 WEM.n2 WEM.n1 0.3605
R7073 WEM.n4 WEM.n3 0.3605
R7074 WEM.n6 WEM.n5 0.3605
R7075 WEM.n8 WEM.n7 0.3605
R7076 WEM.n10 WEM.n9 0.3605
R7077 WEM.n12 WEM.n11 0.3605
R7078 WEM.n14 WEM.n13 0.3605
R7079 WEM.n16 WEM.n15 0.3605
R7080 WEM.n18 WEM.n17 0.3605
R7081 WEM.n20 WEM.n19 0.3605
R7082 WEM.n22 WEM.n21 0.3605
R7083 WEM.n24 WEM.n23 0.3605
R7084 WEM.n26 WEM.n25 0.3605
R7085 WEM.n28 WEM.n27 0.3605
R7086 WEM.n30 WEM.n29 0.3605
R7087 WEM WEM.n33 0.278536
R7088 a_14472_n708.n1 a_14472_n708.t19 31.0255
R7089 a_14472_n708.n2 a_14472_n708.t29 31.0255
R7090 a_14472_n708.n4 a_14472_n708.t20 31.0255
R7091 a_14472_n708.n6 a_14472_n708.t30 31.0255
R7092 a_14472_n708.n8 a_14472_n708.t4 31.0255
R7093 a_14472_n708.n10 a_14472_n708.t18 31.0255
R7094 a_14472_n708.n12 a_14472_n708.t21 31.0255
R7095 a_14472_n708.n14 a_14472_n708.t31 31.0255
R7096 a_14472_n708.n16 a_14472_n708.t5 31.0255
R7097 a_14472_n708.n18 a_14472_n708.t27 31.0255
R7098 a_14472_n708.n20 a_14472_n708.t35 31.0255
R7099 a_14472_n708.n22 a_14472_n708.t13 31.0255
R7100 a_14472_n708.n24 a_14472_n708.t16 31.0255
R7101 a_14472_n708.n26 a_14472_n708.t32 31.0255
R7102 a_14472_n708.n28 a_14472_n708.t6 31.0255
R7103 a_14472_n708.n30 a_14472_n708.t11 31.0255
R7104 a_14472_n708.n1 a_14472_n708.t12 27.8969
R7105 a_14472_n708.n2 a_14472_n708.t14 27.8969
R7106 a_14472_n708.n4 a_14472_n708.t17 27.8969
R7107 a_14472_n708.n6 a_14472_n708.t15 27.8969
R7108 a_14472_n708.n8 a_14472_n708.t7 27.8969
R7109 a_14472_n708.n10 a_14472_n708.t28 27.8969
R7110 a_14472_n708.n12 a_14472_n708.t26 27.8969
R7111 a_14472_n708.n14 a_14472_n708.t24 27.8969
R7112 a_14472_n708.n16 a_14472_n708.t8 27.8969
R7113 a_14472_n708.n18 a_14472_n708.t9 27.8969
R7114 a_14472_n708.n20 a_14472_n708.t34 27.8969
R7115 a_14472_n708.n22 a_14472_n708.t25 27.8969
R7116 a_14472_n708.n24 a_14472_n708.t22 27.8969
R7117 a_14472_n708.n26 a_14472_n708.t10 27.8969
R7118 a_14472_n708.n28 a_14472_n708.t23 27.8969
R7119 a_14472_n708.n30 a_14472_n708.t33 27.8969
R7120 a_14472_n708.n3 a_14472_n708.n1 13.8288
R7121 a_14472_n708.n3 a_14472_n708.n2 12.5495
R7122 a_14472_n708.n5 a_14472_n708.n4 12.5495
R7123 a_14472_n708.n7 a_14472_n708.n6 12.5495
R7124 a_14472_n708.n9 a_14472_n708.n8 12.5495
R7125 a_14472_n708.n11 a_14472_n708.n10 12.5495
R7126 a_14472_n708.n13 a_14472_n708.n12 12.5495
R7127 a_14472_n708.n15 a_14472_n708.n14 12.5495
R7128 a_14472_n708.n17 a_14472_n708.n16 12.5495
R7129 a_14472_n708.n19 a_14472_n708.n18 12.5495
R7130 a_14472_n708.n21 a_14472_n708.n20 12.5495
R7131 a_14472_n708.n23 a_14472_n708.n22 12.5495
R7132 a_14472_n708.n25 a_14472_n708.n24 12.5495
R7133 a_14472_n708.n27 a_14472_n708.n26 12.5495
R7134 a_14472_n708.n29 a_14472_n708.n28 12.5495
R7135 a_14472_n708.n31 a_14472_n708.n30 12.5495
R7136 a_14472_n708.n32 a_14472_n708.n0 6.45898
R7137 a_14472_n708.n32 a_14472_n708.n31 5.79746
R7138 a_14472_n708.n33 a_14472_n708.n32 2.99572
R7139 a_14472_n708.n0 a_14472_n708.t3 2.64244
R7140 a_14472_n708.n0 a_14472_n708.t2 2.64244
R7141 a_14472_n708.t1 a_14472_n708.n33 1.46824
R7142 a_14472_n708.n33 a_14472_n708.t0 1.46824
R7143 a_14472_n708.n7 a_14472_n708.n5 1.27979
R7144 a_14472_n708.n11 a_14472_n708.n9 1.27979
R7145 a_14472_n708.n15 a_14472_n708.n13 1.27979
R7146 a_14472_n708.n19 a_14472_n708.n17 1.27979
R7147 a_14472_n708.n23 a_14472_n708.n21 1.27979
R7148 a_14472_n708.n27 a_14472_n708.n25 1.27979
R7149 a_14472_n708.n31 a_14472_n708.n29 1.27979
R7150 a_14472_n708.n5 a_14472_n708.n3 1.24121
R7151 a_14472_n708.n9 a_14472_n708.n7 1.24121
R7152 a_14472_n708.n13 a_14472_n708.n11 1.24121
R7153 a_14472_n708.n17 a_14472_n708.n15 1.24121
R7154 a_14472_n708.n21 a_14472_n708.n19 1.24121
R7155 a_14472_n708.n25 a_14472_n708.n23 1.24121
R7156 a_14472_n708.n29 a_14472_n708.n27 1.24121
R7157 RA7.t20 RA7.t44 70.3934
R7158 RA7.t47 RA7.t6 70.3934
R7159 RA7.t46 RA7.t35 70.3934
R7160 RA7.t14 RA7.t33 70.3934
R7161 RA7.t15 RA7.t42 70.3934
R7162 RA7.t27 RA7.t2 70.3934
R7163 RA7.t43 RA7.t19 70.3934
R7164 RA7.t10 RA7.t31 70.3934
R7165 RA7.t16 RA7.t40 70.3934
R7166 RA7.t29 RA7.t5 70.3934
R7167 RA7.t28 RA7.t4 70.3934
R7168 RA7.t12 RA7.t21 70.3934
R7169 RA7.t18 RA7.t41 70.3934
R7170 RA7.t32 RA7.t9 70.3934
R7171 RA7.t30 RA7.t7 70.3934
R7172 RA7.t45 RA7.t34 70.3934
R7173 RA7.n29 RA7.t20 31.2862
R7174 RA7.n27 RA7.t47 31.2862
R7175 RA7.n25 RA7.t46 31.2862
R7176 RA7.n23 RA7.t14 31.2862
R7177 RA7.n21 RA7.t15 31.2862
R7178 RA7.n19 RA7.t27 31.2862
R7179 RA7.n17 RA7.t43 31.2862
R7180 RA7.n15 RA7.t10 31.2862
R7181 RA7.n13 RA7.t16 31.2862
R7182 RA7.n11 RA7.t29 31.2862
R7183 RA7.n9 RA7.t28 31.2862
R7184 RA7.n7 RA7.t12 31.2862
R7185 RA7.n5 RA7.t18 31.2862
R7186 RA7.n3 RA7.t32 31.2862
R7187 RA7.n1 RA7.t30 31.2862
R7188 RA7.n0 RA7.t45 31.2862
R7189 RA7.n2 RA7.n0 21.0181
R7190 RA7.n30 RA7.n29 17.0453
R7191 RA7.n28 RA7.n27 17.0453
R7192 RA7.n26 RA7.n25 17.0453
R7193 RA7.n24 RA7.n23 17.0453
R7194 RA7.n22 RA7.n21 17.0453
R7195 RA7.n20 RA7.n19 17.0453
R7196 RA7.n18 RA7.n17 17.0453
R7197 RA7.n16 RA7.n15 17.0453
R7198 RA7.n14 RA7.n13 17.0453
R7199 RA7.n12 RA7.n11 17.0453
R7200 RA7.n10 RA7.n9 17.0453
R7201 RA7.n8 RA7.n7 17.0453
R7202 RA7.n6 RA7.n5 17.0453
R7203 RA7.n4 RA7.n3 17.0453
R7204 RA7.n2 RA7.n1 17.0453
R7205 RA7.n29 RA7.t17 15.6434
R7206 RA7.n27 RA7.t39 15.6434
R7207 RA7.n25 RA7.t38 15.6434
R7208 RA7.n23 RA7.t3 15.6434
R7209 RA7.n21 RA7.t8 15.6434
R7210 RA7.n19 RA7.t22 15.6434
R7211 RA7.n17 RA7.t36 15.6434
R7212 RA7.n15 RA7.t0 15.6434
R7213 RA7.n13 RA7.t11 15.6434
R7214 RA7.n11 RA7.t24 15.6434
R7215 RA7.n9 RA7.t23 15.6434
R7216 RA7.n7 RA7.t1 15.6434
R7217 RA7.n5 RA7.t13 15.6434
R7218 RA7.n3 RA7.t26 15.6434
R7219 RA7.n1 RA7.t25 15.6434
R7220 RA7.n0 RA7.t37 15.6434
R7221 RA7 RA7.n30 4.50371
R7222 RA7.n4 RA7.n2 3.97336
R7223 RA7.n6 RA7.n4 3.97336
R7224 RA7.n8 RA7.n6 3.97336
R7225 RA7.n10 RA7.n8 3.97336
R7226 RA7.n12 RA7.n10 3.97336
R7227 RA7.n14 RA7.n12 3.97336
R7228 RA7.n16 RA7.n14 3.97336
R7229 RA7.n18 RA7.n16 3.97336
R7230 RA7.n20 RA7.n18 3.97336
R7231 RA7.n22 RA7.n20 3.97336
R7232 RA7.n24 RA7.n22 3.97336
R7233 RA7.n26 RA7.n24 3.97336
R7234 RA7.n28 RA7.n26 3.97336
R7235 RA7.n30 RA7.n28 3.97336
R7236 RB1.t45 RB1.t8 69.3795
R7237 RB1.t9 RB1.t21 69.3795
R7238 RB1.t33 RB1.t42 69.3795
R7239 RB1.t1 RB1.t27 69.3795
R7240 RB1.t24 RB1.t44 69.3795
R7241 RB1.t2 RB1.t17 69.3795
R7242 RB1.t30 RB1.t37 69.3795
R7243 RB1.t11 RB1.t23 69.3795
R7244 RB1.t29 RB1.t5 69.3795
R7245 RB1.t15 RB1.t32 69.3795
R7246 RB1.t34 RB1.t47 69.3795
R7247 RB1.t6 RB1.t14 69.3795
R7248 RB1.t3 RB1.t12 69.3795
R7249 RB1.t22 RB1.t38 69.3795
R7250 RB1.t43 RB1.t18 69.3795
R7251 RB1.t13 RB1.t20 69.3795
R7252 RB1.n29 RB1.t36 30.2434
R7253 RB1.n27 RB1.t0 30.2434
R7254 RB1.n25 RB1.t28 30.2434
R7255 RB1.n23 RB1.t39 30.2434
R7256 RB1.n21 RB1.t19 30.2434
R7257 RB1.n19 RB1.t40 30.2434
R7258 RB1.n17 RB1.t26 30.2434
R7259 RB1.n15 RB1.t4 30.2434
R7260 RB1.n13 RB1.t25 30.2434
R7261 RB1.n11 RB1.t10 30.2434
R7262 RB1.n9 RB1.t31 30.2434
R7263 RB1.n7 RB1.t46 30.2434
R7264 RB1.n5 RB1.t41 30.2434
R7265 RB1.n3 RB1.t16 30.2434
R7266 RB1.n1 RB1.t35 30.2434
R7267 RB1.n0 RB1.t7 30.2434
R7268 RB1.n2 RB1.n0 21.0176
R7269 RB1.n30 RB1.n29 17.0448
R7270 RB1.n28 RB1.n27 17.0448
R7271 RB1.n26 RB1.n25 17.0448
R7272 RB1.n24 RB1.n23 17.0448
R7273 RB1.n22 RB1.n21 17.0448
R7274 RB1.n20 RB1.n19 17.0448
R7275 RB1.n18 RB1.n17 17.0448
R7276 RB1.n16 RB1.n15 17.0448
R7277 RB1.n14 RB1.n13 17.0448
R7278 RB1.n12 RB1.n11 17.0448
R7279 RB1.n10 RB1.n9 17.0448
R7280 RB1.n8 RB1.n7 17.0448
R7281 RB1.n6 RB1.n5 17.0448
R7282 RB1.n4 RB1.n3 17.0448
R7283 RB1.n2 RB1.n1 17.0448
R7284 RB1.n29 RB1.t45 16.6862
R7285 RB1.n27 RB1.t9 16.6862
R7286 RB1.n25 RB1.t33 16.6862
R7287 RB1.n23 RB1.t1 16.6862
R7288 RB1.n21 RB1.t24 16.6862
R7289 RB1.n19 RB1.t2 16.6862
R7290 RB1.n17 RB1.t30 16.6862
R7291 RB1.n15 RB1.t11 16.6862
R7292 RB1.n13 RB1.t29 16.6862
R7293 RB1.n11 RB1.t15 16.6862
R7294 RB1.n9 RB1.t34 16.6862
R7295 RB1.n7 RB1.t6 16.6862
R7296 RB1.n5 RB1.t3 16.6862
R7297 RB1.n3 RB1.t22 16.6862
R7298 RB1.n1 RB1.t43 16.6862
R7299 RB1.n0 RB1.t13 16.6862
R7300 RB1 RB1.n30 5.78461
R7301 RB1.n4 RB1.n2 3.97336
R7302 RB1.n6 RB1.n4 3.97336
R7303 RB1.n8 RB1.n6 3.97336
R7304 RB1.n10 RB1.n8 3.97336
R7305 RB1.n12 RB1.n10 3.97336
R7306 RB1.n14 RB1.n12 3.97336
R7307 RB1.n16 RB1.n14 3.97336
R7308 RB1.n18 RB1.n16 3.97336
R7309 RB1.n20 RB1.n18 3.97336
R7310 RB1.n22 RB1.n20 3.97336
R7311 RB1.n24 RB1.n22 3.97336
R7312 RB1.n26 RB1.n24 3.97336
R7313 RB1.n28 RB1.n26 3.97336
R7314 RB1.n30 RB1.n28 3.97336
R7315 a_9528_n708.n1 a_9528_n708.t22 31.0255
R7316 a_9528_n708.n2 a_9528_n708.t34 31.0255
R7317 a_9528_n708.n4 a_9528_n708.t27 31.0255
R7318 a_9528_n708.n6 a_9528_n708.t6 31.0255
R7319 a_9528_n708.n8 a_9528_n708.t12 31.0255
R7320 a_9528_n708.n10 a_9528_n708.t26 31.0255
R7321 a_9528_n708.n12 a_9528_n708.t28 31.0255
R7322 a_9528_n708.n14 a_9528_n708.t7 31.0255
R7323 a_9528_n708.n16 a_9528_n708.t13 31.0255
R7324 a_9528_n708.n18 a_9528_n708.t35 31.0255
R7325 a_9528_n708.n20 a_9528_n708.t10 31.0255
R7326 a_9528_n708.n22 a_9528_n708.t21 31.0255
R7327 a_9528_n708.n24 a_9528_n708.t24 31.0255
R7328 a_9528_n708.n26 a_9528_n708.t4 31.0255
R7329 a_9528_n708.n28 a_9528_n708.t11 31.0255
R7330 a_9528_n708.n30 a_9528_n708.t20 31.0255
R7331 a_9528_n708.n1 a_9528_n708.t14 27.8969
R7332 a_9528_n708.n2 a_9528_n708.t15 27.8969
R7333 a_9528_n708.n4 a_9528_n708.t25 27.8969
R7334 a_9528_n708.n6 a_9528_n708.t23 27.8969
R7335 a_9528_n708.n8 a_9528_n708.t16 27.8969
R7336 a_9528_n708.n10 a_9528_n708.t5 27.8969
R7337 a_9528_n708.n12 a_9528_n708.t33 27.8969
R7338 a_9528_n708.n14 a_9528_n708.t31 27.8969
R7339 a_9528_n708.n16 a_9528_n708.t17 27.8969
R7340 a_9528_n708.n18 a_9528_n708.t18 27.8969
R7341 a_9528_n708.n20 a_9528_n708.t9 27.8969
R7342 a_9528_n708.n22 a_9528_n708.t32 27.8969
R7343 a_9528_n708.n24 a_9528_n708.t29 27.8969
R7344 a_9528_n708.n26 a_9528_n708.t19 27.8969
R7345 a_9528_n708.n28 a_9528_n708.t30 27.8969
R7346 a_9528_n708.n30 a_9528_n708.t8 27.8969
R7347 a_9528_n708.n3 a_9528_n708.n1 13.8288
R7348 a_9528_n708.n3 a_9528_n708.n2 12.5495
R7349 a_9528_n708.n5 a_9528_n708.n4 12.5495
R7350 a_9528_n708.n7 a_9528_n708.n6 12.5495
R7351 a_9528_n708.n9 a_9528_n708.n8 12.5495
R7352 a_9528_n708.n11 a_9528_n708.n10 12.5495
R7353 a_9528_n708.n13 a_9528_n708.n12 12.5495
R7354 a_9528_n708.n15 a_9528_n708.n14 12.5495
R7355 a_9528_n708.n17 a_9528_n708.n16 12.5495
R7356 a_9528_n708.n19 a_9528_n708.n18 12.5495
R7357 a_9528_n708.n21 a_9528_n708.n20 12.5495
R7358 a_9528_n708.n23 a_9528_n708.n22 12.5495
R7359 a_9528_n708.n25 a_9528_n708.n24 12.5495
R7360 a_9528_n708.n27 a_9528_n708.n26 12.5495
R7361 a_9528_n708.n29 a_9528_n708.n28 12.5495
R7362 a_9528_n708.n31 a_9528_n708.n30 12.5495
R7363 a_9528_n708.n32 a_9528_n708.n0 6.45898
R7364 a_9528_n708.n32 a_9528_n708.n31 5.79746
R7365 a_9528_n708.n33 a_9528_n708.n32 2.99572
R7366 a_9528_n708.n0 a_9528_n708.t3 2.64244
R7367 a_9528_n708.n0 a_9528_n708.t2 2.64244
R7368 a_9528_n708.n33 a_9528_n708.t0 1.46824
R7369 a_9528_n708.t1 a_9528_n708.n33 1.46824
R7370 a_9528_n708.n7 a_9528_n708.n5 1.27979
R7371 a_9528_n708.n11 a_9528_n708.n9 1.27979
R7372 a_9528_n708.n15 a_9528_n708.n13 1.27979
R7373 a_9528_n708.n19 a_9528_n708.n17 1.27979
R7374 a_9528_n708.n23 a_9528_n708.n21 1.27979
R7375 a_9528_n708.n27 a_9528_n708.n25 1.27979
R7376 a_9528_n708.n31 a_9528_n708.n29 1.27979
R7377 a_9528_n708.n5 a_9528_n708.n3 1.24121
R7378 a_9528_n708.n9 a_9528_n708.n7 1.24121
R7379 a_9528_n708.n13 a_9528_n708.n11 1.24121
R7380 a_9528_n708.n17 a_9528_n708.n15 1.24121
R7381 a_9528_n708.n21 a_9528_n708.n19 1.24121
R7382 a_9528_n708.n25 a_9528_n708.n23 1.24121
R7383 a_9528_n708.n29 a_9528_n708.n27 1.24121
R7384 a_1129_n862.n2 a_1129_n862.t32 18.9023
R7385 a_1129_n862.n0 a_1129_n862.t17 16.1132
R7386 a_1129_n862.n2 a_1129_n862.t33 15.6434
R7387 a_1129_n862.n30 a_1129_n862.t20 15.4511
R7388 a_1129_n862.n27 a_1129_n862.t22 15.4511
R7389 a_1129_n862.n26 a_1129_n862.t12 15.4511
R7390 a_1129_n862.n23 a_1129_n862.t7 15.4511
R7391 a_1129_n862.n22 a_1129_n862.t6 15.4511
R7392 a_1129_n862.n19 a_1129_n862.t16 15.4511
R7393 a_1129_n862.n18 a_1129_n862.t4 15.4511
R7394 a_1129_n862.n15 a_1129_n862.t14 15.4511
R7395 a_1129_n862.n14 a_1129_n862.t2 15.4511
R7396 a_1129_n862.n11 a_1129_n862.t9 15.4511
R7397 a_1129_n862.n10 a_1129_n862.t3 15.4511
R7398 a_1129_n862.n7 a_1129_n862.t5 15.4511
R7399 a_1129_n862.n6 a_1129_n862.t15 15.4511
R7400 a_1129_n862.n3 a_1129_n862.t11 15.4511
R7401 a_1129_n862.t0 a_1129_n862.n31 15.4511
R7402 a_1129_n862.n0 a_1129_n862.t24 14.8566
R7403 a_1129_n862.n1 a_1129_n862.t1 14.8566
R7404 a_1129_n862.n29 a_1129_n862.t26 14.8566
R7405 a_1129_n862.n28 a_1129_n862.t25 14.8566
R7406 a_1129_n862.n25 a_1129_n862.t13 14.8566
R7407 a_1129_n862.n24 a_1129_n862.t31 14.8566
R7408 a_1129_n862.n21 a_1129_n862.t21 14.8566
R7409 a_1129_n862.n20 a_1129_n862.t29 14.8566
R7410 a_1129_n862.n17 a_1129_n862.t8 14.8566
R7411 a_1129_n862.n16 a_1129_n862.t10 14.8566
R7412 a_1129_n862.n13 a_1129_n862.t18 14.8566
R7413 a_1129_n862.n12 a_1129_n862.t28 14.8566
R7414 a_1129_n862.n9 a_1129_n862.t19 14.8566
R7415 a_1129_n862.n8 a_1129_n862.t27 14.8566
R7416 a_1129_n862.n5 a_1129_n862.t23 14.8566
R7417 a_1129_n862.n4 a_1129_n862.t30 14.8566
R7418 a_1129_n862.n3 a_1129_n862.n2 14.5641
R7419 a_1129_n862.n31 a_1129_n862.n30 0.746214
R7420 a_1129_n862.n27 a_1129_n862.n26 0.746214
R7421 a_1129_n862.n23 a_1129_n862.n22 0.746214
R7422 a_1129_n862.n19 a_1129_n862.n18 0.746214
R7423 a_1129_n862.n15 a_1129_n862.n14 0.746214
R7424 a_1129_n862.n11 a_1129_n862.n10 0.746214
R7425 a_1129_n862.n7 a_1129_n862.n6 0.746214
R7426 a_1129_n862.n31 a_1129_n862.n1 0.662643
R7427 a_1129_n862.n30 a_1129_n862.n29 0.662643
R7428 a_1129_n862.n28 a_1129_n862.n27 0.662643
R7429 a_1129_n862.n26 a_1129_n862.n25 0.662643
R7430 a_1129_n862.n24 a_1129_n862.n23 0.662643
R7431 a_1129_n862.n22 a_1129_n862.n21 0.662643
R7432 a_1129_n862.n20 a_1129_n862.n19 0.662643
R7433 a_1129_n862.n18 a_1129_n862.n17 0.662643
R7434 a_1129_n862.n16 a_1129_n862.n15 0.662643
R7435 a_1129_n862.n14 a_1129_n862.n13 0.662643
R7436 a_1129_n862.n12 a_1129_n862.n11 0.662643
R7437 a_1129_n862.n10 a_1129_n862.n9 0.662643
R7438 a_1129_n862.n8 a_1129_n862.n7 0.662643
R7439 a_1129_n862.n6 a_1129_n862.n5 0.662643
R7440 a_1129_n862.n4 a_1129_n862.n3 0.662643
R7441 a_1129_n862.n1 a_1129_n862.n0 0.4505
R7442 a_1129_n862.n29 a_1129_n862.n28 0.4505
R7443 a_1129_n862.n25 a_1129_n862.n24 0.4505
R7444 a_1129_n862.n21 a_1129_n862.n20 0.4505
R7445 a_1129_n862.n17 a_1129_n862.n16 0.4505
R7446 a_1129_n862.n13 a_1129_n862.n12 0.4505
R7447 a_1129_n862.n9 a_1129_n862.n8 0.4505
R7448 a_1129_n862.n5 a_1129_n862.n4 0.4505
R7449 a_31776_n708.n1 a_31776_n708.t16 31.0255
R7450 a_31776_n708.n2 a_31776_n708.t26 31.0255
R7451 a_31776_n708.n4 a_31776_n708.t32 31.0255
R7452 a_31776_n708.n6 a_31776_n708.t10 31.0255
R7453 a_31776_n708.n8 a_31776_n708.t19 31.0255
R7454 a_31776_n708.n10 a_31776_n708.t31 31.0255
R7455 a_31776_n708.n12 a_31776_n708.t33 31.0255
R7456 a_31776_n708.n14 a_31776_n708.t11 31.0255
R7457 a_31776_n708.n16 a_31776_n708.t20 31.0255
R7458 a_31776_n708.n18 a_31776_n708.t7 31.0255
R7459 a_31776_n708.n20 a_31776_n708.t17 31.0255
R7460 a_31776_n708.n22 a_31776_n708.t27 31.0255
R7461 a_31776_n708.n24 a_31776_n708.t29 31.0255
R7462 a_31776_n708.n26 a_31776_n708.t8 31.0255
R7463 a_31776_n708.n28 a_31776_n708.t18 31.0255
R7464 a_31776_n708.n30 a_31776_n708.t25 31.0255
R7465 a_31776_n708.n1 a_31776_n708.t13 27.8969
R7466 a_31776_n708.n2 a_31776_n708.t15 27.8969
R7467 a_31776_n708.n4 a_31776_n708.t30 27.8969
R7468 a_31776_n708.n6 a_31776_n708.t28 27.8969
R7469 a_31776_n708.n8 a_31776_n708.t21 27.8969
R7470 a_31776_n708.n10 a_31776_n708.t9 27.8969
R7471 a_31776_n708.n12 a_31776_n708.t6 27.8969
R7472 a_31776_n708.n14 a_31776_n708.t4 27.8969
R7473 a_31776_n708.n16 a_31776_n708.t22 27.8969
R7474 a_31776_n708.n18 a_31776_n708.t23 27.8969
R7475 a_31776_n708.n20 a_31776_n708.t14 27.8969
R7476 a_31776_n708.n22 a_31776_n708.t5 27.8969
R7477 a_31776_n708.n24 a_31776_n708.t34 27.8969
R7478 a_31776_n708.n26 a_31776_n708.t24 27.8969
R7479 a_31776_n708.n28 a_31776_n708.t35 27.8969
R7480 a_31776_n708.n30 a_31776_n708.t12 27.8969
R7481 a_31776_n708.n3 a_31776_n708.n1 13.8288
R7482 a_31776_n708.n3 a_31776_n708.n2 12.5495
R7483 a_31776_n708.n5 a_31776_n708.n4 12.5495
R7484 a_31776_n708.n7 a_31776_n708.n6 12.5495
R7485 a_31776_n708.n9 a_31776_n708.n8 12.5495
R7486 a_31776_n708.n11 a_31776_n708.n10 12.5495
R7487 a_31776_n708.n13 a_31776_n708.n12 12.5495
R7488 a_31776_n708.n15 a_31776_n708.n14 12.5495
R7489 a_31776_n708.n17 a_31776_n708.n16 12.5495
R7490 a_31776_n708.n19 a_31776_n708.n18 12.5495
R7491 a_31776_n708.n21 a_31776_n708.n20 12.5495
R7492 a_31776_n708.n23 a_31776_n708.n22 12.5495
R7493 a_31776_n708.n25 a_31776_n708.n24 12.5495
R7494 a_31776_n708.n27 a_31776_n708.n26 12.5495
R7495 a_31776_n708.n29 a_31776_n708.n28 12.5495
R7496 a_31776_n708.n31 a_31776_n708.n30 12.5495
R7497 a_31776_n708.n32 a_31776_n708.n0 6.45898
R7498 a_31776_n708.n32 a_31776_n708.n31 5.79746
R7499 a_31776_n708.n33 a_31776_n708.n32 2.99572
R7500 a_31776_n708.n0 a_31776_n708.t3 2.64244
R7501 a_31776_n708.n0 a_31776_n708.t2 2.64244
R7502 a_31776_n708.t1 a_31776_n708.n33 1.46824
R7503 a_31776_n708.n33 a_31776_n708.t0 1.46824
R7504 a_31776_n708.n7 a_31776_n708.n5 1.27979
R7505 a_31776_n708.n11 a_31776_n708.n9 1.27979
R7506 a_31776_n708.n15 a_31776_n708.n13 1.27979
R7507 a_31776_n708.n19 a_31776_n708.n17 1.27979
R7508 a_31776_n708.n23 a_31776_n708.n21 1.27979
R7509 a_31776_n708.n27 a_31776_n708.n25 1.27979
R7510 a_31776_n708.n31 a_31776_n708.n29 1.27979
R7511 a_31776_n708.n5 a_31776_n708.n3 1.24121
R7512 a_31776_n708.n9 a_31776_n708.n7 1.24121
R7513 a_31776_n708.n13 a_31776_n708.n11 1.24121
R7514 a_31776_n708.n17 a_31776_n708.n15 1.24121
R7515 a_31776_n708.n21 a_31776_n708.n19 1.24121
R7516 a_31776_n708.n25 a_31776_n708.n23 1.24121
R7517 a_31776_n708.n29 a_31776_n708.n27 1.24121
R7518 RB13.t24 RB13.t42 69.3795
R7519 RB13.t7 RB13.t34 69.3795
R7520 RB13.t11 RB13.t32 69.3795
R7521 RB13.t6 RB13.t35 69.3795
R7522 RB13.t45 RB13.t17 69.3795
R7523 RB13.t43 RB13.t22 69.3795
R7524 RB13.t47 RB13.t16 69.3795
R7525 RB13.t44 RB13.t27 69.3795
R7526 RB13.t1 RB13.t23 69.3795
R7527 RB13.t9 RB13.t31 69.3795
R7528 RB13.t4 RB13.t21 69.3795
R7529 RB13.t46 RB13.t15 69.3795
R7530 RB13.t10 RB13.t29 69.3795
R7531 RB13.t14 RB13.t33 69.3795
R7532 RB13.t8 RB13.t30 69.3795
R7533 RB13.t3 RB13.t19 69.3795
R7534 RB13.n29 RB13.t12 30.2434
R7535 RB13.n27 RB13.t40 30.2434
R7536 RB13.n25 RB13.t39 30.2434
R7537 RB13.n23 RB13.t18 30.2434
R7538 RB13.n21 RB13.t20 30.2434
R7539 RB13.n19 RB13.t37 30.2434
R7540 RB13.n17 RB13.t36 30.2434
R7541 RB13.n15 RB13.t5 30.2434
R7542 RB13.n13 RB13.t26 30.2434
R7543 RB13.n11 RB13.t25 30.2434
R7544 RB13.n9 RB13.t38 30.2434
R7545 RB13.n7 RB13.t0 30.2434
R7546 RB13.n5 RB13.t13 30.2434
R7547 RB13.n3 RB13.t28 30.2434
R7548 RB13.n1 RB13.t41 30.2434
R7549 RB13.n0 RB13.t2 30.2434
R7550 RB13.n2 RB13.n0 21.0176
R7551 RB13.n30 RB13.n29 17.0448
R7552 RB13.n28 RB13.n27 17.0448
R7553 RB13.n26 RB13.n25 17.0448
R7554 RB13.n24 RB13.n23 17.0448
R7555 RB13.n22 RB13.n21 17.0448
R7556 RB13.n20 RB13.n19 17.0448
R7557 RB13.n18 RB13.n17 17.0448
R7558 RB13.n16 RB13.n15 17.0448
R7559 RB13.n14 RB13.n13 17.0448
R7560 RB13.n12 RB13.n11 17.0448
R7561 RB13.n10 RB13.n9 17.0448
R7562 RB13.n8 RB13.n7 17.0448
R7563 RB13.n6 RB13.n5 17.0448
R7564 RB13.n4 RB13.n3 17.0448
R7565 RB13.n2 RB13.n1 17.0448
R7566 RB13.n29 RB13.t24 16.6862
R7567 RB13.n27 RB13.t7 16.6862
R7568 RB13.n25 RB13.t11 16.6862
R7569 RB13.n23 RB13.t6 16.6862
R7570 RB13.n21 RB13.t45 16.6862
R7571 RB13.n19 RB13.t43 16.6862
R7572 RB13.n17 RB13.t47 16.6862
R7573 RB13.n15 RB13.t44 16.6862
R7574 RB13.n13 RB13.t1 16.6862
R7575 RB13.n11 RB13.t9 16.6862
R7576 RB13.n9 RB13.t4 16.6862
R7577 RB13.n7 RB13.t46 16.6862
R7578 RB13.n5 RB13.t10 16.6862
R7579 RB13.n3 RB13.t14 16.6862
R7580 RB13.n1 RB13.t8 16.6862
R7581 RB13.n0 RB13.t3 16.6862
R7582 RB13 RB13.n30 5.78621
R7583 RB13.n4 RB13.n2 3.97336
R7584 RB13.n6 RB13.n4 3.97336
R7585 RB13.n8 RB13.n6 3.97336
R7586 RB13.n10 RB13.n8 3.97336
R7587 RB13.n12 RB13.n10 3.97336
R7588 RB13.n14 RB13.n12 3.97336
R7589 RB13.n16 RB13.n14 3.97336
R7590 RB13.n18 RB13.n16 3.97336
R7591 RB13.n20 RB13.n18 3.97336
R7592 RB13.n22 RB13.n20 3.97336
R7593 RB13.n24 RB13.n22 3.97336
R7594 RB13.n26 RB13.n24 3.97336
R7595 RB13.n28 RB13.n26 3.97336
R7596 RB13.n30 RB13.n28 3.97336
R7597 a_n884_6102.n1 a_n884_6102.t15 29.9245
R7598 a_n884_6102.n30 a_n884_6102.t5 29.3395
R7599 a_n884_6102.n28 a_n884_6102.t26 29.3395
R7600 a_n884_6102.n26 a_n884_6102.t14 29.3395
R7601 a_n884_6102.n24 a_n884_6102.t12 29.3395
R7602 a_n884_6102.n22 a_n884_6102.t21 29.3395
R7603 a_n884_6102.n20 a_n884_6102.t20 29.3395
R7604 a_n884_6102.n18 a_n884_6102.t31 29.3395
R7605 a_n884_6102.n16 a_n884_6102.t7 29.3395
R7606 a_n884_6102.n14 a_n884_6102.t6 29.3395
R7607 a_n884_6102.n12 a_n884_6102.t24 29.3395
R7608 a_n884_6102.n10 a_n884_6102.t33 29.3395
R7609 a_n884_6102.n8 a_n884_6102.t11 29.3395
R7610 a_n884_6102.n6 a_n884_6102.t9 29.3395
R7611 a_n884_6102.n4 a_n884_6102.t28 29.3395
R7612 a_n884_6102.n2 a_n884_6102.t34 29.3395
R7613 a_n884_6102.n31 a_n884_6102.t32 27.973
R7614 a_n884_6102.n29 a_n884_6102.t19 27.973
R7615 a_n884_6102.n27 a_n884_6102.t35 27.973
R7616 a_n884_6102.n25 a_n884_6102.t17 27.973
R7617 a_n884_6102.n23 a_n884_6102.t16 27.973
R7618 a_n884_6102.n21 a_n884_6102.t23 27.973
R7619 a_n884_6102.n19 a_n884_6102.t22 27.973
R7620 a_n884_6102.n17 a_n884_6102.t10 27.973
R7621 a_n884_6102.n15 a_n884_6102.t8 27.973
R7622 a_n884_6102.n13 a_n884_6102.t27 27.973
R7623 a_n884_6102.n11 a_n884_6102.t25 27.973
R7624 a_n884_6102.n9 a_n884_6102.t4 27.973
R7625 a_n884_6102.n7 a_n884_6102.t13 27.973
R7626 a_n884_6102.n5 a_n884_6102.t18 27.973
R7627 a_n884_6102.n3 a_n884_6102.t30 27.973
R7628 a_n884_6102.n1 a_n884_6102.t29 27.973
R7629 a_n884_6102.n32 a_n884_6102.n31 10.1914
R7630 a_n884_6102.n32 a_n884_6102.n0 7.10204
R7631 a_n884_6102.n2 a_n884_6102.n1 3.38836
R7632 a_n884_6102.n4 a_n884_6102.n3 3.38836
R7633 a_n884_6102.n6 a_n884_6102.n5 3.38836
R7634 a_n884_6102.n8 a_n884_6102.n7 3.38836
R7635 a_n884_6102.n10 a_n884_6102.n9 3.38836
R7636 a_n884_6102.n12 a_n884_6102.n11 3.38836
R7637 a_n884_6102.n14 a_n884_6102.n13 3.38836
R7638 a_n884_6102.n16 a_n884_6102.n15 3.38836
R7639 a_n884_6102.n18 a_n884_6102.n17 3.38836
R7640 a_n884_6102.n20 a_n884_6102.n19 3.38836
R7641 a_n884_6102.n22 a_n884_6102.n21 3.38836
R7642 a_n884_6102.n24 a_n884_6102.n23 3.38836
R7643 a_n884_6102.n26 a_n884_6102.n25 3.38836
R7644 a_n884_6102.n28 a_n884_6102.n27 3.38836
R7645 a_n884_6102.n30 a_n884_6102.n29 3.38836
R7646 a_n884_6102.n0 a_n884_6102.t2 3.00946
R7647 a_n884_6102.n33 a_n884_6102.n32 2.63313
R7648 a_n884_6102.n0 a_n884_6102.t3 2.44528
R7649 a_n884_6102.t0 a_n884_6102.n33 1.67214
R7650 a_n884_6102.n33 a_n884_6102.t1 1.35871
R7651 a_n884_6102.n3 a_n884_6102.n2 0.5855
R7652 a_n884_6102.n5 a_n884_6102.n4 0.5855
R7653 a_n884_6102.n7 a_n884_6102.n6 0.5855
R7654 a_n884_6102.n9 a_n884_6102.n8 0.5855
R7655 a_n884_6102.n11 a_n884_6102.n10 0.5855
R7656 a_n884_6102.n13 a_n884_6102.n12 0.5855
R7657 a_n884_6102.n15 a_n884_6102.n14 0.5855
R7658 a_n884_6102.n17 a_n884_6102.n16 0.5855
R7659 a_n884_6102.n19 a_n884_6102.n18 0.5855
R7660 a_n884_6102.n21 a_n884_6102.n20 0.5855
R7661 a_n884_6102.n23 a_n884_6102.n22 0.5855
R7662 a_n884_6102.n25 a_n884_6102.n24 0.5855
R7663 a_n884_6102.n27 a_n884_6102.n26 0.5855
R7664 a_n884_6102.n29 a_n884_6102.n28 0.5855
R7665 a_n884_6102.n31 a_n884_6102.n30 0.5855
R7666 WE10.n0 WE10.t1 38.1951
R7667 WE10 WE10.n0 17.4479
R7668 WE10.n0 WE10.t0 17.0773
R7669 QB8b.n0 QB8b.t1 13.1454
R7670 QB8b.n0 QB8b.t0 9.29658
R7671 QB8b QB8b.n0 4.69014
R7672 a_30793_n862.n2 a_30793_n862.t32 18.9023
R7673 a_30793_n862.n0 a_30793_n862.t16 16.1132
R7674 a_30793_n862.n2 a_30793_n862.t33 15.6434
R7675 a_30793_n862.n30 a_30793_n862.t22 15.4511
R7676 a_30793_n862.n27 a_30793_n862.t25 15.4511
R7677 a_30793_n862.n26 a_30793_n862.t11 15.4511
R7678 a_30793_n862.n23 a_30793_n862.t8 15.4511
R7679 a_30793_n862.n22 a_30793_n862.t15 15.4511
R7680 a_30793_n862.n19 a_30793_n862.t14 15.4511
R7681 a_30793_n862.n18 a_30793_n862.t4 15.4511
R7682 a_30793_n862.n15 a_30793_n862.t12 15.4511
R7683 a_30793_n862.n14 a_30793_n862.t2 15.4511
R7684 a_30793_n862.n11 a_30793_n862.t9 15.4511
R7685 a_30793_n862.n10 a_30793_n862.t3 15.4511
R7686 a_30793_n862.n7 a_30793_n862.t7 15.4511
R7687 a_30793_n862.n6 a_30793_n862.t13 15.4511
R7688 a_30793_n862.n3 a_30793_n862.t10 15.4511
R7689 a_30793_n862.t0 a_30793_n862.n31 15.4511
R7690 a_30793_n862.n0 a_30793_n862.t6 14.8566
R7691 a_30793_n862.n1 a_30793_n862.t31 14.8566
R7692 a_30793_n862.n29 a_30793_n862.t5 14.8566
R7693 a_30793_n862.n28 a_30793_n862.t30 14.8566
R7694 a_30793_n862.n25 a_30793_n862.t21 14.8566
R7695 a_30793_n862.n24 a_30793_n862.t19 14.8566
R7696 a_30793_n862.n21 a_30793_n862.t23 14.8566
R7697 a_30793_n862.n20 a_30793_n862.t18 14.8566
R7698 a_30793_n862.n17 a_30793_n862.t20 14.8566
R7699 a_30793_n862.n16 a_30793_n862.t29 14.8566
R7700 a_30793_n862.n13 a_30793_n862.t17 14.8566
R7701 a_30793_n862.n12 a_30793_n862.t24 14.8566
R7702 a_30793_n862.n9 a_30793_n862.t1 14.8566
R7703 a_30793_n862.n8 a_30793_n862.t28 14.8566
R7704 a_30793_n862.n5 a_30793_n862.t27 14.8566
R7705 a_30793_n862.n4 a_30793_n862.t26 14.8566
R7706 a_30793_n862.n3 a_30793_n862.n2 14.5641
R7707 a_30793_n862.n31 a_30793_n862.n30 0.746214
R7708 a_30793_n862.n27 a_30793_n862.n26 0.746214
R7709 a_30793_n862.n23 a_30793_n862.n22 0.746214
R7710 a_30793_n862.n19 a_30793_n862.n18 0.746214
R7711 a_30793_n862.n15 a_30793_n862.n14 0.746214
R7712 a_30793_n862.n11 a_30793_n862.n10 0.746214
R7713 a_30793_n862.n7 a_30793_n862.n6 0.746214
R7714 a_30793_n862.n31 a_30793_n862.n1 0.662643
R7715 a_30793_n862.n30 a_30793_n862.n29 0.662643
R7716 a_30793_n862.n28 a_30793_n862.n27 0.662643
R7717 a_30793_n862.n26 a_30793_n862.n25 0.662643
R7718 a_30793_n862.n24 a_30793_n862.n23 0.662643
R7719 a_30793_n862.n22 a_30793_n862.n21 0.662643
R7720 a_30793_n862.n20 a_30793_n862.n19 0.662643
R7721 a_30793_n862.n18 a_30793_n862.n17 0.662643
R7722 a_30793_n862.n16 a_30793_n862.n15 0.662643
R7723 a_30793_n862.n14 a_30793_n862.n13 0.662643
R7724 a_30793_n862.n12 a_30793_n862.n11 0.662643
R7725 a_30793_n862.n10 a_30793_n862.n9 0.662643
R7726 a_30793_n862.n8 a_30793_n862.n7 0.662643
R7727 a_30793_n862.n6 a_30793_n862.n5 0.662643
R7728 a_30793_n862.n4 a_30793_n862.n3 0.662643
R7729 a_30793_n862.n1 a_30793_n862.n0 0.4505
R7730 a_30793_n862.n29 a_30793_n862.n28 0.4505
R7731 a_30793_n862.n25 a_30793_n862.n24 0.4505
R7732 a_30793_n862.n21 a_30793_n862.n20 0.4505
R7733 a_30793_n862.n17 a_30793_n862.n16 0.4505
R7734 a_30793_n862.n13 a_30793_n862.n12 0.4505
R7735 a_30793_n862.n9 a_30793_n862.n8 0.4505
R7736 a_30793_n862.n5 a_30793_n862.n4 0.4505
R7737 a_23647_n2146.n3 a_23647_n2146.t32 18.9023
R7738 a_23647_n2146.n0 a_23647_n2146.t20 16.1106
R7739 a_23647_n2146.n3 a_23647_n2146.t33 15.6434
R7740 a_23647_n2146.n2 a_23647_n2146.t4 15.4484
R7741 a_23647_n2146.n28 a_23647_n2146.t8 15.4484
R7742 a_23647_n2146.n27 a_23647_n2146.t11 15.4484
R7743 a_23647_n2146.n24 a_23647_n2146.t2 15.4484
R7744 a_23647_n2146.n23 a_23647_n2146.t5 15.4484
R7745 a_23647_n2146.n20 a_23647_n2146.t13 15.4484
R7746 a_23647_n2146.n19 a_23647_n2146.t27 15.4484
R7747 a_23647_n2146.n16 a_23647_n2146.t9 15.4484
R7748 a_23647_n2146.n15 a_23647_n2146.t6 15.4484
R7749 a_23647_n2146.n12 a_23647_n2146.t12 15.4484
R7750 a_23647_n2146.n11 a_23647_n2146.t3 15.4484
R7751 a_23647_n2146.n8 a_23647_n2146.t30 15.4484
R7752 a_23647_n2146.n7 a_23647_n2146.t7 15.4484
R7753 a_23647_n2146.n4 a_23647_n2146.t1 15.4484
R7754 a_23647_n2146.t0 a_23647_n2146.n31 15.4484
R7755 a_23647_n2146.n0 a_23647_n2146.t23 14.854
R7756 a_23647_n2146.n1 a_23647_n2146.t28 14.854
R7757 a_23647_n2146.n30 a_23647_n2146.t31 14.854
R7758 a_23647_n2146.n29 a_23647_n2146.t25 14.854
R7759 a_23647_n2146.n26 a_23647_n2146.t15 14.854
R7760 a_23647_n2146.n25 a_23647_n2146.t14 14.854
R7761 a_23647_n2146.n22 a_23647_n2146.t26 14.854
R7762 a_23647_n2146.n21 a_23647_n2146.t19 14.854
R7763 a_23647_n2146.n18 a_23647_n2146.t10 14.854
R7764 a_23647_n2146.n17 a_23647_n2146.t18 14.854
R7765 a_23647_n2146.n14 a_23647_n2146.t29 14.854
R7766 a_23647_n2146.n13 a_23647_n2146.t24 14.854
R7767 a_23647_n2146.n10 a_23647_n2146.t17 14.854
R7768 a_23647_n2146.n9 a_23647_n2146.t21 14.854
R7769 a_23647_n2146.n6 a_23647_n2146.t22 14.854
R7770 a_23647_n2146.n5 a_23647_n2146.t16 14.854
R7771 a_23647_n2146.n4 a_23647_n2146.n3 14.5641
R7772 a_23647_n2146.n31 a_23647_n2146.n2 0.746214
R7773 a_23647_n2146.n28 a_23647_n2146.n27 0.746214
R7774 a_23647_n2146.n24 a_23647_n2146.n23 0.746214
R7775 a_23647_n2146.n20 a_23647_n2146.n19 0.746214
R7776 a_23647_n2146.n16 a_23647_n2146.n15 0.746214
R7777 a_23647_n2146.n12 a_23647_n2146.n11 0.746214
R7778 a_23647_n2146.n8 a_23647_n2146.n7 0.746214
R7779 a_23647_n2146.n2 a_23647_n2146.n1 0.662643
R7780 a_23647_n2146.n31 a_23647_n2146.n30 0.662643
R7781 a_23647_n2146.n29 a_23647_n2146.n28 0.662643
R7782 a_23647_n2146.n27 a_23647_n2146.n26 0.662643
R7783 a_23647_n2146.n25 a_23647_n2146.n24 0.662643
R7784 a_23647_n2146.n23 a_23647_n2146.n22 0.662643
R7785 a_23647_n2146.n21 a_23647_n2146.n20 0.662643
R7786 a_23647_n2146.n19 a_23647_n2146.n18 0.662643
R7787 a_23647_n2146.n17 a_23647_n2146.n16 0.662643
R7788 a_23647_n2146.n15 a_23647_n2146.n14 0.662643
R7789 a_23647_n2146.n13 a_23647_n2146.n12 0.662643
R7790 a_23647_n2146.n11 a_23647_n2146.n10 0.662643
R7791 a_23647_n2146.n9 a_23647_n2146.n8 0.662643
R7792 a_23647_n2146.n7 a_23647_n2146.n6 0.662643
R7793 a_23647_n2146.n5 a_23647_n2146.n4 0.662643
R7794 a_23647_n2146.n1 a_23647_n2146.n0 0.4505
R7795 a_23647_n2146.n30 a_23647_n2146.n29 0.4505
R7796 a_23647_n2146.n26 a_23647_n2146.n25 0.4505
R7797 a_23647_n2146.n22 a_23647_n2146.n21 0.4505
R7798 a_23647_n2146.n18 a_23647_n2146.n17 0.4505
R7799 a_23647_n2146.n14 a_23647_n2146.n13 0.4505
R7800 a_23647_n2146.n10 a_23647_n2146.n9 0.4505
R7801 a_23647_n2146.n6 a_23647_n2146.n5 0.4505
R7802 a_n1204_6102.n1 a_n1204_6102.t27 29.7679
R7803 a_n1204_6102.n30 a_n1204_6102.t14 29.4079
R7804 a_n1204_6102.n28 a_n1204_6102.t38 29.4079
R7805 a_n1204_6102.n26 a_n1204_6102.t25 29.4079
R7806 a_n1204_6102.n24 a_n1204_6102.t23 29.4079
R7807 a_n1204_6102.n22 a_n1204_6102.t36 29.4079
R7808 a_n1204_6102.n20 a_n1204_6102.t35 29.4079
R7809 a_n1204_6102.n18 a_n1204_6102.t9 29.4079
R7810 a_n1204_6102.n16 a_n1204_6102.t18 29.4079
R7811 a_n1204_6102.n14 a_n1204_6102.t17 29.4079
R7812 a_n1204_6102.n12 a_n1204_6102.t37 29.4079
R7813 a_n1204_6102.n10 a_n1204_6102.t10 29.4079
R7814 a_n1204_6102.n8 a_n1204_6102.t22 29.4079
R7815 a_n1204_6102.n6 a_n1204_6102.t20 29.4079
R7816 a_n1204_6102.n4 a_n1204_6102.t39 29.4079
R7817 a_n1204_6102.n2 a_n1204_6102.t11 29.4079
R7818 a_n1204_6102.n31 a_n1204_6102.t32 29.1445
R7819 a_n1204_6102.n29 a_n1204_6102.t13 29.1445
R7820 a_n1204_6102.n27 a_n1204_6102.t33 29.1445
R7821 a_n1204_6102.n25 a_n1204_6102.t8 29.1445
R7822 a_n1204_6102.n23 a_n1204_6102.t7 29.1445
R7823 a_n1204_6102.n21 a_n1204_6102.t21 29.1445
R7824 a_n1204_6102.n19 a_n1204_6102.t19 29.1445
R7825 a_n1204_6102.n17 a_n1204_6102.t5 29.1445
R7826 a_n1204_6102.n15 a_n1204_6102.t4 29.1445
R7827 a_n1204_6102.n13 a_n1204_6102.t26 29.1445
R7828 a_n1204_6102.n11 a_n1204_6102.t24 29.1445
R7829 a_n1204_6102.n9 a_n1204_6102.t34 29.1445
R7830 a_n1204_6102.n7 a_n1204_6102.t6 29.1445
R7831 a_n1204_6102.n5 a_n1204_6102.t12 29.1445
R7832 a_n1204_6102.n3 a_n1204_6102.t30 29.1445
R7833 a_n1204_6102.n1 a_n1204_6102.t29 29.1445
R7834 a_n1204_6102.n33 a_n1204_6102.t16 24.7684
R7835 a_n1204_6102.n33 a_n1204_6102.t31 24.1166
R7836 a_n1204_6102.n34 a_n1204_6102.t15 23.7255
R7837 a_n1204_6102.n34 a_n1204_6102.t28 23.0737
R7838 a_n1204_6102.n34 a_n1204_6102.n33 17.1396
R7839 a_n1204_6102.n32 a_n1204_6102.n31 10.2862
R7840 a_n1204_6102.n35 a_n1204_6102.n34 8.0005
R7841 a_n1204_6102.n32 a_n1204_6102.n0 6.86767
R7842 a_n1204_6102.n2 a_n1204_6102.n1 3.61336
R7843 a_n1204_6102.n4 a_n1204_6102.n3 3.61336
R7844 a_n1204_6102.n6 a_n1204_6102.n5 3.61336
R7845 a_n1204_6102.n8 a_n1204_6102.n7 3.61336
R7846 a_n1204_6102.n10 a_n1204_6102.n9 3.61336
R7847 a_n1204_6102.n12 a_n1204_6102.n11 3.61336
R7848 a_n1204_6102.n14 a_n1204_6102.n13 3.61336
R7849 a_n1204_6102.n16 a_n1204_6102.n15 3.61336
R7850 a_n1204_6102.n18 a_n1204_6102.n17 3.61336
R7851 a_n1204_6102.n20 a_n1204_6102.n19 3.61336
R7852 a_n1204_6102.n22 a_n1204_6102.n21 3.61336
R7853 a_n1204_6102.n24 a_n1204_6102.n23 3.61336
R7854 a_n1204_6102.n26 a_n1204_6102.n25 3.61336
R7855 a_n1204_6102.n28 a_n1204_6102.n27 3.61336
R7856 a_n1204_6102.n30 a_n1204_6102.n29 3.61336
R7857 a_n1204_6102.n36 a_n1204_6102.n35 3.45159
R7858 a_n1204_6102.n0 a_n1204_6102.t3 2.58003
R7859 a_n1204_6102.n0 a_n1204_6102.t2 2.58003
R7860 a_n1204_6102.n36 a_n1204_6102.t0 1.43357
R7861 a_n1204_6102.t1 a_n1204_6102.n36 1.43357
R7862 a_n1204_6102.n3 a_n1204_6102.n2 0.3605
R7863 a_n1204_6102.n5 a_n1204_6102.n4 0.3605
R7864 a_n1204_6102.n7 a_n1204_6102.n6 0.3605
R7865 a_n1204_6102.n9 a_n1204_6102.n8 0.3605
R7866 a_n1204_6102.n11 a_n1204_6102.n10 0.3605
R7867 a_n1204_6102.n13 a_n1204_6102.n12 0.3605
R7868 a_n1204_6102.n15 a_n1204_6102.n14 0.3605
R7869 a_n1204_6102.n17 a_n1204_6102.n16 0.3605
R7870 a_n1204_6102.n19 a_n1204_6102.n18 0.3605
R7871 a_n1204_6102.n21 a_n1204_6102.n20 0.3605
R7872 a_n1204_6102.n23 a_n1204_6102.n22 0.3605
R7873 a_n1204_6102.n25 a_n1204_6102.n24 0.3605
R7874 a_n1204_6102.n27 a_n1204_6102.n26 0.3605
R7875 a_n1204_6102.n29 a_n1204_6102.n28 0.3605
R7876 a_n1204_6102.n31 a_n1204_6102.n30 0.3605
R7877 a_n1204_6102.n35 a_n1204_6102.n32 0.169589
R7878 a_36007_n2146.n3 a_36007_n2146.t32 18.9023
R7879 a_36007_n2146.n0 a_36007_n2146.t20 16.1106
R7880 a_36007_n2146.n3 a_36007_n2146.t33 15.6434
R7881 a_36007_n2146.n2 a_36007_n2146.t5 15.4484
R7882 a_36007_n2146.n28 a_36007_n2146.t9 15.4484
R7883 a_36007_n2146.n27 a_36007_n2146.t11 15.4484
R7884 a_36007_n2146.n24 a_36007_n2146.t3 15.4484
R7885 a_36007_n2146.n23 a_36007_n2146.t6 15.4484
R7886 a_36007_n2146.n20 a_36007_n2146.t13 15.4484
R7887 a_36007_n2146.n19 a_36007_n2146.t26 15.4484
R7888 a_36007_n2146.n16 a_36007_n2146.t10 15.4484
R7889 a_36007_n2146.n15 a_36007_n2146.t7 15.4484
R7890 a_36007_n2146.n12 a_36007_n2146.t12 15.4484
R7891 a_36007_n2146.n11 a_36007_n2146.t4 15.4484
R7892 a_36007_n2146.n8 a_36007_n2146.t27 15.4484
R7893 a_36007_n2146.n7 a_36007_n2146.t8 15.4484
R7894 a_36007_n2146.n4 a_36007_n2146.t1 15.4484
R7895 a_36007_n2146.t0 a_36007_n2146.n31 15.4484
R7896 a_36007_n2146.n0 a_36007_n2146.t29 14.854
R7897 a_36007_n2146.n1 a_36007_n2146.t28 14.854
R7898 a_36007_n2146.n30 a_36007_n2146.t23 14.854
R7899 a_36007_n2146.n29 a_36007_n2146.t14 14.854
R7900 a_36007_n2146.n26 a_36007_n2146.t18 14.854
R7901 a_36007_n2146.n25 a_36007_n2146.t2 14.854
R7902 a_36007_n2146.n22 a_36007_n2146.t30 14.854
R7903 a_36007_n2146.n21 a_36007_n2146.t24 14.854
R7904 a_36007_n2146.n18 a_36007_n2146.t17 14.854
R7905 a_36007_n2146.n17 a_36007_n2146.t15 14.854
R7906 a_36007_n2146.n14 a_36007_n2146.t16 14.854
R7907 a_36007_n2146.n13 a_36007_n2146.t21 14.854
R7908 a_36007_n2146.n10 a_36007_n2146.t25 14.854
R7909 a_36007_n2146.n9 a_36007_n2146.t22 14.854
R7910 a_36007_n2146.n6 a_36007_n2146.t31 14.854
R7911 a_36007_n2146.n5 a_36007_n2146.t19 14.854
R7912 a_36007_n2146.n4 a_36007_n2146.n3 14.5641
R7913 a_36007_n2146.n31 a_36007_n2146.n2 0.746214
R7914 a_36007_n2146.n28 a_36007_n2146.n27 0.746214
R7915 a_36007_n2146.n24 a_36007_n2146.n23 0.746214
R7916 a_36007_n2146.n20 a_36007_n2146.n19 0.746214
R7917 a_36007_n2146.n16 a_36007_n2146.n15 0.746214
R7918 a_36007_n2146.n12 a_36007_n2146.n11 0.746214
R7919 a_36007_n2146.n8 a_36007_n2146.n7 0.746214
R7920 a_36007_n2146.n2 a_36007_n2146.n1 0.662643
R7921 a_36007_n2146.n31 a_36007_n2146.n30 0.662643
R7922 a_36007_n2146.n29 a_36007_n2146.n28 0.662643
R7923 a_36007_n2146.n27 a_36007_n2146.n26 0.662643
R7924 a_36007_n2146.n25 a_36007_n2146.n24 0.662643
R7925 a_36007_n2146.n23 a_36007_n2146.n22 0.662643
R7926 a_36007_n2146.n21 a_36007_n2146.n20 0.662643
R7927 a_36007_n2146.n19 a_36007_n2146.n18 0.662643
R7928 a_36007_n2146.n17 a_36007_n2146.n16 0.662643
R7929 a_36007_n2146.n15 a_36007_n2146.n14 0.662643
R7930 a_36007_n2146.n13 a_36007_n2146.n12 0.662643
R7931 a_36007_n2146.n11 a_36007_n2146.n10 0.662643
R7932 a_36007_n2146.n9 a_36007_n2146.n8 0.662643
R7933 a_36007_n2146.n7 a_36007_n2146.n6 0.662643
R7934 a_36007_n2146.n5 a_36007_n2146.n4 0.662643
R7935 a_36007_n2146.n1 a_36007_n2146.n0 0.4505
R7936 a_36007_n2146.n30 a_36007_n2146.n29 0.4505
R7937 a_36007_n2146.n26 a_36007_n2146.n25 0.4505
R7938 a_36007_n2146.n22 a_36007_n2146.n21 0.4505
R7939 a_36007_n2146.n18 a_36007_n2146.n17 0.4505
R7940 a_36007_n2146.n14 a_36007_n2146.n13 0.4505
R7941 a_36007_n2146.n10 a_36007_n2146.n9 0.4505
R7942 a_36007_n2146.n6 a_36007_n2146.n5 0.4505
R7943 a_38479_n2146.n3 a_38479_n2146.t32 18.9023
R7944 a_38479_n2146.n0 a_38479_n2146.t22 16.1106
R7945 a_38479_n2146.n3 a_38479_n2146.t33 15.6434
R7946 a_38479_n2146.n2 a_38479_n2146.t4 15.4484
R7947 a_38479_n2146.n28 a_38479_n2146.t10 15.4484
R7948 a_38479_n2146.n27 a_38479_n2146.t14 15.4484
R7949 a_38479_n2146.n24 a_38479_n2146.t2 15.4484
R7950 a_38479_n2146.n23 a_38479_n2146.t5 15.4484
R7951 a_38479_n2146.n20 a_38479_n2146.t16 15.4484
R7952 a_38479_n2146.n19 a_38479_n2146.t26 15.4484
R7953 a_38479_n2146.n16 a_38479_n2146.t11 15.4484
R7954 a_38479_n2146.n15 a_38479_n2146.t7 15.4484
R7955 a_38479_n2146.n12 a_38479_n2146.t15 15.4484
R7956 a_38479_n2146.n11 a_38479_n2146.t3 15.4484
R7957 a_38479_n2146.n8 a_38479_n2146.t29 15.4484
R7958 a_38479_n2146.n7 a_38479_n2146.t8 15.4484
R7959 a_38479_n2146.n4 a_38479_n2146.t1 15.4484
R7960 a_38479_n2146.t0 a_38479_n2146.n31 15.4484
R7961 a_38479_n2146.n0 a_38479_n2146.t27 14.854
R7962 a_38479_n2146.n1 a_38479_n2146.t18 14.854
R7963 a_38479_n2146.n30 a_38479_n2146.t30 14.854
R7964 a_38479_n2146.n29 a_38479_n2146.t20 14.854
R7965 a_38479_n2146.n26 a_38479_n2146.t28 14.854
R7966 a_38479_n2146.n25 a_38479_n2146.t31 14.854
R7967 a_38479_n2146.n22 a_38479_n2146.t9 14.854
R7968 a_38479_n2146.n21 a_38479_n2146.t19 14.854
R7969 a_38479_n2146.n18 a_38479_n2146.t13 14.854
R7970 a_38479_n2146.n17 a_38479_n2146.t12 14.854
R7971 a_38479_n2146.n14 a_38479_n2146.t23 14.854
R7972 a_38479_n2146.n13 a_38479_n2146.t17 14.854
R7973 a_38479_n2146.n10 a_38479_n2146.t6 14.854
R7974 a_38479_n2146.n9 a_38479_n2146.t25 14.854
R7975 a_38479_n2146.n6 a_38479_n2146.t24 14.854
R7976 a_38479_n2146.n5 a_38479_n2146.t21 14.854
R7977 a_38479_n2146.n4 a_38479_n2146.n3 14.5641
R7978 a_38479_n2146.n31 a_38479_n2146.n2 0.746214
R7979 a_38479_n2146.n28 a_38479_n2146.n27 0.746214
R7980 a_38479_n2146.n24 a_38479_n2146.n23 0.746214
R7981 a_38479_n2146.n20 a_38479_n2146.n19 0.746214
R7982 a_38479_n2146.n16 a_38479_n2146.n15 0.746214
R7983 a_38479_n2146.n12 a_38479_n2146.n11 0.746214
R7984 a_38479_n2146.n8 a_38479_n2146.n7 0.746214
R7985 a_38479_n2146.n2 a_38479_n2146.n1 0.662643
R7986 a_38479_n2146.n31 a_38479_n2146.n30 0.662643
R7987 a_38479_n2146.n29 a_38479_n2146.n28 0.662643
R7988 a_38479_n2146.n27 a_38479_n2146.n26 0.662643
R7989 a_38479_n2146.n25 a_38479_n2146.n24 0.662643
R7990 a_38479_n2146.n23 a_38479_n2146.n22 0.662643
R7991 a_38479_n2146.n21 a_38479_n2146.n20 0.662643
R7992 a_38479_n2146.n19 a_38479_n2146.n18 0.662643
R7993 a_38479_n2146.n17 a_38479_n2146.n16 0.662643
R7994 a_38479_n2146.n15 a_38479_n2146.n14 0.662643
R7995 a_38479_n2146.n13 a_38479_n2146.n12 0.662643
R7996 a_38479_n2146.n11 a_38479_n2146.n10 0.662643
R7997 a_38479_n2146.n9 a_38479_n2146.n8 0.662643
R7998 a_38479_n2146.n7 a_38479_n2146.n6 0.662643
R7999 a_38479_n2146.n5 a_38479_n2146.n4 0.662643
R8000 a_38479_n2146.n1 a_38479_n2146.n0 0.4505
R8001 a_38479_n2146.n30 a_38479_n2146.n29 0.4505
R8002 a_38479_n2146.n26 a_38479_n2146.n25 0.4505
R8003 a_38479_n2146.n22 a_38479_n2146.n21 0.4505
R8004 a_38479_n2146.n18 a_38479_n2146.n17 0.4505
R8005 a_38479_n2146.n14 a_38479_n2146.n13 0.4505
R8006 a_38479_n2146.n10 a_38479_n2146.n9 0.4505
R8007 a_38479_n2146.n6 a_38479_n2146.n5 0.4505
R8008 a_18433_n862.n21 a_18433_n862.t32 18.9023
R8009 a_18433_n862.n0 a_18433_n862.t16 16.1132
R8010 a_18433_n862.n21 a_18433_n862.t33 15.6434
R8011 a_18433_n862.n2 a_18433_n862.t1 15.4511
R8012 a_18433_n862.n3 a_18433_n862.t21 15.4511
R8013 a_18433_n862.n6 a_18433_n862.t23 15.4511
R8014 a_18433_n862.n7 a_18433_n862.t11 15.4511
R8015 a_18433_n862.n10 a_18433_n862.t20 15.4511
R8016 a_18433_n862.n11 a_18433_n862.t15 15.4511
R8017 a_18433_n862.n14 a_18433_n862.t14 15.4511
R8018 a_18433_n862.n15 a_18433_n862.t6 15.4511
R8019 a_18433_n862.n18 a_18433_n862.t12 15.4511
R8020 a_18433_n862.n19 a_18433_n862.t4 15.4511
R8021 a_18433_n862.n30 a_18433_n862.t8 15.4511
R8022 a_18433_n862.n29 a_18433_n862.t5 15.4511
R8023 a_18433_n862.n26 a_18433_n862.t7 15.4511
R8024 a_18433_n862.n25 a_18433_n862.t13 15.4511
R8025 a_18433_n862.n22 a_18433_n862.t9 15.4511
R8026 a_18433_n862.n0 a_18433_n862.t25 14.8566
R8027 a_18433_n862.n1 a_18433_n862.t30 14.8566
R8028 a_18433_n862.n4 a_18433_n862.t29 14.8566
R8029 a_18433_n862.n5 a_18433_n862.t18 14.8566
R8030 a_18433_n862.n8 a_18433_n862.t31 14.8566
R8031 a_18433_n862.n9 a_18433_n862.t24 14.8566
R8032 a_18433_n862.n12 a_18433_n862.t17 14.8566
R8033 a_18433_n862.n13 a_18433_n862.t3 14.8566
R8034 a_18433_n862.n16 a_18433_n862.t26 14.8566
R8035 a_18433_n862.n17 a_18433_n862.t19 14.8566
R8036 a_18433_n862.n20 a_18433_n862.t22 14.8566
R8037 a_18433_n862.n28 a_18433_n862.t28 14.8566
R8038 a_18433_n862.n27 a_18433_n862.t10 14.8566
R8039 a_18433_n862.n24 a_18433_n862.t27 14.8566
R8040 a_18433_n862.n23 a_18433_n862.t2 14.8566
R8041 a_18433_n862.t0 a_18433_n862.n31 14.8566
R8042 a_18433_n862.n22 a_18433_n862.n21 14.5641
R8043 a_18433_n862.n3 a_18433_n862.n2 0.746214
R8044 a_18433_n862.n7 a_18433_n862.n6 0.746214
R8045 a_18433_n862.n11 a_18433_n862.n10 0.746214
R8046 a_18433_n862.n15 a_18433_n862.n14 0.746214
R8047 a_18433_n862.n19 a_18433_n862.n18 0.746214
R8048 a_18433_n862.n30 a_18433_n862.n29 0.746214
R8049 a_18433_n862.n26 a_18433_n862.n25 0.746214
R8050 a_18433_n862.n2 a_18433_n862.n1 0.662643
R8051 a_18433_n862.n4 a_18433_n862.n3 0.662643
R8052 a_18433_n862.n6 a_18433_n862.n5 0.662643
R8053 a_18433_n862.n8 a_18433_n862.n7 0.662643
R8054 a_18433_n862.n10 a_18433_n862.n9 0.662643
R8055 a_18433_n862.n12 a_18433_n862.n11 0.662643
R8056 a_18433_n862.n14 a_18433_n862.n13 0.662643
R8057 a_18433_n862.n16 a_18433_n862.n15 0.662643
R8058 a_18433_n862.n18 a_18433_n862.n17 0.662643
R8059 a_18433_n862.n20 a_18433_n862.n19 0.662643
R8060 a_18433_n862.n31 a_18433_n862.n30 0.662643
R8061 a_18433_n862.n29 a_18433_n862.n28 0.662643
R8062 a_18433_n862.n27 a_18433_n862.n26 0.662643
R8063 a_18433_n862.n25 a_18433_n862.n24 0.662643
R8064 a_18433_n862.n23 a_18433_n862.n22 0.662643
R8065 a_18433_n862.n1 a_18433_n862.n0 0.4505
R8066 a_18433_n862.n5 a_18433_n862.n4 0.4505
R8067 a_18433_n862.n9 a_18433_n862.n8 0.4505
R8068 a_18433_n862.n13 a_18433_n862.n12 0.4505
R8069 a_18433_n862.n17 a_18433_n862.n16 0.4505
R8070 a_18433_n862.n31 a_18433_n862.n20 0.4505
R8071 a_18433_n862.n28 a_18433_n862.n27 0.4505
R8072 a_18433_n862.n24 a_18433_n862.n23 0.4505
R8073 a_11017_n862.n2 a_11017_n862.t32 18.9023
R8074 a_11017_n862.n0 a_11017_n862.t16 16.1132
R8075 a_11017_n862.n2 a_11017_n862.t33 15.6434
R8076 a_11017_n862.n30 a_11017_n862.t26 15.4511
R8077 a_11017_n862.n27 a_11017_n862.t29 15.4511
R8078 a_11017_n862.n26 a_11017_n862.t11 15.4511
R8079 a_11017_n862.n23 a_11017_n862.t7 15.4511
R8080 a_11017_n862.n22 a_11017_n862.t15 15.4511
R8081 a_11017_n862.n19 a_11017_n862.t14 15.4511
R8082 a_11017_n862.n18 a_11017_n862.t4 15.4511
R8083 a_11017_n862.n15 a_11017_n862.t12 15.4511
R8084 a_11017_n862.n14 a_11017_n862.t2 15.4511
R8085 a_11017_n862.n11 a_11017_n862.t8 15.4511
R8086 a_11017_n862.n10 a_11017_n862.t3 15.4511
R8087 a_11017_n862.n7 a_11017_n862.t5 15.4511
R8088 a_11017_n862.n6 a_11017_n862.t13 15.4511
R8089 a_11017_n862.n3 a_11017_n862.t10 15.4511
R8090 a_11017_n862.t0 a_11017_n862.n31 15.4511
R8091 a_11017_n862.n0 a_11017_n862.t30 14.8566
R8092 a_11017_n862.n1 a_11017_n862.t1 14.8566
R8093 a_11017_n862.n29 a_11017_n862.t31 14.8566
R8094 a_11017_n862.n28 a_11017_n862.t19 14.8566
R8095 a_11017_n862.n25 a_11017_n862.t9 14.8566
R8096 a_11017_n862.n24 a_11017_n862.t27 14.8566
R8097 a_11017_n862.n21 a_11017_n862.t18 14.8566
R8098 a_11017_n862.n20 a_11017_n862.t25 14.8566
R8099 a_11017_n862.n17 a_11017_n862.t17 14.8566
R8100 a_11017_n862.n16 a_11017_n862.t6 14.8566
R8101 a_11017_n862.n13 a_11017_n862.t24 14.8566
R8102 a_11017_n862.n12 a_11017_n862.t28 14.8566
R8103 a_11017_n862.n9 a_11017_n862.t22 14.8566
R8104 a_11017_n862.n8 a_11017_n862.t23 14.8566
R8105 a_11017_n862.n5 a_11017_n862.t21 14.8566
R8106 a_11017_n862.n4 a_11017_n862.t20 14.8566
R8107 a_11017_n862.n3 a_11017_n862.n2 14.5641
R8108 a_11017_n862.n31 a_11017_n862.n30 0.746214
R8109 a_11017_n862.n27 a_11017_n862.n26 0.746214
R8110 a_11017_n862.n23 a_11017_n862.n22 0.746214
R8111 a_11017_n862.n19 a_11017_n862.n18 0.746214
R8112 a_11017_n862.n15 a_11017_n862.n14 0.746214
R8113 a_11017_n862.n11 a_11017_n862.n10 0.746214
R8114 a_11017_n862.n7 a_11017_n862.n6 0.746214
R8115 a_11017_n862.n31 a_11017_n862.n1 0.662643
R8116 a_11017_n862.n30 a_11017_n862.n29 0.662643
R8117 a_11017_n862.n28 a_11017_n862.n27 0.662643
R8118 a_11017_n862.n26 a_11017_n862.n25 0.662643
R8119 a_11017_n862.n24 a_11017_n862.n23 0.662643
R8120 a_11017_n862.n22 a_11017_n862.n21 0.662643
R8121 a_11017_n862.n20 a_11017_n862.n19 0.662643
R8122 a_11017_n862.n18 a_11017_n862.n17 0.662643
R8123 a_11017_n862.n16 a_11017_n862.n15 0.662643
R8124 a_11017_n862.n14 a_11017_n862.n13 0.662643
R8125 a_11017_n862.n12 a_11017_n862.n11 0.662643
R8126 a_11017_n862.n10 a_11017_n862.n9 0.662643
R8127 a_11017_n862.n8 a_11017_n862.n7 0.662643
R8128 a_11017_n862.n6 a_11017_n862.n5 0.662643
R8129 a_11017_n862.n4 a_11017_n862.n3 0.662643
R8130 a_11017_n862.n1 a_11017_n862.n0 0.4505
R8131 a_11017_n862.n29 a_11017_n862.n28 0.4505
R8132 a_11017_n862.n25 a_11017_n862.n24 0.4505
R8133 a_11017_n862.n21 a_11017_n862.n20 0.4505
R8134 a_11017_n862.n17 a_11017_n862.n16 0.4505
R8135 a_11017_n862.n13 a_11017_n862.n12 0.4505
R8136 a_11017_n862.n9 a_11017_n862.n8 0.4505
R8137 a_11017_n862.n5 a_11017_n862.n4 0.4505
R8138 RA4.t1 RA4.t25 70.3934
R8139 RA4.t28 RA4.t36 70.3934
R8140 RA4.t27 RA4.t17 70.3934
R8141 RA4.t43 RA4.t15 70.3934
R8142 RA4.t45 RA4.t23 70.3934
R8143 RA4.t8 RA4.t32 70.3934
R8144 RA4.t24 RA4.t0 70.3934
R8145 RA4.t41 RA4.t12 70.3934
R8146 RA4.t46 RA4.t21 70.3934
R8147 RA4.t10 RA4.t35 70.3934
R8148 RA4.t9 RA4.t33 70.3934
R8149 RA4.t42 RA4.t2 70.3934
R8150 RA4.t47 RA4.t22 70.3934
R8151 RA4.t13 RA4.t39 70.3934
R8152 RA4.t11 RA4.t37 70.3934
R8153 RA4.t26 RA4.t16 70.3934
R8154 RA4.n29 RA4.t1 31.2862
R8155 RA4.n27 RA4.t28 31.2862
R8156 RA4.n25 RA4.t27 31.2862
R8157 RA4.n23 RA4.t43 31.2862
R8158 RA4.n21 RA4.t45 31.2862
R8159 RA4.n19 RA4.t8 31.2862
R8160 RA4.n17 RA4.t24 31.2862
R8161 RA4.n15 RA4.t41 31.2862
R8162 RA4.n13 RA4.t46 31.2862
R8163 RA4.n11 RA4.t10 31.2862
R8164 RA4.n9 RA4.t9 31.2862
R8165 RA4.n7 RA4.t42 31.2862
R8166 RA4.n5 RA4.t47 31.2862
R8167 RA4.n3 RA4.t13 31.2862
R8168 RA4.n1 RA4.t11 31.2862
R8169 RA4.n0 RA4.t26 31.2862
R8170 RA4.n2 RA4.n0 21.0181
R8171 RA4.n30 RA4.n29 17.0453
R8172 RA4.n28 RA4.n27 17.0453
R8173 RA4.n26 RA4.n25 17.0453
R8174 RA4.n24 RA4.n23 17.0453
R8175 RA4.n22 RA4.n21 17.0453
R8176 RA4.n20 RA4.n19 17.0453
R8177 RA4.n18 RA4.n17 17.0453
R8178 RA4.n16 RA4.n15 17.0453
R8179 RA4.n14 RA4.n13 17.0453
R8180 RA4.n12 RA4.n11 17.0453
R8181 RA4.n10 RA4.n9 17.0453
R8182 RA4.n8 RA4.n7 17.0453
R8183 RA4.n6 RA4.n5 17.0453
R8184 RA4.n4 RA4.n3 17.0453
R8185 RA4.n2 RA4.n1 17.0453
R8186 RA4.n29 RA4.t44 15.6434
R8187 RA4.n27 RA4.t20 15.6434
R8188 RA4.n25 RA4.t19 15.6434
R8189 RA4.n23 RA4.t31 15.6434
R8190 RA4.n21 RA4.t34 15.6434
R8191 RA4.n19 RA4.t3 15.6434
R8192 RA4.n17 RA4.t14 15.6434
R8193 RA4.n15 RA4.t29 15.6434
R8194 RA4.n13 RA4.t38 15.6434
R8195 RA4.n11 RA4.t5 15.6434
R8196 RA4.n9 RA4.t4 15.6434
R8197 RA4.n7 RA4.t30 15.6434
R8198 RA4.n5 RA4.t40 15.6434
R8199 RA4.n3 RA4.t7 15.6434
R8200 RA4.n1 RA4.t6 15.6434
R8201 RA4.n0 RA4.t18 15.6434
R8202 RA4 RA4.n30 4.50211
R8203 RA4.n4 RA4.n2 3.97336
R8204 RA4.n6 RA4.n4 3.97336
R8205 RA4.n8 RA4.n6 3.97336
R8206 RA4.n10 RA4.n8 3.97336
R8207 RA4.n12 RA4.n10 3.97336
R8208 RA4.n14 RA4.n12 3.97336
R8209 RA4.n16 RA4.n14 3.97336
R8210 RA4.n18 RA4.n16 3.97336
R8211 RA4.n20 RA4.n18 3.97336
R8212 RA4.n22 RA4.n20 3.97336
R8213 RA4.n24 RA4.n22 3.97336
R8214 RA4.n26 RA4.n24 3.97336
R8215 RA4.n28 RA4.n26 3.97336
R8216 RA4.n30 RA4.n28 3.97336
R8217 CLK.n0 CLK.t0 33.763
R8218 CLK.n0 CLK.t1 21.5094
R8219 CLK CLK.n0 17.7307
R8220 a_3871_n2146.n9 a_3871_n2146.t32 18.9023
R8221 a_3871_n2146.n0 a_3871_n2146.t21 16.1106
R8222 a_3871_n2146.n9 a_3871_n2146.t33 15.6434
R8223 a_3871_n2146.n2 a_3871_n2146.t6 15.4484
R8224 a_3871_n2146.n3 a_3871_n2146.t1 15.4484
R8225 a_3871_n2146.n6 a_3871_n2146.t12 15.4484
R8226 a_3871_n2146.n7 a_3871_n2146.t14 15.4484
R8227 a_3871_n2146.n30 a_3871_n2146.t4 15.4484
R8228 a_3871_n2146.n29 a_3871_n2146.t7 15.4484
R8229 a_3871_n2146.n26 a_3871_n2146.t17 15.4484
R8230 a_3871_n2146.n25 a_3871_n2146.t26 15.4484
R8231 a_3871_n2146.n22 a_3871_n2146.t13 15.4484
R8232 a_3871_n2146.n21 a_3871_n2146.t9 15.4484
R8233 a_3871_n2146.n18 a_3871_n2146.t16 15.4484
R8234 a_3871_n2146.n17 a_3871_n2146.t5 15.4484
R8235 a_3871_n2146.n14 a_3871_n2146.t30 15.4484
R8236 a_3871_n2146.n13 a_3871_n2146.t11 15.4484
R8237 a_3871_n2146.n10 a_3871_n2146.t2 15.4484
R8238 a_3871_n2146.n0 a_3871_n2146.t10 14.854
R8239 a_3871_n2146.n1 a_3871_n2146.t3 14.854
R8240 a_3871_n2146.n4 a_3871_n2146.t27 14.854
R8241 a_3871_n2146.n5 a_3871_n2146.t8 14.854
R8242 a_3871_n2146.n8 a_3871_n2146.t28 14.854
R8243 a_3871_n2146.n28 a_3871_n2146.t23 14.854
R8244 a_3871_n2146.n27 a_3871_n2146.t22 14.854
R8245 a_3871_n2146.n24 a_3871_n2146.t29 14.854
R8246 a_3871_n2146.n23 a_3871_n2146.t24 14.854
R8247 a_3871_n2146.n20 a_3871_n2146.t20 14.854
R8248 a_3871_n2146.n19 a_3871_n2146.t19 14.854
R8249 a_3871_n2146.n16 a_3871_n2146.t25 14.854
R8250 a_3871_n2146.n15 a_3871_n2146.t31 14.854
R8251 a_3871_n2146.n12 a_3871_n2146.t15 14.854
R8252 a_3871_n2146.n11 a_3871_n2146.t18 14.854
R8253 a_3871_n2146.t0 a_3871_n2146.n31 14.854
R8254 a_3871_n2146.n10 a_3871_n2146.n9 14.5641
R8255 a_3871_n2146.n3 a_3871_n2146.n2 0.746214
R8256 a_3871_n2146.n7 a_3871_n2146.n6 0.746214
R8257 a_3871_n2146.n30 a_3871_n2146.n29 0.746214
R8258 a_3871_n2146.n26 a_3871_n2146.n25 0.746214
R8259 a_3871_n2146.n22 a_3871_n2146.n21 0.746214
R8260 a_3871_n2146.n18 a_3871_n2146.n17 0.746214
R8261 a_3871_n2146.n14 a_3871_n2146.n13 0.746214
R8262 a_3871_n2146.n2 a_3871_n2146.n1 0.662643
R8263 a_3871_n2146.n4 a_3871_n2146.n3 0.662643
R8264 a_3871_n2146.n6 a_3871_n2146.n5 0.662643
R8265 a_3871_n2146.n8 a_3871_n2146.n7 0.662643
R8266 a_3871_n2146.n31 a_3871_n2146.n30 0.662643
R8267 a_3871_n2146.n29 a_3871_n2146.n28 0.662643
R8268 a_3871_n2146.n27 a_3871_n2146.n26 0.662643
R8269 a_3871_n2146.n25 a_3871_n2146.n24 0.662643
R8270 a_3871_n2146.n23 a_3871_n2146.n22 0.662643
R8271 a_3871_n2146.n21 a_3871_n2146.n20 0.662643
R8272 a_3871_n2146.n19 a_3871_n2146.n18 0.662643
R8273 a_3871_n2146.n17 a_3871_n2146.n16 0.662643
R8274 a_3871_n2146.n15 a_3871_n2146.n14 0.662643
R8275 a_3871_n2146.n13 a_3871_n2146.n12 0.662643
R8276 a_3871_n2146.n11 a_3871_n2146.n10 0.662643
R8277 a_3871_n2146.n1 a_3871_n2146.n0 0.4505
R8278 a_3871_n2146.n5 a_3871_n2146.n4 0.4505
R8279 a_3871_n2146.n31 a_3871_n2146.n8 0.4505
R8280 a_3871_n2146.n28 a_3871_n2146.n27 0.4505
R8281 a_3871_n2146.n24 a_3871_n2146.n23 0.4505
R8282 a_3871_n2146.n20 a_3871_n2146.n19 0.4505
R8283 a_3871_n2146.n16 a_3871_n2146.n15 0.4505
R8284 a_3871_n2146.n12 a_3871_n2146.n11 0.4505
R8285 QB6b.n0 QB6b.t1 13.1454
R8286 QB6b.n0 QB6b.t0 9.29658
R8287 QB6b QB6b.n0 4.69014
R8288 WE2.n0 WE2.t0 38.1951
R8289 WE2 WE2.n0 17.435
R8290 WE2.n0 WE2.t1 17.0773
R8291 RA6.t20 RA6.t44 70.3934
R8292 RA6.t47 RA6.t6 70.3934
R8293 RA6.t46 RA6.t35 70.3934
R8294 RA6.t13 RA6.t33 70.3934
R8295 RA6.t15 RA6.t42 70.3934
R8296 RA6.t27 RA6.t1 70.3934
R8297 RA6.t43 RA6.t19 70.3934
R8298 RA6.t10 RA6.t31 70.3934
R8299 RA6.t16 RA6.t39 70.3934
R8300 RA6.t29 RA6.t5 70.3934
R8301 RA6.t28 RA6.t3 70.3934
R8302 RA6.t12 RA6.t21 70.3934
R8303 RA6.t18 RA6.t41 70.3934
R8304 RA6.t32 RA6.t8 70.3934
R8305 RA6.t30 RA6.t7 70.3934
R8306 RA6.t45 RA6.t34 70.3934
R8307 RA6.n29 RA6.t20 31.2862
R8308 RA6.n27 RA6.t47 31.2862
R8309 RA6.n25 RA6.t46 31.2862
R8310 RA6.n23 RA6.t13 31.2862
R8311 RA6.n21 RA6.t15 31.2862
R8312 RA6.n19 RA6.t27 31.2862
R8313 RA6.n17 RA6.t43 31.2862
R8314 RA6.n15 RA6.t10 31.2862
R8315 RA6.n13 RA6.t16 31.2862
R8316 RA6.n11 RA6.t29 31.2862
R8317 RA6.n9 RA6.t28 31.2862
R8318 RA6.n7 RA6.t12 31.2862
R8319 RA6.n5 RA6.t18 31.2862
R8320 RA6.n3 RA6.t32 31.2862
R8321 RA6.n1 RA6.t30 31.2862
R8322 RA6.n0 RA6.t45 31.2862
R8323 RA6.n2 RA6.n0 21.0181
R8324 RA6.n30 RA6.n29 17.0453
R8325 RA6.n28 RA6.n27 17.0453
R8326 RA6.n26 RA6.n25 17.0453
R8327 RA6.n24 RA6.n23 17.0453
R8328 RA6.n22 RA6.n21 17.0453
R8329 RA6.n20 RA6.n19 17.0453
R8330 RA6.n18 RA6.n17 17.0453
R8331 RA6.n16 RA6.n15 17.0453
R8332 RA6.n14 RA6.n13 17.0453
R8333 RA6.n12 RA6.n11 17.0453
R8334 RA6.n10 RA6.n9 17.0453
R8335 RA6.n8 RA6.n7 17.0453
R8336 RA6.n6 RA6.n5 17.0453
R8337 RA6.n4 RA6.n3 17.0453
R8338 RA6.n2 RA6.n1 17.0453
R8339 RA6.n29 RA6.t17 15.6434
R8340 RA6.n27 RA6.t40 15.6434
R8341 RA6.n25 RA6.t38 15.6434
R8342 RA6.n23 RA6.t4 15.6434
R8343 RA6.n21 RA6.t9 15.6434
R8344 RA6.n19 RA6.t22 15.6434
R8345 RA6.n17 RA6.t36 15.6434
R8346 RA6.n15 RA6.t0 15.6434
R8347 RA6.n13 RA6.t11 15.6434
R8348 RA6.n11 RA6.t24 15.6434
R8349 RA6.n9 RA6.t23 15.6434
R8350 RA6.n7 RA6.t2 15.6434
R8351 RA6.n5 RA6.t14 15.6434
R8352 RA6.n3 RA6.t26 15.6434
R8353 RA6.n1 RA6.t25 15.6434
R8354 RA6.n0 RA6.t37 15.6434
R8355 RA6 RA6.n30 4.50532
R8356 RA6.n4 RA6.n2 3.97336
R8357 RA6.n6 RA6.n4 3.97336
R8358 RA6.n8 RA6.n6 3.97336
R8359 RA6.n10 RA6.n8 3.97336
R8360 RA6.n12 RA6.n10 3.97336
R8361 RA6.n14 RA6.n12 3.97336
R8362 RA6.n16 RA6.n14 3.97336
R8363 RA6.n18 RA6.n16 3.97336
R8364 RA6.n20 RA6.n18 3.97336
R8365 RA6.n22 RA6.n20 3.97336
R8366 RA6.n24 RA6.n22 3.97336
R8367 RA6.n26 RA6.n24 3.97336
R8368 RA6.n28 RA6.n26 3.97336
R8369 RA6.n30 RA6.n28 3.97336
R8370 a_13489_n862.n2 a_13489_n862.t32 18.9023
R8371 a_13489_n862.n0 a_13489_n862.t13 16.1132
R8372 a_13489_n862.n2 a_13489_n862.t33 15.6434
R8373 a_13489_n862.n30 a_13489_n862.t17 15.4511
R8374 a_13489_n862.n27 a_13489_n862.t22 15.4511
R8375 a_13489_n862.n26 a_13489_n862.t30 15.4511
R8376 a_13489_n862.n23 a_13489_n862.t16 15.4511
R8377 a_13489_n862.n22 a_13489_n862.t26 15.4511
R8378 a_13489_n862.n19 a_13489_n862.t10 15.4511
R8379 a_13489_n862.n18 a_13489_n862.t3 15.4511
R8380 a_13489_n862.n15 a_13489_n862.t8 15.4511
R8381 a_13489_n862.n14 a_13489_n862.t1 15.4511
R8382 a_13489_n862.n11 a_13489_n862.t6 15.4511
R8383 a_13489_n862.n10 a_13489_n862.t2 15.4511
R8384 a_13489_n862.n7 a_13489_n862.t5 15.4511
R8385 a_13489_n862.n6 a_13489_n862.t9 15.4511
R8386 a_13489_n862.n3 a_13489_n862.t7 15.4511
R8387 a_13489_n862.t0 a_13489_n862.n31 15.4511
R8388 a_13489_n862.n0 a_13489_n862.t18 14.8566
R8389 a_13489_n862.n1 a_13489_n862.t27 14.8566
R8390 a_13489_n862.n29 a_13489_n862.t19 14.8566
R8391 a_13489_n862.n28 a_13489_n862.t15 14.8566
R8392 a_13489_n862.n25 a_13489_n862.t11 14.8566
R8393 a_13489_n862.n24 a_13489_n862.t25 14.8566
R8394 a_13489_n862.n21 a_13489_n862.t28 14.8566
R8395 a_13489_n862.n20 a_13489_n862.t21 14.8566
R8396 a_13489_n862.n17 a_13489_n862.t24 14.8566
R8397 a_13489_n862.n16 a_13489_n862.t20 14.8566
R8398 a_13489_n862.n13 a_13489_n862.t29 14.8566
R8399 a_13489_n862.n12 a_13489_n862.t31 14.8566
R8400 a_13489_n862.n9 a_13489_n862.t12 14.8566
R8401 a_13489_n862.n8 a_13489_n862.t23 14.8566
R8402 a_13489_n862.n5 a_13489_n862.t4 14.8566
R8403 a_13489_n862.n4 a_13489_n862.t14 14.8566
R8404 a_13489_n862.n3 a_13489_n862.n2 14.5641
R8405 a_13489_n862.n31 a_13489_n862.n30 0.746214
R8406 a_13489_n862.n27 a_13489_n862.n26 0.746214
R8407 a_13489_n862.n23 a_13489_n862.n22 0.746214
R8408 a_13489_n862.n19 a_13489_n862.n18 0.746214
R8409 a_13489_n862.n15 a_13489_n862.n14 0.746214
R8410 a_13489_n862.n11 a_13489_n862.n10 0.746214
R8411 a_13489_n862.n7 a_13489_n862.n6 0.746214
R8412 a_13489_n862.n31 a_13489_n862.n1 0.662643
R8413 a_13489_n862.n30 a_13489_n862.n29 0.662643
R8414 a_13489_n862.n28 a_13489_n862.n27 0.662643
R8415 a_13489_n862.n26 a_13489_n862.n25 0.662643
R8416 a_13489_n862.n24 a_13489_n862.n23 0.662643
R8417 a_13489_n862.n22 a_13489_n862.n21 0.662643
R8418 a_13489_n862.n20 a_13489_n862.n19 0.662643
R8419 a_13489_n862.n18 a_13489_n862.n17 0.662643
R8420 a_13489_n862.n16 a_13489_n862.n15 0.662643
R8421 a_13489_n862.n14 a_13489_n862.n13 0.662643
R8422 a_13489_n862.n12 a_13489_n862.n11 0.662643
R8423 a_13489_n862.n10 a_13489_n862.n9 0.662643
R8424 a_13489_n862.n8 a_13489_n862.n7 0.662643
R8425 a_13489_n862.n6 a_13489_n862.n5 0.662643
R8426 a_13489_n862.n4 a_13489_n862.n3 0.662643
R8427 a_13489_n862.n1 a_13489_n862.n0 0.4505
R8428 a_13489_n862.n29 a_13489_n862.n28 0.4505
R8429 a_13489_n862.n25 a_13489_n862.n24 0.4505
R8430 a_13489_n862.n21 a_13489_n862.n20 0.4505
R8431 a_13489_n862.n17 a_13489_n862.n16 0.4505
R8432 a_13489_n862.n13 a_13489_n862.n12 0.4505
R8433 a_13489_n862.n9 a_13489_n862.n8 0.4505
R8434 a_13489_n862.n5 a_13489_n862.n4 0.4505
R8435 RA5.t33 RA5.t5 70.3934
R8436 RA5.t9 RA5.t18 70.3934
R8437 RA5.t8 RA5.t47 70.3934
R8438 RA5.t23 RA5.t45 70.3934
R8439 RA5.t24 RA5.t2 70.3934
R8440 RA5.t39 RA5.t14 70.3934
R8441 RA5.t3 RA5.t32 70.3934
R8442 RA5.t21 RA5.t43 70.3934
R8443 RA5.t26 RA5.t0 70.3934
R8444 RA5.t41 RA5.t16 70.3934
R8445 RA5.t40 RA5.t15 70.3934
R8446 RA5.t22 RA5.t34 70.3934
R8447 RA5.t29 RA5.t1 70.3934
R8448 RA5.t44 RA5.t20 70.3934
R8449 RA5.t42 RA5.t19 70.3934
R8450 RA5.t7 RA5.t46 70.3934
R8451 RA5.n29 RA5.t33 31.2862
R8452 RA5.n27 RA5.t9 31.2862
R8453 RA5.n25 RA5.t8 31.2862
R8454 RA5.n23 RA5.t23 31.2862
R8455 RA5.n21 RA5.t24 31.2862
R8456 RA5.n19 RA5.t39 31.2862
R8457 RA5.n17 RA5.t3 31.2862
R8458 RA5.n15 RA5.t21 31.2862
R8459 RA5.n13 RA5.t26 31.2862
R8460 RA5.n11 RA5.t41 31.2862
R8461 RA5.n9 RA5.t40 31.2862
R8462 RA5.n7 RA5.t22 31.2862
R8463 RA5.n5 RA5.t29 31.2862
R8464 RA5.n3 RA5.t44 31.2862
R8465 RA5.n1 RA5.t42 31.2862
R8466 RA5.n0 RA5.t7 31.2862
R8467 RA5.n2 RA5.n0 21.0181
R8468 RA5.n30 RA5.n29 17.0453
R8469 RA5.n28 RA5.n27 17.0453
R8470 RA5.n26 RA5.n25 17.0453
R8471 RA5.n24 RA5.n23 17.0453
R8472 RA5.n22 RA5.n21 17.0453
R8473 RA5.n20 RA5.n19 17.0453
R8474 RA5.n18 RA5.n17 17.0453
R8475 RA5.n16 RA5.n15 17.0453
R8476 RA5.n14 RA5.n13 17.0453
R8477 RA5.n12 RA5.n11 17.0453
R8478 RA5.n10 RA5.n9 17.0453
R8479 RA5.n8 RA5.n7 17.0453
R8480 RA5.n6 RA5.n5 17.0453
R8481 RA5.n4 RA5.n3 17.0453
R8482 RA5.n2 RA5.n1 17.0453
R8483 RA5.n29 RA5.t17 15.6434
R8484 RA5.n27 RA5.t38 15.6434
R8485 RA5.n25 RA5.t37 15.6434
R8486 RA5.n23 RA5.t10 15.6434
R8487 RA5.n21 RA5.t11 15.6434
R8488 RA5.n19 RA5.t25 15.6434
R8489 RA5.n17 RA5.t35 15.6434
R8490 RA5.n15 RA5.t4 15.6434
R8491 RA5.n13 RA5.t12 15.6434
R8492 RA5.n11 RA5.t28 15.6434
R8493 RA5.n9 RA5.t27 15.6434
R8494 RA5.n7 RA5.t6 15.6434
R8495 RA5.n5 RA5.t13 15.6434
R8496 RA5.n3 RA5.t31 15.6434
R8497 RA5.n1 RA5.t30 15.6434
R8498 RA5.n0 RA5.t36 15.6434
R8499 RA5 RA5.n30 4.50532
R8500 RA5.n4 RA5.n2 3.97336
R8501 RA5.n6 RA5.n4 3.97336
R8502 RA5.n8 RA5.n6 3.97336
R8503 RA5.n10 RA5.n8 3.97336
R8504 RA5.n12 RA5.n10 3.97336
R8505 RA5.n14 RA5.n12 3.97336
R8506 RA5.n16 RA5.n14 3.97336
R8507 RA5.n18 RA5.n16 3.97336
R8508 RA5.n20 RA5.n18 3.97336
R8509 RA5.n22 RA5.n20 3.97336
R8510 RA5.n24 RA5.n22 3.97336
R8511 RA5.n26 RA5.n24 3.97336
R8512 RA5.n28 RA5.n26 3.97336
R8513 RA5.n30 RA5.n28 3.97336
R8514 a_25849_n862.n2 a_25849_n862.t32 18.9023
R8515 a_25849_n862.n0 a_25849_n862.t11 16.1132
R8516 a_25849_n862.n2 a_25849_n862.t33 15.6434
R8517 a_25849_n862.n30 a_25849_n862.t18 15.4511
R8518 a_25849_n862.n27 a_25849_n862.t21 15.4511
R8519 a_25849_n862.n26 a_25849_n862.t30 15.4511
R8520 a_25849_n862.n23 a_25849_n862.t12 15.4511
R8521 a_25849_n862.n22 a_25849_n862.t25 15.4511
R8522 a_25849_n862.n19 a_25849_n862.t10 15.4511
R8523 a_25849_n862.n18 a_25849_n862.t4 15.4511
R8524 a_25849_n862.n15 a_25849_n862.t8 15.4511
R8525 a_25849_n862.n14 a_25849_n862.t2 15.4511
R8526 a_25849_n862.n11 a_25849_n862.t6 15.4511
R8527 a_25849_n862.n10 a_25849_n862.t3 15.4511
R8528 a_25849_n862.n7 a_25849_n862.t5 15.4511
R8529 a_25849_n862.n6 a_25849_n862.t9 15.4511
R8530 a_25849_n862.n3 a_25849_n862.t7 15.4511
R8531 a_25849_n862.t0 a_25849_n862.n31 15.4511
R8532 a_25849_n862.n0 a_25849_n862.t1 14.8566
R8533 a_25849_n862.n1 a_25849_n862.t27 14.8566
R8534 a_25849_n862.n29 a_25849_n862.t20 14.8566
R8535 a_25849_n862.n28 a_25849_n862.t26 14.8566
R8536 a_25849_n862.n25 a_25849_n862.t24 14.8566
R8537 a_25849_n862.n24 a_25849_n862.t29 14.8566
R8538 a_25849_n862.n21 a_25849_n862.t14 14.8566
R8539 a_25849_n862.n20 a_25849_n862.t22 14.8566
R8540 a_25849_n862.n17 a_25849_n862.t13 14.8566
R8541 a_25849_n862.n16 a_25849_n862.t19 14.8566
R8542 a_25849_n862.n13 a_25849_n862.t16 14.8566
R8543 a_25849_n862.n12 a_25849_n862.t28 14.8566
R8544 a_25849_n862.n9 a_25849_n862.t17 14.8566
R8545 a_25849_n862.n8 a_25849_n862.t23 14.8566
R8546 a_25849_n862.n5 a_25849_n862.t15 14.8566
R8547 a_25849_n862.n4 a_25849_n862.t31 14.8566
R8548 a_25849_n862.n3 a_25849_n862.n2 14.5641
R8549 a_25849_n862.n31 a_25849_n862.n30 0.746214
R8550 a_25849_n862.n27 a_25849_n862.n26 0.746214
R8551 a_25849_n862.n23 a_25849_n862.n22 0.746214
R8552 a_25849_n862.n19 a_25849_n862.n18 0.746214
R8553 a_25849_n862.n15 a_25849_n862.n14 0.746214
R8554 a_25849_n862.n11 a_25849_n862.n10 0.746214
R8555 a_25849_n862.n7 a_25849_n862.n6 0.746214
R8556 a_25849_n862.n31 a_25849_n862.n1 0.662643
R8557 a_25849_n862.n30 a_25849_n862.n29 0.662643
R8558 a_25849_n862.n28 a_25849_n862.n27 0.662643
R8559 a_25849_n862.n26 a_25849_n862.n25 0.662643
R8560 a_25849_n862.n24 a_25849_n862.n23 0.662643
R8561 a_25849_n862.n22 a_25849_n862.n21 0.662643
R8562 a_25849_n862.n20 a_25849_n862.n19 0.662643
R8563 a_25849_n862.n18 a_25849_n862.n17 0.662643
R8564 a_25849_n862.n16 a_25849_n862.n15 0.662643
R8565 a_25849_n862.n14 a_25849_n862.n13 0.662643
R8566 a_25849_n862.n12 a_25849_n862.n11 0.662643
R8567 a_25849_n862.n10 a_25849_n862.n9 0.662643
R8568 a_25849_n862.n8 a_25849_n862.n7 0.662643
R8569 a_25849_n862.n6 a_25849_n862.n5 0.662643
R8570 a_25849_n862.n4 a_25849_n862.n3 0.662643
R8571 a_25849_n862.n1 a_25849_n862.n0 0.4505
R8572 a_25849_n862.n29 a_25849_n862.n28 0.4505
R8573 a_25849_n862.n25 a_25849_n862.n24 0.4505
R8574 a_25849_n862.n21 a_25849_n862.n20 0.4505
R8575 a_25849_n862.n17 a_25849_n862.n16 0.4505
R8576 a_25849_n862.n13 a_25849_n862.n12 0.4505
R8577 a_25849_n862.n9 a_25849_n862.n8 0.4505
R8578 a_25849_n862.n5 a_25849_n862.n4 0.4505
R8579 D15.n0 D15.t0 31.0255
R8580 D15.n0 D15.t1 27.8969
R8581 D15 D15.n0 14.0409
R8582 a_8545_n862.n2 a_8545_n862.t32 18.9023
R8583 a_8545_n862.n0 a_8545_n862.t13 16.1132
R8584 a_8545_n862.n2 a_8545_n862.t33 15.6434
R8585 a_8545_n862.n30 a_8545_n862.t17 15.4511
R8586 a_8545_n862.n27 a_8545_n862.t21 15.4511
R8587 a_8545_n862.n26 a_8545_n862.t30 15.4511
R8588 a_8545_n862.n23 a_8545_n862.t14 15.4511
R8589 a_8545_n862.n22 a_8545_n862.t27 15.4511
R8590 a_8545_n862.n19 a_8545_n862.t12 15.4511
R8591 a_8545_n862.n18 a_8545_n862.t3 15.4511
R8592 a_8545_n862.n15 a_8545_n862.t10 15.4511
R8593 a_8545_n862.n14 a_8545_n862.t1 15.4511
R8594 a_8545_n862.n11 a_8545_n862.t6 15.4511
R8595 a_8545_n862.n10 a_8545_n862.t2 15.4511
R8596 a_8545_n862.n7 a_8545_n862.t4 15.4511
R8597 a_8545_n862.n6 a_8545_n862.t11 15.4511
R8598 a_8545_n862.n3 a_8545_n862.t7 15.4511
R8599 a_8545_n862.t0 a_8545_n862.n31 15.4511
R8600 a_8545_n862.n0 a_8545_n862.t23 14.8566
R8601 a_8545_n862.n1 a_8545_n862.t5 14.8566
R8602 a_8545_n862.n29 a_8545_n862.t20 14.8566
R8603 a_8545_n862.n28 a_8545_n862.t28 14.8566
R8604 a_8545_n862.n25 a_8545_n862.t19 14.8566
R8605 a_8545_n862.n24 a_8545_n862.t29 14.8566
R8606 a_8545_n862.n21 a_8545_n862.t22 14.8566
R8607 a_8545_n862.n20 a_8545_n862.t18 14.8566
R8608 a_8545_n862.n17 a_8545_n862.t25 14.8566
R8609 a_8545_n862.n16 a_8545_n862.t16 14.8566
R8610 a_8545_n862.n13 a_8545_n862.t24 14.8566
R8611 a_8545_n862.n12 a_8545_n862.t9 14.8566
R8612 a_8545_n862.n9 a_8545_n862.t31 14.8566
R8613 a_8545_n862.n8 a_8545_n862.t26 14.8566
R8614 a_8545_n862.n5 a_8545_n862.t15 14.8566
R8615 a_8545_n862.n4 a_8545_n862.t8 14.8566
R8616 a_8545_n862.n3 a_8545_n862.n2 14.5641
R8617 a_8545_n862.n31 a_8545_n862.n30 0.746214
R8618 a_8545_n862.n27 a_8545_n862.n26 0.746214
R8619 a_8545_n862.n23 a_8545_n862.n22 0.746214
R8620 a_8545_n862.n19 a_8545_n862.n18 0.746214
R8621 a_8545_n862.n15 a_8545_n862.n14 0.746214
R8622 a_8545_n862.n11 a_8545_n862.n10 0.746214
R8623 a_8545_n862.n7 a_8545_n862.n6 0.746214
R8624 a_8545_n862.n31 a_8545_n862.n1 0.662643
R8625 a_8545_n862.n30 a_8545_n862.n29 0.662643
R8626 a_8545_n862.n28 a_8545_n862.n27 0.662643
R8627 a_8545_n862.n26 a_8545_n862.n25 0.662643
R8628 a_8545_n862.n24 a_8545_n862.n23 0.662643
R8629 a_8545_n862.n22 a_8545_n862.n21 0.662643
R8630 a_8545_n862.n20 a_8545_n862.n19 0.662643
R8631 a_8545_n862.n18 a_8545_n862.n17 0.662643
R8632 a_8545_n862.n16 a_8545_n862.n15 0.662643
R8633 a_8545_n862.n14 a_8545_n862.n13 0.662643
R8634 a_8545_n862.n12 a_8545_n862.n11 0.662643
R8635 a_8545_n862.n10 a_8545_n862.n9 0.662643
R8636 a_8545_n862.n8 a_8545_n862.n7 0.662643
R8637 a_8545_n862.n6 a_8545_n862.n5 0.662643
R8638 a_8545_n862.n4 a_8545_n862.n3 0.662643
R8639 a_8545_n862.n1 a_8545_n862.n0 0.4505
R8640 a_8545_n862.n29 a_8545_n862.n28 0.4505
R8641 a_8545_n862.n25 a_8545_n862.n24 0.4505
R8642 a_8545_n862.n21 a_8545_n862.n20 0.4505
R8643 a_8545_n862.n17 a_8545_n862.n16 0.4505
R8644 a_8545_n862.n13 a_8545_n862.n12 0.4505
R8645 a_8545_n862.n9 a_8545_n862.n8 0.4505
R8646 a_8545_n862.n5 a_8545_n862.n4 0.4505
R8647 a_12000_n708.n1 a_12000_n708.t16 31.0255
R8648 a_12000_n708.n2 a_12000_n708.t20 31.0255
R8649 a_12000_n708.n4 a_12000_n708.t32 31.0255
R8650 a_12000_n708.n6 a_12000_n708.t11 31.0255
R8651 a_12000_n708.n8 a_12000_n708.t18 31.0255
R8652 a_12000_n708.n10 a_12000_n708.t30 31.0255
R8653 a_12000_n708.n12 a_12000_n708.t33 31.0255
R8654 a_12000_n708.n14 a_12000_n708.t12 31.0255
R8655 a_12000_n708.n16 a_12000_n708.t19 31.0255
R8656 a_12000_n708.n18 a_12000_n708.t7 31.0255
R8657 a_12000_n708.n20 a_12000_n708.t17 31.0255
R8658 a_12000_n708.n22 a_12000_n708.t26 31.0255
R8659 a_12000_n708.n24 a_12000_n708.t28 31.0255
R8660 a_12000_n708.n26 a_12000_n708.t31 31.0255
R8661 a_12000_n708.n28 a_12000_n708.t9 31.0255
R8662 a_12000_n708.n30 a_12000_n708.t25 31.0255
R8663 a_12000_n708.n1 a_12000_n708.t10 27.8969
R8664 a_12000_n708.n2 a_12000_n708.t13 27.8969
R8665 a_12000_n708.n4 a_12000_n708.t29 27.8969
R8666 a_12000_n708.n6 a_12000_n708.t27 27.8969
R8667 a_12000_n708.n8 a_12000_n708.t21 27.8969
R8668 a_12000_n708.n10 a_12000_n708.t8 27.8969
R8669 a_12000_n708.n12 a_12000_n708.t6 27.8969
R8670 a_12000_n708.n14 a_12000_n708.t4 27.8969
R8671 a_12000_n708.n16 a_12000_n708.t22 27.8969
R8672 a_12000_n708.n18 a_12000_n708.t23 27.8969
R8673 a_12000_n708.n20 a_12000_n708.t15 27.8969
R8674 a_12000_n708.n22 a_12000_n708.t5 27.8969
R8675 a_12000_n708.n24 a_12000_n708.t34 27.8969
R8676 a_12000_n708.n26 a_12000_n708.t24 27.8969
R8677 a_12000_n708.n28 a_12000_n708.t35 27.8969
R8678 a_12000_n708.n30 a_12000_n708.t14 27.8969
R8679 a_12000_n708.n3 a_12000_n708.n1 13.8288
R8680 a_12000_n708.n3 a_12000_n708.n2 12.5495
R8681 a_12000_n708.n5 a_12000_n708.n4 12.5495
R8682 a_12000_n708.n7 a_12000_n708.n6 12.5495
R8683 a_12000_n708.n9 a_12000_n708.n8 12.5495
R8684 a_12000_n708.n11 a_12000_n708.n10 12.5495
R8685 a_12000_n708.n13 a_12000_n708.n12 12.5495
R8686 a_12000_n708.n15 a_12000_n708.n14 12.5495
R8687 a_12000_n708.n17 a_12000_n708.n16 12.5495
R8688 a_12000_n708.n19 a_12000_n708.n18 12.5495
R8689 a_12000_n708.n21 a_12000_n708.n20 12.5495
R8690 a_12000_n708.n23 a_12000_n708.n22 12.5495
R8691 a_12000_n708.n25 a_12000_n708.n24 12.5495
R8692 a_12000_n708.n27 a_12000_n708.n26 12.5495
R8693 a_12000_n708.n29 a_12000_n708.n28 12.5495
R8694 a_12000_n708.n31 a_12000_n708.n30 12.5495
R8695 a_12000_n708.n32 a_12000_n708.n0 6.45898
R8696 a_12000_n708.n32 a_12000_n708.n31 5.79746
R8697 a_12000_n708.n33 a_12000_n708.n32 2.99572
R8698 a_12000_n708.n0 a_12000_n708.t2 2.64244
R8699 a_12000_n708.n0 a_12000_n708.t3 2.64244
R8700 a_12000_n708.n33 a_12000_n708.t0 1.46824
R8701 a_12000_n708.t1 a_12000_n708.n33 1.46824
R8702 a_12000_n708.n7 a_12000_n708.n5 1.27979
R8703 a_12000_n708.n11 a_12000_n708.n9 1.27979
R8704 a_12000_n708.n15 a_12000_n708.n13 1.27979
R8705 a_12000_n708.n19 a_12000_n708.n17 1.27979
R8706 a_12000_n708.n23 a_12000_n708.n21 1.27979
R8707 a_12000_n708.n27 a_12000_n708.n25 1.27979
R8708 a_12000_n708.n31 a_12000_n708.n29 1.27979
R8709 a_12000_n708.n5 a_12000_n708.n3 1.24121
R8710 a_12000_n708.n9 a_12000_n708.n7 1.24121
R8711 a_12000_n708.n13 a_12000_n708.n11 1.24121
R8712 a_12000_n708.n17 a_12000_n708.n15 1.24121
R8713 a_12000_n708.n21 a_12000_n708.n19 1.24121
R8714 a_12000_n708.n25 a_12000_n708.n23 1.24121
R8715 a_12000_n708.n29 a_12000_n708.n27 1.24121
R8716 a_n884_2182.n1 a_n884_2182.t10 29.9245
R8717 a_n884_2182.n30 a_n884_2182.t34 29.3395
R8718 a_n884_2182.n28 a_n884_2182.t23 29.3395
R8719 a_n884_2182.n26 a_n884_2182.t9 29.3395
R8720 a_n884_2182.n24 a_n884_2182.t8 29.3395
R8721 a_n884_2182.n22 a_n884_2182.t21 29.3395
R8722 a_n884_2182.n20 a_n884_2182.t19 29.3395
R8723 a_n884_2182.n18 a_n884_2182.t27 29.3395
R8724 a_n884_2182.n16 a_n884_2182.t5 29.3395
R8725 a_n884_2182.n14 a_n884_2182.t4 29.3395
R8726 a_n884_2182.n12 a_n884_2182.t22 29.3395
R8727 a_n884_2182.n10 a_n884_2182.t30 29.3395
R8728 a_n884_2182.n8 a_n884_2182.t7 29.3395
R8729 a_n884_2182.n6 a_n884_2182.t6 29.3395
R8730 a_n884_2182.n4 a_n884_2182.t24 29.3395
R8731 a_n884_2182.n2 a_n884_2182.t32 29.3395
R8732 a_n884_2182.n31 a_n884_2182.t17 27.973
R8733 a_n884_2182.n29 a_n884_2182.t35 27.973
R8734 a_n884_2182.n27 a_n884_2182.t18 27.973
R8735 a_n884_2182.n25 a_n884_2182.t31 27.973
R8736 a_n884_2182.n23 a_n884_2182.t29 27.973
R8737 a_n884_2182.n21 a_n884_2182.t12 27.973
R8738 a_n884_2182.n19 a_n884_2182.t11 27.973
R8739 a_n884_2182.n17 a_n884_2182.t26 27.973
R8740 a_n884_2182.n15 a_n884_2182.t25 27.973
R8741 a_n884_2182.n13 a_n884_2182.t14 27.973
R8742 a_n884_2182.n11 a_n884_2182.t13 27.973
R8743 a_n884_2182.n9 a_n884_2182.t20 27.973
R8744 a_n884_2182.n7 a_n884_2182.t28 27.973
R8745 a_n884_2182.n5 a_n884_2182.t33 27.973
R8746 a_n884_2182.n3 a_n884_2182.t16 27.973
R8747 a_n884_2182.n1 a_n884_2182.t15 27.973
R8748 a_n884_2182.n32 a_n884_2182.n31 10.1914
R8749 a_n884_2182.n32 a_n884_2182.n0 7.10204
R8750 a_n884_2182.n2 a_n884_2182.n1 3.38836
R8751 a_n884_2182.n4 a_n884_2182.n3 3.38836
R8752 a_n884_2182.n6 a_n884_2182.n5 3.38836
R8753 a_n884_2182.n8 a_n884_2182.n7 3.38836
R8754 a_n884_2182.n10 a_n884_2182.n9 3.38836
R8755 a_n884_2182.n12 a_n884_2182.n11 3.38836
R8756 a_n884_2182.n14 a_n884_2182.n13 3.38836
R8757 a_n884_2182.n16 a_n884_2182.n15 3.38836
R8758 a_n884_2182.n18 a_n884_2182.n17 3.38836
R8759 a_n884_2182.n20 a_n884_2182.n19 3.38836
R8760 a_n884_2182.n22 a_n884_2182.n21 3.38836
R8761 a_n884_2182.n24 a_n884_2182.n23 3.38836
R8762 a_n884_2182.n26 a_n884_2182.n25 3.38836
R8763 a_n884_2182.n28 a_n884_2182.n27 3.38836
R8764 a_n884_2182.n30 a_n884_2182.n29 3.38836
R8765 a_n884_2182.n0 a_n884_2182.t2 3.00946
R8766 a_n884_2182.n33 a_n884_2182.n32 2.63313
R8767 a_n884_2182.n0 a_n884_2182.t3 2.44528
R8768 a_n884_2182.t1 a_n884_2182.n33 1.67214
R8769 a_n884_2182.n33 a_n884_2182.t0 1.35871
R8770 a_n884_2182.n3 a_n884_2182.n2 0.5855
R8771 a_n884_2182.n5 a_n884_2182.n4 0.5855
R8772 a_n884_2182.n7 a_n884_2182.n6 0.5855
R8773 a_n884_2182.n9 a_n884_2182.n8 0.5855
R8774 a_n884_2182.n11 a_n884_2182.n10 0.5855
R8775 a_n884_2182.n13 a_n884_2182.n12 0.5855
R8776 a_n884_2182.n15 a_n884_2182.n14 0.5855
R8777 a_n884_2182.n17 a_n884_2182.n16 0.5855
R8778 a_n884_2182.n19 a_n884_2182.n18 0.5855
R8779 a_n884_2182.n21 a_n884_2182.n20 0.5855
R8780 a_n884_2182.n23 a_n884_2182.n22 0.5855
R8781 a_n884_2182.n25 a_n884_2182.n24 0.5855
R8782 a_n884_2182.n27 a_n884_2182.n26 0.5855
R8783 a_n884_2182.n29 a_n884_2182.n28 0.5855
R8784 a_n884_2182.n31 a_n884_2182.n30 0.5855
R8785 a_n884_1398.n1 a_n884_1398.t15 29.9245
R8786 a_n884_1398.n30 a_n884_1398.t35 29.3395
R8787 a_n884_1398.n28 a_n884_1398.t27 29.3395
R8788 a_n884_1398.n26 a_n884_1398.t14 29.3395
R8789 a_n884_1398.n24 a_n884_1398.t13 29.3395
R8790 a_n884_1398.n22 a_n884_1398.t24 29.3395
R8791 a_n884_1398.n20 a_n884_1398.t22 29.3395
R8792 a_n884_1398.n18 a_n884_1398.t30 29.3395
R8793 a_n884_1398.n16 a_n884_1398.t8 29.3395
R8794 a_n884_1398.n14 a_n884_1398.t6 29.3395
R8795 a_n884_1398.n12 a_n884_1398.t26 29.3395
R8796 a_n884_1398.n10 a_n884_1398.t32 29.3395
R8797 a_n884_1398.n8 a_n884_1398.t12 29.3395
R8798 a_n884_1398.n6 a_n884_1398.t11 29.3395
R8799 a_n884_1398.n4 a_n884_1398.t28 29.3395
R8800 a_n884_1398.n2 a_n884_1398.t33 29.3395
R8801 a_n884_1398.n31 a_n884_1398.t29 27.973
R8802 a_n884_1398.n29 a_n884_1398.t17 27.973
R8803 a_n884_1398.n27 a_n884_1398.t31 27.973
R8804 a_n884_1398.n25 a_n884_1398.t10 27.973
R8805 a_n884_1398.n23 a_n884_1398.t9 27.973
R8806 a_n884_1398.n21 a_n884_1398.t19 27.973
R8807 a_n884_1398.n19 a_n884_1398.t18 27.973
R8808 a_n884_1398.n17 a_n884_1398.t5 27.973
R8809 a_n884_1398.n15 a_n884_1398.t4 27.973
R8810 a_n884_1398.n13 a_n884_1398.t21 27.973
R8811 a_n884_1398.n11 a_n884_1398.t20 27.973
R8812 a_n884_1398.n9 a_n884_1398.t34 27.973
R8813 a_n884_1398.n7 a_n884_1398.t7 27.973
R8814 a_n884_1398.n5 a_n884_1398.t16 27.973
R8815 a_n884_1398.n3 a_n884_1398.t25 27.973
R8816 a_n884_1398.n1 a_n884_1398.t23 27.973
R8817 a_n884_1398.n32 a_n884_1398.n31 10.1914
R8818 a_n884_1398.n32 a_n884_1398.n0 7.10204
R8819 a_n884_1398.n2 a_n884_1398.n1 3.38836
R8820 a_n884_1398.n4 a_n884_1398.n3 3.38836
R8821 a_n884_1398.n6 a_n884_1398.n5 3.38836
R8822 a_n884_1398.n8 a_n884_1398.n7 3.38836
R8823 a_n884_1398.n10 a_n884_1398.n9 3.38836
R8824 a_n884_1398.n12 a_n884_1398.n11 3.38836
R8825 a_n884_1398.n14 a_n884_1398.n13 3.38836
R8826 a_n884_1398.n16 a_n884_1398.n15 3.38836
R8827 a_n884_1398.n18 a_n884_1398.n17 3.38836
R8828 a_n884_1398.n20 a_n884_1398.n19 3.38836
R8829 a_n884_1398.n22 a_n884_1398.n21 3.38836
R8830 a_n884_1398.n24 a_n884_1398.n23 3.38836
R8831 a_n884_1398.n26 a_n884_1398.n25 3.38836
R8832 a_n884_1398.n28 a_n884_1398.n27 3.38836
R8833 a_n884_1398.n30 a_n884_1398.n29 3.38836
R8834 a_n884_1398.n0 a_n884_1398.t3 3.00946
R8835 a_n884_1398.n33 a_n884_1398.n32 2.63313
R8836 a_n884_1398.n0 a_n884_1398.t2 2.44528
R8837 a_n884_1398.t1 a_n884_1398.n33 1.67214
R8838 a_n884_1398.n33 a_n884_1398.t0 1.35871
R8839 a_n884_1398.n3 a_n884_1398.n2 0.5855
R8840 a_n884_1398.n5 a_n884_1398.n4 0.5855
R8841 a_n884_1398.n7 a_n884_1398.n6 0.5855
R8842 a_n884_1398.n9 a_n884_1398.n8 0.5855
R8843 a_n884_1398.n11 a_n884_1398.n10 0.5855
R8844 a_n884_1398.n13 a_n884_1398.n12 0.5855
R8845 a_n884_1398.n15 a_n884_1398.n14 0.5855
R8846 a_n884_1398.n17 a_n884_1398.n16 0.5855
R8847 a_n884_1398.n19 a_n884_1398.n18 0.5855
R8848 a_n884_1398.n21 a_n884_1398.n20 0.5855
R8849 a_n884_1398.n23 a_n884_1398.n22 0.5855
R8850 a_n884_1398.n25 a_n884_1398.n24 0.5855
R8851 a_n884_1398.n27 a_n884_1398.n26 0.5855
R8852 a_n884_1398.n29 a_n884_1398.n28 0.5855
R8853 a_n884_1398.n31 a_n884_1398.n30 0.5855
R8854 WE0.n0 WE0.t1 38.1951
R8855 WE0 WE0.n0 17.4511
R8856 WE0.n0 WE0.t0 17.0773
R8857 a_n884_2966.n1 a_n884_2966.t29 29.9245
R8858 a_n884_2966.n30 a_n884_2966.t21 29.3395
R8859 a_n884_2966.n28 a_n884_2966.t10 29.3395
R8860 a_n884_2966.n26 a_n884_2966.t28 29.3395
R8861 a_n884_2966.n24 a_n884_2966.t27 29.3395
R8862 a_n884_2966.n22 a_n884_2966.t7 29.3395
R8863 a_n884_2966.n20 a_n884_2966.t6 29.3395
R8864 a_n884_2966.n18 a_n884_2966.t12 29.3395
R8865 a_n884_2966.n16 a_n884_2966.t24 29.3395
R8866 a_n884_2966.n14 a_n884_2966.t23 29.3395
R8867 a_n884_2966.n12 a_n884_2966.t9 29.3395
R8868 a_n884_2966.n10 a_n884_2966.t15 29.3395
R8869 a_n884_2966.n8 a_n884_2966.t26 29.3395
R8870 a_n884_2966.n6 a_n884_2966.t25 29.3395
R8871 a_n884_2966.n4 a_n884_2966.t11 29.3395
R8872 a_n884_2966.n2 a_n884_2966.t19 29.3395
R8873 a_n884_2966.n31 a_n884_2966.t4 27.973
R8874 a_n884_2966.n29 a_n884_2966.t22 27.973
R8875 a_n884_2966.n27 a_n884_2966.t5 27.973
R8876 a_n884_2966.n25 a_n884_2966.t18 27.973
R8877 a_n884_2966.n23 a_n884_2966.t17 27.973
R8878 a_n884_2966.n21 a_n884_2966.t31 27.973
R8879 a_n884_2966.n19 a_n884_2966.t30 27.973
R8880 a_n884_2966.n17 a_n884_2966.t14 27.973
R8881 a_n884_2966.n15 a_n884_2966.t13 27.973
R8882 a_n884_2966.n13 a_n884_2966.t33 27.973
R8883 a_n884_2966.n11 a_n884_2966.t32 27.973
R8884 a_n884_2966.n9 a_n884_2966.t8 27.973
R8885 a_n884_2966.n7 a_n884_2966.t16 27.973
R8886 a_n884_2966.n5 a_n884_2966.t20 27.973
R8887 a_n884_2966.n3 a_n884_2966.t35 27.973
R8888 a_n884_2966.n1 a_n884_2966.t34 27.973
R8889 a_n884_2966.n32 a_n884_2966.n31 10.1914
R8890 a_n884_2966.n32 a_n884_2966.n0 7.10204
R8891 a_n884_2966.n2 a_n884_2966.n1 3.38836
R8892 a_n884_2966.n4 a_n884_2966.n3 3.38836
R8893 a_n884_2966.n6 a_n884_2966.n5 3.38836
R8894 a_n884_2966.n8 a_n884_2966.n7 3.38836
R8895 a_n884_2966.n10 a_n884_2966.n9 3.38836
R8896 a_n884_2966.n12 a_n884_2966.n11 3.38836
R8897 a_n884_2966.n14 a_n884_2966.n13 3.38836
R8898 a_n884_2966.n16 a_n884_2966.n15 3.38836
R8899 a_n884_2966.n18 a_n884_2966.n17 3.38836
R8900 a_n884_2966.n20 a_n884_2966.n19 3.38836
R8901 a_n884_2966.n22 a_n884_2966.n21 3.38836
R8902 a_n884_2966.n24 a_n884_2966.n23 3.38836
R8903 a_n884_2966.n26 a_n884_2966.n25 3.38836
R8904 a_n884_2966.n28 a_n884_2966.n27 3.38836
R8905 a_n884_2966.n30 a_n884_2966.n29 3.38836
R8906 a_n884_2966.n0 a_n884_2966.t3 3.00946
R8907 a_n884_2966.n33 a_n884_2966.n32 2.63313
R8908 a_n884_2966.n0 a_n884_2966.t2 2.44528
R8909 a_n884_2966.t1 a_n884_2966.n33 1.67214
R8910 a_n884_2966.n33 a_n884_2966.t0 1.35871
R8911 a_n884_2966.n3 a_n884_2966.n2 0.5855
R8912 a_n884_2966.n5 a_n884_2966.n4 0.5855
R8913 a_n884_2966.n7 a_n884_2966.n6 0.5855
R8914 a_n884_2966.n9 a_n884_2966.n8 0.5855
R8915 a_n884_2966.n11 a_n884_2966.n10 0.5855
R8916 a_n884_2966.n13 a_n884_2966.n12 0.5855
R8917 a_n884_2966.n15 a_n884_2966.n14 0.5855
R8918 a_n884_2966.n17 a_n884_2966.n16 0.5855
R8919 a_n884_2966.n19 a_n884_2966.n18 0.5855
R8920 a_n884_2966.n21 a_n884_2966.n20 0.5855
R8921 a_n884_2966.n23 a_n884_2966.n22 0.5855
R8922 a_n884_2966.n25 a_n884_2966.n24 0.5855
R8923 a_n884_2966.n27 a_n884_2966.n26 0.5855
R8924 a_n884_2966.n29 a_n884_2966.n28 0.5855
R8925 a_n884_2966.n31 a_n884_2966.n30 0.5855
R8926 a_38209_n862.n2 a_38209_n862.t32 18.9023
R8927 a_38209_n862.n0 a_38209_n862.t14 16.1132
R8928 a_38209_n862.n2 a_38209_n862.t33 15.6434
R8929 a_38209_n862.n30 a_38209_n862.t23 15.4511
R8930 a_38209_n862.n27 a_38209_n862.t25 15.4511
R8931 a_38209_n862.n26 a_38209_n862.t30 15.4511
R8932 a_38209_n862.n23 a_38209_n862.t19 15.4511
R8933 a_38209_n862.n22 a_38209_n862.t28 15.4511
R8934 a_38209_n862.n19 a_38209_n862.t13 15.4511
R8935 a_38209_n862.n18 a_38209_n862.t4 15.4511
R8936 a_38209_n862.n15 a_38209_n862.t11 15.4511
R8937 a_38209_n862.n14 a_38209_n862.t2 15.4511
R8938 a_38209_n862.n11 a_38209_n862.t7 15.4511
R8939 a_38209_n862.n10 a_38209_n862.t3 15.4511
R8940 a_38209_n862.n7 a_38209_n862.t5 15.4511
R8941 a_38209_n862.n6 a_38209_n862.t12 15.4511
R8942 a_38209_n862.n3 a_38209_n862.t9 15.4511
R8943 a_38209_n862.t0 a_38209_n862.n31 15.4511
R8944 a_38209_n862.n0 a_38209_n862.t27 14.8566
R8945 a_38209_n862.n1 a_38209_n862.t10 14.8566
R8946 a_38209_n862.n29 a_38209_n862.t21 14.8566
R8947 a_38209_n862.n28 a_38209_n862.t16 14.8566
R8948 a_38209_n862.n25 a_38209_n862.t15 14.8566
R8949 a_38209_n862.n24 a_38209_n862.t24 14.8566
R8950 a_38209_n862.n21 a_38209_n862.t1 14.8566
R8951 a_38209_n862.n20 a_38209_n862.t20 14.8566
R8952 a_38209_n862.n17 a_38209_n862.t18 14.8566
R8953 a_38209_n862.n16 a_38209_n862.t31 14.8566
R8954 a_38209_n862.n13 a_38209_n862.t22 14.8566
R8955 a_38209_n862.n12 a_38209_n862.t26 14.8566
R8956 a_38209_n862.n9 a_38209_n862.t6 14.8566
R8957 a_38209_n862.n8 a_38209_n862.t29 14.8566
R8958 a_38209_n862.n5 a_38209_n862.t8 14.8566
R8959 a_38209_n862.n4 a_38209_n862.t17 14.8566
R8960 a_38209_n862.n3 a_38209_n862.n2 14.5641
R8961 a_38209_n862.n31 a_38209_n862.n30 0.746214
R8962 a_38209_n862.n27 a_38209_n862.n26 0.746214
R8963 a_38209_n862.n23 a_38209_n862.n22 0.746214
R8964 a_38209_n862.n19 a_38209_n862.n18 0.746214
R8965 a_38209_n862.n15 a_38209_n862.n14 0.746214
R8966 a_38209_n862.n11 a_38209_n862.n10 0.746214
R8967 a_38209_n862.n7 a_38209_n862.n6 0.746214
R8968 a_38209_n862.n31 a_38209_n862.n1 0.662643
R8969 a_38209_n862.n30 a_38209_n862.n29 0.662643
R8970 a_38209_n862.n28 a_38209_n862.n27 0.662643
R8971 a_38209_n862.n26 a_38209_n862.n25 0.662643
R8972 a_38209_n862.n24 a_38209_n862.n23 0.662643
R8973 a_38209_n862.n22 a_38209_n862.n21 0.662643
R8974 a_38209_n862.n20 a_38209_n862.n19 0.662643
R8975 a_38209_n862.n18 a_38209_n862.n17 0.662643
R8976 a_38209_n862.n16 a_38209_n862.n15 0.662643
R8977 a_38209_n862.n14 a_38209_n862.n13 0.662643
R8978 a_38209_n862.n12 a_38209_n862.n11 0.662643
R8979 a_38209_n862.n10 a_38209_n862.n9 0.662643
R8980 a_38209_n862.n8 a_38209_n862.n7 0.662643
R8981 a_38209_n862.n6 a_38209_n862.n5 0.662643
R8982 a_38209_n862.n4 a_38209_n862.n3 0.662643
R8983 a_38209_n862.n1 a_38209_n862.n0 0.4505
R8984 a_38209_n862.n29 a_38209_n862.n28 0.4505
R8985 a_38209_n862.n25 a_38209_n862.n24 0.4505
R8986 a_38209_n862.n21 a_38209_n862.n20 0.4505
R8987 a_38209_n862.n17 a_38209_n862.n16 0.4505
R8988 a_38209_n862.n13 a_38209_n862.n12 0.4505
R8989 a_38209_n862.n9 a_38209_n862.n8 0.4505
R8990 a_38209_n862.n5 a_38209_n862.n4 0.4505
R8991 D6.n0 D6.t1 31.0255
R8992 D6.n0 D6.t0 27.8969
R8993 D6 D6.n0 14.0521
R8994 QA2b.n0 QA2b.t1 13.1454
R8995 QA2b.n0 QA2b.t0 9.29658
R8996 QA2b QA2b.n0 4.69014
R8997 WE1.n0 WE1.t1 38.1951
R8998 WE1 WE1.n0 17.4511
R8999 WE1.n0 WE1.t0 17.0773
R9000 a_n884_3750.n1 a_n884_3750.t21 29.9245
R9001 a_n884_3750.n30 a_n884_3750.t12 29.3395
R9002 a_n884_3750.n28 a_n884_3750.t33 29.3395
R9003 a_n884_3750.n26 a_n884_3750.t20 29.3395
R9004 a_n884_3750.n24 a_n884_3750.t19 29.3395
R9005 a_n884_3750.n22 a_n884_3750.t31 29.3395
R9006 a_n884_3750.n20 a_n884_3750.t30 29.3395
R9007 a_n884_3750.n18 a_n884_3750.t4 29.3395
R9008 a_n884_3750.n16 a_n884_3750.t16 29.3395
R9009 a_n884_3750.n14 a_n884_3750.t15 29.3395
R9010 a_n884_3750.n12 a_n884_3750.t32 29.3395
R9011 a_n884_3750.n10 a_n884_3750.t6 29.3395
R9012 a_n884_3750.n8 a_n884_3750.t18 29.3395
R9013 a_n884_3750.n6 a_n884_3750.t17 29.3395
R9014 a_n884_3750.n4 a_n884_3750.t35 29.3395
R9015 a_n884_3750.n2 a_n884_3750.t9 29.3395
R9016 a_n884_3750.n31 a_n884_3750.t28 27.973
R9017 a_n884_3750.n29 a_n884_3750.t14 27.973
R9018 a_n884_3750.n27 a_n884_3750.t29 27.973
R9019 a_n884_3750.n25 a_n884_3750.t11 27.973
R9020 a_n884_3750.n23 a_n884_3750.t10 27.973
R9021 a_n884_3750.n21 a_n884_3750.t23 27.973
R9022 a_n884_3750.n19 a_n884_3750.t22 27.973
R9023 a_n884_3750.n17 a_n884_3750.t7 27.973
R9024 a_n884_3750.n15 a_n884_3750.t5 27.973
R9025 a_n884_3750.n13 a_n884_3750.t25 27.973
R9026 a_n884_3750.n11 a_n884_3750.t24 27.973
R9027 a_n884_3750.n9 a_n884_3750.t34 27.973
R9028 a_n884_3750.n7 a_n884_3750.t8 27.973
R9029 a_n884_3750.n5 a_n884_3750.t13 27.973
R9030 a_n884_3750.n3 a_n884_3750.t27 27.973
R9031 a_n884_3750.n1 a_n884_3750.t26 27.973
R9032 a_n884_3750.n32 a_n884_3750.n31 10.1914
R9033 a_n884_3750.n32 a_n884_3750.n0 7.10204
R9034 a_n884_3750.n2 a_n884_3750.n1 3.38836
R9035 a_n884_3750.n4 a_n884_3750.n3 3.38836
R9036 a_n884_3750.n6 a_n884_3750.n5 3.38836
R9037 a_n884_3750.n8 a_n884_3750.n7 3.38836
R9038 a_n884_3750.n10 a_n884_3750.n9 3.38836
R9039 a_n884_3750.n12 a_n884_3750.n11 3.38836
R9040 a_n884_3750.n14 a_n884_3750.n13 3.38836
R9041 a_n884_3750.n16 a_n884_3750.n15 3.38836
R9042 a_n884_3750.n18 a_n884_3750.n17 3.38836
R9043 a_n884_3750.n20 a_n884_3750.n19 3.38836
R9044 a_n884_3750.n22 a_n884_3750.n21 3.38836
R9045 a_n884_3750.n24 a_n884_3750.n23 3.38836
R9046 a_n884_3750.n26 a_n884_3750.n25 3.38836
R9047 a_n884_3750.n28 a_n884_3750.n27 3.38836
R9048 a_n884_3750.n30 a_n884_3750.n29 3.38836
R9049 a_n884_3750.n0 a_n884_3750.t3 3.00946
R9050 a_n884_3750.n33 a_n884_3750.n32 2.63313
R9051 a_n884_3750.n0 a_n884_3750.t2 2.44528
R9052 a_n884_3750.t1 a_n884_3750.n33 1.67214
R9053 a_n884_3750.n33 a_n884_3750.t0 1.35871
R9054 a_n884_3750.n3 a_n884_3750.n2 0.5855
R9055 a_n884_3750.n5 a_n884_3750.n4 0.5855
R9056 a_n884_3750.n7 a_n884_3750.n6 0.5855
R9057 a_n884_3750.n9 a_n884_3750.n8 0.5855
R9058 a_n884_3750.n11 a_n884_3750.n10 0.5855
R9059 a_n884_3750.n13 a_n884_3750.n12 0.5855
R9060 a_n884_3750.n15 a_n884_3750.n14 0.5855
R9061 a_n884_3750.n17 a_n884_3750.n16 0.5855
R9062 a_n884_3750.n19 a_n884_3750.n18 0.5855
R9063 a_n884_3750.n21 a_n884_3750.n20 0.5855
R9064 a_n884_3750.n23 a_n884_3750.n22 0.5855
R9065 a_n884_3750.n25 a_n884_3750.n24 0.5855
R9066 a_n884_3750.n27 a_n884_3750.n26 0.5855
R9067 a_n884_3750.n29 a_n884_3750.n28 0.5855
R9068 a_n884_3750.n31 a_n884_3750.n30 0.5855
R9069 QB14b.n0 QB14b.t1 13.1454
R9070 QB14b.n0 QB14b.t0 9.29658
R9071 QB14b QB14b.n0 4.69014
R9072 D13.n0 D13.t0 31.0255
R9073 D13.n0 D13.t1 27.8969
R9074 D13 D13.n0 14.0296
R9075 QB0b.n0 QB0b.t1 13.1454
R9076 QB0b.n0 QB0b.t0 9.29658
R9077 QB0b QB0b.n0 4.69014
R9078 D2.n0 D2.t1 31.0255
R9079 D2.n0 D2.t0 27.8969
R9080 D2 D2.n0 14.057
R9081 QA4b.n0 QA4b.t1 13.1454
R9082 QA4b.n0 QA4b.t0 9.29658
R9083 QA4b QA4b.n0 4.69014
R9084 D4.n0 D4.t1 31.0255
R9085 D4.n0 D4.t0 27.8969
R9086 D4 D4.n0 14.0666
R9087 WE13.n0 WE13.t0 38.1951
R9088 WE13 WE13.n0 17.4495
R9089 WE13.n0 WE13.t1 17.0773
R9090 WE7.n0 WE7.t0 38.1951
R9091 WE7 WE7.n0 17.4366
R9092 WE7.n0 WE7.t1 17.0773
R9093 QB7b.n0 QB7b.t1 13.1454
R9094 QB7b.n0 QB7b.t0 9.29658
R9095 QB7b QB7b.n0 4.69014
R9096 QA10b.n0 QA10b.t1 13.1454
R9097 QA10b.n0 QA10b.t0 9.29658
R9098 QA10b QA10b.n0 4.69014
R9099 WE14.n0 WE14.t0 38.1951
R9100 WE14 WE14.n0 17.443
R9101 WE14.n0 WE14.t1 17.0773
R9102 D7.n0 D7.t1 31.0255
R9103 D7.n0 D7.t0 27.8969
R9104 D7 D7.n0 14.0521
R9105 D14.n0 D14.t1 31.0255
R9106 D14.n0 D14.t0 27.8969
R9107 D14 D14.n0 14.0361
R9108 QA0b.n0 QA0b.t1 13.1454
R9109 QA0b.n0 QA0b.t0 9.29658
R9110 QA0b QA0b.n0 4.69014
R9111 QB11b.n0 QB11b.t1 13.1454
R9112 QB11b.n0 QB11b.t0 9.29658
R9113 QB11b QB11b.n0 4.69014
R9114 D8.n0 D8.t1 31.0255
R9115 D8.n0 D8.t0 27.8969
R9116 D8 D8.n0 14.0538
R9117 QB3b.n0 QB3b.t1 13.1454
R9118 QB3b.n0 QB3b.t0 9.29658
R9119 QB3b QB3b.n0 4.69014
R9120 WE6.n0 WE6.t0 38.1951
R9121 WE6 WE6.n0 17.4366
R9122 WE6.n0 WE6.t1 17.0773
R9123 QB5b.n0 QB5b.t1 13.1454
R9124 QB5b.n0 QB5b.t0 9.29658
R9125 QB5b QB5b.n0 4.69014
R9126 QA8b.n0 QA8b.t1 13.1454
R9127 QA8b.n0 QA8b.t0 9.29658
R9128 QA8b QA8b.n0 4.69014
R9129 D0.n0 D0.t1 31.0255
R9130 D0.n0 D0.t0 27.8969
R9131 D0 D0.n0 14.0505
R9132 QA14b.n0 QA14b.t1 13.1454
R9133 QA14b.n0 QA14b.t0 9.29658
R9134 QA14b QA14b.n0 4.69014
R9135 D11.n0 D11.t1 31.0255
R9136 D11.n0 D11.t0 27.8969
R9137 D11 D11.n0 14.0425
R9138 QB15b.n0 QB15b.t1 13.1454
R9139 QB15b.n0 QB15b.t0 9.29658
R9140 QB15b QB15b.n0 4.69014
R9141 WE4.n0 WE4.t1 38.1951
R9142 WE4 WE4.n0 17.4366
R9143 WE4.n0 WE4.t0 17.0773
R9144 WE8.n0 WE8.t1 38.1951
R9145 WE8 WE8.n0 17.4495
R9146 WE8.n0 WE8.t0 17.0773
R9147 QB1b.n0 QB1b.t1 13.1454
R9148 QB1b.n0 QB1b.t0 9.29658
R9149 QB1b QB1b.n0 4.69014
R9150 WE9.n0 WE9.t1 38.1951
R9151 WE9 WE9.n0 17.4366
R9152 WE9.n0 WE9.t0 17.0773
R9153 D12.n0 D12.t1 31.0255
R9154 D12.n0 D12.t0 27.8969
R9155 D12 D12.n0 14.0425
R9156 D10.n0 D10.t1 31.0255
R9157 D10.n0 D10.t0 27.8969
R9158 D10 D10.n0 14.0393
R9159 WE15.n0 WE15.t0 38.1951
R9160 WE15 WE15.n0 17.4511
R9161 WE15.n0 WE15.t1 17.0773
R9162 WE11.n0 WE11.t0 38.1951
R9163 WE11 WE11.n0 17.4446
R9164 WE11.n0 WE11.t1 17.0773
R9165 QA5b.n0 QA5b.t1 13.1454
R9166 QA5b.n0 QA5b.t0 9.29658
R9167 QA5b QA5b.n0 4.69014
R9168 QB9b.n0 QB9b.t1 13.1454
R9169 QB9b.n0 QB9b.t0 9.29658
R9170 QB9b QB9b.n0 4.69014
R9171 QA12b.n0 QA12b.t1 13.1454
R9172 QA12b.n0 QA12b.t0 9.29658
R9173 QA12b QA12b.n0 4.69014
R9174 WE3.n0 WE3.t1 38.1951
R9175 WE3 WE3.n0 17.4334
R9176 WE3.n0 WE3.t0 17.0773
R9177 WE5.n0 WE5.t0 38.1951
R9178 WE5 WE5.n0 17.427
R9179 WE5.n0 WE5.t1 17.0773
R9180 D1.n0 D1.t1 31.0255
R9181 D1.n0 D1.t0 27.8969
R9182 D1 D1.n0 14.0538
R9183 QA15b.n0 QA15b.t1 13.1454
R9184 QA15b.n0 QA15b.t0 9.29658
R9185 QA15b QA15b.n0 4.69014
R9186 QA1b.n0 QA1b.t1 13.1454
R9187 QA1b.n0 QA1b.t0 9.29658
R9188 QA1b QA1b.n0 4.69014
R9189 QB13b.n0 QB13b.t1 13.1454
R9190 QB13b.n0 QB13b.t0 9.29658
R9191 QB13b QB13b.n0 4.69014
R9192 QA9b.n0 QA9b.t1 13.1454
R9193 QA9b.n0 QA9b.t0 9.29658
R9194 QA9b QA9b.n0 4.69014
R9195 QA7b.n0 QA7b.t1 13.1454
R9196 QA7b.n0 QA7b.t0 9.29658
R9197 QA7b QA7b.n0 4.69014
R9198 WE12.n0 WE12.t1 38.1951
R9199 WE12 WE12.n0 17.4446
R9200 WE12.n0 WE12.t0 17.0773
R9201 D3.n0 D3.t1 31.0255
R9202 D3.n0 D3.t0 27.8969
R9203 D3 D3.n0 14.057
R9204 QB2b.n0 QB2b.t1 13.1454
R9205 QB2b.n0 QB2b.t0 9.29658
R9206 QB2b QB2b.n0 4.69014
R9207 D5.n0 D5.t1 31.0255
R9208 D5.n0 D5.t0 27.8969
R9209 D5 D5.n0 14.0409
R9210 QB4b.n0 QB4b.t1 13.1454
R9211 QB4b.n0 QB4b.t0 9.29658
R9212 QB4b QB4b.n0 4.69014
R9213 QA3b.n0 QA3b.t1 13.1454
R9214 QA3b.n0 QA3b.t0 9.29658
R9215 QA3b QA3b.n0 4.69014
R9216 QA11b.n0 QA11b.t1 13.1454
R9217 QA11b.n0 QA11b.t0 9.29658
R9218 QA11b QA11b.n0 4.69014
C0 a_36002_4096# a_35269_3750# 0.12913f
C1 a_8381_6978# VDD 0.26764f
C2 a_30629_4534# RA8 0.1633f
C3 a_2498_4064# a_2364_3750# 0.68196f
C4 a_22909_9238# a_23213_9238# 0.40203f
C5 a_23642_7232# a_22909_6886# 0.12913f
C6 a_21170_3124# VDD 0.28227f
C7 a_36972_6886# VDD 0.41797f
C8 a_12512_n1738# WEM 0.29267f
C9 VDD RB15 2.94964f
C10 a_20437_1398# RA12 0.14389f
C11 a_36972_4534# VDD 0.41797f
C12 a_7442_5632# VDD 0.41955f
C13 a_18269_n170# VDD 0.26764f
C14 a_20437_4534# a_21170_4692# 0.12913f
C15 a_13021_2182# VDD 0.27315f
C16 a_19802_2496# a_20437_2182# 0.13953f
C17 a_38045_6978# a_37741_6886# 0.40203f
C18 a_8810_1556# RB12 0.1782f
C19 a_965_6102# VDD 0.26764f
C20 a_22909_1398# VDD 0.27315f
C21 a_36002_5664# VDD 0.28275f
C22 a_17330_928# VDD 0.41955f
C23 a_5605_6886# RA5 0.14389f
C24 a_30325_4534# a_30629_4534# 0.40203f
C25 a_27218_9428# a_27853_9238# 0.13953f
C26 a_5605_n170# VDD 0.27315f
C27 a_7442_5632# a_8077_5318# 0.13953f
C28 a_15797_10806# VDD 0.26763f
C29 a_15797_n862# a_15493_n954# 0.40203f
C30 a_5909_3842# VDD 0.26764f
C31 a_34500_2966# VDD 0.41797f
C32 a_7442_928# VDD 0.41955f
C33 a_37741_n954# VDD 0.27315f
C34 a_3866_7828# VDD 0.28227f
C35 a_10549_5318# RA7 0.14389f
C36 a_32797_10806# VDD 0.27315f
C37 a_34500_3750# VDD 0.41797f
C38 a_27218_928# a_27853_614# 0.13953f
C39 a_15493_3750# RA9 0.14389f
C40 a_4970_2496# VDD 0.41955f
C41 a_23213_7670# VDD 0.26764f
C42 a_32028_1398# VDD 0.41797f
C43 a_37106_9428# a_36972_9238# 0.68196f
C44 a_19802_20# a_20437_n170# 0.13953f
C45 a_5605_6102# VDD 0.27315f
C46 a_3437_10114# RA1 0.1633f
C47 a_20437_2182# RA11 0.14389f
C48 a_33530_2528# VDD 0.28227f
C49 a_22909_9238# RA2 0.14389f
C50 a_15493_614# VDD 0.27315f
C51 a_30629_706# RA13 0.1633f
C52 a_29690_n640# VDD 0.41954f
C53 a_11282_9396# RB2 0.1782f
C54 a_n108_10806# VDD 0.41823f
C55 a_8810_8800# VDD 0.28275f
C56 a_26114_10368# VDD 0.28227f
C57 a_18698_10368# RB1 0.1782f
C58 a_21170_4096# a_20437_3750# 0.12913f
C59 a_10853_4534# RA8 0.1633f
C60 a_38045_8546# VDD 0.26764f
C61 VDD RB6 2.79986f
C62 a_37106_3156# a_37741_2966# 0.13953f
C63 a_13021_9238# a_13325_9238# 0.40203f
C64 a_34634_7860# a_34500_7670# 0.68196f
C65 a_8810_7232# a_8077_6886# 0.12913f
C66 a_35573_3842# a_35269_3750# 0.40203f
C67 a_7308_6886# VDD 0.41797f
C68 a_32797_4534# RA8 0.14389f
C69 a_10549_4534# a_11282_4692# 0.12913f
C70 a_24746_6292# a_25381_6102# 0.13953f
C71 a_4970_928# a_4836_614# 0.68196f
C72 a_4970_2496# a_5605_2182# 0.13953f
C73 a_2364_10806# WE0CLK 0.22071f
C74 a_20741_2966# VDD 0.26764f
C75 a_23213_6978# a_22909_6886# 0.40203f
C76 a_37106_7200# VDD 0.41955f
C77 a_12008_n1782# WEM 0.23385f
C78 a_21170_4692# RB8 0.1782f
C79 a_38474_6260# RB6 0.1782f
C80 a_35573_n862# RA15 0.1633f
C81 a_20437_n170# VDD 0.27315f
C82 a_6338_5664# VDD 0.28227f
C83 a_37106_4724# VDD 0.41955f
C84 a_34634_10996# a_34500_10806# 0.68196f
C85 a_20437_4534# a_20741_4534# 0.40203f
C86 a_12386_9428# a_13021_9238# 0.13953f
C87 a_34634_8768# a_34500_8454# 0.68196f
C88 a_8077_n954# VDD 0.27315f
C89 a_16952_n1782# a_17456_n1738# 0.67695f
C90 a_17965_10022# VDD 0.27315f
C91 a_38045_1398# RA12 0.1633f
C92 a_3133_6102# VDD 0.27315f
C93 a_38474_n12# VDD 0.27344f
C94 a_35573_5410# VDD 0.26764f
C95 a_16226_960# VDD 0.28275f
C96 a_32162_6292# a_32028_6102# 0.68196f
C97 a_4836_3750# VDD 0.41797f
C98 a_17965_10806# VDD 0.27315f
C99 a_12386_928# a_13021_614# 0.13953f
C100 a_34634_3156# VDD 0.41955f
C101 a_23642_9396# VDD 0.28227f
C102 RB9 RB10 0.39209f
C103 VDD D13 0.36033f
C104 WE10 RA10 0.10549f
C105 a_3437_7670# VDD 0.26764f
C106 a_7442_9428# a_7308_9238# 0.68196f
C107 a_29690_n640# a_30325_n954# 0.13953f
C108 a_34634_4064# VDD 0.41955f
C109 a_3866_2528# VDD 0.28227f
C110 a_25381_7670# VDD 0.27315f
C111 a_32162_1588# VDD 0.41955f
C112 a_33530_10368# a_32797_10022# 0.12913f
C113 a_n1652_1046# WE13 0.10075f
C114 a_15493_6886# VDD 0.27315f
C115 a_5701_n1738# D2 0.11075f
C116 a_20741_8546# RA3 0.1633f
C117 a_26_10336# a_n108_10022# 0.68196f
C118 a_33101_2274# VDD 0.26764f
C119 a_661_n170# a_1394_n12# 0.12913f
C120 a_29690_4724# a_29556_4534# 0.68196f
C121 a_3133_10806# a_3866_10964# 0.12913f
C122 a_6338_4096# a_5605_3750# 0.12913f
C123 a_28586_n608# VDD 0.28233f
C124 a_8381_n170# RA14 0.1633f
C125 a_25685_6978# RA5 0.1633f
C126 a_16226_960# RB13 0.1782f
C127 a_8381_8546# VDD 0.26764f
C128 a_23213_7670# RA4 0.1633f
C129 a_1394_n12# RB14 0.1782f
C130 a_22274_3156# a_22909_2966# 0.13953f
C131 a_4970_7860# a_4836_7670# 0.68196f
C132 a_25685_10114# VDD 0.26764f
C133 a_20741_3842# a_20437_3750# 0.40203f
C134 a_36002_8800# RB3 0.1782f
C135 a_30629_5410# RA7 0.1633f
C136 a_13021_4534# RA8 0.14389f
C137 a_21170_4692# VDD 0.28227f
C138 a_36972_8454# VDD 0.41797f
C139 a_9914_6292# a_10549_6102# 0.13953f
C140 a_32162_5632# a_32028_5318# 0.68196f
C141 a_8381_6978# a_8077_6886# 0.40203f
C142 a_7442_7200# VDD 0.41955f
C143 a_36972_6102# VDD 0.41797f
C144 a_13021_3750# VDD 0.27315f
C145 a_35573_3842# RA9 0.1633f
C146 a_5909_n862# RA15 0.1633f
C147 a_33530_7828# RB4 0.1782f
C148 a_14858_10996# a_14724_10806# 0.68196f
C149 a_10549_4534# a_10853_4534# 0.40203f
C150 a_27218_3156# a_27084_2966# 0.68196f
C151 a_19802_8768# a_19668_8454# 0.68196f
C152 a_8077_614# VDD 0.27315f
C153 a_2498_10996# WE0CLK 0.28565f
C154 a_22909_2966# VDD 0.27315f
C155 a_965_7670# VDD 0.26764f
C156 a_36002_7232# VDD 0.28275f
C157 a_10040_n1738# WEM 0.29267f
C158 a_37106_10336# a_36972_10022# 0.68196f
C159 a_33101_2966# RA10 0.1633f
C160 a_5909_5410# VDD 0.26764f
C161 a_34500_4534# VDD 0.41797f
C162 VDD RB11 2.80275f
C163 RA5 RB5 18.9728f
C164 a_2498_6292# a_2364_6102# 0.68196f
C165 a_37106_7200# a_37741_6886# 0.13953f
C166 a_3866_9396# VDD 0.28227f
C167 a_21170_n608# RB15 0.1782f
C168 a_20533_n1738# WEM 0.14287f
C169 a_38045_n170# VDD 0.26764f
C170 a_34500_5318# VDD 0.41797f
C171 a_15797_706# VDD 0.26764f
C172 a_26_1588# VDD 0.41955f
C173 a_14858_n640# a_15493_n954# 0.13953f
C174 a_4970_4064# VDD 0.41955f
C175 a_32028_2966# VDD 0.41797f
C176 a_23213_9238# VDD 0.26764f
C177 a_5605_7670# VDD 0.27315f
C178 a_5909_n170# RA14 0.1633f
C179 a_24746_1588# a_24612_1398# 0.68196f
C180 a_18698_10368# a_17965_10022# 0.12913f
C181 a_33530_4096# VDD 0.28227f
C182 a_3437_2274# VDD 0.26764f
C183 a_29556_1398# VDD 0.41797f
C184 a_33101_10114# a_32797_10022# 0.40203f
C185 a_32028_2182# VDD 0.41797f
C186 a_3437_7670# RA4 0.1633f
C187 a_7442_3156# a_8077_2966# 0.13953f
C188 a_29690_2496# a_29556_2182# 0.68196f
C189 a_5909_3842# a_5605_3750# 0.40203f
C190 a_28157_n862# VDD 0.26771f
C191 a_10549_n170# RA14 0.14389f
C192 a_6338_8800# RB3 0.1782f
C193 a_7308_8454# VDD 0.41797f
C194 a_25381_7670# RA4 0.14389f
C195 a_17330_5632# a_17196_5318# 0.68196f
C196 a_24612_10022# VDD 0.41797f
C197 a_38474_8800# a_37741_8454# 0.12913f
C198 a_11282_7232# RB5 0.1782f
C199 a_5909_3842# RA9 0.1633f
C200 a_13754_7828# RB4 0.1782f
C201 a_36972_10806# VDD 0.41797f
C202 a_20741_4534# VDD 0.26764f
C203 a_37106_8768# VDD 0.41955f
C204 a_30325_6102# a_31058_6260# 0.12913f
C205 a_4970_8768# a_4836_8454# 0.68196f
C206 a_661_1398# a_965_1398# 0.40203f
C207 VDD RA2 3.36972f
C208 RA0 RA1 0.33341f
C209 a_34634_4064# a_35269_3750# 0.13953f
C210 a_6338_7232# VDD 0.28227f
C211 a_37106_6292# VDD 0.41955f
C212 a_16226_5664# RB7 0.1782f
C213 a_661_6886# RA5 0.14389f
C214 a_10853_2274# RA11 0.1633f
C215 a_22274_10336# a_22140_10022# 0.68196f
C216 a_13325_2966# RA10 0.1633f
C217 a_661_10022# VDD 0.27315f
C218 a_27853_614# RA13 0.14389f
C219 a_27218_928# a_27084_614# 0.68196f
C220 a_31058_10964# RB0 0.1782f
C221 a_21170_4096# RB9 0.1782f
C222 a_22274_7200# a_22909_6886# 0.13953f
C223 a_3133_7670# VDD 0.27315f
C224 a_35573_6978# VDD 0.26764f
C225 a_9536_n1782# WEM 0.23385f
C226 a_3437_n170# RA14 0.1633f
C227 a_35269_2966# RA10 0.14389f
C228 a_34634_4724# VDD 0.41955f
C229 a_4836_5318# VDD 0.41797f
C230 a_22909_10022# RA1 0.14389f
C231 a_26114_2528# RB11 0.1782f
C232 a_3437_9238# VDD 0.26764f
C233 a_26_2496# VDD 0.41955f
C234 a_23642_3124# RB10 0.1782f
C235 a_34634_5632# VDD 0.41955f
C236 a_14724_614# VDD 0.41797f
C237 a_27853_8454# RA3 0.14389f
C238 a_3866_10368# a_3133_10022# 0.12913f
C239 a_757_n1738# D0 0.11075f
C240 a_25381_9238# VDD 0.27315f
C241 a_32162_3156# VDD 0.41955f
C242 a_3866_4096# VDD 0.28227f
C243 a_965_7670# RA4 0.1633f
C244 a_32797_6886# RA5 0.14389f
C245 a_8077_n170# RA14 0.14389f
C246 a_18269_10114# a_17965_10022# 0.40203f
C247 a_15493_8454# VDD 0.27315f
C248 VDD D0 0.35946f
C249 RB0 CLK 0.18385f
C250 a_33101_3842# VDD 0.26764f
C251 a_9914_10996# a_10549_10806# 0.13953f
C252 a_965_10806# RA0 0.1633f
C253 a_29690_1588# VDD 0.41955f
C254 a_2364_2182# VDD 0.41797f
C255 a_37741_5318# RA7 0.14389f
C256 a_14858_2496# a_14724_2182# 0.68196f
C257 a_36002_5664# a_35269_5318# 0.12913f
C258 a_32162_2496# VDD 0.41955f
C259 a_13021_n954# RA15 0.14389f
C260 a_5605_7670# RA4 0.14389f
C261 a_8381_706# VDD 0.26764f
C262 a_2498_5632# a_2364_5318# 0.68196f
C263 a_21170_6260# VDD 0.28227f
C264 a_23642_8800# a_22909_8454# 0.12913f
C265 a_27084_n954# VDD 0.4212f
C266 a_30629_10114# RA1 0.1633f
C267 a_4970_928# a_5605_614# 0.13953f
C268 a_n1652_10806# WE0 0.10075f
C269 a_36972_7670# VDD 0.41797f
C270 a_7442_8768# VDD 0.41955f
C271 a_20437_6102# a_21170_6260# 0.12913f
C272 a_13021_5318# VDD 0.27315f
C273 a_24746_10336# VDD 0.41955f
C274 a_19802_4064# a_20437_3750# 0.13953f
C275 a_38045_8546# a_37741_8454# 0.40203f
C276 a_n1652_4534# WE8 0.10075f
C277 a_7442_10336# a_7308_10022# 0.68196f
C278 a_37106_10996# VDD 0.41954f
C279 a_22909_4534# VDD 0.27315f
C280 a_965_9238# VDD 0.26764f
C281 a_36002_8800# VDD 0.28275f
C282 a_25685_6102# RA6 0.1633f
C283 a_30325_6102# a_30629_6102# 0.40203f
C284 a_18269_n170# RA14 0.1633f
C285 a_12386_928# a_12252_614# 0.68196f
C286 a_16226_10964# RB0 0.1782f
C287 a_7442_7200# a_8077_6886# 0.13953f
C288 a_5909_6978# VDD 0.26764f
C289 a_34500_6102# VDD 0.41797f
C290 a_15493_2966# RA10 0.14389f
C291 a_27853_1398# a_28586_1556# 0.12913f
C292 a_n108_10806# WE0CLK 0.22071f
C293 a_34500_6886# VDD 0.41797f
C294 a_7568_n1738# WEM 0.29267f
C295 a_5605_n170# RA14 0.14389f
C296 a_3866_3124# RB10 0.1782f
C297 a_26_3156# VDD 0.41955f
C298 a_36002_6260# RB6 0.1782f
C299 a_4970_5632# VDD 0.41955f
C300 a_32028_4534# VDD 0.41797f
C301 a_28586_n12# RB14 0.1782f
C302 a_10549_2182# VDD 0.27315f
C303 a_5605_9238# VDD 0.27315f
C304 VDD RA7 3.36997f
C305 a_35573_1398# RA12 0.1633f
C306 a_18698_1556# VDD 0.28227f
C307 a_33530_5664# VDD 0.28227f
C308 a_36002_n12# VDD 0.28227f
C309 a_3133_6886# RA5 0.14389f
C310 a_14858_928# VDD 0.41955f
C311 a_3437_10114# a_3133_10022# 0.40203f
C312 a_n1652_1398# VDD 0.47501f
C313 a_33530_2528# a_32797_2182# 0.12913f
C314 a_3437_3842# VDD 0.26764f
C315 a_29556_2966# VDD 0.41797f
C316 a_3133_7670# RA4 0.14389f
C317 a_35269_n954# VDD 0.27315f
C318 a_n1652_1046# VDD 0.47501f
C319 a_8077_5318# RA7 0.14389f
C320 a_10549_n170# a_11282_n12# 0.12913f
C321 a_21170_5664# a_20437_5318# 0.12913f
C322 a_28586_10964# VDD 0.28226f
C323 a_32028_3750# VDD 0.41797f
C324 a_3133_10806# RA0 0.14389f
C325 a_13021_3750# RA9 0.14389f
C326 a_2498_2496# VDD 0.41955f
C327 a_27084_1398# VDD 0.41797f
C328 a_37106_4724# a_37741_4534# 0.13953f
C329 a_32162_10336# a_32797_10022# 0.13953f
C330 a_34634_9428# a_34500_9238# 0.68196f
C331 a_8810_8800# a_8077_8454# 0.12913f
C332 a_35573_5410# a_35269_5318# 0.40203f
C333 a_965_10114# RA1 0.1633f
C334 a_17965_2182# RA11 0.14389f
C335 a_31058_2528# VDD 0.28275f
C336 a_10549_6102# a_11282_6260# 0.12913f
C337 a_13021_614# VDD 0.27315f
C338 a_28157_706# RA13 0.1633f
C339 a_24746_7860# a_25381_7670# 0.13953f
C340 a_3133_10806# a_3437_10806# 0.40203f
C341 VDD D15 0.35872f
C342 RA10 RB10 18.9728f
C343 RB5 CLK 0.18513f
C344 a_4970_4064# a_5605_3750# 0.13953f
C345 a_23213_8546# a_22909_8454# 0.40203f
C346 a_20741_6102# VDD 0.26764f
C347 a_27218_n640# VDD 0.41954f
C348 a_6338_8800# VDD 0.28227f
C349 a_37106_7860# VDD 0.41955f
C350 a_5909_6102# RA6 0.1633f
C351 a_20437_6102# a_20741_6102# 0.40203f
C352 a_24746_n640# a_24612_n954# 0.68196f
C353 a_23642_10368# VDD 0.28275f
C354 a_16226_10368# RB1 0.1782f
C355 a_10549_614# RA13 0.14389f
C356 a_23213_10806# RA0 0.1633f
C357 a_35573_8546# VDD 0.26764f
C358 a_3133_9238# VDD 0.27315f
C359 a_27853_6102# RA6 0.14389f
C360 a_17965_1398# a_18698_1556# 0.12913f
C361 a_35269_n170# a_36002_n12# 0.12913f
C362 a_32162_7860# a_32028_7670# 0.68196f
C363 a_20437_n170# RA14 0.14389f
C364 a_4836_6886# VDD 0.41797f
C365 a_34634_6292# VDD 0.41955f
C366 a_16226_6260# RB6 0.1782f
C367 a_26_4064# VDD 0.41955f
C368 a_27853_1398# a_28157_1398# 0.40203f
C369 a_34634_7200# VDD 0.41955f
C370 a_7064_n1782# WEM 0.23385f
C371 a_33101_n862# RA15 0.1633f
C372 a_15797_1398# RA12 0.1633f
C373 a_3866_5664# VDD 0.28227f
C374 a_16226_n12# VDD 0.28227f
C375 a_32162_4724# VDD 0.41955f
C376 a_18698_2528# a_17965_2182# 0.12913f
C377 a_n296_10806# WE0CLK 0.1412f
C378 a_18061_n1738# WEM 0.14287f
C379 a_14480_n1782# a_14984_n1738# 0.67695f
C380 a_5605_n954# VDD 0.27315f
C381 a_15493_10022# VDD 0.27315f
C382 a_37741_1398# RA12 0.14389f
C383 a_18269_1398# VDD 0.26764f
C384 a_35573_n170# VDD 0.26764f
C385 a_33101_5410# VDD 0.26764f
C386 a_13754_960# VDD 0.28227f
C387 a_n1652_10454# WE1 0.10075f
C388 a_34634_1588# a_35269_1398# 0.13953f
C389 a_29690_6292# a_29556_6102# 0.68196f
C390 a_6338_5664# a_5605_5318# 0.12913f
C391 a_33101_2274# a_32797_2182# 0.40203f
C392 a_2364_3750# VDD 0.41797f
C393 a_13754_10964# VDD 0.28226f
C394 a_29690_3156# VDD 0.41955f
C395 a_26114_1556# RB12 0.1782f
C396 a_22274_4724# a_22909_4534# 0.13953f
C397 a_17330_10336# a_17965_10022# 0.13953f
C398 a_4970_9428# a_4836_9238# 0.68196f
C399 a_20741_5410# a_20437_5318# 0.40203f
C400 a_10549_n170# a_10853_n170# 0.40203f
C401 a_32162_4064# VDD 0.41955f
C402 a_26114_960# a_25381_614# 0.12913f
C403 VDD RA12 3.36972f
C404 RA5 RA6 0.30166f
C405 a_661_2966# RA10 0.14389f
C406 a_1394_2528# VDD 0.28275f
C407 a_21170_7828# VDD 0.28227f
C408 a_27218_1588# VDD 0.41955f
C409 a_9914_7860# a_10549_7670# 0.13953f
C410 a_32162_7200# a_32028_6886# 0.68196f
C411 a_8381_8546# a_8077_8454# 0.40203f
C412 a_36972_9238# VDD 0.41797f
C413 a_13021_6886# VDD 0.27315f
C414 a_18269_8546# RA3 0.1633f
C415 a_30629_2274# VDD 0.26764f
C416 a_18269_9238# RA2 0.1633f
C417 a_10549_6102# a_10853_6102# 0.40203f
C418 a_9914_n640# a_9780_n954# 0.68196f
C419 a_27218_4724# a_27084_4534# 0.68196f
C420 a_n108_614# VDD 0.41823f
C421 a_22909_6102# VDD 0.27315f
C422 a_26114_n608# VDD 0.28233f
C423 a_8381_10806# RA0 0.1633f
C424 a_23213_6978# RA5 0.1633f
C425 a_13754_960# RB13 0.1782f
C426 a_31840_10806# WE0CLK 0.13896f
C427 a_34500_7670# VDD 0.41797f
C428 a_5909_8546# VDD 0.26764f
C429 a_8077_6102# RA6 0.14389f
C430 a_n1652_10454# CLK 0.25473f
C431 a_8077_1398# a_8810_1556# 0.12913f
C432 a_25381_n170# a_26114_n12# 0.12913f
C433 a_2498_7860# a_2364_7670# 0.68196f
C434 a_23213_10114# VDD 0.26764f
C435 a_37106_8768# a_37741_8454# 0.13953f
C436 a_33530_8800# RB3 0.1782f
C437 a_25381_10806# RA0 0.14389f
C438 a_28157_5410# RA7 0.1633f
C439 a_28586_9396# RB2 0.1782f
C440 a_34500_10806# VDD 0.41797f
C441 a_34500_8454# VDD 0.41797f
C442 a_17965_1398# a_18269_1398# 0.40203f
C443 a_35269_n170# a_35573_n170# 0.40203f
C444 a_26_4724# VDD 0.41955f
C445 a_4970_7200# VDD 0.41955f
C446 a_32028_6102# VDD 0.41797f
C447 RB10 CLK 0.18513f
C448 a_38474_7232# RB5 0.1782f
C449 a_10549_3750# VDD 0.27315f
C450 a_33101_3842# RA9 0.1633f
C451 a_3437_n862# RA15 0.1633f
C452 a_28157_4534# RA8 0.1633f
C453 a_24746_3156# a_24612_2966# 0.68196f
C454 a_38045_n170# RA14 0.1633f
C455 a_3866_2528# a_3133_2182# 0.12913f
C456 a_18698_3124# VDD 0.28227f
C457 a_33530_7232# VDD 0.28227f
C458 a_5096_n1738# WEM 0.29267f
C459 a_38045_2274# RA11 0.1633f
C460 a_n1652_2966# VDD 0.47501f
C461 a_17965_1398# RA12 0.14389f
C462 a_26_n640# a_n108_n954# 0.68196f
C463 a_29556_4534# VDD 0.41797f
C464 a_3437_5410# VDD 0.26764f
C465 a_15797_n170# VDD 0.26764f
C466 a_19802_1588# a_20437_1398# 0.13953f
C467 a_37741_1398# a_38474_1556# 0.12913f
C468 a_965_706# RA13 0.1633f
C469 a_18269_2274# a_17965_2182# 0.40203f
C470 a_36972_10806# WE0CLK 0.22066f
C471 a_n1652_2614# VDD 0.47501f
C472 a_18698_n608# RB15 0.1782f
C473 a_6338_1556# RB12 0.1782f
C474 VDD WE3 0.22649f
C475 WE1 RA1 0.10549f
C476 RB0 RB1 0.23766f
C477 a_20437_1398# VDD 0.27315f
C478 a_32028_5318# VDD 0.41797f
C479 a_37741_n170# VDD 0.27315f
C480 a_13325_706# VDD 0.26764f
C481 a_7442_4724# a_8077_4534# 0.13953f
C482 a_2498_10336# a_3133_10022# 0.13953f
C483 a_29690_4064# a_29556_3750# 0.68196f
C484 a_5909_5410# a_5605_5318# 0.40203f
C485 a_2498_4064# VDD 0.41955f
C486 a_27084_2966# VDD 0.41797f
C487 a_n1652_n522# WE15 0.10075f
C488 a_38474_1556# VDD 0.27344f
C489 a_22274_1588# a_22140_1398# 0.68196f
C490 a_17330_7200# a_17196_6886# 0.68196f
C491 a_26_2496# a_661_2182# 0.13953f
C492 a_28586_n608# a_27853_n954# 0.12913f
C493 a_31058_4096# VDD 0.28275f
C494 a_25685_706# a_25381_614# 0.40203f
C495 a_24612_1398# VDD 0.41797f
C496 a_20741_7670# VDD 0.26764f
C497 a_30325_7670# a_31058_7828# 0.12913f
C498 a_661_2966# a_965_2966# 0.40203f
C499 a_34634_5632# a_35269_5318# 0.13953f
C500 a_37106_9428# VDD 0.41955f
C501 a_19802_10996# a_20437_10806# 0.13953f
C502 a_17008_10806# WE0CLK 0.13896f
C503 a_29556_2182# VDD 0.41797f
C504 a_1394_7828# RB4 0.1782f
C505 a_20437_9238# RA2 0.14389f
C506 a_15493_n170# a_16226_n12# 0.12913f
C507 a_22274_8768# a_22909_8454# 0.13953f
C508 a_25685_n862# VDD 0.26771f
C509 a_3866_8800# RB3 0.1782f
C510 a_10549_10806# RA0 0.14389f
C511 VDD D2 0.36038f
C512 a_8810_9396# RB2 0.1782f
C513 a_4836_8454# VDD 0.41797f
C514 a_34634_7860# VDD 0.41955f
C515 a_8077_1398# a_8381_1398# 0.40203f
C516 a_26_20# VDD 0.41955f
C517 a_25381_n170# a_25685_n170# 0.40203f
C518 a_22140_10022# VDD 0.41797f
C519 a_26_5632# VDD 0.41955f
C520 a_8810_7232# RB5 0.1782f
C521 a_3437_3842# RA9 0.1633f
C522 a_34634_10996# VDD 0.41954f
C523 a_8381_4534# RA8 0.1633f
C524 a_34634_8768# VDD 0.41955f
C525 a_3866_7232# VDD 0.28227f
C526 a_32162_6292# VDD 0.41955f
C527 a_13754_5664# RB7 0.1782f
C528 a_9914_928# VDD 0.41955f
C529 a_8381_2274# RA11 0.1633f
C530 a_38045_10806# RA0 0.1633f
C531 a_30325_4534# RA8 0.14389f
C532 a_4970_1588# a_5605_1398# 0.13953f
C533 a_25381_614# RA13 0.14389f
C534 a_5909_706# a_5605_614# 0.40203f
C535 a_3437_2274# a_3133_2182# 0.40203f
C536 a_18269_2966# VDD 0.26764f
C537 a_18698_4096# RB9 0.1782f
C538 a_33101_6978# VDD 0.26764f
C539 a_4592_n1782# WEM 0.23385f
C540 a_4970_20# VDD 0.41955f
C541 a_18698_4692# RB8 0.1782f
C542 a_17965_n170# VDD 0.27315f
C543 a_2364_5318# VDD 0.41797f
C544 a_29690_4724# VDD 0.41955f
C545 a_32162_10996# a_32028_10806# 0.68196f
C546 a_37741_1398# a_38045_1398# 0.40203f
C547 a_14858_4064# a_14724_3750# 0.68196f
C548 a_20437_10022# RA1 0.14389f
C549 a_23642_2528# RB11 0.1782f
C550 a_37106_10996# WE0CLK 0.28565f
C551 a_36002_7232# a_35269_6886# 0.12913f
C552 a_32162_5632# VDD 0.41955f
C553 a_12252_614# VDD 0.41797f
C554 a_25381_8454# RA3 0.14389f
C555 a_2498_7200# a_2364_6886# 0.68196f
C556 a_37741_2182# VDD 0.27315f
C557 a_32162_2496# a_32797_2182# 0.13953f
C558 a_13754_n608# a_13021_n954# 0.12913f
C559 a_1394_4096# VDD 0.28275f
C560 a_27218_3156# VDD 0.41955f
C561 a_21170_9396# VDD 0.28227f
C562 a_38045_1398# VDD 0.26764f
C563 a_30325_6886# RA5 0.14389f
C564 a_965_8546# RA3 0.1633f
C565 a_20437_7670# a_21170_7828# 0.12913f
C566 a_13021_8454# VDD 0.27315f
C567 a_28157_n862# a_27853_n954# 0.40203f
C568 a_19802_5632# a_20437_5318# 0.13953f
C569 a_28157_10806# VDD 0.26763f
C570 a_30629_3842# VDD 0.26764f
C571 a_661_10806# RA0 0.14389f
C572 a_24746_1588# VDD 0.41955f
C573 a_22909_7670# VDD 0.27315f
C574 VDD WE8 0.22649f
C575 a_35269_5318# RA7 0.14389f
C576 a_30325_7670# a_30629_7670# 0.40203f
C577 a_7442_8768# a_8077_8454# 0.13953f
C578 a_34500_9238# VDD 0.41797f
C579 a_29690_2496# VDD 0.41955f
C580 a_10549_n954# RA15 0.14389f
C581 a_27853_2966# a_28586_3124# 0.12913f
C582 a_15493_n170# a_15797_n170# 0.40203f
C583 a_37837_n1738# D15 0.11075f
C584 a_24612_n954# VDD 0.4212f
C585 a_28157_10114# RA1 0.1633f
C586 a_26_6292# VDD 0.41955f
C587 a_4970_8768# VDD 0.41955f
C588 a_32028_7670# VDD 0.41797f
C589 a_20741_7670# RA4 0.1633f
C590 a_38045_9238# RA2 0.1633f
C591 a_10549_5318# VDD 0.27315f
C592 a_22274_10336# VDD 0.41955f
C593 a_10549_4534# RA8 0.14389f
C594 a_18698_4692# VDD 0.28227f
C595 a_33530_8800# VDD 0.28227f
C596 a_n1652_4534# VDD 0.47501f
C597 a_661_n954# VDD 0.27315f
C598 a_33530_4096# a_32797_3750# 0.12913f
C599 a_3437_6978# VDD 0.26764f
C600 a_29556_6102# VDD 0.41797f
C601 a_31058_7828# RB4 0.1782f
C602 RA10 RA11 0.33341f
C603 a_n1652_4182# VDD 0.47501f
C604 a_12386_10996# a_12252_10806# 0.68196f
C605 a_21170_7232# a_20437_6886# 0.12913f
C606 a_20437_2966# VDD 0.27315f
C607 a_32028_6886# VDD 0.41797f
C608 a_2624_n1738# WEM 0.29267f
C609 a_27218_20# a_27853_n170# 0.13953f
C610 a_n1652_8886# WE3 0.10075f
C611 a_2364_n170# VDD 0.41797f
C612 a_30629_2966# RA10 0.1633f
C613 a_2498_5632# VDD 0.41955f
C614 a_27084_4534# VDD 0.41797f
C615 a_8077_2182# VDD 0.27315f
C616 a_37106_6292# a_37741_6102# 0.13953f
C617 a_17330_2496# a_17965_2182# 0.13953f
C618 a_35573_6978# a_35269_6886# 0.40203f
C619 a_38474_3124# VDD 0.27344f
C620 a_15589_n1738# WEM 0.14287f
C621 a_31058_5664# VDD 0.28275f
C622 a_12386_928# VDD 0.41955f
C623 a_10549_7670# a_11282_7828# 0.12913f
C624 a_24746_9428# a_25381_9238# 0.13953f
C625 a_4970_5632# a_5605_5318# 0.13953f
C626 a_13325_n862# a_13021_n954# 0.40203f
C627 a_13325_10806# VDD 0.26763f
C628 a_24612_2966# VDD 0.41797f
C629 a_20741_9238# VDD 0.26764f
C630 a_32797_n954# VDD 0.27315f
C631 a_5605_5318# RA7 0.14389f
C632 a_35269_10806# a_36002_10964# 0.12913f
C633 a_20437_7670# a_20741_7670# 0.40203f
C634 a_9914_20# VDD 0.41955f
C635 a_29556_3750# VDD 0.41797f
C636 a_30325_10806# VDD 0.27315f
C637 a_24746_928# a_25381_614# 0.13953f
C638 a_10549_3750# RA9 0.14389f
C639 a_22140_1398# VDD 0.41797f
C640 a_17965_2966# a_18698_3124# 0.12913f
C641 a_32162_9428# a_32028_9238# 0.68196f
C642 a_34634_9428# VDD 0.41955f
C643 a_15493_2182# RA11 0.14389f
C644 a_28586_2528# VDD 0.28227f
C645 a_26_7200# VDD 0.41955f
C646 a_27853_2966# a_28157_2966# 0.40203f
C647 a_25685_706# RA13 0.1633f
C648 a_24746_n640# VDD 0.41954f
C649 a_1394_2528# a_661_2182# 0.12913f
C650 a_3866_8800# VDD 0.28227f
C651 a_32162_7860# VDD 0.41955f
C652 a_22909_7670# RA4 0.14389f
C653 VDD WE13 0.22649f
C654 RB5 RB6 0.39209f
C655 WE6 RA6 0.10549f
C656 a_n1652_n170# VDD 0.47501f
C657 a_21170_10368# VDD 0.28227f
C658 a_18698_4096# a_17965_3750# 0.12913f
C659 a_13754_10368# RB1 0.1782f
C660 a_11282_7828# RB4 0.1782f
C661 a_32028_10806# VDD 0.41797f
C662 a_18269_4534# VDD 0.26764f
C663 a_33101_8546# VDD 0.26764f
C664 a_34634_3156# a_35269_2966# 0.13953f
C665 a_29690_7860# a_29556_7670# 0.68196f
C666 a_6338_7232# a_5605_6886# 0.12913f
C667 a_33101_3842# a_32797_3750# 0.40203f
C668 a_2364_6886# VDD 0.41797f
C669 a_29690_6292# VDD 0.41955f
C670 a_26_10336# a_661_10022# 0.13953f
C671 a_10853_2966# RA10 0.1633f
C672 a_1394_960# VDD 0.28275f
C673 a_22274_6292# a_22909_6102# 0.13953f
C674 a_35573_n170# RA14 0.1633f
C675 a_2498_2496# a_3133_2182# 0.13953f
C676 a_20741_6978# a_20437_6886# 0.40203f
C677 a_32162_7200# VDD 0.41955f
C678 a_2120_n1782# WEM 0.23385f
C679 a_37741_3750# VDD 0.27315f
C680 a_30629_n862# RA15 0.1633f
C681 a_32797_2966# RA10 0.14389f
C682 a_27218_4724# VDD 0.41955f
C683 a_1394_5664# VDD 0.28275f
C684 a_9914_9428# a_10549_9238# 0.13953f
C685 a_32162_8768# a_32028_8454# 0.68196f
C686 a_34500_10806# WE0CLK 0.22071f
C687 a_38045_2966# VDD 0.26764f
C688 a_21170_3124# RB10 0.1782f
C689 a_12008_n1782# a_12512_n1738# 0.67695f
C690 a_3133_n954# VDD 0.27315f
C691 a_38474_4692# RB8 0.1782f
C692 a_13021_10022# VDD 0.27315f
C693 a_30629_5410# VDD 0.26764f
C694 a_11282_960# VDD 0.28227f
C695 a_27853_10806# a_28586_10964# 0.12913f
C696 a_10549_7670# a_10853_7670# 0.40203f
C697 a_27218_6292# a_27084_6102# 0.68196f
C698 a_15493_10806# VDD 0.27315f
C699 a_24746_3156# VDD 0.41955f
C700 a_22909_9238# VDD 0.27315f
C701 a_36002_1556# VDD 0.28227f
C702 a_8077_2966# a_8810_3124# 0.12913f
C703 a_7308_n170# VDD 0.41797f
C704 a_2498_9428# a_2364_9238# 0.68196f
C705 a_27218_n640# a_27853_n954# 0.13953f
C706 a_29690_4064# VDD 0.41955f
C707 a_1394_960# RB13 0.1782f
C708 a_22274_1588# VDD 0.41955f
C709 a_17965_2966# a_18269_2966# 0.40203f
C710 a_31058_10368# a_30325_10022# 0.12913f
C711 a_26_7860# VDD 0.41955f
C712 RA1 RB1 18.9728f
C713 VDD RB3 2.80275f
C714 a_32028_9238# VDD 0.41797f
C715 a_10549_6886# VDD 0.27315f
C716 a_15797_8546# RA3 0.1633f
C717 a_28157_2274# VDD 0.26764f
C718 a_24746_4724# a_24612_4534# 0.68196f
C719 a_3866_4096# a_3133_3750# 0.12913f
C720 a_18698_6260# VDD 0.28227f
C721 a_23642_n608# VDD 0.28281f
C722 a_29690_10996# a_30325_10806# 0.13953f
C723 a_14858_20# VDD 0.41955f
C724 a_2498_1588# a_3133_1398# 0.13953f
C725 a_n1652_6102# VDD 0.47501f
C726 a_20741_6978# RA5 0.1633f
C727 a_11282_960# RB13 0.1782f
C728 a_3437_8546# VDD 0.26764f
C729 a_29556_7670# VDD 0.41797f
C730 a_19802_3156# a_20437_2966# 0.13953f
C731 a_37741_2966# a_38474_3124# 0.12913f
C732 a_20741_10114# VDD 0.26764f
C733 a_18269_3842# a_17965_3750# 0.40203f
C734 a_n1652_5750# VDD 0.47501f
C735 a_31058_8800# RB3 0.1782f
C736 a_25685_5410# RA7 0.1633f
C737 a_20437_4534# VDD 0.27315f
C738 a_32162_10996# VDD 0.41954f
C739 a_32028_8454# VDD 0.41797f
C740 a_23213_6102# RA6 0.1633f
C741 a_7442_6292# a_8077_6102# 0.13953f
C742 a_29690_5632# a_29556_5318# 0.68196f
C743 a_15797_n170# RA14 0.1633f
C744 a_5909_6978# a_5605_6886# 0.40203f
C745 a_2498_7200# VDD 0.41955f
C746 a_27084_6102# VDD 0.41797f
C747 a_36002_7232# RB5 0.1782f
C748 a_8077_3750# VDD 0.27315f
C749 a_30629_3842# RA9 0.1633f
C750 a_13021_2966# RA10 0.14389f
C751 a_38474_4692# VDD 0.27344f
C752 a_17330_8768# a_17196_8454# 0.68196f
C753 a_22274_3156# a_22140_2966# 0.68196f
C754 VDD D4 0.36033f
C755 a_37741_n170# RA14 0.14389f
C756 a_26_4064# a_661_3750# 0.13953f
C757 a_31058_7232# VDD 0.28275f
C758 a_152_n1738# WEM 0.29274f
C759 a_35573_2274# RA11 0.1633f
C760 a_34634_10336# a_34500_10022# 0.68196f
C761 a_33530_6260# RB6 0.1782f
C762 a_24612_4534# VDD 0.41797f
C763 a_26114_n12# RB14 0.1782f
C764 a_20437_10806# a_21170_10964# 0.12913f
C765 a_30325_9238# a_31058_9396# 0.12913f
C766 a_661_4534# a_965_4534# 0.40203f
C767 a_34634_10996# WE0CLK 0.28565f
C768 a_34634_7200# a_35269_6886# 0.13953f
C769 a_16226_n608# RB15 0.1782f
C770 a_33101_1398# RA12 0.1633f
C771 a_2498_10996# a_3133_10806# 0.13953f
C772 a_16226_1556# VDD 0.28227f
C773 a_33530_n12# VDD 0.28227f
C774 a_29556_5318# VDD 0.41797f
C775 a_10853_706# VDD 0.26764f
C776 a_12386_n640# a_13021_n954# 0.13953f
C777 a_22140_2966# VDD 0.41797f
C778 a_32893_n1738# D13 0.11075f
C779 a_35573_1398# VDD 0.26764f
C780 a_8077_2966# a_8381_2966# 0.40203f
C781 a_16226_10368# a_15493_10022# 0.12913f
C782 a_26_1588# a_661_1398# 0.13953f
C783 a_19802_1588# a_19668_1398# 0.68196f
C784 a_26_8768# VDD 0.41955f
C785 a_28586_4096# VDD 0.28227f
C786 a_19668_1398# VDD 0.41797f
C787 RA15 RB15 18.9728f
C788 a_30629_10114# a_30325_10022# 0.40203f
C789 a_32162_9428# VDD 0.41955f
C790 a_27084_2182# VDD 0.41797f
C791 a_4970_3156# a_5605_2966# 0.13953f
C792 a_27218_2496# a_27084_2182# 0.68196f
C793 a_3437_3842# a_3133_3750# 0.40203f
C794 a_18269_6102# VDD 0.26764f
C795 a_23213_n862# VDD 0.26771f
C796 a_1394_8800# RB3 0.1782f
C797 a_12252_n170# VDD 0.41797f
C798 a_2364_8454# VDD 0.41797f
C799 a_29690_7860# VDD 0.41955f
C800 a_3437_6102# RA6 0.1633f
C801 a_37741_n954# RA15 0.14389f
C802 a_35573_9238# RA2 0.1633f
C803 a_14858_5632# a_14724_5318# 0.68196f
C804 a_37741_2966# a_38045_2966# 0.40203f
C805 a_19668_10022# VDD 0.41797f
C806 a_36002_8800# a_35269_8454# 0.12913f
C807 VDD RB8 2.79986f
C808 a_6338_7232# RB5 0.1782f
C809 a_n1652_10806# CLK 0.25473f
C810 a_32162_8768# VDD 0.41955f
C811 a_25381_6102# RA6 0.14389f
C812 a_2498_8768# a_2364_8454# 0.68196f
C813 a_37741_5318# VDD 0.27315f
C814 a_17965_n170# RA14 0.14389f
C815 a_32162_4064# a_32797_3750# 0.13953f
C816 a_1394_7232# VDD 0.28275f
C817 a_27218_6292# VDD 0.41955f
C818 a_11282_5664# RB7 0.1782f
C819 a_5909_2274# RA11 0.1633f
C820 a_19802_10336# a_19668_10022# 0.68196f
C821 a_13754_6260# RB6 0.1782f
C822 a_38045_4534# VDD 0.26764f
C823 a_19802_20# VDD 0.41955f
C824 a_13021_10806# a_13754_10964# 0.12913f
C825 a_20437_9238# a_21170_9396# 0.12913f
C826 a_22909_614# RA13 0.14389f
C827 a_24746_928# a_24612_614# 0.68196f
C828 a_28586_10964# RB0 0.1782f
C829 a_16226_4096# RB9 0.1782f
C830 a_19802_7200# a_20437_6886# 0.13953f
C831 a_30629_6978# VDD 0.26764f
C832 a_661_5318# RA7 0.14389f
C833 a_1394_960# a_661_614# 0.12913f
C834 a_13325_1398# RA12 0.1633f
C835 a_13754_n12# VDD 0.28227f
C836 a_24746_4724# VDD 0.41955f
C837 a_17965_10022# RA1 0.14389f
C838 a_30325_9238# a_30629_9238# 0.40203f
C839 a_21170_2528# RB11 0.1782f
C840 a_36002_3124# VDD 0.28227f
C841 a_13117_n1738# WEM 0.14287f
C842 a_35269_1398# RA12 0.14389f
C843 a_14858_20# a_15493_n170# 0.13953f
C844 a_15797_1398# VDD 0.26764f
C845 a_29690_5632# VDD 0.41955f
C846 a_33101_n170# VDD 0.26764f
C847 a_22909_8454# RA3 0.14389f
C848 a_27853_4534# a_28586_4692# 0.12913f
C849 a_35269_2182# VDD 0.27315f
C850 RB10 RB11 0.23766f
C851 WE11 RA11 0.10549f
C852 a_22274_3156# VDD 0.41955f
C853 a_23642_1556# RB12 0.1782f
C854 a_26_9428# VDD 0.41955f
C855 a_37741_1398# VDD 0.27315f
C856 a_27853_6886# RA5 0.14389f
C857 a_35269_10806# a_35573_10806# 0.40203f
C858 a_15797_10114# a_15493_10022# 0.40203f
C859 a_10549_8454# VDD 0.27315f
C860 a_28157_3842# VDD 0.26764f
C861 a_965_6102# RA6 0.1633f
C862 a_18698_7828# VDD 0.28227f
C863 a_19802_1588# VDD 0.41955f
C864 a_32797_5318# RA7 0.14389f
C865 a_12386_2496# a_12252_2182# 0.68196f
C866 a_n1652_7670# VDD 0.47501f
C867 a_33530_5664# a_32797_5318# 0.12913f
C868 a_29556_9238# VDD 0.41797f
C869 a_27218_2496# VDD 0.41955f
C870 a_37741_3750# RA9 0.14389f
C871 a_n1652_7318# VDD 0.47501f
C872 a_8077_n954# RA15 0.14389f
C873 a_15797_9238# RA2 0.1633f
C874 a_21170_8800# a_20437_8454# 0.12913f
C875 a_20437_6102# VDD 0.27315f
C876 a_22140_n954# VDD 0.4212f
C877 a_25685_10114# RA1 0.1633f
C878 a_27084_7670# VDD 0.41797f
C879 a_2498_8768# VDD 0.41955f
C880 a_5605_6102# RA6 0.14389f
C881 a_37741_9238# RA2 0.14389f
C882 a_37741_614# VDD 0.27315f
C883 a_37106_7860# a_37741_7670# 0.13953f
C884 a_8077_5318# VDD 0.27315f
C885 a_19802_10336# VDD 0.41955f
C886 a_17330_4064# a_17965_3750# 0.13953f
C887 a_35573_8546# a_35269_8454# 0.40203f
C888 a_38474_6260# VDD 0.27344f
C889 a_4970_10336# a_4836_10022# 0.68196f
C890 a_26114_9396# RB2 0.1782f
C891 a_29556_10806# VDD 0.41797f
C892 a_31058_8800# VDD 0.28275f
C893 a_5605_10806# a_6338_10964# 0.12913f
C894 a_10549_9238# a_11282_9396# 0.12913f
C895 a_37106_n640# a_36972_n954# 0.68196f
C896 a_13754_10964# RB0 0.1782f
C897 a_n1652_2966# WE10 0.10075f
C898 a_4970_7200# a_5605_6886# 0.13953f
C899 a_24612_6102# VDD 0.41797f
C900 a_35573_10806# RA0 0.1633f
C901 a_25685_4534# RA8 0.1633f
C902 a_17196_n170# VDD 0.41797f
C903 a_20437_9238# a_20741_9238# 0.40203f
C904 a_16226_3124# VDD 0.28227f
C905 a_29556_6886# VDD 0.41797f
C906 a_n352_n1782# WEM 0.24365f
C907 RA6 RB6 18.9728f
C908 VDD RB13 2.80275f
C909 a_15493_1398# RA12 0.14389f
C910 a_22140_4534# VDD 0.41797f
C911 a_13325_n170# VDD 0.26764f
C912 a_17965_4534# a_18698_4692# 0.12913f
C913 a_5605_2182# VDD 0.27315f
C914 a_32028_10806# WE0CLK 0.22071f
C915 a_35573_2966# VDD 0.26764f
C916 a_3866_1556# RB12 0.1782f
C917 a_36002_4692# RB8 0.1782f
C918 a_17965_1398# VDD 0.27315f
C919 a_35269_n170# VDD 0.27315f
C920 a_28586_5664# VDD 0.28227f
C921 a_27853_10806# a_28157_10806# 0.40203f
C922 a_27853_4534# a_28157_4534# 0.40203f
C923 a_2364_614# VDD 0.41797f
C924 a_31058_2528# a_30325_2182# 0.12913f
C925 a_19668_2966# VDD 0.41797f
C926 a_24746_20# VDD 0.41955f
C927 a_30325_n954# VDD 0.27315f
C928 a_1394_4096# a_661_3750# 0.12913f
C929 a_3133_5318# RA7 0.14389f
C930 a_38474_960# VDD 0.27344f
C931 a_18698_5664# a_17965_5318# 0.12913f
C932 a_26114_10964# VDD 0.28226f
C933 a_27084_3750# VDD 0.41797f
C934 a_3133_6102# RA6 0.14389f
C935 a_8077_3750# RA9 0.14389f
C936 a_17196_1398# VDD 0.41797f
C937 a_18269_7670# VDD 0.26764f
C938 a_34634_4724# a_35269_4534# 0.13953f
C939 a_29690_10336# a_30325_10022# 0.13953f
C940 a_29690_9428# a_29556_9238# 0.68196f
C941 a_6338_8800# a_5605_8454# 0.12913f
C942 a_33101_5410# a_32797_5318# 0.40203f
C943 a_29690_9428# VDD 0.41955f
C944 a_38474_960# a_37741_614# 0.12913f
C945 a_13021_2182# RA11 0.14389f
C946 a_26114_2528# VDD 0.28227f
C947 a_17965_9238# RA2 0.14389f
C948 a_23213_706# RA13 0.1633f
C949 a_22274_7860# a_22909_7670# 0.13953f
C950 a_2498_4064# a_3133_3750# 0.13953f
C951 a_20741_8546# a_20437_8454# 0.40203f
C952 a_22274_n640# VDD 0.41954f
C953 a_37741_6886# VDD 0.27315f
C954 a_6338_9396# RB2 0.1782f
C955 a_1394_8800# VDD 0.28275f
C956 a_27218_7860# VDD 0.41955f
C957 a_22274_n640# a_22140_n954# 0.68196f
C958 a_18698_10368# VDD 0.28227f
C959 a_3437_706# RA13 0.1633f
C960 a_26_10996# a_n108_10806# 0.68196f
C961 a_11282_10368# RB1 0.1782f
C962 a_38045_6102# VDD 0.26764f
C963 a_20741_10806# RA0 0.1633f
C964 VDD RA4 3.36972f
C965 RA1 RA2 0.30166f
C966 a_38474_960# RB13 0.1782f
C967 a_29690_10996# VDD 0.41954f
C968 a_5909_4534# RA8 0.1633f
C969 a_30629_8546# VDD 0.26764f
C970 a_10549_9238# a_10853_9238# 0.40203f
C971 a_27218_7860# a_27084_7670# 0.68196f
C972 a_661_10022# RA1 0.14389f
C973 a_24746_6292# VDD 0.41955f
C974 a_37741_10806# RA0 0.14389f
C975 a_36002_4692# VDD 0.28227f
C976 a_27853_4534# RA8 0.14389f
C977 a_8077_4534# a_8810_4692# 0.12913f
C978 a_15797_2966# VDD 0.26764f
C979 a_27949_n1738# D11 0.11075f
C980 a_29690_7200# VDD 0.41955f
C981 a_16226_4692# RB8 0.1782f
C982 a_35269_3750# VDD 0.27315f
C983 a_28157_n862# RA15 0.1633f
C984 a_15493_n170# VDD 0.27315f
C985 a_22274_4724# VDD 0.41955f
C986 a_29690_10996# a_29556_10806# 0.68196f
C987 a_20437_10806# a_20741_10806# 0.40203f
C988 a_17965_4534# a_18269_4534# 0.40203f
C989 a_16226_2528# a_15493_2182# 0.12913f
C990 a_32162_10996# WE0CLK 0.28565f
C991 a_37741_2966# VDD 0.27315f
C992 a_9536_n1782# a_10040_n1738# 0.67695f
C993 a_10549_10022# VDD 0.27315f
C994 a_28157_5410# VDD 0.26764f
C995 a_32162_1588# a_32797_1398# 0.13953f
C996 a_24746_6292# a_24612_6102# 0.68196f
C997 a_3866_5664# a_3133_5318# 0.12913f
C998 a_30629_2274# a_30325_2182# 0.40203f
C999 a_11282_10964# VDD 0.28226f
C1000 a_19802_3156# VDD 0.41955f
C1001 a_18698_9396# VDD 0.28227f
C1002 a_22140_n170# VDD 0.41797f
C1003 a_2498_3156# a_3133_2966# 0.13953f
C1004 RB2 CLK 0.18513f
C1005 a_n1652_9238# VDD 0.47501f
C1006 VDD D6 0.36038f
C1007 a_38045_706# VDD 0.26764f
C1008 a_14858_10336# a_15493_10022# 0.13953f
C1009 a_19802_4724# a_20437_4534# 0.13953f
C1010 a_37741_4534# a_38474_4692# 0.12913f
C1011 a_18269_5410# a_17965_5318# 0.40203f
C1012 a_27218_4064# VDD 0.41955f
C1013 a_n1652_8886# VDD 0.47501f
C1014 a_23642_960# a_22909_614# 0.12913f
C1015 a_37232_n1738# VDD 0.49525f
C1016 a_20437_7670# VDD 0.27315f
C1017 a_17330_1588# VDD 0.41955f
C1018 a_7442_7860# a_8077_7670# 0.13953f
C1019 a_29690_7200# a_29556_6886# 0.68196f
C1020 a_5909_8546# a_5605_8454# 0.40203f
C1021 a_38045_706# a_37741_614# 0.40203f
C1022 a_27084_9238# VDD 0.41797f
C1023 a_661_1398# RA12 0.14389f
C1024 a_8077_6886# VDD 0.27315f
C1025 a_13325_8546# RA3 0.1633f
C1026 a_25685_2274# VDD 0.26764f
C1027 a_38474_7828# VDD 0.27344f
C1028 a_29690_20# VDD 0.41955f
C1029 a_22274_4724# a_22140_4534# 0.68196f
C1030 a_7442_n640# a_7308_n954# 0.68196f
C1031 a_26_5632# a_661_5318# 0.13953f
C1032 a_21170_n608# VDD 0.28233f
C1033 a_661_614# VDD 0.27315f
C1034 a_5909_10806# RA0 0.1633f
C1035 a_18269_6978# RA5 0.1633f
C1036 a_29368_10806# WE0CLK 0.13896f
C1037 a_24612_7670# VDD 0.41797f
C1038 a_18269_7670# RA4 0.1633f
C1039 a_18269_10114# VDD 0.26764f
C1040 a_661_6102# a_965_6102# 0.40203f
C1041 a_34634_8768# a_35269_8454# 0.13953f
C1042 a_28586_8800# RB3 0.1782f
C1043 a_22909_10806# RA0 0.14389f
C1044 a_23213_5410# RA7 0.1633f
C1045 a_8077_4534# RA8 0.14389f
C1046 a_16226_4692# VDD 0.28227f
C1047 a_29556_8454# VDD 0.41797f
C1048 a_22140_6102# VDD 0.41797f
C1049 a_33530_7232# RB5 0.1782f
C1050 a_5605_3750# VDD 0.27315f
C1051 a_28157_3842# RA9 0.1633f
C1052 a_28586_7828# RB4 0.1782f
C1053 a_35573_4534# VDD 0.26764f
C1054 a_9914_10996# a_9780_10806# 0.68196f
C1055 a_13021_10806# a_13325_10806# 0.40203f
C1056 a_8077_4534# a_8381_4534# 0.40203f
C1057 a_26_3156# a_661_2966# 0.13953f
C1058 a_19802_3156# a_19668_2966# 0.68196f
C1059 a_17965_2966# VDD 0.27315f
C1060 a_2498_20# a_3133_n170# 0.13953f
C1061 a_28586_7232# VDD 0.28227f
C1062 a_38474_5664# RB7 0.1782f
C1063 a_33101_2274# RA11 0.1633f
C1064 a_28157_2966# RA10 0.1633f
C1065 VDD RA9 3.36997f
C1066 a_19668_4534# VDD 0.41797f
C1067 a_17330_1588# a_17965_1398# 0.13953f
C1068 a_15797_2274# a_15493_2182# 0.40203f
C1069 a_10645_n1738# WEM 0.14287f
C1070 a_13754_n608# RB15 0.1782f
C1071 a_27084_5318# VDD 0.41797f
C1072 a_4970_4724# a_5605_4534# 0.13953f
C1073 a_7442_928# a_7308_614# 0.68196f
C1074 a_27218_4064# a_27084_3750# 0.68196f
C1075 a_3437_5410# a_3133_5318# 0.40203f
C1076 a_18269_9238# VDD 0.26764f
C1077 a_17196_2966# VDD 0.41797f
C1078 a_36972_614# VDD 0.41797f
C1079 a_17330_1588# a_17196_1398# 0.68196f
C1080 a_14858_7200# a_14724_6886# 0.68196f
C1081 a_37741_4534# a_38045_4534# 0.40203f
C1082 a_26114_n608# a_25381_n954# 0.12913f
C1083 a_26114_4096# VDD 0.28227f
C1084 a_23213_706# a_22909_614# 0.40203f
C1085 a_7442_10996# a_8077_10806# 0.13953f
C1086 a_36728_n1782# VDD 0.67637f
C1087 a_14724_1398# VDD 0.41797f
C1088 a_37741_8454# VDD 0.27315f
C1089 a_32162_5632# a_32797_5318# 0.13953f
C1090 a_27218_9428# VDD 0.41955f
C1091 RB7 CLK 0.18513f
C1092 RA11 RB11 18.9728f
C1093 a_14536_10806# WE0CLK 0.13896f
C1094 a_24612_2182# VDD 0.41797f
C1095 a_38045_7670# VDD 0.26764f
C1096 a_27084_n170# VDD 0.41797f
C1097 a_19802_8768# a_20437_8454# 0.13953f
C1098 a_20741_n862# VDD 0.26771f
C1099 a_8077_10806# RA0 0.14389f
C1100 a_24746_7860# VDD 0.41955f
C1101 a_1394_6260# RB6 0.1782f
C1102 a_35269_n954# RA15 0.14389f
C1103 a_20437_7670# RA4 0.14389f
C1104 a_17196_10022# VDD 0.41797f
C1105 a_36002_6260# VDD 0.28227f
C1106 a_3866_7232# RB5 0.1782f
C1107 a_661_2182# VDD 0.27315f
C1108 a_8810_7828# RB4 0.1782f
C1109 a_27084_10806# VDD 0.41797f
C1110 a_15797_4534# VDD 0.26764f
C1111 a_29690_8768# VDD 0.41955f
C1112 a_5605_10806# a_5909_10806# 0.40203f
C1113 a_27853_6102# a_28586_6260# 0.12913f
C1114 a_35269_5318# VDD 0.27315f
C1115 VDD WE0CLK 3.31756f
C1116 a_22274_6292# VDD 0.41955f
C1117 a_8810_5664# RB7 0.1782f
C1118 a_34634_20# VDD 0.41955f
C1119 a_3437_2274# RA11 0.1633f
C1120 a_8381_2966# RA10 0.1633f
C1121 a_37741_4534# VDD 0.27315f
C1122 a_20437_614# RA13 0.14389f
C1123 a_33101_n170# RA14 0.1633f
C1124 a_13754_4096# RB9 0.1782f
C1125 a_28157_6978# VDD 0.26764f
C1126 a_30325_2966# RA10 0.14389f
C1127 a_19802_4724# VDD 0.41955f
C1128 a_12386_4064# a_12252_3750# 0.68196f
C1129 a_15493_10022# RA1 0.14389f
C1130 a_35269_1398# a_36002_1556# 0.12913f
C1131 a_18698_2528# RB11 0.1782f
C1132 a_29556_10806# WE0CLK 0.22071f
C1133 a_33530_7232# a_32797_6886# 0.12913f
C1134 a_18698_3124# RB10 0.1782f
C1135 a_27218_5632# VDD 0.41955f
C1136 a_20437_8454# RA3 0.14389f
C1137 a_32797_2182# VDD 0.27315f
C1138 a_11282_n608# a_10549_n954# 0.12913f
C1139 a_29690_2496# a_30325_2182# 0.13953f
C1140 a_17330_3156# VDD 0.41955f
C1141 a_20437_9238# VDD 0.27315f
C1142 a_33530_1556# VDD 0.28227f
C1143 a_37106_928# VDD 0.41955f
C1144 a_25381_6886# RA5 0.14389f
C1145 VDD RA14 3.36972f
C1146 RA6 RA7 0.33341f
C1147 a_8077_8454# VDD 0.27315f
C1148 a_37106_9428# a_37741_9238# 0.13953f
C1149 a_17330_5632# a_17965_5318# 0.13953f
C1150 a_25685_n862# a_25381_n954# 0.40203f
C1151 a_25685_10806# VDD 0.26763f
C1152 a_38474_9396# VDD 0.27344f
C1153 a_25685_3842# VDD 0.26764f
C1154 a_34760_n1738# VDD 0.49525f
C1155 a_14858_1588# VDD 0.41955f
C1156 a_30325_5318# RA7 0.14389f
C1157 a_965_6978# RA5 0.1633f
C1158 a_4970_8768# a_5605_8454# 0.13953f
C1159 a_24612_9238# VDD 0.41797f
C1160 a_37106_928# a_37741_614# 0.13953f
C1161 a_34634_20# a_35269_n170# 0.13953f
C1162 a_3866_960# VDD 0.28227f
C1163 a_35269_3750# RA9 0.14389f
C1164 a_24746_2496# VDD 0.41955f
C1165 a_5605_n954# RA15 0.14389f
C1166 a_16226_6260# VDD 0.28227f
C1167 a_19668_n954# VDD 0.4212f
C1168 a_23213_10114# RA1 0.1633f
C1169 a_23005_n1738# D9 0.11075f
C1170 a_22140_7670# VDD 0.41797f
C1171 a_17965_6102# a_18698_6260# 0.12913f
C1172 a_35269_614# VDD 0.27315f
C1173 a_17330_10336# VDD 0.41955f
C1174 a_5605_5318# VDD 0.27315f
C1175 a_35573_6102# VDD 0.26764f
C1176 a_17965_4534# VDD 0.27315f
C1177 a_27218_10996# VDD 0.41954f
C1178 RB12 CLK 0.18513f
C1179 a_28586_8800# VDD 0.28227f
C1180 a_20741_6102# RA6 0.1633f
C1181 a_38045_7670# RA4 0.1633f
C1182 a_27853_6102# a_28157_6102# 0.40203f
C1183 a_13325_n170# RA14 0.1633f
C1184 a_31058_4096# a_30325_3750# 0.12913f
C1185 a_38474_10368# RB1 0.1782f
C1186 a_19668_6102# VDD 0.41797f
C1187 a_32028_n170# VDD 0.41797f
C1188 a_10549_2966# RA10 0.14389f
C1189 a_1394_5664# a_661_5318# 0.12913f
C1190 a_25381_1398# a_26114_1556# 0.12913f
C1191 a_35269_n170# RA14 0.14389f
C1192 a_18698_7232# a_17965_6886# 0.12913f
C1193 a_27084_6886# VDD 0.41797f
C1194 a_3866_960# RB13 0.1782f
C1195 a_31058_6260# RB6 0.1782f
C1196 a_17196_4534# VDD 0.41797f
C1197 a_23642_n12# RB14 0.1782f
C1198 a_35269_1398# a_35573_1398# 0.40203f
C1199 a_3133_2182# VDD 0.27315f
C1200 a_34634_6292# a_35269_6102# 0.13953f
C1201 RB1 RB2 0.39209f
C1202 VDD WE5 0.22649f
C1203 WE2 RA2 0.10549f
C1204 a_14858_2496# a_15493_2182# 0.13953f
C1205 a_29690_10996# WE0CLK 0.28565f
C1206 a_33101_6978# a_32797_6886# 0.40203f
C1207 a_n1652_7318# WE5 0.10075f
C1208 a_30629_1398# RA12 0.1633f
C1209 a_13754_1556# VDD 0.28227f
C1210 a_31058_n12# VDD 0.28227f
C1211 a_26114_5664# VDD 0.28227f
C1212 a_22274_9428# a_22909_9238# 0.13953f
C1213 a_10853_n862# a_10549_n954# 0.40203f
C1214 a_2498_5632# a_3133_5318# 0.13953f
C1215 a_10853_10806# VDD 0.26763f
C1216 a_14724_2966# VDD 0.41797f
C1217 a_27853_n954# VDD 0.27315f
C1218 a_36728_n1782# a_37232_n1738# 0.67695f
C1219 a_37741_10022# VDD 0.27315f
C1220 a_33101_1398# VDD 0.26764f
C1221 a_36002_960# VDD 0.28275f
C1222 a_24612_3750# VDD 0.41797f
C1223 a_27853_10806# VDD 0.27315f
C1224 a_38045_9238# VDD 0.26764f
C1225 a_22274_928# a_22909_614# 0.13953f
C1226 a_34256_n1782# VDD 0.6765f
C1227 a_3133_614# RA13 0.14389f
C1228 a_5605_3750# RA9 0.14389f
C1229 a_12252_1398# VDD 0.41797f
C1230 a_27218_9428# a_27084_9238# 0.68196f
C1231 a_24746_9428# VDD 0.41955f
C1232 a_10549_2182# RA11 0.14389f
C1233 a_23642_2528# VDD 0.28275f
C1234 a_36002_7828# VDD 0.28227f
C1235 a_8077_6102# a_8810_6260# 0.12913f
C1236 a_20741_706# RA13 0.1633f
C1237 VDD D8 0.36038f
C1238 a_661_3750# VDD 0.27315f
C1239 a_15797_6102# VDD 0.26764f
C1240 a_19802_n640# VDD 0.41954f
C1241 a_2498_928# a_3133_614# 0.13953f
C1242 a_35269_6886# VDD 0.27315f
C1243 a_22274_7860# VDD 0.41955f
C1244 a_33101_9238# RA2 0.1633f
C1245 a_17965_6102# a_18269_6102# 0.40203f
C1246 a_965_n862# a_661_n954# 0.40203f
C1247 a_16226_10368# VDD 0.28275f
C1248 a_8810_10368# RB1 0.1782f
C1249 a_16226_4096# a_15493_3750# 0.12913f
C1250 a_37741_6102# VDD 0.27315f
C1251 a_36002_960# RB13 0.1782f
C1252 a_28157_8546# VDD 0.26764f
C1253 a_22909_6102# RA6 0.14389f
C1254 a_15493_1398# a_16226_1556# 0.12913f
C1255 a_32797_n170# a_33530_n12# 0.12913f
C1256 a_32162_3156# a_32797_2966# 0.13953f
C1257 a_24746_7860# a_24612_7670# 0.68196f
C1258 a_15493_n170# RA14 0.14389f
C1259 a_3866_7232# a_3133_6886# 0.12913f
C1260 a_30629_3842# a_30325_3750# 0.40203f
C1261 a_19802_6292# VDD 0.41955f
C1262 a_2498_4724# a_3133_4534# 0.13953f
C1263 a_11282_6260# RB6 0.1782f
C1264 a_25381_1398# a_25685_1398# 0.40203f
C1265 a_19802_6292# a_20437_6102# 0.13953f
C1266 a_37741_6102# a_38474_6260# 0.12913f
C1267 a_18269_6978# a_17965_6886# 0.40203f
C1268 a_27218_7200# VDD 0.41955f
C1269 a_32797_3750# VDD 0.27315f
C1270 a_25685_n862# RA15 0.1633f
C1271 a_10853_1398# RA12 0.1633f
C1272 a_11282_n12# VDD 0.28227f
C1273 a_17330_4724# VDD 0.41955f
C1274 a_7442_9428# a_8077_9238# 0.13953f
C1275 a_29690_8768# a_29556_8454# 0.68196f
C1276 a_26_1588# a_n108_1398# 0.68196f
C1277 a_33530_3124# VDD 0.28227f
C1278 a_8173_n1738# WEM 0.14287f
C1279 a_7064_n1782# a_7568_n1738# 0.67695f
C1280 a_8077_10022# VDD 0.27315f
C1281 a_32797_1398# RA12 0.14389f
C1282 a_13325_1398# VDD 0.26764f
C1283 a_30629_n170# VDD 0.26764f
C1284 a_25685_5410# VDD 0.26764f
C1285 a_36972_n170# VDD 0.41797f
C1286 a_22274_6292# a_22140_6102# 0.68196f
C1287 a_13021_10806# VDD 0.27315f
C1288 a_26_7200# a_661_6886# 0.13953f
C1289 a_14858_3156# VDD 0.41955f
C1290 a_21170_1556# RB12 0.1782f
C1291 a_38474_3124# RB10 0.1782f
C1292 a_35269_1398# VDD 0.27315f
C1293 a_35573_706# VDD 0.26764f
C1294 a_661_7670# a_965_7670# 0.40203f
C1295 a_24746_n640# a_25381_n954# 0.13953f
C1296 a_24746_4064# VDD 0.41955f
C1297 VDD WE10 0.22649f
C1298 a_32288_n1738# VDD 0.49525f
C1299 a_12386_1588# VDD 0.41955f
C1300 a_16226_7828# VDD 0.28227f
C1301 a_28586_10368# a_27853_10022# 0.12913f
C1302 a_26_10336# VDD 0.41955f
C1303 a_22140_9238# VDD 0.41797f
C1304 a_17330_10996# a_17965_10806# 0.13953f
C1305 a_5605_6886# VDD 0.27315f
C1306 a_10853_8546# RA3 0.1633f
C1307 a_23213_2274# VDD 0.26764f
C1308 a_35573_7670# VDD 0.26764f
C1309 a_13325_9238# RA2 0.1633f
C1310 a_8077_6102# a_8381_6102# 0.40203f
C1311 a_26_4724# a_661_4534# 0.13953f
C1312 a_19802_4724# a_19668_4534# 0.68196f
C1313 a_18698_n608# VDD 0.28233f
C1314 a_17965_6102# VDD 0.27315f
C1315 a_15797_6978# RA5 0.1633f
C1316 a_19668_7670# VDD 0.41797f
C1317 a_5605_1398# a_6338_1556# 0.12913f
C1318 a_35269_9238# RA2 0.14389f
C1319 a_17330_3156# a_17965_2966# 0.13953f
C1320 a_22909_n170# a_23642_n12# 0.12913f
C1321 a_15797_10114# VDD 0.26764f
C1322 a_15797_3842# a_15493_3750# 0.40203f
C1323 a_26114_8800# RB3 0.1782f
C1324 a_20741_5410# RA7 0.1633f
C1325 a_23642_9396# RB2 0.1782f
C1326 a_24612_10806# VDD 0.41797f
C1327 a_27084_8454# VDD 0.41797f
C1328 a_15493_1398# a_15797_1398# 0.40203f
C1329 a_4970_6292# a_5605_6102# 0.13953f
C1330 a_27218_5632# a_27084_5318# 0.68196f
C1331 a_32797_n170# a_33101_n170# 0.40203f
C1332 RA11 RA12 0.30166f
C1333 a_3437_6978# a_3133_6886# 0.40203f
C1334 a_17196_6102# VDD 0.41797f
C1335 a_31058_7232# RB5 0.1782f
C1336 a_3133_3750# VDD 0.27315f
C1337 a_25685_3842# RA9 0.1633f
C1338 a_23213_4534# RA8 0.1633f
C1339 a_17330_3156# a_17196_2966# 0.68196f
C1340 a_14858_8768# a_14724_8454# 0.68196f
C1341 a_37741_6102# a_38045_6102# 0.40203f
C1342 a_13754_3124# VDD 0.28227f
C1343 a_26114_7232# VDD 0.28227f
C1344 a_36002_5664# RB7 0.1782f
C1345 a_30629_2274# RA11 0.1633f
C1346 a_32162_10336# a_32028_10022# 0.68196f
C1347 a_13021_1398# RA12 0.14389f
C1348 a_14724_4534# VDD 0.41797f
C1349 a_10853_n170# VDD 0.26764f
C1350 a_37106_928# a_36972_614# 0.68196f
C1351 a_27084_10806# WE0CLK 0.22071f
C1352 a_32162_7200# a_32797_6886# 0.13953f
C1353 a_33101_2966# VDD 0.26764f
C1354 a_11282_n608# RB15 0.1782f
C1355 WE0 RA0 0.10549f
C1356 a_33530_4692# RB8 0.1782f
C1357 VDD RB0 2.79986f
C1358 a_15493_1398# VDD 0.27315f
C1359 a_24612_5318# VDD 0.41797f
C1360 a_32797_n170# VDD 0.27315f
C1361 a_9914_n640# a_10549_n954# 0.13953f
C1362 a_12252_2966# VDD 0.41797f
C1363 a_661_n954# RA15 0.14389f
C1364 a_34500_614# VDD 0.41797f
C1365 a_14858_1588# a_14724_1398# 0.68196f
C1366 a_13754_10368# a_13021_10022# 0.12913f
C1367 a_18061_n1738# D7 0.11075f
C1368 a_23642_4096# VDD 0.28275f
C1369 a_36002_9396# VDD 0.28227f
C1370 a_31784_n1782# VDD 0.6765f
C1371 a_661_5318# VDD 0.27315f
C1372 a_9780_1398# VDD 0.41797f
C1373 a_15797_7670# VDD 0.26764f
C1374 a_27853_7670# a_28586_7828# 0.12913f
C1375 a_28157_10114# a_27853_10022# 0.40203f
C1376 a_35269_8454# VDD 0.27315f
C1377 a_22274_9428# VDD 0.41955f
C1378 a_37741_7670# VDD 0.27315f
C1379 a_22140_2182# VDD 0.41797f
C1380 a_15493_9238# RA2 0.14389f
C1381 a_13021_n170# a_13754_n12# 0.12913f
C1382 a_24746_2496# a_24612_2182# 0.68196f
C1383 a_18269_n862# VDD 0.26771f
C1384 RB6 RB7 0.23766f
C1385 WE7 RA7 0.10549f
C1386 VDD WE15 0.22608f
C1387 a_3866_9396# RB2 0.1782f
C1388 a_19802_7860# VDD 0.41955f
C1389 a_32797_n954# RA15 0.14389f
C1390 a_22274_20# a_22909_n170# 0.13953f
C1391 a_5605_1398# a_5909_1398# 0.40203f
C1392 a_12386_5632# a_12252_5318# 0.68196f
C1393 a_22909_n170# a_23213_n170# 0.40203f
C1394 a_35269_2966# a_36002_3124# 0.12913f
C1395 a_14724_10022# VDD 0.41797f
C1396 a_33530_8800# a_32797_8454# 0.12913f
C1397 a_1394_7232# RB5 0.1782f
C1398 a_3437_4534# RA8 0.1633f
C1399 a_24746_10996# VDD 0.41954f
C1400 a_27218_8768# VDD 0.41955f
C1401 a_35573_7670# RA4 0.1633f
C1402 a_32797_5318# VDD 0.27315f
C1403 a_4836_614# VDD 0.41797f
C1404 a_29690_4064# a_30325_3750# 0.13953f
C1405 a_17330_6292# VDD 0.41955f
C1406 a_6338_5664# RB7 0.1782f
C1407 a_17330_10336# a_17196_10022# 0.68196f
C1408 a_25381_4534# RA8 0.14389f
C1409 a_33530_4692# VDD 0.28227f
C1410 a_17965_614# RA13 0.14389f
C1411 a_22274_928# a_22140_614# 0.68196f
C1412 a_26114_10964# RB0 0.1782f
C1413 a_13325_2966# VDD 0.26764f
C1414 a_17330_7200# a_17965_6886# 0.13953f
C1415 a_11282_4096# RB9 0.1782f
C1416 a_25685_6978# VDD 0.26764f
C1417 a_1394_10964# VDD 0.28226f
C1418 a_13754_4692# RB8 0.1782f
C1419 a_13021_n170# VDD 0.27315f
C1420 a_14858_4724# VDD 0.41955f
C1421 a_27218_10996# a_27084_10806# 0.68196f
C1422 a_13021_10022# RA1 0.14389f
C1423 a_16226_2528# RB11 0.1782f
C1424 a_27218_10996# WE0CLK 0.28565f
C1425 a_35269_2966# VDD 0.27315f
C1426 a_661_3750# RA9 0.14389f
C1427 a_24746_5632# VDD 0.41955f
C1428 a_17965_8454# RA3 0.14389f
C1429 a_30325_2182# VDD 0.27315f
C1430 a_8810_960# a_8077_614# 0.12913f
C1431 a_7442_20# a_8077_n170# 0.13953f
C1432 a_12386_3156# VDD 0.41955f
C1433 a_16226_9396# VDD 0.28227f
C1434 a_34634_928# VDD 0.41955f
C1435 a_22909_6886# RA5 0.14389f
C1436 a_13325_10114# a_13021_10022# 0.40203f
C1437 a_17965_7670# a_18698_7828# 0.12913f
C1438 a_5605_8454# VDD 0.27315f
C1439 a_5909_706# RA13 0.1633f
C1440 a_23213_3842# VDD 0.26764f
C1441 a_35573_9238# VDD 0.26764f
C1442 a_29816_n1738# VDD 0.49525f
C1443 RA2 RB2 18.9728f
C1444 VDD RB5 2.80275f
C1445 a_9914_1588# VDD 0.41955f
C1446 a_17965_7670# VDD 0.27315f
C1447 a_27853_5318# RA7 0.14389f
C1448 a_9914_2496# a_9780_2182# 0.68196f
C1449 a_27853_7670# a_28157_7670# 0.40203f
C1450 a_31058_5664# a_30325_5318# 0.12913f
C1451 a_965_4534# RA8 0.1633f
C1452 a_19668_9238# VDD 0.41797f
C1453 a_1394_7232# a_661_6886# 0.12913f
C1454 a_22274_2496# VDD 0.41955f
C1455 a_32797_3750# RA9 0.14389f
C1456 a_3133_n954# RA15 0.14389f
C1457 a_25381_2966# a_26114_3124# 0.12913f
C1458 a_13021_n170# a_13325_n170# 0.40203f
C1459 a_18698_8800# a_17965_8454# 0.12913f
C1460 a_17196_n954# VDD 0.4212f
C1461 a_20741_10114# RA1 0.1633f
C1462 a_661_1398# VDD 0.27315f
C1463 a_37741_2182# RA11 0.14389f
C1464 a_17196_7670# VDD 0.41797f
C1465 a_15797_7670# RA4 0.1633f
C1466 a_35269_2966# a_35573_2966# 0.40203f
C1467 a_3133_5318# VDD 0.27315f
C1468 a_32797_614# VDD 0.27315f
C1469 a_34634_7860# a_35269_7670# 0.13953f
C1470 a_14858_10336# VDD 0.41955f
C1471 a_14858_4064# a_15493_3750# 0.13953f
C1472 a_33101_8546# a_32797_8454# 0.40203f
C1473 a_2498_10336# a_2364_10022# 0.68196f
C1474 a_5605_4534# RA8 0.14389f
C1475 a_13754_4692# VDD 0.28227f
C1476 a_26114_8800# VDD 0.28227f
C1477 a_1394_n12# VDD 0.28227f
C1478 a_37741_7670# RA4 0.14389f
C1479 a_34634_n640# a_34500_n954# 0.68196f
C1480 a_2498_7200# a_3133_6886# 0.13953f
C1481 a_36002_10368# RB1 0.1782f
C1482 a_11282_10964# RB0 0.1782f
C1483 a_14724_6102# VDD 0.41797f
C1484 VDD D10 0.36033f
C1485 a_33101_10806# RA0 0.1633f
C1486 a_26114_7828# RB4 0.1782f
C1487 a_26_2496# a_n108_2182# 0.68196f
C1488 a_33101_4534# VDD 0.26764f
C1489 a_7442_10996# a_7308_10806# 0.68196f
C1490 a_3437_706# a_3133_614# 0.40203f
C1491 a_1394_1556# VDD 0.28227f
C1492 a_n1652_1398# WE12 0.10075f
C1493 a_15493_2966# VDD 0.27315f
C1494 a_24612_6886# VDD 0.41797f
C1495 a_25685_2966# RA10 0.1633f
C1496 a_661_9238# RA2 0.14389f
C1497 a_12252_4534# VDD 0.41797f
C1498 a_5701_n1738# WEM 0.14287f
C1499 a_23642_5664# VDD 0.28275f
C1500 a_8077_7670# a_8810_7828# 0.12913f
C1501 a_661_6886# VDD 0.27315f
C1502 a_28586_2528# a_27853_2182# 0.12913f
C1503 a_15797_9238# VDD 0.26764f
C1504 a_9780_2966# VDD 0.41797f
C1505 a_36002_3124# RB10 0.1782f
C1506 a_34256_n1782# a_34760_n1738# 0.67695f
C1507 a_25381_n954# VDD 0.27315f
C1508 a_35269_10022# VDD 0.27315f
C1509 a_33530_960# VDD 0.28227f
C1510 a_17965_7670# a_18269_7670# 0.40203f
C1511 a_16226_5664# a_15493_5318# 0.12913f
C1512 a_23642_10964# VDD 0.28226f
C1513 a_22140_3750# VDD 0.41797f
C1514 a_37741_9238# VDD 0.27315f
C1515 a_965_n862# VDD 0.26771f
C1516 a_29312_n1782# VDD 0.6765f
C1517 a_3133_3750# RA9 0.14389f
C1518 a_7308_1398# VDD 0.41797f
C1519 a_15493_2966# a_16226_3124# 0.12913f
C1520 a_32162_4724# a_32797_4534# 0.13953f
C1521 a_27218_10336# a_27853_10022# 0.13953f
C1522 a_24746_9428# a_24612_9238# 0.68196f
C1523 a_30629_5410# a_30325_5318# 0.40203f
C1524 a_3866_8800# a_3133_8454# 0.12913f
C1525 a_19802_9428# VDD 0.41955f
C1526 a_3133_4534# RA8 0.14389f
C1527 a_n1652_10454# VDD 0.47501f
C1528 a_36002_960# a_35269_614# 0.12913f
C1529 a_2498_6292# a_3133_6102# 0.13953f
C1530 a_8077_2182# RA11 0.14389f
C1531 a_21170_2528# VDD 0.28227f
C1532 a_18269_706# RA13 0.1633f
C1533 a_25381_2966# a_25685_2966# 0.40203f
C1534 a_19802_7860# a_20437_7670# 0.13953f
C1535 a_37741_7670# a_38474_7828# 0.12913f
C1536 a_18269_8546# a_17965_8454# 0.40203f
C1537 a_17330_n640# VDD 0.41954f
C1538 a_27218_10996# a_27853_10806# 0.13953f
C1539 a_32797_6886# VDD 0.27315f
C1540 a_38045_8546# RA3 0.1633f
C1541 VDD RB10 2.79986f
C1542 a_17330_7860# VDD 0.41955f
C1543 a_17965_7670# RA4 0.14389f
C1544 a_19802_n640# a_19668_n954# 0.68196f
C1545 a_13754_10368# VDD 0.28227f
C1546 a_6338_10368# RB1 0.1782f
C1547 a_26_3156# a_n108_2966# 0.68196f
C1548 a_33530_6260# VDD 0.28227f
C1549 a_18269_10806# RA0 0.1633f
C1550 a_6338_7828# RB4 0.1782f
C1551 a_33530_960# RB13 0.1782f
C1552 a_22140_10806# VDD 0.41797f
C1553 a_13325_4534# VDD 0.26764f
C1554 a_25685_8546# VDD 0.26764f
C1555 a_22274_7860# a_22140_7670# 0.68196f
C1556 a_26_8768# a_661_8454# 0.13953f
C1557 a_14858_6292# VDD 0.41955f
C1558 a_35269_10806# RA0 0.14389f
C1559 a_5909_2966# RA10 0.1633f
C1560 a_35269_4534# VDD 0.27315f
C1561 a_30629_n170# RA14 0.1633f
C1562 a_661_9238# a_965_9238# 0.40203f
C1563 a_24746_7200# VDD 0.41955f
C1564 a_30325_3750# VDD 0.27315f
C1565 a_23213_n862# RA15 0.1633f
C1566 a_27853_2966# RA10 0.14389f
C1567 a_12386_4724# VDD 0.41955f
C1568 a_13117_n1738# D5 0.11075f
C1569 a_13754_2528# a_13021_2182# 0.12913f
C1570 a_24612_10806# WE0CLK 0.22071f
C1571 a_16226_3124# RB10 0.1782f
C1572 a_4592_n1782# a_5096_n1738# 0.67695f
C1573 a_5605_10022# VDD 0.27315f
C1574 RB11 RB12 0.39209f
C1575 WE12 RA12 0.10549f
C1576 a_23213_5410# VDD 0.26764f
C1577 a_8077_7670# a_8381_7670# 0.40203f
C1578 a_29690_1588# a_30325_1398# 0.13953f
C1579 a_26_6292# a_661_6102# 0.13953f
C1580 a_19802_6292# a_19668_6102# 0.68196f
C1581 a_28157_2274# a_27853_2182# 0.40203f
C1582 a_8810_10964# VDD 0.28226f
C1583 a_9914_3156# VDD 0.41955f
C1584 a_17965_9238# VDD 0.27315f
C1585 a_38474_n608# RB15 0.1782f
C1586 a_31058_1556# VDD 0.28227f
C1587 a_33101_706# VDD 0.26764f
C1588 a_5605_2966# a_6338_3124# 0.12913f
C1589 a_17330_4724# a_17965_4534# 0.13953f
C1590 a_12386_10336# a_13021_10022# 0.13953f
C1591 a_15797_5410# a_15493_5318# 0.40203f
C1592 a_21170_960# a_20437_614# 0.12913f
C1593 a_22274_4064# VDD 0.41955f
C1594 a_27344_n1738# VDD 0.49525f
C1595 a_n108_n954# VDD 0.42145f
C1596 a_7442_1588# VDD 0.41955f
C1597 a_15493_2966# a_15797_2966# 0.40203f
C1598 a_4970_7860# a_5605_7670# 0.13953f
C1599 a_661_2966# VDD 0.27315f
C1600 a_27218_7200# a_27084_6886# 0.68196f
C1601 VDD RA1 3.36997f
C1602 WE0CLK RB0 18.6116f
C1603 a_3437_8546# a_3133_8454# 0.40203f
C1604 a_38474_n608# a_37741_n954# 0.12913f
C1605 a_17196_9238# VDD 0.41797f
C1606 a_35573_706# a_35269_614# 0.40203f
C1607 a_3133_6886# VDD 0.27315f
C1608 a_8381_8546# RA3 0.1633f
C1609 a_20741_2274# VDD 0.26764f
C1610 a_5605_614# VDD 0.27315f
C1611 a_4970_n640# a_4836_n954# 0.68196f
C1612 a_37741_7670# a_38045_7670# 0.40203f
C1613 a_17330_4724# a_17196_4534# 0.68196f
C1614 a_26_928# a_n108_614# 0.68196f
C1615 a_13754_6260# VDD 0.28227f
C1616 a_16226_n608# VDD 0.28281f
C1617 a_3437_10806# RA0 0.1633f
C1618 a_13325_6978# RA5 0.1633f
C1619 a_26896_10806# WE0CLK 0.13896f
C1620 a_14724_7670# VDD 0.41797f
C1621 a_13325_10114# VDD 0.26764f
C1622 a_33101_6102# VDD 0.26764f
C1623 a_32162_8768# a_32797_8454# 0.13953f
C1624 a_23642_8800# RB3 0.1782f
C1625 a_20437_10806# RA0 0.14389f
C1626 a_1394_3124# VDD 0.28227f
C1627 a_18269_5410# RA7 0.1633f
C1628 a_15493_4534# VDD 0.27315f
C1629 a_22274_10996# VDD 0.41954f
C1630 a_24612_8454# VDD 0.41797f
C1631 a_18269_6102# RA6 0.1633f
C1632 a_10853_n170# RA14 0.1633f
C1633 a_12252_6102# VDD 0.41797f
C1634 a_28586_7232# RB5 0.1782f
C1635 a_23213_3842# RA9 0.1633f
C1636 a_8077_2966# RA10 0.14389f
C1637 VDD RA15 3.47437f
C1638 RA7 RB7 18.9728f
C1639 a_14858_3156# a_14724_2966# 0.68196f
C1640 a_32797_n170# RA14 0.14389f
C1641 a_23642_7232# VDD 0.28275f
C1642 a_33530_5664# RB7 0.1782f
C1643 a_28157_2274# RA11 0.1633f
C1644 a_965_10806# VDD 0.26763f
C1645 a_661_8454# VDD 0.27315f
C1646 a_28586_6260# RB6 0.1782f
C1647 a_9780_4534# VDD 0.41797f
C1648 a_21170_n12# RB14 0.1782f
C1649 a_14858_1588# a_15493_1398# 0.13953f
C1650 a_27853_9238# a_28586_9396# 0.12913f
C1651 a_13325_2274# a_13021_2182# 0.40203f
C1652 a_24746_10996# WE0CLK 0.28565f
C1653 a_38474_4096# RB9 0.1782f
C1654 a_8810_n608# RB15 0.1782f
C1655 a_28157_1398# RA12 0.1633f
C1656 a_6338_960# VDD 0.28227f
C1657 a_11282_1556# VDD 0.28227f
C1658 a_28586_n12# VDD 0.28227f
C1659 a_22140_5318# VDD 0.41797f
C1660 a_24746_4064# a_24612_3750# 0.68196f
C1661 a_7308_2966# VDD 0.41797f
C1662 a_30629_1398# VDD 0.26764f
C1663 a_32028_614# VDD 0.41797f
C1664 a_5605_2966# a_5909_2966# 0.40203f
C1665 a_35269_4534# a_36002_4692# 0.12913f
C1666 a_12386_1588# a_12252_1398# 0.68196f
C1667 a_12386_7200# a_12252_6886# 0.68196f
C1668 a_23642_n608# a_22909_n954# 0.12913f
C1669 a_21170_4096# VDD 0.28227f
C1670 a_20741_706# a_20437_614# 0.40203f
C1671 a_26840_n1782# VDD 0.6765f
C1672 a_4836_1398# VDD 0.41797f
C1673 a_32797_8454# VDD 0.27315f
C1674 a_38045_n862# a_37741_n954# 0.40203f
C1675 a_29690_5632# a_30325_5318# 0.13953f
C1676 a_38474_10964# VDD 0.27343f
C1677 a_17330_9428# VDD 0.41955f
C1678 a_12064_10806# WE0CLK 0.13896f
C1679 a_19668_2182# VDD 0.41797f
C1680 a_33530_7828# VDD 0.28227f
C1681 a_17330_8768# a_17965_8454# 0.13953f
C1682 a_15797_n862# VDD 0.26771f
C1683 a_13325_6102# VDD 0.26764f
C1684 a_5605_10806# RA0 0.14389f
C1685 a_6338_960# RB13 0.1782f
C1686 a_14858_7860# VDD 0.41955f
C1687 a_30325_n954# RA15 0.14389f
C1688 a_30629_9238# RA2 0.1633f
C1689 a_12252_10022# VDD 0.41797f
C1690 RA2 RA3 0.33341f
C1691 VDD RA6 3.36972f
C1692 a_35269_6102# VDD 0.27315f
C1693 a_1394_4692# RB8 0.1782f
C1694 a_24746_8768# VDD 0.41955f
C1695 a_20437_6102# RA6 0.14389f
C1696 a_30325_5318# VDD 0.27315f
C1697 a_13021_n170# RA14 0.14389f
C1698 a_12386_6292# VDD 0.41955f
C1699 a_3866_5664# RB7 0.1782f
C1700 a_8810_6260# RB6 0.1782f
C1701 a_17965_9238# a_18698_9396# 0.12913f
C1702 a_15493_614# RA13 0.14389f
C1703 a_8810_4096# RB9 0.1782f
C1704 a_23213_6978# VDD 0.26764f
C1705 a_3133_10806# VDD 0.27315f
C1706 a_8381_1398# RA12 0.1633f
C1707 a_9914_4724# VDD 0.41955f
C1708 a_10549_10022# RA1 0.14389f
C1709 a_9914_4064# a_9780_3750# 0.68196f
C1710 a_27853_9238# a_28157_9238# 0.40203f
C1711 a_13754_2528# RB11 0.1782f
C1712 a_31058_7232# a_30325_6886# 0.12913f
C1713 a_31058_3124# VDD 0.28227f
C1714 a_3229_n1738# WEM 0.14287f
C1715 a_30325_1398# RA12 0.14389f
C1716 a_10853_1398# VDD 0.26764f
C1717 a_1394_8800# a_661_8454# 0.12913f
C1718 a_28157_n170# VDD 0.26764f
C1719 a_22274_5632# VDD 0.41955f
C1720 a_15493_8454# RA3 0.14389f
C1721 a_25381_4534# a_26114_4692# 0.12913f
C1722 VDD D12 0.36038f
C1723 RB4 CLK 0.18513f
C1724 a_27853_2182# VDD 0.27315f
C1725 a_8810_n608# a_8077_n954# 0.12913f
C1726 a_27218_2496# a_27853_2182# 0.13953f
C1727 a_7442_3156# VDD 0.41955f
C1728 a_18698_1556# RB12 0.1782f
C1729 a_661_4534# VDD 0.27315f
C1730 a_32797_1398# VDD 0.27315f
C1731 a_32162_928# VDD 0.41955f
C1732 a_20437_6886# RA5 0.14389f
C1733 a_35269_4534# a_35573_4534# 0.40203f
C1734 a_3133_8454# VDD 0.27315f
C1735 a_34634_9428# a_35269_9238# 0.13953f
C1736 a_14858_5632# a_15493_5318# 0.13953f
C1737 a_23213_n862# a_22909_n954# 0.40203f
C1738 a_20741_3842# VDD 0.26764f
C1739 a_23213_10806# VDD 0.26763f
C1740 a_24872_n1738# VDD 0.49525f
C1741 a_4970_1588# VDD 0.41955f
C1742 a_13754_7828# VDD 0.28227f
C1743 a_25381_5318# RA7 0.14389f
C1744 a_661_n170# a_965_n170# 0.40203f
C1745 a_2498_8768# a_3133_8454# 0.13953f
C1746 a_14724_9238# VDD 0.41797f
C1747 a_34634_928# a_35269_614# 0.13953f
C1748 a_26_4064# a_n108_3750# 0.68196f
C1749 a_30325_3750# RA9 0.14389f
C1750 a_19802_2496# VDD 0.41955f
C1751 a_33101_7670# VDD 0.26764f
C1752 a_965_5410# RA7 0.1633f
C1753 a_10853_9238# RA2 0.1633f
C1754 a_26_10996# VDD 0.41954f
C1755 a_1394_4692# VDD 0.28227f
C1756 a_14724_n954# VDD 0.4212f
C1757 a_15493_6102# VDD 0.27315f
C1758 a_18269_10114# RA1 0.1633f
C1759 a_35269_2182# RA11 0.14389f
C1760 a_12252_7670# VDD 0.41797f
C1761 a_32797_9238# RA2 0.14389f
C1762 a_30325_614# VDD 0.27315f
C1763 a_12386_10336# VDD 0.41955f
C1764 a_8173_n1738# D3 0.11075f
C1765 a_37106_10996# a_37741_10806# 0.13953f
C1766 a_21170_9396# RB2 0.1782f
C1767 a_19668_10806# VDD 0.41797f
C1768 a_23642_8800# VDD 0.28275f
C1769 a_8077_9238# a_8810_9396# 0.12913f
C1770 a_28586_4096# a_27853_3750# 0.12913f
C1771 a_33530_10368# RB1 0.1782f
C1772 a_9780_6102# VDD 0.41797f
C1773 a_20741_4534# RA8 0.1633f
C1774 a_38045_6102# RA6 0.1633f
C1775 a_17965_9238# a_18269_9238# 0.40203f
C1776 VDD RA11 3.36997f
C1777 a_16226_7232# a_15493_6886# 0.12913f
C1778 a_11282_3124# VDD 0.28227f
C1779 a_22140_6886# VDD 0.41797f
C1780 a_10549_1398# RA12 0.14389f
C1781 a_7308_4534# VDD 0.41797f
C1782 a_15493_4534# a_16226_4692# 0.12913f
C1783 a_32162_6292# a_32797_6102# 0.13953f
C1784 a_12386_2496# a_13021_2182# 0.13953f
C1785 a_22140_10806# WE0CLK 0.22071f
C1786 a_30629_6978# a_30325_6886# 0.40203f
C1787 a_30629_2966# VDD 0.26764f
C1788 a_2498_7860# a_3133_7670# 0.13953f
C1789 a_31058_4692# RB8 0.1782f
C1790 a_13021_1398# VDD 0.27315f
C1791 a_30325_n170# VDD 0.27315f
C1792 a_21170_5664# VDD 0.28227f
C1793 a_25381_4534# a_25685_4534# 0.40203f
C1794 a_19802_9428# a_20437_9238# 0.13953f
C1795 a_37741_9238# a_38474_9396# 0.12913f
C1796 a_8381_n862# a_8077_n954# 0.40203f
C1797 a_8381_10806# VDD 0.26763f
C1798 a_4836_2966# VDD 0.41797f
C1799 a_n1652_5750# WE7 0.10075f
C1800 a_31784_n1782# a_32288_n1738# 0.67695f
C1801 a_22909_n954# VDD 0.27315f
C1802 a_32797_10022# VDD 0.27315f
C1803 a_31058_960# VDD 0.28275f
C1804 a_32797_10806# a_33530_10964# 0.12913f
C1805 a_8077_614# RA13 0.14389f
C1806 a_25381_10806# VDD 0.27315f
C1807 a_26_4724# a_n108_4534# 0.68196f
C1808 a_33530_9396# VDD 0.28227f
C1809 a_19668_3750# VDD 0.41797f
C1810 a_19802_928# a_20437_614# 0.13953f
C1811 a_3133_1398# a_3866_1556# 0.12913f
C1812 a_24368_n1782# VDD 0.6765f
C1813 a_2364_1398# VDD 0.41797f
C1814 a_13325_7670# VDD 0.26764f
C1815 a_22274_9428# a_22140_9238# 0.68196f
C1816 RA12 RB12 18.9728f
C1817 RB9 CLK 0.18513f
C1818 a_37106_n640# a_37741_n954# 0.13953f
C1819 a_14858_9428# VDD 0.41955f
C1820 a_5605_2182# RA11 0.14389f
C1821 a_18698_2528# VDD 0.28227f
C1822 a_35269_7670# VDD 0.27315f
C1823 a_13021_9238# RA2 0.14389f
C1824 a_15797_706# RA13 0.1633f
C1825 a_14858_n640# VDD 0.41954f
C1826 a_30325_6886# VDD 0.27315f
C1827 a_35573_8546# RA3 0.1633f
C1828 a_12386_7860# VDD 0.41955f
C1829 a_11282_10368# VDD 0.28227f
C1830 a_3866_10368# RB1 0.1782f
C1831 a_13754_4096# a_13021_3750# 0.12913f
C1832 VDD WE2 0.22649f
C1833 a_31058_960# RB13 0.1782f
C1834 a_19802_10996# VDD 0.41954f
C1835 a_23213_8546# VDD 0.26764f
C1836 a_33101_7670# RA4 0.1633f
C1837 a_8077_9238# a_8381_9238# 0.40203f
C1838 a_29690_3156# a_30325_2966# 0.13953f
C1839 a_26_7860# a_661_7670# 0.13953f
C1840 a_19802_7860# a_19668_7670# 0.68196f
C1841 a_9914_928# a_10549_614# 0.13953f
C1842 a_28157_3842# a_27853_3750# 0.40203f
C1843 a_9914_6292# VDD 0.41955f
C1844 a_31058_4692# VDD 0.28227f
C1845 a_22909_4534# RA8 0.14389f
C1846 a_5605_4534# a_6338_4692# 0.12913f
C1847 a_17330_6292# a_17965_6102# 0.13953f
C1848 a_10853_2966# VDD 0.26764f
C1849 a_15797_6978# a_15493_6886# 0.40203f
C1850 a_22274_7200# VDD 0.41955f
C1851 a_11282_4692# RB8 0.1782f
C1852 a_27853_3750# VDD 0.27315f
C1853 a_20741_n862# RA15 0.1633f
C1854 a_7442_4724# VDD 0.41955f
C1855 a_24746_10996# a_24612_10806# 0.68196f
C1856 a_15493_4534# a_15797_4534# 0.40203f
C1857 a_4970_9428# a_5605_9238# 0.13953f
C1858 a_27218_8768# a_27084_8454# 0.68196f
C1859 a_661_6102# VDD 0.27315f
C1860 a_22274_10996# WE0CLK 0.28565f
C1861 a_32797_2966# VDD 0.27315f
C1862 a_757_n1738# WEM 0.14287f
C1863 a_3133_10022# VDD 0.27315f
C1864 a_2120_n1782# a_2624_n1738# 0.67695f
C1865 a_20741_5410# VDD 0.26764f
C1866 a_25381_10806# a_26114_10964# 0.12913f
C1867 a_17330_6292# a_17196_6102# 0.68196f
C1868 a_37741_9238# a_38045_9238# 0.40203f
C1869 a_10549_10806# VDD 0.27315f
C1870 a_13754_9396# VDD 0.28227f
C1871 a_4970_3156# VDD 0.41955f
C1872 a_36002_n608# RB15 0.1782f
C1873 RA7 RA8 0.30166f
C1874 VDD WEM 3.88592f
C1875 a_30629_706# VDD 0.26764f
C1876 a_22274_n640# a_22909_n954# 0.13953f
C1877 a_19802_4064# VDD 0.41955f
C1878 a_33101_9238# VDD 0.26764f
C1879 a_4970_10996# a_5605_10806# 0.13953f
C1880 a_38474_1556# RB12 0.1782f
C1881 a_3133_1398# a_3437_1398# 0.40203f
C1882 a_1394_6260# VDD 0.28227f
C1883 a_22400_n1738# VDD 0.49525f
C1884 a_2498_1588# VDD 0.41955f
C1885 a_15493_7670# VDD 0.27315f
C1886 a_26114_10368# a_25381_10022# 0.12913f
C1887 a_7308_614# VDD 0.41797f
C1888 a_38045_10806# VDD 0.26763f
C1889 a_12252_9238# VDD 0.41797f
C1890 a_5909_8546# RA3 0.1633f
C1891 a_18269_2274# VDD 0.26764f
C1892 a_n1652_10806# VDD 0.47499f
C1893 a_14858_4724# a_14724_4534# 0.68196f
C1894 a_13754_n608# VDD 0.28233f
C1895 a_1394_10964# RB0 0.1782f
C1896 a_10853_6978# RA5 0.1633f
C1897 a_9780_7670# VDD 0.41797f
C1898 a_13325_7670# RA4 0.1633f
C1899 a_14858_3156# a_15493_2966# 0.13953f
C1900 a_37106_2496# a_36972_2182# 0.68196f
C1901 a_10853_10114# VDD 0.26764f
C1902 RB14 CLK 0.18513f
C1903 RA14 RA15 0.33341f
C1904 a_13325_3842# a_13021_3750# 0.40203f
C1905 a_21170_8800# RB3 0.1782f
C1906 a_15797_5410# RA7 0.1633f
C1907 a_11282_4692# VDD 0.28227f
C1908 a_22140_8454# VDD 0.41797f
C1909 a_35269_7670# RA4 0.14389f
C1910 a_24746_5632# a_24612_5318# 0.68196f
C1911 a_8810_n12# RB14 0.1782f
C1912 a_7308_6102# VDD 0.41797f
C1913 a_26114_7232# RB5 0.1782f
C1914 a_20741_3842# RA9 0.1633f
C1915 a_23642_7828# RB4 0.1782f
C1916 a_30629_4534# VDD 0.26764f
C1917 a_4970_10996# a_4836_10806# 0.68196f
C1918 a_5605_4534# a_5909_4534# 0.40203f
C1919 a_12386_3156# a_12252_2966# 0.68196f
C1920 a_8381_706# RA13 0.1633f
C1921 a_35269_6102# a_36002_6260# 0.12913f
C1922 a_12386_8768# a_12252_8454# 0.68196f
C1923 a_13021_2966# VDD 0.27315f
C1924 a_21170_7232# VDD 0.28227f
C1925 a_31058_5664# RB7 0.1782f
C1926 a_25685_2274# RA11 0.1633f
C1927 a_661_10806# VDD 0.27315f
C1928 a_29690_10336# a_29556_10022# 0.68196f
C1929 RB2 RB3 0.23766f
C1930 VDD WE7 0.22649f
C1931 WE3 RA3 0.10549f
C1932 a_23213_2966# RA10 0.1633f
C1933 a_4836_4534# VDD 0.41797f
C1934 a_17965_10806# a_18698_10964# 0.12913f
C1935 a_34634_928# a_34500_614# 0.68196f
C1936 a_26_20# a_n108_n170# 0.68196f
C1937 a_36002_4096# RB9 0.1782f
C1938 a_29690_7200# a_30325_6886# 0.13953f
C1939 a_6338_n608# RB15 0.1782f
C1940 a_19668_5318# VDD 0.41797f
C1941 a_37741_10022# RA1 0.14389f
C1942 a_29690_20# a_30325_n170# 0.13953f
C1943 a_7442_n640# a_8077_n954# 0.13953f
C1944 a_13325_9238# VDD 0.26764f
C1945 a_2364_2966# VDD 0.41797f
C1946 a_33530_3124# RB10 0.1782f
C1947 a_29556_614# VDD 0.41797f
C1948 a_9914_1588# a_9780_1398# 0.68196f
C1949 a_11282_10368# a_10549_10022# 0.12913f
C1950 a_18698_4096# VDD 0.28227f
C1951 a_35269_9238# VDD 0.27315f
C1952 a_21896_n1782# VDD 0.6765f
C1953 a_2498_20# a_2364_n170# 0.68196f
C1954 a_n108_1398# VDD 0.41823f
C1955 a_3229_n1738# D1 0.11075f
C1956 a_25685_10114# a_25381_10022# 0.40203f
C1957 a_30325_8454# VDD 0.27315f
C1958 a_12386_9428# VDD 0.41955f
C1959 VDD D14 0.36038f
C1960 a_n1652_9238# WE2 0.10075f
C1961 a_6338_n12# RB14 0.1782f
C1962 a_17196_2182# VDD 0.41797f
C1963 a_22274_2496# a_22140_2182# 0.68196f
C1964 a_13325_n862# VDD 0.26771f
C1965 a_9914_7860# VDD 0.41955f
C1966 a_27853_n954# RA15 0.14389f
C1967 a_15493_7670# RA4 0.14389f
C1968 a_9914_5632# a_9780_5318# 0.68196f
C1969 a_9780_10022# VDD 0.41797f
C1970 a_31058_8800# a_30325_8454# 0.12913f
C1971 a_31058_6260# VDD 0.28227f
C1972 a_3866_7828# RB4 0.1782f
C1973 a_17196_10806# VDD 0.41797f
C1974 a_10853_4534# VDD 0.26764f
C1975 a_22274_8768# VDD 0.41955f
C1976 a_25381_6102# a_26114_6260# 0.12913f
C1977 a_27853_5318# VDD 0.27315f
C1978 a_27218_4064# a_27853_3750# 0.13953f
C1979 a_7442_6292# VDD 0.41955f
C1980 a_1394_5664# RB7 0.1782f
C1981 a_26_10996# WE0CLK 0.28565f
C1982 a_14858_10336# a_14724_10022# 0.68196f
C1983 a_661_7670# VDD 0.27315f
C1984 a_3437_2966# RA10 0.1633f
C1985 a_32797_4534# VDD 0.27315f
C1986 a_35573_6102# RA6 0.1633f
C1987 a_10549_10806# a_11282_10964# 0.12913f
C1988 a_35269_6102# a_35573_6102# 0.40203f
C1989 a_13021_614# RA13 0.14389f
C1990 a_28157_n170# RA14 0.1633f
C1991 a_19802_928# a_19668_614# 0.68196f
C1992 a_23642_10964# RB0 0.1782f
C1993 a_14858_7200# a_15493_6886# 0.13953f
C1994 a_6338_4096# RB9 0.1782f
C1995 a_20741_6978# VDD 0.26764f
C1996 a_25381_2966# RA10 0.14389f
C1997 a_4970_4724# VDD 0.41955f
C1998 a_8077_10022# RA1 0.14389f
C1999 a_32797_1398# a_33530_1556# 0.12913f
C2000 a_11282_2528# RB11 0.1782f
C2001 a_19668_10806# WE0CLK 0.22071f
C2002 a_37232_n1738# WEM 0.29267f
C2003 a_13754_3124# RB10 0.1782f
C2004 a_11282_960# a_10549_614# 0.12913f
C2005 a_26_5632# a_n108_5318# 0.68196f
C2006 a_19802_5632# VDD 0.41955f
C2007 a_13021_8454# RA3 0.14389f
C2008 a_25381_2182# VDD 0.27315f
C2009 a_1394_7828# VDD 0.28227f
C2010 a_3866_n12# RB14 0.1782f
C2011 a_661_2182# RA11 0.14389f
C2012 a_15493_9238# VDD 0.27315f
C2013 a_2498_3156# VDD 0.41955f
C2014 VDD WE12 0.22649f
C2015 a_28586_1556# VDD 0.28227f
C2016 a_29690_928# VDD 0.41955f
C2017 a_17965_6886# RA5 0.14389f
C2018 a_32797_10806# a_33101_10806# 0.40203f
C2019 a_10853_10114# a_10549_10022# 0.40203f
C2020 a_965_2274# VDD 0.26764f
C2021 a_18269_3842# VDD 0.26764f
C2022 a_19928_n1738# VDD 0.49525f
C2023 a_22909_5318# RA7 0.14389f
C2024 a_9914_928# a_9780_614# 0.68196f
C2025 a_7442_2496# a_7308_2182# 0.68196f
C2026 a_28586_5664# a_27853_5318# 0.12913f
C2027 a_36002_10964# VDD 0.28226f
C2028 a_9780_9238# VDD 0.41797f
C2029 a_26_928# VDD 0.41955f
C2030 a_27853_3750# RA9 0.14389f
C2031 a_17330_2496# VDD 0.41955f
C2032 a_965_2966# RA10 0.1633f
C2033 a_16226_8800# a_15493_8454# 0.12913f
C2034 a_11282_6260# VDD 0.28227f
C2035 a_12252_n954# VDD 0.4212f
C2036 a_15797_10114# RA1 0.1633f
C2037 a_32797_2182# RA11 0.14389f
C2038 a_7308_7670# VDD 0.41797f
C2039 a_15493_6102# a_16226_6260# 0.12913f
C2040 a_27853_614# VDD 0.27315f
C2041 a_32162_7860# a_32797_7670# 0.13953f
C2042 a_9914_10336# VDD 0.41955f
C2043 a_4970_20# a_4836_n170# 0.68196f
C2044 a_12386_4064# a_13021_3750# 0.13953f
C2045 a_30629_6102# VDD 0.26764f
C2046 a_30629_8546# a_30325_8454# 0.40203f
C2047 a_2498_9428# a_3133_9238# 0.13953f
C2048 RA12 RA13 0.33341f
C2049 a_13021_4534# VDD 0.27315f
C2050 a_17330_10996# VDD 0.41954f
C2051 a_21170_8800# VDD 0.28227f
C2052 a_15797_6102# RA6 0.1633f
C2053 a_25381_6102# a_25685_6102# 0.40203f
C2054 a_32162_n640# a_32028_n954# 0.68196f
C2055 a_38474_10368# VDD 0.27344f
C2056 a_31058_10368# RB1 0.1782f
C2057 a_8810_10964# RB0 0.1782f
C2058 a_4836_6102# VDD 0.41797f
C2059 a_30629_10806# RA0 0.1633f
C2060 a_5605_2966# RA10 0.14389f
C2061 a_37741_6102# RA6 0.14389f
C2062 a_22909_1398# a_23642_1556# 0.12913f
C2063 a_30325_n170# RA14 0.14389f
C2064 a_26_6292# a_n108_6102# 0.68196f
C2065 a_19668_6886# VDD 0.41797f
C2066 a_3133_2966# a_3866_3124# 0.12913f
C2067 a_26114_6260# RB6 0.1782f
C2068 a_2364_4534# VDD 0.41797f
C2069 a_18698_n12# RB14 0.1782f
C2070 a_32797_1398# a_33101_1398# 0.40203f
C2071 a_661_1398# a_1394_1556# 0.12913f
C2072 VDD RB2 2.79986f
C2073 a_19802_10996# WE0CLK 0.28565f
C2074 a_36728_n1782# WEM 0.23385f
C2075 a_10853_706# a_10549_614# 0.40203f
C2076 a_25685_1398# RA12 0.1633f
C2077 a_661_7670# RA4 0.14389f
C2078 a_8810_1556# VDD 0.28227f
C2079 a_18698_5664# VDD 0.28227f
C2080 a_26114_n12# VDD 0.28227f
C2081 a_25381_10806# a_25685_10806# 0.40203f
C2082 a_26114_2528# a_25381_2182# 0.12913f
C2083 a_n108_2966# VDD 0.41823f
C2084 a_37837_n1738# WEM 0.14268f
C2085 a_20437_n954# VDD 0.27315f
C2086 a_29312_n1782# a_29816_n1738# 0.67695f
C2087 a_30325_10022# VDD 0.27315f
C2088 a_28157_1398# VDD 0.26764f
C2089 a_28586_960# VDD 0.28227f
C2090 a_2176_10806# WE0CLK 0.13896f
C2091 a_n108_2182# VDD 0.41823f
C2092 a_13754_5664# a_13021_5318# 0.12913f
C2093 a_17196_3750# VDD 0.41797f
C2094 a_21170_10964# VDD 0.28226f
C2095 a_36002_1556# RB12 0.1782f
C2096 a_19424_n1782# VDD 0.6765f
C2097 a_24746_10336# a_25381_10022# 0.13953f
C2098 a_29690_4724# a_30325_4534# 0.13953f
C2099 a_26_9428# a_661_9238# 0.13953f
C2100 a_19802_9428# a_19668_9238# 0.68196f
C2101 a_28157_5410# a_27853_5318# 0.40203f
C2102 a_33530_960# a_32797_614# 0.12913f
C2103 a_9914_9428# VDD 0.41955f
C2104 a_14858_10996# a_15493_10806# 0.13953f
C2105 a_3133_2182# RA11 0.14389f
C2106 a_16226_2528# VDD 0.28275f
C2107 a_31058_7828# VDD 0.28227f
C2108 WE8 RA8 0.10549f
C2109 RB7 RB8 0.39209f
C2110 VDD D1 0.36033f
C2111 a_5605_6102# a_6338_6260# 0.12913f
C2112 a_13325_706# RA13 0.1633f
C2113 a_17330_7860# a_17965_7670# 0.13953f
C2114 a_3133_2966# RA10 0.14389f
C2115 a_15797_8546# a_15493_8454# 0.40203f
C2116 a_10853_6102# VDD 0.26764f
C2117 a_12386_n640# VDD 0.41954f
C2118 a_27853_6886# VDD 0.27315f
C2119 a_33101_8546# RA3 0.1633f
C2120 a_7442_7860# VDD 0.41955f
C2121 a_28157_9238# RA2 0.1633f
C2122 a_15493_6102# a_15797_6102# 0.40203f
C2123 a_17330_n640# a_17196_n954# 0.68196f
C2124 a_8810_10368# VDD 0.28275f
C2125 a_661_9238# VDD 0.27315f
C2126 a_1394_10368# RB1 0.1782f
C2127 a_32797_6102# VDD 0.27315f
C2128 a_15797_10806# RA0 0.1633f
C2129 a_38045_6978# RA5 0.1633f
C2130 a_8810_960# VDD 0.28275f
C2131 a_28586_960# RB13 0.1782f
C2132 a_20741_8546# VDD 0.26764f
C2133 a_17965_6102# RA6 0.14389f
C2134 a_13021_1398# a_13754_1556# 0.12913f
C2135 a_30325_n170# a_31058_n12# 0.12913f
C2136 a_17330_7860# a_17196_7670# 0.68196f
C2137 a_38045_10114# VDD 0.26764f
C2138 a_4970_6292# VDD 0.41955f
C2139 a_n1652_10806# WE0CLK 0.14793f
C2140 a_32797_10806# RA0 0.14389f
C2141 a_6338_6260# RB6 0.1782f
C2142 a_22909_1398# a_23213_1398# 0.40203f
C2143 a_19802_7200# VDD 0.41955f
C2144 a_3133_2966# a_3437_2966# 0.40203f
C2145 a_1394_9396# VDD 0.28227f
C2146 a_25381_3750# VDD 0.27315f
C2147 a_18269_n862# RA15 0.1633f
C2148 a_7442_20# a_7308_n170# 0.68196f
C2149 a_5909_1398# RA12 0.1633f
C2150 RB14 RB15 0.23766f
C2151 WE15 RA15 0.10549f
C2152 a_2498_4724# VDD 0.41955f
C2153 a_17965_10806# a_18269_10806# 0.40203f
C2154 a_11282_2528# a_10549_2182# 0.12913f
C2155 a_38474_10964# RB0 0.1782f
C2156 a_28586_3124# VDD 0.28227f
C2157 a_34760_n1738# WEM 0.29267f
C2158 a_965_3842# VDD 0.26764f
C2159 a_27853_1398# RA12 0.14389f
C2160 a_8381_1398# VDD 0.26764f
C2161 a_18269_5410# VDD 0.26764f
C2162 a_25685_n170# VDD 0.26764f
C2163 a_27218_1588# a_27853_1398# 0.13953f
C2164 a_14858_6292# a_14724_6102# 0.68196f
C2165 a_25685_2274# a_25381_2182# 0.40203f
C2166 a_6338_10964# VDD 0.28226f
C2167 a_33530_n608# RB15 0.1782f
C2168 a_16226_1556# RB12 0.1782f
C2169 a_8810_960# RB13 0.1782f
C2170 a_30325_1398# VDD 0.27315f
C2171 a_28157_706# VDD 0.26764f
C2172 a_14858_4724# a_15493_4534# 0.13953f
C2173 a_9914_10336# a_10549_10022# 0.13953f
C2174 a_37106_4064# a_36972_3750# 0.68196f
C2175 RA3 RB3 18.9728f
C2176 VDD RB7 2.80275f
C2177 a_13325_5410# a_13021_5318# 0.40203f
C2178 a_17330_4064# VDD 0.41955f
C2179 a_18698_960# a_17965_614# 0.12913f
C2180 a_17330_20# a_17965_n170# 0.13953f
C2181 a_17456_n1738# VDD 0.49525f
C2182 a_3133_n170# a_3866_n12# 0.12913f
C2183 a_11282_7828# VDD 0.28227f
C2184 a_37106_1588# a_36972_1398# 0.68196f
C2185 a_24746_7200# a_24612_6886# 0.68196f
C2186 a_10549_614# VDD 0.27315f
C2187 a_36002_n608# a_35269_n954# 0.12913f
C2188 a_7308_9238# VDD 0.41797f
C2189 a_33101_706# a_32797_614# 0.40203f
C2190 a_3437_8546# RA3 0.1633f
C2191 a_15797_2274# VDD 0.26764f
C2192 a_30629_7670# VDD 0.26764f
C2193 a_8381_9238# RA2 0.1633f
C2194 a_5605_6102# a_5909_6102# 0.40203f
C2195 a_2498_n640# a_2364_n954# 0.68196f
C2196 a_12386_4724# a_12252_4534# 0.68196f
C2197 a_35269_7670# a_36002_7828# 0.12913f
C2198 a_13021_6102# VDD 0.27315f
C2199 a_11282_n608# VDD 0.28233f
C2200 a_26_928# a_661_614# 0.13953f
C2201 a_8381_6978# RA5 0.1633f
C2202 a_24424_10806# WE0CLK 0.13896f
C2203 a_4836_7670# VDD 0.41797f
C2204 a_30325_9238# RA2 0.14389f
C2205 a_20437_n170# a_21170_n12# 0.12913f
C2206 a_8381_10114# VDD 0.26764f
C2207 a_29690_8768# a_30325_8454# 0.13953f
C2208 a_18698_8800# RB3 0.1782f
C2209 a_17965_10806# RA0 0.14389f
C2210 a_13325_5410# RA7 0.1633f
C2211 a_18698_9396# RB2 0.1782f
C2212 a_14724_10806# VDD 0.41797f
C2213 a_19668_8454# VDD 0.41797f
C2214 a_13021_1398# a_13325_1398# 0.40203f
C2215 a_30325_n170# a_30629_n170# 0.40203f
C2216 a_36972_10022# VDD 0.41797f
C2217 a_2364_6102# VDD 0.41797f
C2218 a_23642_7232# RB5 0.1782f
C2219 a_18269_3842# RA9 0.1633f
C2220 a_2498_20# VDD 0.41955f
C2221 a_18269_4534# RA8 0.1633f
C2222 a_10549_10806# a_10853_10806# 0.40203f
C2223 a_9914_3156# a_9780_2966# 0.68196f
C2224 a_8810_3124# VDD 0.28227f
C2225 a_18698_7232# VDD 0.28227f
C2226 a_28586_5664# RB7 0.1782f
C2227 a_23213_2274# RA11 0.1633f
C2228 a_8077_1398# RA12 0.14389f
C2229 a_n108_4534# VDD 0.41823f
C2230 a_12386_1588# a_13021_1398# 0.13953f
C2231 a_10853_2274# a_10549_2182# 0.40203f
C2232 a_17196_10806# WE0CLK 0.22071f
C2233 a_33530_4096# RB9 0.1782f
C2234 a_28157_2966# VDD 0.26764f
C2235 a_3866_n608# RB15 0.1782f
C2236 a_34256_n1782# WEM 0.23385f
C2237 a_n352_n1782# a_152_n1738# 0.67695f
C2238 a_28586_4692# RB8 0.1782f
C2239 a_n108_3750# VDD 0.41823f
C2240 a_10549_1398# VDD 0.27315f
C2241 a_27853_n170# VDD 0.27315f
C2242 a_17196_5318# VDD 0.41797f
C2243 a_38474_n12# RB14 0.1782f
C2244 a_22274_4064# a_22140_3750# 0.68196f
C2245 a_35269_10022# RA1 0.14389f
C2246 a_38474_2528# RB11 0.1782f
C2247 a_27084_614# VDD 0.41797f
C2248 a_7442_1588# a_7308_1398# 0.68196f
C2249 a_9914_7200# a_9780_6886# 0.68196f
C2250 a_9914_20# a_9780_n170# 0.68196f
C2251 a_21170_n608# a_20437_n954# 0.12913f
C2252 a_18269_706# a_17965_614# 0.40203f
C2253 a_31058_9396# VDD 0.28227f
C2254 a_16226_4096# VDD 0.28275f
C2255 a_16952_n1782# VDD 0.6765f
C2256 a_3133_n170# a_3437_n170# 0.40203f
C2257 a_10853_7670# VDD 0.26764f
C2258 a_25381_7670# a_26114_7828# 0.12913f
C2259 a_27853_8454# VDD 0.27315f
C2260 a_27218_5632# a_27853_5318# 0.13953f
C2261 a_35573_10806# VDD 0.26763f
C2262 a_35573_n862# a_35269_n954# 0.40203f
C2263 a_7442_9428# VDD 0.41955f
C2264 a_9592_10806# WE0CLK 0.13896f
C2265 a_14724_2182# VDD 0.41797f
C2266 a_32797_7670# VDD 0.27315f
C2267 a_10549_9238# RA2 0.14389f
C2268 a_965_2274# a_661_2182# 0.40203f
C2269 a_35269_7670# a_35573_7670# 0.40203f
C2270 VDD RB12 2.79986f
C2271 a_14858_8768# a_15493_8454# 0.13953f
C2272 a_10853_n862# VDD 0.26771f
C2273 a_4970_7860# VDD 0.41955f
C2274 a_25381_n954# RA15 0.14389f
C2275 a_20437_n170# a_20741_n170# 0.40203f
C2276 a_32797_2966# a_33530_3124# 0.12913f
C2277 a_7308_10022# VDD 0.41797f
C2278 a_26_7200# a_n108_6886# 0.68196f
C2279 a_14858_10996# VDD 0.41954f
C2280 a_19802_8768# VDD 0.41955f
C2281 a_965_n862# RA15 0.1633f
C2282 a_30629_7670# RA4 0.1633f
C2283 a_965_706# VDD 0.26764f
C2284 a_25381_5318# VDD 0.27315f
C2285 a_37106_10336# VDD 0.41955f
C2286 a_2498_6292# VDD 0.41955f
C2287 a_1394_3124# RB10 0.1782f
C2288 a_n108_n170# VDD 0.41823f
C2289 a_28586_4692# VDD 0.28227f
C2290 a_20437_4534# RA8 0.14389f
C2291 a_965_5410# VDD 0.26764f
C2292 a_8381_2966# VDD 0.26764f
C2293 a_3866_4096# RB9 0.1782f
C2294 a_18269_6978# VDD 0.26764f
C2295 a_8810_4692# RB8 0.1782f
C2296 a_22274_10996# a_22140_10806# 0.68196f
C2297 a_5605_10022# RA1 0.14389f
C2298 a_7442_4064# a_7308_3750# 0.68196f
C2299 RB12 RB13 0.23766f
C2300 WE13 RA13 0.10549f
C2301 a_8810_2528# RB11 0.1782f
C2302 a_17330_10996# WE0CLK 0.28565f
C2303 a_30325_2966# VDD 0.27315f
C2304 a_28586_7232# a_27853_6886# 0.12913f
C2305 a_32288_n1738# WEM 0.29267f
C2306 a_17330_5632# VDD 0.41955f
C2307 a_10549_8454# RA3 0.14389f
C2308 a_22909_2182# VDD 0.27315f
C2309 a_24746_2496# a_25381_2182# 0.13953f
C2310 a_7442_20# VDD 0.41955f
C2311 a_6338_n608# a_5605_n954# 0.12913f
C2312 a_11282_9396# VDD 0.28227f
C2313 a_35365_n1738# WEM 0.14287f
C2314 a_15493_6886# RA5 0.14389f
C2315 a_27218_928# VDD 0.41955f
C2316 a_15493_7670# a_16226_7828# 0.12913f
C2317 a_32162_9428# a_32797_9238# 0.13953f
C2318 a_20741_n862# a_20437_n954# 0.40203f
C2319 a_12386_5632# a_13021_5318# 0.13953f
C2320 a_15797_3842# VDD 0.26764f
C2321 a_20741_10806# VDD 0.26763f
C2322 a_30629_9238# VDD 0.26764f
C2323 VDD RA3 3.36997f
C2324 a_14984_n1738# VDD 0.49525f
C2325 a_13021_7670# VDD 0.27315f
C2326 a_20437_5318# RA7 0.14389f
C2327 a_25381_7670# a_25685_7670# 0.40203f
C2328 a_37741_10806# VDD 0.27315f
C2329 a_4836_9238# VDD 0.41797f
C2330 a_32162_928# a_32797_614# 0.13953f
C2331 a_n1652_n522# CLK 0.25473f
C2332 a_25381_3750# RA9 0.14389f
C2333 a_14858_2496# VDD 0.41955f
C2334 a_22909_2966# a_23642_3124# 0.12913f
C2335 a_26_7860# a_n108_7670# 0.68196f
C2336 a_9780_n954# VDD 0.4212f
C2337 a_24746_10996# a_25381_10806# 0.13953f
C2338 a_3133_4534# a_3866_4692# 0.12913f
C2339 a_13325_10114# RA1 0.1633f
C2340 a_12386_20# a_12252_n170# 0.68196f
C2341 a_30325_2182# RA11 0.14389f
C2342 a_965_3842# RA9 0.1633f
C2343 a_2364_7670# VDD 0.41797f
C2344 a_10853_7670# RA4 0.1633f
C2345 a_661_2966# a_1394_3124# 0.12913f
C2346 a_32797_2966# a_33101_2966# 0.40203f
C2347 a_25381_614# VDD 0.27315f
C2348 a_7442_10336# VDD 0.41955f
C2349 a_8810_4692# VDD 0.28227f
C2350 a_18698_8800# VDD 0.28227f
C2351 a_32797_7670# RA4 0.14389f
C2352 a_36002_10368# VDD 0.28275f
C2353 a_28586_10368# RB1 0.1782f
C2354 a_26114_4096# a_25381_3750# 0.12913f
C2355 a_n108_6102# VDD 0.41823f
C2356 RA8 RB8 18.9728f
C2357 RB1 CLK 0.18513f
C2358 VDD D3 0.36038f
C2359 a_21170_7828# RB4 0.1782f
C2360 a_38474_9396# RB2 0.1782f
C2361 a_28157_4534# VDD 0.26764f
C2362 a_2498_10996# a_2364_10806# 0.68196f
C2363 a_8077_n170# a_8810_n12# 0.12913f
C2364 a_n108_5318# VDD 0.41823f
C2365 a_13754_7232# a_13021_6886# 0.12913f
C2366 a_10549_2966# VDD 0.27315f
C2367 a_17196_6886# VDD 0.41797f
C2368 a_20741_2966# RA10 0.1633f
C2369 a_38045_4534# RA8 0.1633f
C2370 a_29690_6292# a_30325_6102# 0.13953f
C2371 a_9780_614# VDD 0.41797f
C2372 a_9914_2496# a_10549_2182# 0.13953f
C2373 a_1394_10368# a_661_10022# 0.12913f
C2374 a_28157_6978# a_27853_6886# 0.40203f
C2375 a_31784_n1782# WEM 0.23385f
C2376 a_16226_5664# VDD 0.28275f
C2377 a_6338_960# a_5605_614# 0.12913f
C2378 a_5605_7670# a_6338_7828# 0.12913f
C2379 a_17330_9428# a_17965_9238# 0.13953f
C2380 a_5909_n862# a_5605_n954# 0.40203f
C2381 a_5909_10806# VDD 0.26763f
C2382 a_4836_n170# VDD 0.41797f
C2383 a_10853_9238# VDD 0.26764f
C2384 a_31058_3124# RB10 0.1782f
C2385 a_26840_n1782# a_27344_n1738# 0.67695f
C2386 a_17965_n954# VDD 0.27315f
C2387 a_27853_10022# VDD 0.27315f
C2388 a_26114_960# VDD 0.28227f
C2389 a_15493_7670# a_15797_7670# 0.40203f
C2390 CLK RB15 0.18385f
C2391 a_22909_10806# VDD 0.27315f
C2392 a_14724_3750# VDD 0.41797f
C2393 a_n1652_4182# WE9 0.10075f
C2394 a_32797_9238# VDD 0.27315f
C2395 a_17330_928# a_17965_614# 0.13953f
C2396 a_14480_n1782# VDD 0.6765f
C2397 a_13021_2966# a_13754_3124# 0.12913f
C2398 a_17330_9428# a_17196_9238# 0.68196f
C2399 a_34634_n640# a_35269_n954# 0.13953f
C2400 a_4970_9428# VDD 0.41955f
C2401 a_35365_n1738# D14 0.11075f
C2402 a_12386_20# VDD 0.41955f
C2403 a_13754_2528# VDD 0.28227f
C2404 a_10853_706# RA13 0.1633f
C2405 a_22909_2966# a_23213_2966# 0.40203f
C2406 a_38474_10368# a_37741_10022# 0.12913f
C2407 a_9914_n640# VDD 0.41954f
C2408 a_3133_4534# a_3437_4534# 0.40203f
C2409 a_25381_6886# VDD 0.27315f
C2410 VDD RA8 3.36972f
C2411 RA3 RA4 0.30166f
C2412 a_30629_8546# RA3 0.1633f
C2413 a_2498_7860# VDD 0.41955f
C2414 a_13021_7670# RA4 0.14389f
C2415 a_6338_10368# VDD 0.28227f
C2416 a_11282_4096# a_10549_3750# 0.12913f
C2417 a_38474_n608# VDD 0.2735f
C2418 a_28586_6260# VDD 0.28227f
C2419 a_965_6978# VDD 0.26764f
C2420 a_35573_6978# RA5 0.1633f
C2421 a_26114_960# RB13 0.1782f
C2422 a_12252_10806# VDD 0.41797f
C2423 a_8381_4534# VDD 0.26764f
C2424 a_18269_8546# VDD 0.26764f
C2425 a_27218_3156# a_27853_2966# 0.13953f
C2426 a_14858_7860# a_14724_7670# 0.68196f
C2427 a_35573_10114# VDD 0.26764f
C2428 a_25685_3842# a_25381_3750# 0.40203f
C2429 a_30325_4534# VDD 0.27315f
C2430 a_965_706# a_661_614# 0.40203f
C2431 a_33101_6102# RA6 0.1633f
C2432 a_8077_n170# a_8381_n170# 0.40203f
C2433 a_14858_6292# a_15493_6102# 0.13953f
C2434 a_37106_5632# a_36972_5318# 0.68196f
C2435 a_14858_20# a_14724_n170# 0.68196f
C2436 a_25685_n170# RA14 0.1633f
C2437 a_13325_6978# a_13021_6886# 0.40203f
C2438 a_17330_7200# VDD 0.41955f
C2439 a_22909_3750# VDD 0.27315f
C2440 a_15797_n862# RA15 0.1633f
C2441 a_22909_2966# RA10 0.14389f
C2442 a_37106_3156# a_36972_2966# 0.68196f
C2443 a_24746_8768# a_24612_8454# 0.68196f
C2444 a_965_10114# a_661_10022# 0.40203f
C2445 a_14724_10806# WE0CLK 0.22071f
C2446 a_29816_n1738# WEM 0.29267f
C2447 RB6 CLK 0.18513f
C2448 a_11282_3124# RB10 0.1782f
C2449 a_15797_5410# VDD 0.26764f
C2450 a_36002_n12# RB14 0.1782f
C2451 a_5605_7670# a_5909_7670# 0.40203f
C2452 a_35269_9238# a_36002_9396# 0.12913f
C2453 a_12386_6292# a_12252_6102# 0.68196f
C2454 a_8077_10806# VDD 0.27315f
C2455 a_13021_9238# VDD 0.27315f
C2456 a_31058_n608# RB15 0.1782f
C2457 a_26114_1556# VDD 0.28227f
C2458 a_25685_706# VDD 0.26764f
C2459 a_5605_n170# a_6338_n12# 0.12913f
C2460 a_19802_n640# a_20437_n954# 0.13953f
C2461 a_14858_4064# VDD 0.41955f
C2462 a_12512_n1738# VDD 0.49525f
C2463 a_13021_2966# a_13325_2966# 0.40203f
C2464 a_34634_1588# a_34500_1398# 0.68196f
C2465 a_23642_10368# a_22909_10022# 0.12913f
C2466 a_2364_9238# VDD 0.41797f
C2467 a_661_10806# a_1394_10964# 0.12913f
C2468 a_9780_n170# VDD 0.41797f
C2469 a_13325_2274# VDD 0.26764f
C2470 a_9914_4724# a_9780_4534# 0.68196f
C2471 a_38045_10114# a_37741_10022# 0.40203f
C2472 a_8810_6260# VDD 0.28227f
C2473 a_8810_n608# VDD 0.28281f
C2474 a_5909_6978# RA5 0.1633f
C2475 a_n108_7670# VDD 0.41823f
C2476 a_12386_3156# a_13021_2966# 0.13953f
C2477 a_34634_2496# a_34500_2182# 0.68196f
C2478 a_5909_10114# VDD 0.26764f
C2479 a_10853_3842# a_10549_3750# 0.40203f
C2480 a_28157_6102# VDD 0.26764f
C2481 a_38045_n862# VDD 0.26771f
C2482 a_37106_20# a_37741_n170# 0.13953f
C2483 a_16226_8800# RB3 0.1782f
C2484 a_n108_6886# VDD 0.41823f
C2485 a_10853_5410# RA7 0.1633f
C2486 a_10549_4534# VDD 0.27315f
C2487 a_12386_10996# VDD 0.41954f
C2488 a_17196_8454# VDD 0.41797f
C2489 a_13325_6102# RA6 0.1633f
C2490 a_22274_5632# a_22140_5318# 0.68196f
C2491 a_34500_10022# VDD 0.41797f
C2492 a_17330_20# VDD 0.41955f
C2493 a_21170_7232# RB5 0.1782f
C2494 a_15797_3842# RA9 0.1633f
C2495 VDD RA13 3.36997f
C2496 a_35269_6102# RA6 0.14389f
C2497 a_7442_3156# a_7308_2966# 0.68196f
C2498 a_9914_8768# a_9780_8454# 0.68196f
C2499 a_27853_n170# RA14 0.14389f
C2500 a_16226_7232# VDD 0.28275f
C2501 a_26114_5664# RB7 0.1782f
C2502 a_20741_2274# RA11 0.1633f
C2503 a_27218_10336# a_27084_10022# 0.68196f
C2504 a_23642_6260# RB6 0.1782f
C2505 a_16226_n12# RB14 0.1782f
C2506 a_25381_9238# a_26114_9396# 0.12913f
C2507 a_37741_614# RA13 0.14389f
C2508 a_32162_928# a_32028_614# 0.68196f
C2509 a_14858_10996# WE0CLK 0.28565f
C2510 a_36002_10964# RB0 0.1782f
C2511 a_27218_7200# a_27853_6886# 0.13953f
C2512 a_31058_4096# RB9 0.1782f
C2513 a_29312_n1782# WEM 0.23385f
C2514 a_1394_n608# RB15 0.1782f
C2515 a_2498_928# VDD 0.41955f
C2516 a_23213_1398# RA12 0.1633f
C2517 a_6338_1556# VDD 0.28227f
C2518 a_14724_5318# VDD 0.41797f
C2519 a_23642_n12# VDD 0.28227f
C2520 a_32797_10022# RA1 0.14389f
C2521 a_965_3842# a_661_3750# 0.40203f
C2522 a_35269_9238# a_35573_9238# 0.40203f
C2523 a_36002_2528# RB11 0.1782f
C2524 a_4970_n640# a_5605_n954# 0.13953f
C2525 a_32893_n1738# WEM 0.14287f
C2526 a_17330_20# a_17196_n170# 0.68196f
C2527 a_25685_1398# VDD 0.26764f
C2528 a_24612_614# VDD 0.41797f
C2529 a_37741_8454# RA3 0.14389f
C2530 a_4970_1588# a_4836_1398# 0.68196f
C2531 a_8810_10368# a_8077_10022# 0.12913f
C2532 a_32797_4534# a_33530_4692# 0.12913f
C2533 a_5605_n170# a_5909_n170# 0.40203f
C2534 a_13754_4096# VDD 0.28227f
C2535 a_33530_1556# RB12 0.1782f
C2536 a_12008_n1782# VDD 0.6765f
C2537 RA13 RB13 18.9728f
C2538 RB11 CLK 0.18513f
C2539 a_n1652_n170# WE14 0.10075f
C2540 a_26_8768# a_n108_8454# 0.68196f
C2541 a_23213_10114# a_22909_10022# 0.40203f
C2542 a_25381_8454# VDD 0.27315f
C2543 a_2498_9428# VDD 0.41955f
C2544 a_12252_2182# VDD 0.41797f
C2545 a_28586_7828# VDD 0.28227f
C2546 a_19802_2496# a_19668_2182# 0.68196f
C2547 a_965_8546# VDD 0.26764f
C2548 a_8381_6102# VDD 0.26764f
C2549 a_8381_n862# VDD 0.26771f
C2550 a_n1652_7670# WE4 0.10075f
C2551 a_22909_n954# RA15 0.14389f
C2552 VDD WE4 0.22649f
C2553 a_25685_9238# RA2 0.1633f
C2554 a_7442_5632# a_7308_5318# 0.68196f
C2555 a_4836_10022# VDD 0.41797f
C2556 a_28586_8800# a_27853_8454# 0.12913f
C2557 a_30325_6102# VDD 0.27315f
C2558 a_36972_n954# VDD 0.4212f
C2559 a_34634_10996# a_35269_10806# 0.13953f
C2560 a_17330_8768# VDD 0.41955f
C2561 a_15493_6102# RA6 0.14389f
C2562 a_22909_5318# VDD 0.27315f
C2563 a_34634_10336# VDD 0.41955f
C2564 a_2498_928# a_2364_614# 0.68196f
C2565 a_14724_n170# VDD 0.41797f
C2566 a_24746_4064# a_25381_3750# 0.13953f
C2567 a_12386_10336# a_12252_10022# 0.68196f
C2568 a_3866_6260# RB6 0.1782f
C2569 a_36002_9396# RB2 0.1782f
C2570 a_15493_9238# a_16226_9396# 0.12913f
C2571 a_17330_928# a_17196_614# 0.68196f
C2572 a_21170_10964# RB0 0.1782f
C2573 a_12386_7200# a_13021_6886# 0.13953f
C2574 a_1394_4096# RB9 0.1782f
C2575 a_15797_6978# VDD 0.26764f
C2576 a_3437_1398# RA12 0.1633f
C2577 a_35573_4534# RA8 0.1633f
C2578 a_3133_10022# RA1 0.14389f
C2579 a_25381_9238# a_25685_9238# 0.40203f
C2580 a_6338_2528# RB11 0.1782f
C2581 a_26114_3124# VDD 0.28227f
C2582 a_27344_n1738# WEM 0.29267f
C2583 a_25381_1398# RA12 0.14389f
C2584 a_22274_20# VDD 0.41955f
C2585 a_5909_1398# VDD 0.26764f
C2586 a_14858_5632# VDD 0.41955f
C2587 a_23213_n170# VDD 0.26764f
C2588 VDD D5 0.36038f
C2589 RA8 RA9 0.33341f
C2590 a_8077_8454# RA3 0.14389f
C2591 a_30421_n1738# D12 0.11075f
C2592 a_22909_4534# a_23642_4692# 0.12913f
C2593 a_20437_2182# VDD 0.27315f
C2594 a_26_9428# a_n108_9238# 0.68196f
C2595 a_13754_1556# RB12 0.1782f
C2596 a_3133_6102# a_3866_6260# 0.12913f
C2597 a_27853_1398# VDD 0.27315f
C2598 a_24746_928# VDD 0.41955f
C2599 a_13021_6886# RA5 0.14389f
C2600 a_661_4534# a_1394_4692# 0.12913f
C2601 a_8381_10114# a_8077_10022# 0.40203f
C2602 a_32797_4534# a_33101_4534# 0.40203f
C2603 a_38474_2528# a_37741_2182# 0.12913f
C2604 a_13325_3842# VDD 0.26764f
C2605 a_10040_n1738# VDD 0.49525f
C2606 a_8810_7828# VDD 0.28227f
C2607 a_17965_5318# RA7 0.14389f
C2608 a_4970_2496# a_4836_2182# 0.68196f
C2609 a_26114_5664# a_25381_5318# 0.12913f
C2610 a_33530_10964# VDD 0.28226f
C2611 a_n108_9238# VDD 0.41823f
C2612 a_22909_3750# RA9 0.14389f
C2613 a_12386_2496# VDD 0.41955f
C2614 a_28157_7670# VDD 0.26764f
C2615 a_5909_9238# RA2 0.1633f
C2616 a_37106_10336# a_37741_10022# 0.13953f
C2617 a_19802_20# a_19668_n170# 0.68196f
C2618 a_26_20# a_661_n170# 0.13953f
C2619 a_n108_8454# VDD 0.41823f
C2620 a_13754_8800# a_13021_8454# 0.12913f
C2621 a_10549_6102# VDD 0.27315f
C2622 a_7308_n954# VDD 0.4212f
C2623 a_10853_10114# RA1 0.1633f
C2624 a_27853_2182# RA11 0.14389f
C2625 a_27853_9238# RA2 0.14389f
C2626 a_22909_614# VDD 0.27315f
C2627 a_38045_706# RA13 0.1633f
C2628 a_29690_7860# a_30325_7670# 0.13953f
C2629 a_4970_10336# VDD 0.41955f
C2630 a_965_1398# RA12 0.1633f
C2631 a_9914_4064# a_10549_3750# 0.13953f
C2632 a_28157_8546# a_27853_8454# 0.40203f
C2633 a_37106_n640# VDD 0.41954f
C2634 a_16226_9396# RB2 0.1782f
C2635 a_9780_10806# VDD 0.41797f
C2636 a_16226_8800# VDD 0.28275f
C2637 a_5605_9238# a_6338_9396# 0.12913f
C2638 a_29690_n640# a_29556_n954# 0.68196f
C2639 a_33530_10368# VDD 0.28227f
C2640 a_6338_10964# RB0 0.1782f
C2641 a_26114_10368# RB1 0.1782f
C2642 a_28157_10806# RA0 0.1633f
C2643 a_15797_4534# RA8 0.1633f
C2644 a_15493_9238# a_15797_9238# 0.40203f
C2645 VDD WE9 0.22649f
C2646 RB3 RB4 0.39209f
C2647 WE4 RA4 0.10549f
C2648 a_6338_3124# VDD 0.28227f
C2649 a_14724_6886# VDD 0.41797f
C2650 a_661_614# RA13 0.14389f
C2651 a_5605_1398# RA12 0.14389f
C2652 a_37741_4534# RA8 0.14389f
C2653 a_13021_4534# a_13754_4692# 0.12913f
C2654 a_12252_10806# WE0CLK 0.22071f
C2655 a_25685_2966# VDD 0.26764f
C2656 a_26840_n1782# WEM 0.23385f
C2657 a_26114_4692# RB8 0.1782f
C2658 a_19668_n170# VDD 0.41797f
C2659 a_8077_1398# VDD 0.27315f
C2660 a_13754_5664# VDD 0.28227f
C2661 a_25381_n170# VDD 0.27315f
C2662 a_22909_4534# a_23213_4534# 0.40203f
C2663 a_23642_2528# a_22909_2182# 0.12913f
C2664 a_3133_6102# a_3437_6102# 0.40203f
C2665 a_15493_n954# VDD 0.27315f
C2666 a_24368_n1782# a_24872_n1738# 0.67695f
C2667 a_25381_10022# VDD 0.27315f
C2668 a_661_6102# RA6 0.14389f
C2669 a_23642_960# VDD 0.28275f
C2670 a_38045_2274# a_37741_2182# 0.40203f
C2671 a_11282_5664# a_10549_5318# 0.12913f
C2672 a_18698_10964# VDD 0.28226f
C2673 a_28586_9396# VDD 0.28227f
C2674 a_12252_3750# VDD 0.41797f
C2675 a_9536_n1782# VDD 0.6765f
C2676 a_8381_7670# VDD 0.26764f
C2677 a_27218_4724# a_27853_4534# 0.13953f
C2678 a_22274_10336# a_22909_10022# 0.13953f
C2679 a_14858_9428# a_14724_9238# 0.68196f
C2680 a_27218_20# VDD 0.41955f
C2681 a_25685_5410# a_25381_5318# 0.40203f
C2682 a_31058_960# a_30325_614# 0.12913f
C2683 a_661_10806# a_965_10806# 0.40203f
C2684 a_n1652_1398# CLK 0.25473f
C2685 a_11282_2528# VDD 0.28227f
C2686 a_30325_7670# VDD 0.27315f
C2687 a_8077_9238# RA2 0.14389f
C2688 a_14858_7860# a_15493_7670# 0.13953f
C2689 a_37106_7200# a_36972_6886# 0.68196f
C2690 a_13325_8546# a_13021_8454# 0.40203f
C2691 a_7442_n640# VDD 0.41954f
C2692 a_n1652_1046# CLK 0.25473f
C2693 a_22909_6886# VDD 0.27315f
C2694 a_28157_8546# RA3 0.1633f
C2695 a_14858_n640# a_14724_n954# 0.68196f
C2696 a_3866_10368# VDD 0.28227f
C2697 a_37106_4724# a_36972_4534# 0.68196f
C2698 a_3133_1398# RA12 0.14389f
C2699 a_36002_n608# VDD 0.28281f
C2700 VDD WE0 0.22608f
C2701 a_13325_10806# RA0 0.1633f
C2702 a_33101_6978# RA5 0.1633f
C2703 a_23642_960# RB13 0.1782f
C2704 a_36784_10806# WE0CLK 0.13896f
C2705 a_9914_10996# VDD 0.41954f
C2706 a_15797_8546# VDD 0.26764f
C2707 a_28157_7670# RA4 0.1633f
C2708 a_5605_9238# a_5909_9238# 0.40203f
C2709 a_12386_7860# a_12252_7670# 0.68196f
C2710 a_33101_10114# VDD 0.26764f
C2711 a_30325_10806# RA0 0.14389f
C2712 a_22274_20# a_22140_n170# 0.68196f
C2713 a_38045_5410# RA7 0.1633f
C2714 a_24746_20# a_25381_n170# 0.13953f
C2715 a_17965_4534# RA8 0.14389f
C2716 a_26114_4692# VDD 0.28227f
C2717 a_5909_2966# VDD 0.26764f
C2718 a_14858_7200# VDD 0.41955f
C2719 a_6338_4692# RB8 0.1782f
C2720 a_20437_3750# VDD 0.27315f
C2721 a_13325_n862# RA15 0.1633f
C2722 a_19802_10996# a_19668_10806# 0.68196f
C2723 a_13021_4534# a_13325_4534# 0.40203f
C2724 a_34634_3156# a_34500_2966# 0.68196f
C2725 a_12386_10996# WE0CLK 0.28565f
C2726 a_8810_2528# a_8077_2182# 0.12913f
C2727 a_27853_2966# VDD 0.27315f
C2728 a_24872_n1738# WEM 0.29267f
C2729 a_13325_5410# VDD 0.26764f
C2730 a_24746_1588# a_25381_1398# 0.13953f
C2731 a_9914_6292# a_9780_6102# 0.68196f
C2732 VDD WE14 0.22649f
C2733 a_23213_2274# a_22909_2182# 0.40203f
C2734 a_3866_10964# VDD 0.28226f
C2735 a_8810_9396# VDD 0.28227f
C2736 a_30421_n1738# WEM 0.14287f
C2737 a_28586_n608# RB15 0.1782f
C2738 a_23213_706# VDD 0.26764f
C2739 a_12386_4724# a_13021_4534# 0.13953f
C2740 a_7442_10336# a_8077_10022# 0.13953f
C2741 a_34634_4064# a_34500_3750# 0.68196f
C2742 a_10853_5410# a_10549_5318# 0.40203f
C2743 a_12386_4064# VDD 0.41955f
C2744 a_28157_9238# VDD 0.26764f
C2745 a_16226_960# a_15493_614# 0.12913f
C2746 a_7568_n1738# VDD 0.49525f
C2747 a_10549_7670# VDD 0.27315f
C2748 a_3437_706# VDD 0.26764f
C2749 a_22274_7200# a_22140_6886# 0.68196f
C2750 a_32162_1588# a_32028_1398# 0.68196f
C2751 a_24612_n170# VDD 0.41797f
C2752 a_33530_n608# a_32797_n954# 0.12913f
C2753 a_30629_706# a_30325_614# 0.40203f
C2754 a_10853_2274# VDD 0.26764f
C2755 a_7442_4724# a_7308_4534# 0.68196f
C2756 a_6338_n608# VDD 0.28233f
C2757 a_3437_6978# RA5 0.1633f
C2758 a_21952_10806# WE0CLK 0.13896f
C2759 a_8381_7670# RA4 0.1633f
C2760 RA13 RA14 0.30166f
C2761 a_3437_10114# VDD 0.26764f
C2762 a_27218_8768# a_27853_8454# 0.13953f
C2763 a_35573_n862# VDD 0.26771f
C2764 a_13754_8800# RB3 0.1782f
C2765 a_15493_10806# RA0 0.14389f
C2766 a_8381_5410# RA7 0.1633f
C2767 a_32162_20# VDD 0.41955f
C2768 a_6338_4692# VDD 0.28227f
C2769 a_14724_8454# VDD 0.41797f
C2770 a_7442_928# a_8077_614# 0.13953f
C2771 a_30325_7670# RA4 0.14389f
C2772 a_965_5410# a_661_5318# 0.40203f
C2773 a_32028_10022# VDD 0.41797f
C2774 a_18698_7232# RB5 0.1782f
C2775 a_25477_n1738# D10 0.11075f
C2776 a_13325_3842# RA9 0.1633f
C2777 a_18698_7828# RB4 0.1782f
C2778 a_25685_4534# VDD 0.26764f
C2779 a_4970_3156# a_4836_2966# 0.68196f
C2780 a_32797_6102# a_33530_6260# 0.12913f
C2781 a_8077_2966# VDD 0.27315f
C2782 a_13754_7232# VDD 0.28227f
C2783 a_23642_5664# RB7 0.1782f
C2784 VDD RB4 2.79986f
C2785 a_18269_2274# RA11 0.1633f
C2786 a_18269_2966# RA10 0.1633f
C2787 a_26_10996# a_661_10806# 0.13953f
C2788 a_9914_1588# a_10549_1398# 0.13953f
C2789 a_35269_614# RA13 0.14389f
C2790 a_8381_2274# a_8077_2182# 0.40203f
C2791 a_28586_4096# RB9 0.1782f
C2792 a_24368_n1782# WEM 0.23385f
C2793 a_12252_5318# VDD 0.41797f
C2794 a_30325_10022# RA1 0.14389f
C2795 a_19802_4064# a_19668_3750# 0.68196f
C2796 a_24746_20# a_24612_n170# 0.68196f
C2797 a_33530_2528# RB11 0.1782f
C2798 a_8381_9238# VDD 0.26764f
C2799 a_28586_3124# RB10 0.1782f
C2800 a_22140_614# VDD 0.41797f
C2801 a_35269_8454# RA3 0.14389f
C2802 a_2498_1588# a_2364_1398# 0.68196f
C2803 a_7442_7200# a_7308_6886# 0.68196f
C2804 a_n1652_2966# CLK 0.25473f
C2805 a_18698_n608# a_17965_n954# 0.12913f
C2806 a_37106_2496# a_37741_2182# 0.13953f
C2807 a_11282_4096# VDD 0.28227f
C2808 a_30325_9238# VDD 0.27315f
C2809 a_15797_706# a_15493_614# 0.40203f
C2810 a_7064_n1782# VDD 0.6765f
C2811 a_n1652_2614# CLK 0.25473f
C2812 a_22909_8454# VDD 0.27315f
C2813 a_24746_5632# a_25381_5318# 0.13953f
C2814 a_33101_n862# a_32797_n954# 0.40203f
C2815 a_33101_10806# VDD 0.26763f
C2816 WE9 RA9 0.10549f
C2817 VDD D7 0.36033f
C2818 RB8 RB9 0.23766f
C2819 a_7120_10806# WE0CLK 0.13896f
C2820 a_9780_2182# VDD 0.41797f
C2821 a_12386_8768# a_13021_8454# 0.13953f
C2822 a_5909_n862# VDD 0.26771f
C2823 a_20437_n954# RA15 0.14389f
C2824 a_10549_7670# RA4 0.14389f
C2825 a_2364_10022# VDD 0.41797f
C2826 a_26114_6260# VDD 0.28227f
C2827 a_34500_n954# VDD 0.4212f
C2828 a_38045_10114# RA1 0.1633f
C2829 a_29556_n170# VDD 0.41797f
C2830 a_7308_10806# VDD 0.41797f
C2831 a_5909_4534# VDD 0.26764f
C2832 a_14858_8768# VDD 0.41955f
C2833 a_22909_6102# a_23642_6260# 0.12913f
C2834 a_20437_5318# VDD 0.27315f
C2835 a_32162_10336# VDD 0.41955f
C2836 a_3133_7670# a_3866_7828# 0.12913f
C2837 a_27853_4534# VDD 0.27315f
C2838 a_30629_6102# RA6 0.1633f
C2839 a_661_6102# a_1394_6260# 0.12913f
C2840 a_32797_6102# a_33101_6102# 0.40203f
C2841 a_23213_n170# RA14 0.1633f
C2842 a_38474_4096# a_37741_3750# 0.12913f
C2843 a_13325_6978# VDD 0.26764f
C2844 a_1394_1556# RB12 0.1782f
C2845 a_20437_2966# RA10 0.14389f
C2846 a_30325_1398# a_31058_1556# 0.12913f
C2847 a_4970_4064# a_4836_3750# 0.68196f
C2848 a_37106_20# VDD 0.41955f
C2849 a_3866_2528# RB11 0.1782f
C2850 a_9780_10806# WE0CLK 0.22071f
C2851 a_26114_7232# a_25381_6886# 0.12913f
C2852 a_22400_n1738# WEM 0.29267f
C2853 a_8810_3124# RB10 0.1782f
C2854 a_12386_5632# VDD 0.41955f
C2855 a_33530_n12# RB14 0.1782f
C2856 a_5605_8454# RA3 0.14389f
C2857 a_17965_2182# VDD 0.27315f
C2858 a_22274_2496# a_22909_2182# 0.13953f
C2859 a_3866_n608# a_3133_n954# 0.12913f
C2860 a_10549_9238# VDD 0.27315f
C2861 VDD RB9 2.80275f
C2862 RA4 RB4 18.9728f
C2863 a_23642_1556# VDD 0.28227f
C2864 a_22274_928# VDD 0.41955f
C2865 a_10549_6886# RA5 0.14389f
C2866 a_29690_9428# a_30325_9238# 0.13953f
C2867 a_9914_5632# a_10549_5318# 0.13953f
C2868 a_18269_n862# a_17965_n954# 0.40203f
C2869 a_18269_10806# VDD 0.26763f
C2870 a_10853_3842# VDD 0.26764f
C2871 a_5096_n1738# VDD 0.49525f
C2872 a_15493_5318# RA7 0.14389f
C2873 a_35269_10806# VDD 0.27315f
C2874 a_29690_928# a_30325_614# 0.13953f
C2875 a_12386_10996# a_13021_10806# 0.13953f
C2876 a_27218_20# a_27084_n170# 0.68196f
C2877 a_20437_3750# RA9 0.14389f
C2878 a_9914_2496# VDD 0.41955f
C2879 a_6338_6260# VDD 0.28227f
C2880 a_26_n640# a_661_n954# 0.13953f
C2881 a_4836_n954# VDD 0.4212f
C2882 a_8381_10114# RA1 0.1633f
C2883 a_25381_2182# RA11 0.14389f
C2884 a_38474_2528# VDD 0.27344f
C2885 a_13021_6102# a_13754_6260# 0.12913f
C2886 a_20437_614# VDD 0.27315f
C2887 a_35573_706# RA13 0.1633f
C2888 a_2498_10336# VDD 0.41955f
C2889 a_25685_6102# VDD 0.26764f
C2890 a_34634_n640# VDD 0.41954f
C2891 a_965_2274# RA11 0.1633f
C2892 a_7442_10996# VDD 0.41954f
C2893 a_8077_4534# VDD 0.27315f
C2894 a_13754_8800# VDD 0.28227f
C2895 a_10853_6102# RA6 0.1633f
C2896 a_22909_6102# a_23213_6102# 0.40203f
C2897 a_31058_10368# VDD 0.28275f
C2898 a_23642_10368# RB1 0.1782f
C2899 a_23642_4096# a_22909_3750# 0.12913f
C2900 a_3133_7670# a_3437_7670# 0.40203f
C2901 a_32797_6102# RA6 0.14389f
C2902 a_20437_1398# a_21170_1556# 0.12913f
C2903 a_25381_n170# RA14 0.14389f
C2904 a_38045_3842# a_37741_3750# 0.40203f
C2905 a_11282_7232# a_10549_6886# 0.12913f
C2906 a_12252_6886# VDD 0.41797f
C2907 a_21170_6260# RB6 0.1782f
C2908 a_38474_7828# RB4 0.1782f
C2909 VDD RA0 3.36959f
C2910 a_13754_n12# RB14 0.1782f
C2911 a_12386_20# a_13021_n170# 0.13953f
C2912 a_30325_1398# a_30629_1398# 0.40203f
C2913 a_27218_6292# a_27853_6102# 0.13953f
C2914 a_34500_n170# VDD 0.41797f
C2915 a_7442_2496# a_8077_2182# 0.13953f
C2916 a_9914_10996# WE0CLK 0.28565f
C2917 a_25685_6978# a_25381_6886# 0.40203f
C2918 a_21896_n1782# WEM 0.23385f
C2919 a_n1652_4534# CLK 0.25473f
C2920 a_20741_1398# RA12 0.1633f
C2921 a_38045_2966# RA10 0.1633f
C2922 a_3866_1556# VDD 0.28227f
C2923 a_21170_n12# VDD 0.28227f
C2924 a_11282_5664# VDD 0.28227f
C2925 a_14858_9428# a_15493_9238# 0.13953f
C2926 a_37106_8768# a_36972_8454# 0.68196f
C2927 a_3437_n862# a_3133_n954# 0.40203f
C2928 a_3437_10806# VDD 0.26763f
C2929 a_27949_n1738# WEM 0.14287f
C2930 a_n1652_4182# CLK 0.25473f
C2931 a_21896_n1782# a_22400_n1738# 0.67695f
C2932 a_13021_n954# VDD 0.27315f
C2933 a_22909_10022# VDD 0.27315f
C2934 a_23213_1398# VDD 0.26764f
C2935 a_21170_960# VDD 0.28227f
C2936 a_30325_10806# a_31058_10964# 0.12913f
C2937 a_37106_6292# a_36972_6102# 0.68196f
C2938 a_9780_3750# VDD 0.41797f
C2939 a_20437_10806# VDD 0.27315f
C2940 a_14858_928# a_15493_614# 0.13953f
C2941 a_31058_1556# RB12 0.1782f
C2942 a_4592_n1782# VDD 0.6765f
C2943 a_661_n170# VDD 0.27315f
C2944 a_12386_9428# a_12252_9238# 0.68196f
C2945 a_n1652_2614# WE11 0.10075f
C2946 a_32162_n640# a_32797_n954# 0.13953f
C2947 VDD RB14 2.79986f
C2948 a_8810_2528# VDD 0.28275f
C2949 a_26114_7828# VDD 0.28227f
C2950 a_20533_n1738# D8 0.11075f
C2951 a_36002_10368# a_35269_10022# 0.12913f
C2952 a_5909_6102# VDD 0.26764f
C2953 a_4970_n640# VDD 0.41954f
C2954 a_20437_6886# VDD 0.27315f
C2955 a_25685_8546# RA3 0.1633f
C2956 a_38045_2274# VDD 0.26764f
C2957 a_13021_6102# a_13325_6102# 0.40203f
C2958 a_23213_9238# RA2 0.1633f
C2959 a_34634_4724# a_34500_4534# 0.68196f
C2960 a_1394_10368# VDD 0.28275f
C2961 a_8810_4096# a_8077_3750# 0.12913f
C2962 a_33530_n608# VDD 0.28233f
C2963 a_27853_6102# VDD 0.27315f
C2964 a_4970_928# VDD 0.41955f
C2965 a_30629_6978# RA5 0.1633f
C2966 a_21170_960# RB13 0.1782f
C2967 a_13325_8546# VDD 0.26764f
C2968 a_13021_6102# RA6 0.14389f
C2969 a_10549_1398# a_11282_1556# 0.12913f
C2970 a_29690_20# a_29556_n170# 0.68196f
C2971 a_24746_3156# a_25381_2966# 0.13953f
C2972 a_27853_n170# a_28586_n12# 0.12913f
C2973 a_9914_7860# a_9780_7670# 0.68196f
C2974 a_30629_10114# VDD 0.26764f
C2975 a_23213_3842# a_22909_3750# 0.40203f
C2976 a_35573_5410# RA7 0.1633f
C2977 a_33530_9396# RB2 0.1782f
C2978 a_20437_1398# a_20741_1398# 0.40203f
C2979 a_12386_6292# a_13021_6102# 0.13953f
C2980 a_34634_5632# a_34500_5318# 0.68196f
C2981 a_10853_6978# a_10549_6886# 0.40203f
C2982 a_12386_7200# VDD 0.41955f
C2983 a_17965_3750# VDD 0.27315f
C2984 RB13 RB14 0.39209f
C2985 WE14 RA14 0.10549f
C2986 a_10853_n862# RA15 0.1633f
C2987 a_n1652_n170# CLK 0.25473f
C2988 a_33101_4534# RA8 0.1633f
C2989 a_32162_3156# a_32028_2966# 0.68196f
C2990 a_22274_8768# a_22140_8454# 0.68196f
C2991 a_23642_3124# VDD 0.28227f
C2992 a_19928_n1738# WEM 0.29267f
C2993 a_8381_706# a_8077_614# 0.40203f
C2994 a_3133_614# VDD 0.27315f
C2995 a_22909_1398# RA12 0.14389f
C2996 a_3437_1398# VDD 0.26764f
C2997 a_20741_n170# VDD 0.26764f
C2998 a_10853_5410# VDD 0.26764f
C2999 a_22909_10806# a_23642_10964# 0.12913f
C3000 a_7442_6292# a_7308_6102# 0.68196f
C3001 a_5605_10806# VDD 0.27315f
C3002 a_26114_n608# RB15 0.1782f
C3003 a_11282_1556# RB12 0.1782f
C3004 a_25381_1398# VDD 0.27315f
C3005 a_20741_706# VDD 0.26764f
C3006 VDD RA5 3.36997f
C3007 a_17330_n640# a_17965_n954# 0.13953f
C3008 a_9914_4064# VDD 0.41955f
C3009 a_2624_n1738# VDD 0.49525f
C3010 a_6338_7828# VDD 0.28227f
C3011 a_29690_1588# a_29556_1398# 0.68196f
C3012 a_965_6978# a_661_6886# 0.40203f
C3013 a_21170_10368# a_20437_10022# 0.12913f
C3014 a_38474_4096# VDD 0.27344f
C3015 a_8381_2274# VDD 0.26764f
C3016 a_25685_7670# VDD 0.26764f
C3017 a_3437_9238# RA2 0.1633f
C3018 a_32797_7670# a_33530_7828# 0.12913f
C3019 a_4970_4724# a_4836_4534# 0.68196f
C3020 a_35573_10114# a_35269_10022# 0.40203f
C3021 a_8077_6102# VDD 0.27315f
C3022 a_3866_n608# VDD 0.28233f
C3023 a_36972_2182# VDD 0.41797f
C3024 a_25381_9238# RA2 0.14389f
C3025 a_9914_3156# a_10549_2966# 0.13953f
C3026 a_32162_2496# a_32028_2182# 0.68196f
C3027 a_17965_n170# a_18698_n12# 0.12913f
C3028 a_965_10114# VDD 0.26764f
C3029 a_965_n170# VDD 0.26764f
C3030 a_8381_3842# a_8077_3750# 0.40203f
C3031 a_33101_n862# VDD 0.26771f
C3032 a_11282_8800# RB3 0.1782f
C3033 a_5909_5410# RA7 0.1633f
C3034 a_13754_9396# RB2 0.1782f
C3035 a_4836_10806# VDD 0.41797f
C3036 RA9 RB9 18.9728f
C3037 RB3 CLK 0.18513f
C3038 VDD D9 0.36038f
C3039 a_12252_8454# VDD 0.41797f
C3040 a_10549_1398# a_10853_1398# 0.40203f
C3041 a_27853_n170# a_28157_n170# 0.40203f
C3042 a_19802_5632# a_19668_5318# 0.68196f
C3043 a_29556_10022# VDD 0.41797f
C3044 a_965_1398# VDD 0.26764f
C3045 a_16226_7232# RB5 0.1782f
C3046 a_661_8454# RA3 0.14389f
C3047 a_10853_3842# RA9 0.1633f
C3048 a_1394_n608# a_661_n954# 0.12913f
C3049 a_13325_4534# RA8 0.1633f
C3050 a_7442_8768# a_7308_8454# 0.68196f
C3051 a_2498_3156# a_2364_2966# 0.68196f
C3052 a_n1652_6102# CLK 0.25473f
C3053 a_37106_4064# a_37741_3750# 0.13953f
C3054 a_3866_3124# VDD 0.28227f
C3055 a_11282_7232# VDD 0.28227f
C3056 a_21170_5664# RB7 0.1782f
C3057 a_15797_2274# RA11 0.1633f
C3058 a_24746_10336# a_24612_10022# 0.68196f
C3059 a_35269_4534# RA8 0.14389f
C3060 a_n1652_5750# CLK 0.25473f
C3061 a_15493_10806# a_16226_10964# 0.12913f
C3062 a_32797_614# RA13 0.14389f
C3063 a_29690_928# a_29556_614# 0.68196f
C3064 a_33530_10964# RB0 0.1782f
C3065 a_7308_10806# WE0CLK 0.22071f
C3066 a_23213_2966# VDD 0.26764f
C3067 a_24746_7200# a_25381_6886# 0.13953f
C3068 a_26114_4096# RB9 0.1782f
C3069 a_19424_n1782# WEM 0.23385f
C3070 a_32162_20# a_32028_n170# 0.68196f
C3071 a_23642_4692# RB8 0.1782f
C3072 a_5605_1398# VDD 0.27315f
C3073 a_9780_5318# VDD 0.41797f
C3074 a_22909_n170# VDD 0.27315f
C3075 a_37106_10996# a_36972_10806# 0.68196f
C3076 a_27853_10022# RA1 0.14389f
C3077 a_31058_2528# RB11 0.1782f
C3078 a_2498_n640# a_3133_n954# 0.13953f
C3079 a_965_9238# RA2 0.1633f
C3080 a_19668_614# VDD 0.41797f
C3081 a_32797_8454# RA3 0.14389f
C3082 a_6338_10368# a_5605_10022# 0.12913f
C3083 a_8810_4096# VDD 0.28275f
C3084 a_26114_9396# VDD 0.28227f
C3085 a_2120_n1782# VDD 0.6765f
C3086 a_5909_7670# VDD 0.26764f
C3087 a_37741_6886# RA5 0.14389f
C3088 a_22909_7670# a_23642_7828# 0.12913f
C3089 a_37741_10806# a_38474_10964# 0.12913f
C3090 a_20741_10114# a_20437_10022# 0.40203f
C3091 a_20437_8454# VDD 0.27315f
C3092 a_38045_3842# VDD 0.26764f
C3093 a_3133_9238# a_3866_9396# 0.12913f
C3094 a_7308_2182# VDD 0.41797f
C3095 a_27853_7670# VDD 0.27315f
C3096 a_5605_9238# RA2 0.14389f
C3097 a_17330_2496# a_17196_2182# 0.68196f
C3098 a_661_7670# a_1394_7828# 0.12913f
C3099 a_32797_7670# a_33101_7670# 0.40203f
C3100 VDD RA10 3.36972f
C3101 RA4 RA5 0.33341f
C3102 a_38474_5664# a_37741_5318# 0.12913f
C3103 a_3437_n862# VDD 0.26771f
C3104 a_22274_10996# a_22909_10806# 0.13953f
C3105 a_37106_2496# VDD 0.41955f
C3106 a_17965_n954# RA15 0.14389f
C3107 a_30325_2966# a_31058_3124# 0.12913f
C3108 a_17965_n170# a_18269_n170# 0.40203f
C3109 a_4970_5632# a_4836_5318# 0.68196f
C3110 a_n108_10022# VDD 0.41823f
C3111 a_3133_n170# VDD 0.27315f
C3112 a_26114_8800# a_25381_8454# 0.12913f
C3113 a_32028_n954# VDD 0.4212f
C3114 a_n1652_6102# WE6 0.10075f
C3115 a_9914_20# a_10549_n170# 0.13953f
C3116 a_35573_10114# RA1 0.1633f
C3117 a_4970_10996# VDD 0.41954f
C3118 a_12386_8768# VDD 0.41955f
C3119 a_25685_7670# RA4 0.1633f
C3120 a_4970_20# a_5605_n170# 0.13953f
C3121 a_29690_10336# VDD 0.41955f
C3122 a_17965_5318# VDD 0.27315f
C3123 a_22274_4064# a_22909_3750# 0.13953f
C3124 a_3133_1398# VDD 0.27315f
C3125 a_9914_10336# a_9780_10022# 0.68196f
C3126 a_15493_4534# RA8 0.14389f
C3127 a_23642_4692# VDD 0.28227f
C3128 a_8077_10806# a_8810_10964# 0.12913f
C3129 a_37741_n170# a_38474_n12# 0.12913f
C3130 a_14858_928# a_14724_614# 0.68196f
C3131 a_9914_7200# a_10549_6886# 0.13953f
C3132 a_18698_10964# RB0 0.1782f
C3133 a_3437_2966# VDD 0.26764f
C3134 a_10853_6978# VDD 0.26764f
C3135 a_3866_4692# RB8 0.1782f
C3136 a_36002_7828# RB4 0.1782f
C3137 RB8 CLK 0.18513f
C3138 a_17330_10996# a_17196_10806# 0.68196f
C3139 a_1394_2528# RB11 0.1782f
C3140 a_7442_10996# WE0CLK 0.28565f
C3141 a_25381_2966# VDD 0.27315f
C3142 a_17456_n1738# WEM 0.29267f
C3143 a_35573_2966# RA10 0.1633f
C3144 a_9914_5632# VDD 0.41955f
C3145 a_3133_8454# RA3 0.14389f
C3146 a_15493_2182# VDD 0.27315f
C3147 a_6338_9396# VDD 0.28227f
C3148 a_25477_n1738# WEM 0.14287f
C3149 a_3133_9238# RA2 0.14389f
C3150 a_15589_n1738# D6 0.11075f
C3151 a_38474_5664# VDD 0.27344f
C3152 a_26_n640# VDD 0.41954f
C3153 a_19802_928# VDD 0.41955f
C3154 a_8077_6886# RA5 0.14389f
C3155 a_13021_7670# a_13754_7828# 0.12913f
C3156 a_30325_10806# a_30629_10806# 0.40203f
C3157 a_5909_10114# a_5605_10022# 0.40203f
C3158 a_36002_2528# a_35269_2182# 0.12913f
C3159 WE0CLK RA0 0.41943f
C3160 a_8381_3842# VDD 0.26764f
C3161 VDD WE1 0.22649f
C3162 a_25685_9238# VDD 0.26764f
C3163 a_152_n1738# VDD 0.49525f
C3164 a_8077_7670# VDD 0.27315f
C3165 a_13021_5318# RA7 0.14389f
C3166 a_34634_20# a_34500_n170# 0.68196f
C3167 a_2498_2496# a_2364_2182# 0.68196f
C3168 a_22909_7670# a_23213_7670# 0.40203f
C3169 a_23642_5664# a_22909_5318# 0.12913f
C3170 a_36972_3750# VDD 0.41797f
C3171 a_31058_10964# VDD 0.28226f
C3172 a_3133_9238# a_3437_9238# 0.40203f
C3173 a_17965_3750# RA9 0.14389f
C3174 a_7442_2496# VDD 0.41955f
C3175 a_36972_1398# VDD 0.41797f
C3176 a_20437_2966# a_21170_3124# 0.12913f
C3177 a_34634_10336# a_35269_10022# 0.13953f
C3178 a_11282_8800# a_10549_8454# 0.12913f
C3179 a_38045_5410# a_37741_5318# 0.40203f
C3180 a_2364_n954# VDD 0.4212f
C3181 a_5909_10114# RA1 0.1633f
C3182 a_22909_2182# RA11 0.14389f
C3183 a_965_2966# VDD 0.26764f
C3184 a_36002_2528# VDD 0.28275f
C3185 a_5909_7670# RA4 0.1633f
C3186 a_30325_2966# a_30629_2966# 0.40203f
C3187 a_33101_706# RA13 0.1633f
C3188 a_17965_614# VDD 0.27315f
C3189 a_27218_7860# a_27853_7670# 0.13953f
C3190 a_7442_4064# a_8077_3750# 0.13953f
C3191 a_25685_8546# a_25381_8454# 0.40203f
C3192 a_32162_n640# VDD 0.41954f
C3193 a_n1652_7670# CLK 0.25473f
C3194 a_3866_4692# VDD 0.28227f
C3195 a_11282_8800# VDD 0.28227f
C3196 a_27853_7670# RA4 0.14389f
C3197 a_27218_n640# a_27084_n954# 0.68196f
C3198 a_28586_10368# VDD 0.28227f
C3199 VDD CLK 2.71262f
C3200 a_3866_10964# RB0 0.1782f
C3201 a_21170_10368# RB1 0.1782f
C3202 a_n1652_7318# CLK 0.25473f
C3203 a_25685_10806# RA0 0.1633f
C3204 a_16226_7828# RB4 0.1782f
C3205 a_23213_4534# VDD 0.26764f
C3206 a_5605_614# RA13 0.14389f
C3207 a_37741_n170# a_38045_n170# 0.40203f
C3208 a_8810_n12# VDD 0.28227f
C3209 a_37106_7860# a_36972_7670# 0.68196f
C3210 a_5605_2966# VDD 0.27315f
C3211 a_9780_6886# VDD 0.41797f
C3212 a_15797_2966# RA10 0.1633f
C3213 a_5909_706# VDD 0.26764f
C3214 a_16952_n1782# WEM 0.23385f
C3215 a_38045_n862# RA15 0.1633f
C3216 a_37741_2966# RA10 0.14389f
C3217 a_8810_5664# VDD 0.28275f
C3218 a_661_n170# RA14 0.14389f
C3219 a_22909_10806# a_23213_10806# 0.40203f
C3220 a_21170_2528# a_20437_2182# 0.12913f
C3221 a_5909_9238# VDD 0.26764f
C3222 a_26114_3124# RB10 0.1782f
C3223 a_19424_n1782# a_19928_n1738# 0.67695f
C3224 a_10549_n954# VDD 0.27315f
C3225 a_20437_10022# VDD 0.27315f
C3226 a_38045_5410# VDD 0.26764f
C3227 a_18698_960# VDD 0.28227f
C3228 a_13021_7670# a_13325_7670# 0.40203f
C3229 RB13 CLK 0.18513f
C3230 a_37106_1588# a_37741_1398# 0.13953f
C3231 RA14 RB14 18.9728f
C3232 a_34634_6292# a_34500_6102# 0.68196f
C3233 a_8810_5664# a_8077_5318# 0.12913f
C3234 a_35573_2274# a_35269_2182# 0.40203f
C3235 a_16226_10964# VDD 0.28226f
C3236 a_7308_3750# VDD 0.41797f
C3237 a_27853_9238# VDD 0.27315f
C3238 a_661_4534# RA8 0.14389f
C3239 a_32162_20# a_32797_n170# 0.13953f
C3240 a_10549_2966# a_11282_3124# 0.12913f
C3241 a_24746_4724# a_25381_4534# 0.13953f
C3242 a_19802_10336# a_20437_10022# 0.13953f
C3243 a_9914_9428# a_9780_9238# 0.68196f
C3244 a_23213_5410# a_22909_5318# 0.40203f
C3245 a_37106_4064# VDD 0.41955f
C3246 a_28586_960# a_27853_614# 0.12913f
C3247 a_37106_1588# VDD 0.41955f
C3248 a_6338_2528# VDD 0.28227f
C3249 a_20437_2966# a_20741_2966# 0.40203f
C3250 a_12386_7860# a_13021_7670# 0.13953f
C3251 a_34634_7200# a_34500_6886# 0.68196f
C3252 a_10853_8546# a_10549_8454# 0.40203f
C3253 a_2498_n640# VDD 0.41954f
C3254 VDD WE6 0.22649f
C3255 a_17965_6886# VDD 0.27315f
C3256 a_6338_n12# VDD 0.28227f
C3257 a_23213_8546# RA3 0.1633f
C3258 a_3133_2966# VDD 0.27315f
C3259 a_35573_2274# VDD 0.26764f
C3260 a_8077_7670# RA4 0.14389f
C3261 a_12386_n640# a_12252_n954# 0.68196f
C3262 a_32162_4724# a_32028_4534# 0.68196f
C3263 a_23642_6260# VDD 0.28227f
C3264 a_31058_n608# VDD 0.28281f
C3265 a_37106_20# a_36972_n170# 0.68196f
C3266 a_10853_10806# RA0 0.1633f
C3267 a_28157_6978# RA5 0.1633f
C3268 a_18698_960# RB13 0.1782f
C3269 a_34312_10806# WE0CLK 0.13896f
C3270 a_3437_4534# VDD 0.26764f
C3271 a_2364_10806# VDD 0.41797f
C3272 a_10853_8546# VDD 0.26764f
C3273 a_7442_7860# a_7308_7670# 0.68196f
C3274 a_28157_10114# VDD 0.26764f
C3275 a_38474_8800# RB3 0.1782f
C3276 a_27853_10806# RA0 0.14389f
C3277 a_33101_5410# RA7 0.1633f
C3278 a_25381_4534# VDD 0.27315f
C3279 a_28157_6102# RA6 0.1633f
C3280 a_8381_n170# VDD 0.26764f
C3281 a_20741_n170# RA14 0.1633f
C3282 a_9914_7200# VDD 0.41955f
C3283 a_15493_3750# VDD 0.27315f
C3284 a_38045_3842# RA9 0.1633f
C3285 a_8381_n862# RA15 0.1633f
C3286 a_17965_2966# RA10 0.14389f
C3287 a_15493_10806# a_15797_10806# 0.40203f
C3288 a_29690_3156# a_29556_2966# 0.68196f
C3289 a_965_8546# a_661_8454# 0.40203f
C3290 a_6338_2528# a_5605_2182# 0.12913f
C3291 a_4836_10806# WE0CLK 0.22071f
C3292 RA9 RA10 0.30166f
C3293 VDD D11 0.36038f
C3294 a_38474_7232# VDD 0.27344f
C3295 a_14984_n1738# WEM 0.29267f
C3296 a_6338_3124# RB10 0.1782f
C3297 a_3866_960# a_3133_614# 0.12913f
C3298 a_8381_5410# VDD 0.26764f
C3299 a_31058_n12# RB14 0.1782f
C3300 a_22274_1588# a_22909_1398# 0.13953f
C3301 a_4970_6292# a_4836_6102# 0.68196f
C3302 a_32797_9238# a_33530_9396# 0.12913f
C3303 a_20741_2274# a_20437_2182# 0.40203f
C3304 a_8077_9238# VDD 0.27315f
C3305 a_23642_n608# RB15 0.1782f
C3306 a_21170_1556# VDD 0.28227f
C3307 a_36972_5318# VDD 0.41797f
C3308 a_18269_706# VDD 0.26764f
C3309 a_4970_10336# a_5605_10022# 0.13953f
C3310 a_9914_4724# a_10549_4534# 0.13953f
C3311 a_32162_4064# a_32028_3750# 0.68196f
C3312 a_3866_n12# VDD 0.28227f
C3313 a_8381_5410# a_8077_5318# 0.40203f
C3314 a_13754_960# a_13021_614# 0.12913f
C3315 a_36972_2966# VDD 0.41797f
C3316 a_7442_4064# VDD 0.41955f
C3317 a_n352_n1782# VDD 0.67199f
C3318 a_10549_2966# a_10853_2966# 0.40203f
C3319 a_27218_1588# a_27084_1398# 0.68196f
C3320 a_19802_7200# a_19668_6886# 0.68196f
C3321 a_37741_10806# a_38045_10806# 0.40203f
C3322 a_31058_n608# a_30325_n954# 0.12913f
C3323 a_965_4534# VDD 0.26764f
C3324 a_28157_706# a_27853_614# 0.40203f
C3325 a_36002_4096# VDD 0.28275f
C3326 a_965_n170# RA14 0.1633f
C3327 a_5909_2274# VDD 0.26764f
C3328 a_34500_1398# VDD 0.41797f
C3329 a_1394_9396# RB2 0.1782f
C3330 a_2498_4724# a_2364_4534# 0.68196f
C3331 a_n1652_9238# CLK 0.25473f
C3332 a_3866_6260# VDD 0.28227f
C3333 a_37106_5632# a_37741_5318# 0.13953f
C3334 a_1394_n608# VDD 0.28281f
C3335 a_5909_n170# VDD 0.26764f
C3336 a_19480_10806# WE0CLK 0.13896f
C3337 a_34500_2182# VDD 0.41797f
C3338 a_n1652_8886# CLK 0.25473f
C3339 a_23213_6102# VDD 0.26764f
C3340 a_24746_8768# a_25381_8454# 0.13953f
C3341 a_30629_n862# VDD 0.26771f
C3342 a_8810_8800# RB3 0.1782f
C3343 a_32162_10996# a_32797_10806# 0.13953f
C3344 a_13021_10806# RA0 0.14389f
C3345 a_3437_5410# RA7 0.1633f
C3346 a_2498_10996# VDD 0.41954f
C3347 a_5605_4534# VDD 0.27315f
C3348 a_9780_8454# VDD 0.41797f
C3349 a_8381_6102# RA6 0.1633f
C3350 a_27084_10022# VDD 0.41797f
C3351 a_13754_7232# RB5 0.1782f
C3352 VDD WE11 0.22649f
C3353 RB4 RB5 0.23766f
C3354 a_8381_3842# RA9 0.1633f
C3355 WE5 RA5 0.10549f
C3356 a_30325_6102# RA6 0.14389f
C3357 a_8077_10806# a_8381_10806# 0.40203f
C3358 a_10549_n170# VDD 0.27315f
C3359 a_10645_n1738# D4 0.11075f
C3360 a_22909_n170# RA14 0.14389f
C3361 a_8810_7232# VDD 0.28275f
C3362 a_18698_5664# RB7 0.1782f
C3363 a_13325_2274# RA11 0.1633f
C3364 a_18698_6260# RB6 0.1782f
C3365 a_11282_n12# RB14 0.1782f
C3366 a_7442_1588# a_8077_1398# 0.13953f
C3367 a_22909_9238# a_23642_9396# 0.12913f
C3368 a_30325_614# RA13 0.14389f
C3369 a_4970_10996# WE0CLK 0.28565f
C3370 a_5909_2274# a_5605_2182# 0.40203f
C3371 a_23642_4096# RB9 0.1782f
C3372 a_38045_6978# VDD 0.26764f
C3373 a_14480_n1782# WEM 0.23385f
C3374 a_18269_1398# RA12 0.1633f
C3375 a_7308_5318# VDD 0.41797f
C3376 a_18698_n12# VDD 0.28227f
C3377 a_17330_4064# a_17196_3750# 0.68196f
C3378 a_25381_10022# RA1 0.14389f
C3379 a_661_9238# a_1394_9396# 0.12913f
C3380 a_32797_9238# a_33101_9238# 0.40203f
C3381 a_28586_2528# RB11 0.1782f
C3382 a_38474_7232# a_37741_6886# 0.12913f
C3383 a_23005_n1738# WEM 0.14287f
C3384 a_20741_1398# VDD 0.26764f
C3385 a_n1652_n522# VDD 0.47631f
C3386 a_37106_5632# VDD 0.41955f
C3387 a_17196_614# VDD 0.41797f
C3388 a_30325_8454# RA3 0.14389f
C3389 a_30325_4534# a_31058_4692# 0.12913f
C3390 a_4970_7200# a_4836_6886# 0.68196f
C3391 a_3437_n170# VDD 0.26764f
C3392 a_34634_2496# a_35269_2182# 0.13953f
C3393 a_16226_n608# a_15493_n954# 0.12913f
C3394 a_6338_4096# VDD 0.28227f
C3395 a_13325_706# a_13021_614# 0.40203f
C3396 a_37106_3156# VDD 0.41955f
C3397 a_28586_1556# RB12 0.1782f
C3398 a_35269_6886# RA5 0.14389f
C3399 a_17965_8454# VDD 0.27315f
C3400 a_30629_n862# a_30325_n954# 0.40203f
C3401 a_22274_5632# a_22909_5318# 0.13953f
C3402 a_35573_3842# VDD 0.26764f
C3403 a_3133_4534# VDD 0.27315f
C3404 a_30629_10806# VDD 0.26763f
C3405 a_3133_n170# RA14 0.14389f
C3406 a_4648_10806# WE0CLK 0.13896f
C3407 a_4836_2182# VDD 0.41797f
C3408 a_23642_7828# VDD 0.28227f
C3409 a_34634_1588# VDD 0.41955f
C3410 a_9914_8768# a_10549_8454# 0.13953f
C3411 a_3437_6102# VDD 0.26764f
C3412 a_8077_n170# VDD 0.27315f
C3413 VDD RB1 2.80275f
C3414 RA0 RB0 18.9728f
C3415 a_34634_2496# VDD 0.41955f
C3416 a_15493_n954# RA15 0.14389f
C3417 a_20741_9238# RA2 0.1633f
C3418 a_29556_n954# VDD 0.4212f
C3419 a_25381_6102# VDD 0.27315f
C3420 a_33101_10114# RA1 0.1633f
C3421 a_9914_8768# VDD 0.41955f
C3422 a_10549_6102# RA6 0.14389f
C3423 a_15493_5318# VDD 0.27315f
C3424 a_27218_10336# VDD 0.41955f
C3425 a_31058_9396# RB2 0.1782f
C3426 a_38474_8800# VDD 0.27344f
C3427 a_13021_9238# a_13754_9396# 0.12913f
C3428 QB15b VSS 0.22657f
C3429 QA15b VSS 0.18761f
C3430 QB14b VSS 0.21476f
C3431 QA14b VSS 0.18761f
C3432 QB13b VSS 0.21532f
C3433 QA13b VSS 0.18761f
C3434 QB12b VSS 0.21476f
C3435 QA12b VSS 0.18761f
C3436 QB11b VSS 0.21532f
C3437 QA11b VSS 0.18761f
C3438 QB10b VSS 0.21532f
C3439 QA10b VSS 0.18761f
C3440 QB9b VSS 0.21476f
C3441 QA9b VSS 0.18761f
C3442 QB8b VSS 0.21532f
C3443 QA8b VSS 0.18761f
C3444 QB7b VSS 0.21532f
C3445 QA7b VSS 0.18761f
C3446 QB6b VSS 0.21476f
C3447 QA6b VSS 0.18761f
C3448 QB5b VSS 0.21532f
C3449 QA5b VSS 0.18761f
C3450 QB4b VSS 0.21532f
C3451 QA4b VSS 0.18761f
C3452 QB3b VSS 0.21476f
C3453 QA3b VSS 0.18761f
C3454 QB2b VSS 0.21532f
C3455 QA2b VSS 0.18761f
C3456 QB1b VSS 0.21532f
C3457 QA1b VSS 0.18761f
C3458 QB0b VSS 0.21476f
C3459 QA0b VSS 0.18761f
C3460 D15 VSS 0.34576f
C3461 D14 VSS 0.3383f
C3462 D13 VSS 0.3383f
C3463 D12 VSS 0.3383f
C3464 D11 VSS 0.3383f
C3465 D10 VSS 0.3383f
C3466 D9 VSS 0.3383f
C3467 D8 VSS 0.3383f
C3468 D7 VSS 0.3383f
C3469 D6 VSS 0.3383f
C3470 D5 VSS 0.3383f
C3471 D4 VSS 0.3383f
C3472 D3 VSS 0.3383f
C3473 D2 VSS 0.3383f
C3474 D1 VSS 0.3383f
C3475 D0 VSS 0.33929f
C3476 WEM VSS 6.62008f
C3477 RB15 VSS 9.73339f
C3478 RA15 VSS 8.25894f
C3479 CLK VSS 5.35525f
C3480 WE15 VSS 0.25886f
C3481 RB14 VSS 9.45592f
C3482 RA14 VSS 8.09311f
C3483 WE14 VSS 0.24767f
C3484 RB13 VSS 9.45538f
C3485 RA13 VSS 8.09155f
C3486 WE13 VSS 0.24767f
C3487 RB12 VSS 9.45372f
C3488 RA12 VSS 8.09198f
C3489 WE12 VSS 0.24767f
C3490 RB11 VSS 9.45445f
C3491 RA11 VSS 8.09198f
C3492 WE11 VSS 0.24767f
C3493 RB10 VSS 9.42188f
C3494 RA10 VSS 8.06625f
C3495 WE10 VSS 0.24767f
C3496 RB9 VSS 9.45592f
C3497 RA9 VSS 8.09347f
C3498 WE9 VSS 0.24767f
C3499 RB8 VSS 9.45519f
C3500 RA8 VSS 8.09385f
C3501 WE8 VSS 0.24767f
C3502 RB7 VSS 9.45648f
C3503 RA7 VSS 8.09267f
C3504 WE7 VSS 0.24767f
C3505 RB6 VSS 9.45409f
C3506 RA6 VSS 8.09198f
C3507 WE6 VSS 0.24767f
C3508 RB5 VSS 9.45445f
C3509 RA5 VSS 8.09198f
C3510 WE5 VSS 0.24767f
C3511 RB4 VSS 9.45482f
C3512 RA4 VSS 8.09273f
C3513 WE4 VSS 0.24767f
C3514 RB3 VSS 9.45555f
C3515 RA3 VSS 8.0931f
C3516 WE3 VSS 0.24767f
C3517 RB2 VSS 9.45519f
C3518 RA2 VSS 8.09422f
C3519 WE2 VSS 0.24767f
C3520 RB1 VSS 9.45575f
C3521 RA1 VSS 8.09192f
C3522 WE1 VSS 0.24767f
C3523 RB0 VSS 9.90235f
C3524 RA0 VSS 8.47507f
C3525 WE0CLK VSS 11.45993f
C3526 WE0 VSS 0.25886f
C3527 VDD VSS 0.87765p
C3528 a_37837_n1738# VSS 0.13693f
C3529 a_35365_n1738# VSS 0.124f
C3530 a_32893_n1738# VSS 0.124f
C3531 a_30421_n1738# VSS 0.124f
C3532 a_27949_n1738# VSS 0.124f
C3533 a_25477_n1738# VSS 0.124f
C3534 a_23005_n1738# VSS 0.124f
C3535 a_20533_n1738# VSS 0.124f
C3536 a_18061_n1738# VSS 0.124f
C3537 a_15589_n1738# VSS 0.124f
C3538 a_13117_n1738# VSS 0.124f
C3539 a_10645_n1738# VSS 0.124f
C3540 a_8173_n1738# VSS 0.124f
C3541 a_5701_n1738# VSS 0.124f
C3542 a_3229_n1738# VSS 0.124f
C3543 a_757_n1738# VSS 0.124f
C3544 a_37232_n1738# VSS 0.43837f
C3545 a_36728_n1782# VSS 0.79212f
C3546 a_34760_n1738# VSS 0.43837f
C3547 a_34256_n1782# VSS 0.79199f
C3548 a_32288_n1738# VSS 0.43837f
C3549 a_31784_n1782# VSS 0.79199f
C3550 a_29816_n1738# VSS 0.43837f
C3551 a_29312_n1782# VSS 0.79199f
C3552 a_27344_n1738# VSS 0.43837f
C3553 a_26840_n1782# VSS 0.79199f
C3554 a_24872_n1738# VSS 0.43837f
C3555 a_24368_n1782# VSS 0.79199f
C3556 a_22400_n1738# VSS 0.43837f
C3557 a_21896_n1782# VSS 0.79199f
C3558 a_19928_n1738# VSS 0.43837f
C3559 a_19424_n1782# VSS 0.79199f
C3560 a_17456_n1738# VSS 0.43837f
C3561 a_16952_n1782# VSS 0.79199f
C3562 a_14984_n1738# VSS 0.43837f
C3563 a_14480_n1782# VSS 0.79199f
C3564 a_12512_n1738# VSS 0.43837f
C3565 a_12008_n1782# VSS 0.79199f
C3566 a_10040_n1738# VSS 0.43837f
C3567 a_9536_n1782# VSS 0.79199f
C3568 a_7568_n1738# VSS 0.43837f
C3569 a_7064_n1782# VSS 0.79199f
C3570 a_5096_n1738# VSS 0.43837f
C3571 a_4592_n1782# VSS 0.79199f
C3572 a_2624_n1738# VSS 0.43837f
C3573 a_2120_n1782# VSS 0.79199f
C3574 a_152_n1738# VSS 0.43837f
C3575 a_n352_n1782# VSS 0.78942f
C3576 a_37741_n954# VSS 1.03998f
C3577 a_36784_n954# VSS 0.1323f
C3578 a_35269_n954# VSS 1.03998f
C3579 a_34312_n954# VSS 0.1323f
C3580 a_32797_n954# VSS 1.03998f
C3581 a_31840_n954# VSS 0.1323f
C3582 a_30325_n954# VSS 1.03998f
C3583 a_29368_n954# VSS 0.1323f
C3584 a_27853_n954# VSS 1.03998f
C3585 a_26896_n954# VSS 0.1323f
C3586 a_25381_n954# VSS 1.03998f
C3587 a_24424_n954# VSS 0.1323f
C3588 a_22909_n954# VSS 1.03998f
C3589 a_21952_n954# VSS 0.1323f
C3590 a_20437_n954# VSS 1.03998f
C3591 a_19480_n954# VSS 0.1323f
C3592 a_17965_n954# VSS 1.03998f
C3593 a_17008_n954# VSS 0.1323f
C3594 a_15493_n954# VSS 1.03998f
C3595 a_14536_n954# VSS 0.1323f
C3596 a_13021_n954# VSS 1.03998f
C3597 a_12064_n954# VSS 0.1323f
C3598 a_10549_n954# VSS 1.03998f
C3599 a_9592_n954# VSS 0.1323f
C3600 a_8077_n954# VSS 1.03998f
C3601 a_7120_n954# VSS 0.1323f
C3602 a_5605_n954# VSS 1.03998f
C3603 a_4648_n954# VSS 0.1323f
C3604 a_3133_n954# VSS 1.03998f
C3605 a_2176_n954# VSS 0.1323f
C3606 a_661_n954# VSS 1.03998f
C3607 a_n296_n954# VSS 0.12163f
C3608 a_38474_n608# VSS 0.14472f
C3609 a_36972_n954# VSS 0.66723f
C3610 a_37106_n640# VSS 0.48032f
C3611 a_36002_n608# VSS 0.11713f
C3612 a_34500_n954# VSS 0.66608f
C3613 a_34634_n640# VSS 0.48032f
C3614 a_33530_n608# VSS 0.11715f
C3615 a_32028_n954# VSS 0.66608f
C3616 a_32162_n640# VSS 0.48032f
C3617 a_31058_n608# VSS 0.11713f
C3618 a_29556_n954# VSS 0.66608f
C3619 a_29690_n640# VSS 0.48032f
C3620 a_28586_n608# VSS 0.11715f
C3621 a_27084_n954# VSS 0.66608f
C3622 a_27218_n640# VSS 0.48032f
C3623 a_26114_n608# VSS 0.11715f
C3624 a_24612_n954# VSS 0.66608f
C3625 a_24746_n640# VSS 0.48032f
C3626 a_23642_n608# VSS 0.11713f
C3627 a_22140_n954# VSS 0.66608f
C3628 a_22274_n640# VSS 0.48032f
C3629 a_21170_n608# VSS 0.11715f
C3630 a_19668_n954# VSS 0.66608f
C3631 a_19802_n640# VSS 0.48032f
C3632 a_18698_n608# VSS 0.11715f
C3633 a_17196_n954# VSS 0.66608f
C3634 a_17330_n640# VSS 0.48032f
C3635 a_16226_n608# VSS 0.11713f
C3636 a_14724_n954# VSS 0.66608f
C3637 a_14858_n640# VSS 0.48032f
C3638 a_13754_n608# VSS 0.11715f
C3639 a_12252_n954# VSS 0.66608f
C3640 a_12386_n640# VSS 0.48032f
C3641 a_11282_n608# VSS 0.11715f
C3642 a_9780_n954# VSS 0.66608f
C3643 a_9914_n640# VSS 0.48032f
C3644 a_8810_n608# VSS 0.11713f
C3645 a_7308_n954# VSS 0.66608f
C3646 a_7442_n640# VSS 0.48032f
C3647 a_6338_n608# VSS 0.11715f
C3648 a_4836_n954# VSS 0.66608f
C3649 a_4970_n640# VSS 0.48032f
C3650 a_3866_n608# VSS 0.11715f
C3651 a_2364_n954# VSS 0.66608f
C3652 a_2498_n640# VSS 0.48032f
C3653 a_1394_n608# VSS 0.11713f
C3654 a_n108_n954# VSS 0.66608f
C3655 a_26_n640# VSS 0.48032f
C3656 a_n1652_n522# VSS 0.57112f
C3657 a_38474_n12# VSS 0.14468f
C3658 a_36002_n12# VSS 0.11712f
C3659 a_37741_n170# VSS 1.03998f
C3660 a_36784_n170# VSS 0.1323f
C3661 a_33530_n12# VSS 0.11712f
C3662 a_35269_n170# VSS 1.03998f
C3663 a_34312_n170# VSS 0.1323f
C3664 a_31058_n12# VSS 0.11712f
C3665 a_32797_n170# VSS 1.03998f
C3666 a_31840_n170# VSS 0.1323f
C3667 a_28586_n12# VSS 0.11712f
C3668 a_30325_n170# VSS 1.03998f
C3669 a_29368_n170# VSS 0.1323f
C3670 a_26114_n12# VSS 0.11712f
C3671 a_27853_n170# VSS 1.03998f
C3672 a_26896_n170# VSS 0.1323f
C3673 a_23642_n12# VSS 0.11712f
C3674 a_25381_n170# VSS 1.03998f
C3675 a_24424_n170# VSS 0.1323f
C3676 a_21170_n12# VSS 0.11712f
C3677 a_22909_n170# VSS 1.03998f
C3678 a_21952_n170# VSS 0.1323f
C3679 a_18698_n12# VSS 0.11712f
C3680 a_20437_n170# VSS 1.03998f
C3681 a_19480_n170# VSS 0.1323f
C3682 a_16226_n12# VSS 0.11712f
C3683 a_17965_n170# VSS 1.03998f
C3684 a_17008_n170# VSS 0.1323f
C3685 a_13754_n12# VSS 0.11712f
C3686 a_15493_n170# VSS 1.03998f
C3687 a_14536_n170# VSS 0.1323f
C3688 a_11282_n12# VSS 0.11712f
C3689 a_13021_n170# VSS 1.03998f
C3690 a_12064_n170# VSS 0.1323f
C3691 a_8810_n12# VSS 0.11712f
C3692 a_10549_n170# VSS 1.03998f
C3693 a_9592_n170# VSS 0.1323f
C3694 a_6338_n12# VSS 0.11712f
C3695 a_8077_n170# VSS 1.03998f
C3696 a_7120_n170# VSS 0.1323f
C3697 a_3866_n12# VSS 0.11712f
C3698 a_5605_n170# VSS 1.03998f
C3699 a_4648_n170# VSS 0.1323f
C3700 a_1394_n12# VSS 0.11712f
C3701 a_3133_n170# VSS 1.03998f
C3702 a_2176_n170# VSS 0.1323f
C3703 a_661_n170# VSS 1.03998f
C3704 a_n296_n170# VSS 0.12163f
C3705 a_36972_n170# VSS 0.65932f
C3706 a_37106_20# VSS 0.47592f
C3707 a_34500_n170# VSS 0.65817f
C3708 a_34634_20# VSS 0.47592f
C3709 a_32028_n170# VSS 0.65817f
C3710 a_32162_20# VSS 0.47592f
C3711 a_29556_n170# VSS 0.65817f
C3712 a_29690_20# VSS 0.47592f
C3713 a_27084_n170# VSS 0.65817f
C3714 a_27218_20# VSS 0.47592f
C3715 a_24612_n170# VSS 0.65817f
C3716 a_24746_20# VSS 0.47592f
C3717 a_22140_n170# VSS 0.65817f
C3718 a_22274_20# VSS 0.47592f
C3719 a_19668_n170# VSS 0.65817f
C3720 a_19802_20# VSS 0.47592f
C3721 a_17196_n170# VSS 0.65817f
C3722 a_17330_20# VSS 0.47592f
C3723 a_14724_n170# VSS 0.65817f
C3724 a_14858_20# VSS 0.47592f
C3725 a_12252_n170# VSS 0.65817f
C3726 a_12386_20# VSS 0.47592f
C3727 a_9780_n170# VSS 0.65817f
C3728 a_9914_20# VSS 0.47592f
C3729 a_7308_n170# VSS 0.65817f
C3730 a_7442_20# VSS 0.47592f
C3731 a_4836_n170# VSS 0.65817f
C3732 a_4970_20# VSS 0.47592f
C3733 a_2364_n170# VSS 0.65817f
C3734 a_2498_20# VSS 0.47592f
C3735 a_n108_n170# VSS 0.65817f
C3736 a_26_20# VSS 0.47592f
C3737 a_n1652_n170# VSS 0.55816f
C3738 a_37741_614# VSS 1.03998f
C3739 a_36784_614# VSS 0.13233f
C3740 a_35269_614# VSS 1.03998f
C3741 a_34312_614# VSS 0.1323f
C3742 a_32797_614# VSS 1.03998f
C3743 a_31840_614# VSS 0.13233f
C3744 a_30325_614# VSS 1.03998f
C3745 a_29368_614# VSS 0.1323f
C3746 a_27853_614# VSS 1.03998f
C3747 a_26896_614# VSS 0.1323f
C3748 a_25381_614# VSS 1.03998f
C3749 a_24424_614# VSS 0.13233f
C3750 a_22909_614# VSS 1.03998f
C3751 a_21952_614# VSS 0.1323f
C3752 a_20437_614# VSS 1.03998f
C3753 a_19480_614# VSS 0.1323f
C3754 a_17965_614# VSS 1.03998f
C3755 a_17008_614# VSS 0.13233f
C3756 a_15493_614# VSS 1.03998f
C3757 a_14536_614# VSS 0.1323f
C3758 a_13021_614# VSS 1.03998f
C3759 a_12064_614# VSS 0.1323f
C3760 a_10549_614# VSS 1.03998f
C3761 a_9592_614# VSS 0.13233f
C3762 a_8077_614# VSS 1.03998f
C3763 a_7120_614# VSS 0.1323f
C3764 a_5605_614# VSS 1.03998f
C3765 a_4648_614# VSS 0.1323f
C3766 a_3133_614# VSS 1.03998f
C3767 a_2176_614# VSS 0.13233f
C3768 a_661_614# VSS 1.03998f
C3769 a_n296_614# VSS 0.12163f
C3770 a_38474_960# VSS 0.14468f
C3771 a_36972_614# VSS 0.65932f
C3772 a_37106_928# VSS 0.47592f
C3773 a_36002_960# VSS 0.11709f
C3774 a_34500_614# VSS 0.65819f
C3775 a_34634_928# VSS 0.47592f
C3776 a_33530_960# VSS 0.11712f
C3777 a_32028_614# VSS 0.65817f
C3778 a_32162_928# VSS 0.47592f
C3779 a_31058_960# VSS 0.11709f
C3780 a_29556_614# VSS 0.65819f
C3781 a_29690_928# VSS 0.47592f
C3782 a_28586_960# VSS 0.11712f
C3783 a_27084_614# VSS 0.65817f
C3784 a_27218_928# VSS 0.47592f
C3785 a_26114_960# VSS 0.11712f
C3786 a_24612_614# VSS 0.65817f
C3787 a_24746_928# VSS 0.47592f
C3788 a_23642_960# VSS 0.11709f
C3789 a_22140_614# VSS 0.65819f
C3790 a_22274_928# VSS 0.47592f
C3791 a_21170_960# VSS 0.11712f
C3792 a_19668_614# VSS 0.65817f
C3793 a_19802_928# VSS 0.47592f
C3794 a_18698_960# VSS 0.11712f
C3795 a_17196_614# VSS 0.65817f
C3796 a_17330_928# VSS 0.47592f
C3797 a_16226_960# VSS 0.11709f
C3798 a_14724_614# VSS 0.65819f
C3799 a_14858_928# VSS 0.47592f
C3800 a_13754_960# VSS 0.11712f
C3801 a_12252_614# VSS 0.65817f
C3802 a_12386_928# VSS 0.47592f
C3803 a_11282_960# VSS 0.11712f
C3804 a_9780_614# VSS 0.65817f
C3805 a_9914_928# VSS 0.47592f
C3806 a_8810_960# VSS 0.11709f
C3807 a_7308_614# VSS 0.65819f
C3808 a_7442_928# VSS 0.47592f
C3809 a_6338_960# VSS 0.11712f
C3810 a_4836_614# VSS 0.65817f
C3811 a_4970_928# VSS 0.47592f
C3812 a_3866_960# VSS 0.11712f
C3813 a_2364_614# VSS 0.65817f
C3814 a_2498_928# VSS 0.47592f
C3815 a_1394_960# VSS 0.11709f
C3816 a_n108_614# VSS 0.65819f
C3817 a_26_928# VSS 0.47592f
C3818 a_n1652_1046# VSS 0.55816f
C3819 a_38474_1556# VSS 0.14468f
C3820 a_36002_1556# VSS 0.11712f
C3821 a_37741_1398# VSS 1.03998f
C3822 a_36784_1398# VSS 0.1323f
C3823 a_33530_1556# VSS 0.11712f
C3824 a_35269_1398# VSS 1.03998f
C3825 a_34312_1398# VSS 0.1323f
C3826 a_31058_1556# VSS 0.11712f
C3827 a_32797_1398# VSS 1.03998f
C3828 a_31840_1398# VSS 0.1323f
C3829 a_28586_1556# VSS 0.11712f
C3830 a_30325_1398# VSS 1.03998f
C3831 a_29368_1398# VSS 0.1323f
C3832 a_26114_1556# VSS 0.11712f
C3833 a_27853_1398# VSS 1.03998f
C3834 a_26896_1398# VSS 0.1323f
C3835 a_23642_1556# VSS 0.11712f
C3836 a_25381_1398# VSS 1.03998f
C3837 a_24424_1398# VSS 0.1323f
C3838 a_21170_1556# VSS 0.11712f
C3839 a_22909_1398# VSS 1.03998f
C3840 a_21952_1398# VSS 0.1323f
C3841 a_18698_1556# VSS 0.11712f
C3842 a_20437_1398# VSS 1.03998f
C3843 a_19480_1398# VSS 0.1323f
C3844 a_16226_1556# VSS 0.11712f
C3845 a_17965_1398# VSS 1.03998f
C3846 a_17008_1398# VSS 0.1323f
C3847 a_13754_1556# VSS 0.11712f
C3848 a_15493_1398# VSS 1.03998f
C3849 a_14536_1398# VSS 0.1323f
C3850 a_11282_1556# VSS 0.11712f
C3851 a_13021_1398# VSS 1.03998f
C3852 a_12064_1398# VSS 0.1323f
C3853 a_8810_1556# VSS 0.11712f
C3854 a_10549_1398# VSS 1.03998f
C3855 a_9592_1398# VSS 0.1323f
C3856 a_6338_1556# VSS 0.11712f
C3857 a_8077_1398# VSS 1.03998f
C3858 a_7120_1398# VSS 0.1323f
C3859 a_3866_1556# VSS 0.11712f
C3860 a_5605_1398# VSS 1.03998f
C3861 a_4648_1398# VSS 0.1323f
C3862 a_1394_1556# VSS 0.11712f
C3863 a_3133_1398# VSS 1.03998f
C3864 a_2176_1398# VSS 0.1323f
C3865 a_661_1398# VSS 1.03998f
C3866 a_n296_1398# VSS 0.12163f
C3867 a_36972_1398# VSS 0.65932f
C3868 a_37106_1588# VSS 0.47592f
C3869 a_34500_1398# VSS 0.65817f
C3870 a_34634_1588# VSS 0.47592f
C3871 a_32028_1398# VSS 0.65817f
C3872 a_32162_1588# VSS 0.47592f
C3873 a_29556_1398# VSS 0.65817f
C3874 a_29690_1588# VSS 0.47592f
C3875 a_27084_1398# VSS 0.65817f
C3876 a_27218_1588# VSS 0.47592f
C3877 a_24612_1398# VSS 0.65817f
C3878 a_24746_1588# VSS 0.47592f
C3879 a_22140_1398# VSS 0.65817f
C3880 a_22274_1588# VSS 0.47592f
C3881 a_19668_1398# VSS 0.65817f
C3882 a_19802_1588# VSS 0.47592f
C3883 a_17196_1398# VSS 0.65817f
C3884 a_17330_1588# VSS 0.47592f
C3885 a_14724_1398# VSS 0.65817f
C3886 a_14858_1588# VSS 0.47592f
C3887 a_12252_1398# VSS 0.65817f
C3888 a_12386_1588# VSS 0.47592f
C3889 a_9780_1398# VSS 0.65817f
C3890 a_9914_1588# VSS 0.47592f
C3891 a_7308_1398# VSS 0.65817f
C3892 a_7442_1588# VSS 0.47592f
C3893 a_4836_1398# VSS 0.65817f
C3894 a_4970_1588# VSS 0.47592f
C3895 a_2364_1398# VSS 0.65817f
C3896 a_2498_1588# VSS 0.47592f
C3897 a_n108_1398# VSS 0.65817f
C3898 a_26_1588# VSS 0.47592f
C3899 a_n1652_1398# VSS 0.55816f
C3900 a_37741_2182# VSS 1.03998f
C3901 a_36784_2182# VSS 0.1323f
C3902 a_35269_2182# VSS 1.03998f
C3903 a_34312_2182# VSS 0.1323f
C3904 a_32797_2182# VSS 1.03998f
C3905 a_31840_2182# VSS 0.1323f
C3906 a_30325_2182# VSS 1.03998f
C3907 a_29368_2182# VSS 0.1323f
C3908 a_27853_2182# VSS 1.03998f
C3909 a_26896_2182# VSS 0.1323f
C3910 a_25381_2182# VSS 1.03998f
C3911 a_24424_2182# VSS 0.1323f
C3912 a_22909_2182# VSS 1.03998f
C3913 a_21952_2182# VSS 0.1323f
C3914 a_20437_2182# VSS 1.03998f
C3915 a_19480_2182# VSS 0.1323f
C3916 a_17965_2182# VSS 1.03998f
C3917 a_17008_2182# VSS 0.1323f
C3918 a_15493_2182# VSS 1.03998f
C3919 a_14536_2182# VSS 0.1323f
C3920 a_13021_2182# VSS 1.03998f
C3921 a_12064_2182# VSS 0.1323f
C3922 a_10549_2182# VSS 1.03998f
C3923 a_9592_2182# VSS 0.1323f
C3924 a_8077_2182# VSS 1.03998f
C3925 a_7120_2182# VSS 0.1323f
C3926 a_5605_2182# VSS 1.03998f
C3927 a_4648_2182# VSS 0.1323f
C3928 a_3133_2182# VSS 1.03998f
C3929 a_2176_2182# VSS 0.1323f
C3930 a_661_2182# VSS 1.03998f
C3931 a_n296_2182# VSS 0.12163f
C3932 a_38474_2528# VSS 0.14468f
C3933 a_36972_2182# VSS 0.65932f
C3934 a_37106_2496# VSS 0.47592f
C3935 a_36002_2528# VSS 0.11709f
C3936 a_34500_2182# VSS 0.65817f
C3937 a_34634_2496# VSS 0.47592f
C3938 a_33530_2528# VSS 0.11712f
C3939 a_32028_2182# VSS 0.65817f
C3940 a_32162_2496# VSS 0.47592f
C3941 a_31058_2528# VSS 0.11709f
C3942 a_29556_2182# VSS 0.65817f
C3943 a_29690_2496# VSS 0.47592f
C3944 a_28586_2528# VSS 0.11712f
C3945 a_27084_2182# VSS 0.65817f
C3946 a_27218_2496# VSS 0.47592f
C3947 a_26114_2528# VSS 0.11712f
C3948 a_24612_2182# VSS 0.65817f
C3949 a_24746_2496# VSS 0.47592f
C3950 a_23642_2528# VSS 0.11709f
C3951 a_22140_2182# VSS 0.65817f
C3952 a_22274_2496# VSS 0.47592f
C3953 a_21170_2528# VSS 0.11712f
C3954 a_19668_2182# VSS 0.65817f
C3955 a_19802_2496# VSS 0.47592f
C3956 a_18698_2528# VSS 0.11712f
C3957 a_17196_2182# VSS 0.65817f
C3958 a_17330_2496# VSS 0.47592f
C3959 a_16226_2528# VSS 0.11709f
C3960 a_14724_2182# VSS 0.65817f
C3961 a_14858_2496# VSS 0.47592f
C3962 a_13754_2528# VSS 0.11712f
C3963 a_12252_2182# VSS 0.65817f
C3964 a_12386_2496# VSS 0.47592f
C3965 a_11282_2528# VSS 0.11712f
C3966 a_9780_2182# VSS 0.65817f
C3967 a_9914_2496# VSS 0.47592f
C3968 a_8810_2528# VSS 0.11709f
C3969 a_7308_2182# VSS 0.65817f
C3970 a_7442_2496# VSS 0.47592f
C3971 a_6338_2528# VSS 0.11712f
C3972 a_4836_2182# VSS 0.65817f
C3973 a_4970_2496# VSS 0.47592f
C3974 a_3866_2528# VSS 0.11712f
C3975 a_2364_2182# VSS 0.65817f
C3976 a_2498_2496# VSS 0.47592f
C3977 a_1394_2528# VSS 0.11709f
C3978 a_n108_2182# VSS 0.65817f
C3979 a_26_2496# VSS 0.47592f
C3980 a_n1652_2614# VSS 0.55816f
C3981 a_38474_3124# VSS 0.14468f
C3982 a_36002_3124# VSS 0.11712f
C3983 a_37741_2966# VSS 1.03998f
C3984 a_36784_2966# VSS 0.1323f
C3985 a_33530_3124# VSS 0.11712f
C3986 a_35269_2966# VSS 1.03998f
C3987 a_34312_2966# VSS 0.1323f
C3988 a_31058_3124# VSS 0.11712f
C3989 a_32797_2966# VSS 1.03998f
C3990 a_31840_2966# VSS 0.1323f
C3991 a_28586_3124# VSS 0.11712f
C3992 a_30325_2966# VSS 1.03998f
C3993 a_29368_2966# VSS 0.1323f
C3994 a_26114_3124# VSS 0.11712f
C3995 a_27853_2966# VSS 1.03998f
C3996 a_26896_2966# VSS 0.1323f
C3997 a_23642_3124# VSS 0.11712f
C3998 a_25381_2966# VSS 1.03998f
C3999 a_24424_2966# VSS 0.1323f
C4000 a_21170_3124# VSS 0.11712f
C4001 a_22909_2966# VSS 1.03998f
C4002 a_21952_2966# VSS 0.1323f
C4003 a_18698_3124# VSS 0.11712f
C4004 a_20437_2966# VSS 1.03998f
C4005 a_19480_2966# VSS 0.1323f
C4006 a_16226_3124# VSS 0.11712f
C4007 a_17965_2966# VSS 1.03998f
C4008 a_17008_2966# VSS 0.1323f
C4009 a_13754_3124# VSS 0.11712f
C4010 a_15493_2966# VSS 1.03998f
C4011 a_14536_2966# VSS 0.1323f
C4012 a_11282_3124# VSS 0.11712f
C4013 a_13021_2966# VSS 1.03998f
C4014 a_12064_2966# VSS 0.1323f
C4015 a_8810_3124# VSS 0.11712f
C4016 a_10549_2966# VSS 1.03998f
C4017 a_9592_2966# VSS 0.1323f
C4018 a_6338_3124# VSS 0.11712f
C4019 a_8077_2966# VSS 1.03998f
C4020 a_7120_2966# VSS 0.1323f
C4021 a_3866_3124# VSS 0.11712f
C4022 a_5605_2966# VSS 1.03998f
C4023 a_4648_2966# VSS 0.1323f
C4024 a_1394_3124# VSS 0.11712f
C4025 a_3133_2966# VSS 1.03998f
C4026 a_2176_2966# VSS 0.1323f
C4027 a_661_2966# VSS 1.03998f
C4028 a_n296_2966# VSS 0.12163f
C4029 a_36972_2966# VSS 0.65932f
C4030 a_37106_3156# VSS 0.47592f
C4031 a_34500_2966# VSS 0.65817f
C4032 a_34634_3156# VSS 0.47592f
C4033 a_32028_2966# VSS 0.65817f
C4034 a_32162_3156# VSS 0.47592f
C4035 a_29556_2966# VSS 0.65817f
C4036 a_29690_3156# VSS 0.47592f
C4037 a_27084_2966# VSS 0.65817f
C4038 a_27218_3156# VSS 0.47592f
C4039 a_24612_2966# VSS 0.65817f
C4040 a_24746_3156# VSS 0.47592f
C4041 a_22140_2966# VSS 0.65817f
C4042 a_22274_3156# VSS 0.47592f
C4043 a_19668_2966# VSS 0.65817f
C4044 a_19802_3156# VSS 0.47592f
C4045 a_17196_2966# VSS 0.65817f
C4046 a_17330_3156# VSS 0.47592f
C4047 a_14724_2966# VSS 0.65817f
C4048 a_14858_3156# VSS 0.47592f
C4049 a_12252_2966# VSS 0.65817f
C4050 a_12386_3156# VSS 0.47592f
C4051 a_9780_2966# VSS 0.65817f
C4052 a_9914_3156# VSS 0.47592f
C4053 a_7308_2966# VSS 0.65817f
C4054 a_7442_3156# VSS 0.47592f
C4055 a_4836_2966# VSS 0.65817f
C4056 a_4970_3156# VSS 0.47592f
C4057 a_2364_2966# VSS 0.65817f
C4058 a_2498_3156# VSS 0.47592f
C4059 a_n108_2966# VSS 0.65817f
C4060 a_26_3156# VSS 0.47592f
C4061 a_n1652_2966# VSS 0.55816f
C4062 a_37741_3750# VSS 1.03998f
C4063 a_36784_3750# VSS 0.1323f
C4064 a_35269_3750# VSS 1.03998f
C4065 a_34312_3750# VSS 0.1323f
C4066 a_32797_3750# VSS 1.03998f
C4067 a_31840_3750# VSS 0.1323f
C4068 a_30325_3750# VSS 1.03998f
C4069 a_29368_3750# VSS 0.1323f
C4070 a_27853_3750# VSS 1.03998f
C4071 a_26896_3750# VSS 0.1323f
C4072 a_25381_3750# VSS 1.03998f
C4073 a_24424_3750# VSS 0.1323f
C4074 a_22909_3750# VSS 1.03998f
C4075 a_21952_3750# VSS 0.1323f
C4076 a_20437_3750# VSS 1.03998f
C4077 a_19480_3750# VSS 0.1323f
C4078 a_17965_3750# VSS 1.03998f
C4079 a_17008_3750# VSS 0.1323f
C4080 a_15493_3750# VSS 1.03998f
C4081 a_14536_3750# VSS 0.1323f
C4082 a_13021_3750# VSS 1.03998f
C4083 a_12064_3750# VSS 0.1323f
C4084 a_10549_3750# VSS 1.03998f
C4085 a_9592_3750# VSS 0.1323f
C4086 a_8077_3750# VSS 1.03998f
C4087 a_7120_3750# VSS 0.1323f
C4088 a_5605_3750# VSS 1.03998f
C4089 a_4648_3750# VSS 0.1323f
C4090 a_3133_3750# VSS 1.03998f
C4091 a_2176_3750# VSS 0.1323f
C4092 a_661_3750# VSS 1.03998f
C4093 a_n296_3750# VSS 0.12163f
C4094 a_38474_4096# VSS 0.14468f
C4095 a_36972_3750# VSS 0.65932f
C4096 a_37106_4064# VSS 0.47592f
C4097 a_36002_4096# VSS 0.11709f
C4098 a_34500_3750# VSS 0.65817f
C4099 a_34634_4064# VSS 0.47592f
C4100 a_33530_4096# VSS 0.11712f
C4101 a_32028_3750# VSS 0.65817f
C4102 a_32162_4064# VSS 0.47592f
C4103 a_31058_4096# VSS 0.11709f
C4104 a_29556_3750# VSS 0.65817f
C4105 a_29690_4064# VSS 0.47592f
C4106 a_28586_4096# VSS 0.11712f
C4107 a_27084_3750# VSS 0.65817f
C4108 a_27218_4064# VSS 0.47592f
C4109 a_26114_4096# VSS 0.11712f
C4110 a_24612_3750# VSS 0.65817f
C4111 a_24746_4064# VSS 0.47592f
C4112 a_23642_4096# VSS 0.11709f
C4113 a_22140_3750# VSS 0.65817f
C4114 a_22274_4064# VSS 0.47592f
C4115 a_21170_4096# VSS 0.11712f
C4116 a_19668_3750# VSS 0.65817f
C4117 a_19802_4064# VSS 0.47592f
C4118 a_18698_4096# VSS 0.11712f
C4119 a_17196_3750# VSS 0.65817f
C4120 a_17330_4064# VSS 0.47592f
C4121 a_16226_4096# VSS 0.11709f
C4122 a_14724_3750# VSS 0.65817f
C4123 a_14858_4064# VSS 0.47592f
C4124 a_13754_4096# VSS 0.11712f
C4125 a_12252_3750# VSS 0.65817f
C4126 a_12386_4064# VSS 0.47592f
C4127 a_11282_4096# VSS 0.11712f
C4128 a_9780_3750# VSS 0.65817f
C4129 a_9914_4064# VSS 0.47592f
C4130 a_8810_4096# VSS 0.11709f
C4131 a_7308_3750# VSS 0.65817f
C4132 a_7442_4064# VSS 0.47592f
C4133 a_6338_4096# VSS 0.11712f
C4134 a_4836_3750# VSS 0.65817f
C4135 a_4970_4064# VSS 0.47592f
C4136 a_3866_4096# VSS 0.11712f
C4137 a_2364_3750# VSS 0.65817f
C4138 a_2498_4064# VSS 0.47592f
C4139 a_1394_4096# VSS 0.11709f
C4140 a_n108_3750# VSS 0.65817f
C4141 a_26_4064# VSS 0.47592f
C4142 a_n1652_4182# VSS 0.55816f
C4143 a_38474_4692# VSS 0.14468f
C4144 a_36002_4692# VSS 0.11712f
C4145 a_37741_4534# VSS 1.03998f
C4146 a_36784_4534# VSS 0.1323f
C4147 a_33530_4692# VSS 0.11712f
C4148 a_35269_4534# VSS 1.03998f
C4149 a_34312_4534# VSS 0.1323f
C4150 a_31058_4692# VSS 0.11712f
C4151 a_32797_4534# VSS 1.03998f
C4152 a_31840_4534# VSS 0.1323f
C4153 a_28586_4692# VSS 0.11712f
C4154 a_30325_4534# VSS 1.03998f
C4155 a_29368_4534# VSS 0.1323f
C4156 a_26114_4692# VSS 0.11712f
C4157 a_27853_4534# VSS 1.03998f
C4158 a_26896_4534# VSS 0.1323f
C4159 a_23642_4692# VSS 0.11712f
C4160 a_25381_4534# VSS 1.03998f
C4161 a_24424_4534# VSS 0.1323f
C4162 a_21170_4692# VSS 0.11712f
C4163 a_22909_4534# VSS 1.03998f
C4164 a_21952_4534# VSS 0.1323f
C4165 a_18698_4692# VSS 0.11712f
C4166 a_20437_4534# VSS 1.03998f
C4167 a_19480_4534# VSS 0.1323f
C4168 a_16226_4692# VSS 0.11712f
C4169 a_17965_4534# VSS 1.03998f
C4170 a_17008_4534# VSS 0.1323f
C4171 a_13754_4692# VSS 0.11712f
C4172 a_15493_4534# VSS 1.03998f
C4173 a_14536_4534# VSS 0.1323f
C4174 a_11282_4692# VSS 0.11712f
C4175 a_13021_4534# VSS 1.03998f
C4176 a_12064_4534# VSS 0.1323f
C4177 a_8810_4692# VSS 0.11712f
C4178 a_10549_4534# VSS 1.03998f
C4179 a_9592_4534# VSS 0.1323f
C4180 a_6338_4692# VSS 0.11712f
C4181 a_8077_4534# VSS 1.03998f
C4182 a_7120_4534# VSS 0.1323f
C4183 a_3866_4692# VSS 0.11712f
C4184 a_5605_4534# VSS 1.03998f
C4185 a_4648_4534# VSS 0.1323f
C4186 a_1394_4692# VSS 0.11712f
C4187 a_3133_4534# VSS 1.03998f
C4188 a_2176_4534# VSS 0.1323f
C4189 a_661_4534# VSS 1.03998f
C4190 a_n296_4534# VSS 0.12163f
C4191 a_36972_4534# VSS 0.65932f
C4192 a_37106_4724# VSS 0.47592f
C4193 a_34500_4534# VSS 0.65817f
C4194 a_34634_4724# VSS 0.47592f
C4195 a_32028_4534# VSS 0.65817f
C4196 a_32162_4724# VSS 0.47592f
C4197 a_29556_4534# VSS 0.65817f
C4198 a_29690_4724# VSS 0.47592f
C4199 a_27084_4534# VSS 0.65817f
C4200 a_27218_4724# VSS 0.47592f
C4201 a_24612_4534# VSS 0.65817f
C4202 a_24746_4724# VSS 0.47592f
C4203 a_22140_4534# VSS 0.65817f
C4204 a_22274_4724# VSS 0.47592f
C4205 a_19668_4534# VSS 0.65817f
C4206 a_19802_4724# VSS 0.47592f
C4207 a_17196_4534# VSS 0.65817f
C4208 a_17330_4724# VSS 0.47592f
C4209 a_14724_4534# VSS 0.65817f
C4210 a_14858_4724# VSS 0.47592f
C4211 a_12252_4534# VSS 0.65817f
C4212 a_12386_4724# VSS 0.47592f
C4213 a_9780_4534# VSS 0.65817f
C4214 a_9914_4724# VSS 0.47592f
C4215 a_7308_4534# VSS 0.65817f
C4216 a_7442_4724# VSS 0.47592f
C4217 a_4836_4534# VSS 0.65817f
C4218 a_4970_4724# VSS 0.47592f
C4219 a_2364_4534# VSS 0.65817f
C4220 a_2498_4724# VSS 0.47592f
C4221 a_n108_4534# VSS 0.65817f
C4222 a_26_4724# VSS 0.47592f
C4223 a_n1652_4534# VSS 0.55816f
C4224 a_37741_5318# VSS 1.03998f
C4225 a_36784_5318# VSS 0.13233f
C4226 a_35269_5318# VSS 1.03998f
C4227 a_34312_5318# VSS 0.1323f
C4228 a_32797_5318# VSS 1.03998f
C4229 a_31840_5318# VSS 0.13233f
C4230 a_30325_5318# VSS 1.03998f
C4231 a_29368_5318# VSS 0.1323f
C4232 a_27853_5318# VSS 1.03998f
C4233 a_26896_5318# VSS 0.1323f
C4234 a_25381_5318# VSS 1.03998f
C4235 a_24424_5318# VSS 0.13233f
C4236 a_22909_5318# VSS 1.03998f
C4237 a_21952_5318# VSS 0.1323f
C4238 a_20437_5318# VSS 1.03998f
C4239 a_19480_5318# VSS 0.1323f
C4240 a_17965_5318# VSS 1.03998f
C4241 a_17008_5318# VSS 0.13233f
C4242 a_15493_5318# VSS 1.03998f
C4243 a_14536_5318# VSS 0.1323f
C4244 a_13021_5318# VSS 1.03998f
C4245 a_12064_5318# VSS 0.1323f
C4246 a_10549_5318# VSS 1.03998f
C4247 a_9592_5318# VSS 0.13233f
C4248 a_8077_5318# VSS 1.03998f
C4249 a_7120_5318# VSS 0.1323f
C4250 a_5605_5318# VSS 1.03998f
C4251 a_4648_5318# VSS 0.1323f
C4252 a_3133_5318# VSS 1.03998f
C4253 a_2176_5318# VSS 0.13233f
C4254 a_661_5318# VSS 1.03998f
C4255 a_n296_5318# VSS 0.12163f
C4256 a_38474_5664# VSS 0.14468f
C4257 a_36972_5318# VSS 0.65932f
C4258 a_37106_5632# VSS 0.47592f
C4259 a_36002_5664# VSS 0.11709f
C4260 a_34500_5318# VSS 0.65819f
C4261 a_34634_5632# VSS 0.47592f
C4262 a_33530_5664# VSS 0.11712f
C4263 a_32028_5318# VSS 0.65817f
C4264 a_32162_5632# VSS 0.47592f
C4265 a_31058_5664# VSS 0.11709f
C4266 a_29556_5318# VSS 0.65819f
C4267 a_29690_5632# VSS 0.47592f
C4268 a_28586_5664# VSS 0.11712f
C4269 a_27084_5318# VSS 0.65817f
C4270 a_27218_5632# VSS 0.47592f
C4271 a_26114_5664# VSS 0.11712f
C4272 a_24612_5318# VSS 0.65817f
C4273 a_24746_5632# VSS 0.47592f
C4274 a_23642_5664# VSS 0.11709f
C4275 a_22140_5318# VSS 0.65819f
C4276 a_22274_5632# VSS 0.47592f
C4277 a_21170_5664# VSS 0.11712f
C4278 a_19668_5318# VSS 0.65817f
C4279 a_19802_5632# VSS 0.47592f
C4280 a_18698_5664# VSS 0.11712f
C4281 a_17196_5318# VSS 0.65817f
C4282 a_17330_5632# VSS 0.47592f
C4283 a_16226_5664# VSS 0.11709f
C4284 a_14724_5318# VSS 0.65819f
C4285 a_14858_5632# VSS 0.47592f
C4286 a_13754_5664# VSS 0.11712f
C4287 a_12252_5318# VSS 0.65817f
C4288 a_12386_5632# VSS 0.47592f
C4289 a_11282_5664# VSS 0.11712f
C4290 a_9780_5318# VSS 0.65817f
C4291 a_9914_5632# VSS 0.47592f
C4292 a_8810_5664# VSS 0.11709f
C4293 a_7308_5318# VSS 0.65819f
C4294 a_7442_5632# VSS 0.47592f
C4295 a_6338_5664# VSS 0.11712f
C4296 a_4836_5318# VSS 0.65817f
C4297 a_4970_5632# VSS 0.47592f
C4298 a_3866_5664# VSS 0.11712f
C4299 a_2364_5318# VSS 0.65817f
C4300 a_2498_5632# VSS 0.47592f
C4301 a_1394_5664# VSS 0.11709f
C4302 a_n108_5318# VSS 0.65819f
C4303 a_26_5632# VSS 0.47592f
C4304 a_n1652_5750# VSS 0.55816f
C4305 a_38474_6260# VSS 0.14468f
C4306 a_36002_6260# VSS 0.11712f
C4307 a_37741_6102# VSS 1.03998f
C4308 a_36784_6102# VSS 0.1323f
C4309 a_33530_6260# VSS 0.11712f
C4310 a_35269_6102# VSS 1.03998f
C4311 a_34312_6102# VSS 0.1323f
C4312 a_31058_6260# VSS 0.11712f
C4313 a_32797_6102# VSS 1.03998f
C4314 a_31840_6102# VSS 0.1323f
C4315 a_28586_6260# VSS 0.11712f
C4316 a_30325_6102# VSS 1.03998f
C4317 a_29368_6102# VSS 0.1323f
C4318 a_26114_6260# VSS 0.11712f
C4319 a_27853_6102# VSS 1.03998f
C4320 a_26896_6102# VSS 0.1323f
C4321 a_23642_6260# VSS 0.11712f
C4322 a_25381_6102# VSS 1.03998f
C4323 a_24424_6102# VSS 0.1323f
C4324 a_21170_6260# VSS 0.11712f
C4325 a_22909_6102# VSS 1.03998f
C4326 a_21952_6102# VSS 0.1323f
C4327 a_18698_6260# VSS 0.11712f
C4328 a_20437_6102# VSS 1.03998f
C4329 a_19480_6102# VSS 0.1323f
C4330 a_16226_6260# VSS 0.11712f
C4331 a_17965_6102# VSS 1.03998f
C4332 a_17008_6102# VSS 0.1323f
C4333 a_13754_6260# VSS 0.11712f
C4334 a_15493_6102# VSS 1.03998f
C4335 a_14536_6102# VSS 0.1323f
C4336 a_11282_6260# VSS 0.11712f
C4337 a_13021_6102# VSS 1.03998f
C4338 a_12064_6102# VSS 0.1323f
C4339 a_8810_6260# VSS 0.11712f
C4340 a_10549_6102# VSS 1.03998f
C4341 a_9592_6102# VSS 0.1323f
C4342 a_6338_6260# VSS 0.11712f
C4343 a_8077_6102# VSS 1.03998f
C4344 a_7120_6102# VSS 0.1323f
C4345 a_3866_6260# VSS 0.11712f
C4346 a_5605_6102# VSS 1.03998f
C4347 a_4648_6102# VSS 0.1323f
C4348 a_1394_6260# VSS 0.11712f
C4349 a_3133_6102# VSS 1.03998f
C4350 a_2176_6102# VSS 0.1323f
C4351 a_661_6102# VSS 1.03998f
C4352 a_n296_6102# VSS 0.12163f
C4353 a_36972_6102# VSS 0.65932f
C4354 a_37106_6292# VSS 0.47592f
C4355 a_34500_6102# VSS 0.65817f
C4356 a_34634_6292# VSS 0.47592f
C4357 a_32028_6102# VSS 0.65817f
C4358 a_32162_6292# VSS 0.47592f
C4359 a_29556_6102# VSS 0.65817f
C4360 a_29690_6292# VSS 0.47592f
C4361 a_27084_6102# VSS 0.65817f
C4362 a_27218_6292# VSS 0.47592f
C4363 a_24612_6102# VSS 0.65817f
C4364 a_24746_6292# VSS 0.47592f
C4365 a_22140_6102# VSS 0.65817f
C4366 a_22274_6292# VSS 0.47592f
C4367 a_19668_6102# VSS 0.65817f
C4368 a_19802_6292# VSS 0.47592f
C4369 a_17196_6102# VSS 0.65817f
C4370 a_17330_6292# VSS 0.47592f
C4371 a_14724_6102# VSS 0.65817f
C4372 a_14858_6292# VSS 0.47592f
C4373 a_12252_6102# VSS 0.65817f
C4374 a_12386_6292# VSS 0.47592f
C4375 a_9780_6102# VSS 0.65817f
C4376 a_9914_6292# VSS 0.47592f
C4377 a_7308_6102# VSS 0.65817f
C4378 a_7442_6292# VSS 0.47592f
C4379 a_4836_6102# VSS 0.65817f
C4380 a_4970_6292# VSS 0.47592f
C4381 a_2364_6102# VSS 0.65817f
C4382 a_2498_6292# VSS 0.47592f
C4383 a_n108_6102# VSS 0.65817f
C4384 a_26_6292# VSS 0.47592f
C4385 a_n1652_6102# VSS 0.55816f
C4386 a_37741_6886# VSS 1.03998f
C4387 a_36784_6886# VSS 0.1323f
C4388 a_35269_6886# VSS 1.03998f
C4389 a_34312_6886# VSS 0.1323f
C4390 a_32797_6886# VSS 1.03998f
C4391 a_31840_6886# VSS 0.1323f
C4392 a_30325_6886# VSS 1.03998f
C4393 a_29368_6886# VSS 0.1323f
C4394 a_27853_6886# VSS 1.03998f
C4395 a_26896_6886# VSS 0.1323f
C4396 a_25381_6886# VSS 1.03998f
C4397 a_24424_6886# VSS 0.1323f
C4398 a_22909_6886# VSS 1.03998f
C4399 a_21952_6886# VSS 0.1323f
C4400 a_20437_6886# VSS 1.03998f
C4401 a_19480_6886# VSS 0.1323f
C4402 a_17965_6886# VSS 1.03998f
C4403 a_17008_6886# VSS 0.1323f
C4404 a_15493_6886# VSS 1.03998f
C4405 a_14536_6886# VSS 0.1323f
C4406 a_13021_6886# VSS 1.03998f
C4407 a_12064_6886# VSS 0.1323f
C4408 a_10549_6886# VSS 1.03998f
C4409 a_9592_6886# VSS 0.1323f
C4410 a_8077_6886# VSS 1.03998f
C4411 a_7120_6886# VSS 0.1323f
C4412 a_5605_6886# VSS 1.03998f
C4413 a_4648_6886# VSS 0.1323f
C4414 a_3133_6886# VSS 1.03998f
C4415 a_2176_6886# VSS 0.1323f
C4416 a_661_6886# VSS 1.03998f
C4417 a_n296_6886# VSS 0.12163f
C4418 a_38474_7232# VSS 0.14468f
C4419 a_36972_6886# VSS 0.65932f
C4420 a_37106_7200# VSS 0.47592f
C4421 a_36002_7232# VSS 0.11709f
C4422 a_34500_6886# VSS 0.65817f
C4423 a_34634_7200# VSS 0.47592f
C4424 a_33530_7232# VSS 0.11712f
C4425 a_32028_6886# VSS 0.65817f
C4426 a_32162_7200# VSS 0.47592f
C4427 a_31058_7232# VSS 0.11709f
C4428 a_29556_6886# VSS 0.65817f
C4429 a_29690_7200# VSS 0.47592f
C4430 a_28586_7232# VSS 0.11712f
C4431 a_27084_6886# VSS 0.65817f
C4432 a_27218_7200# VSS 0.47592f
C4433 a_26114_7232# VSS 0.11712f
C4434 a_24612_6886# VSS 0.65817f
C4435 a_24746_7200# VSS 0.47592f
C4436 a_23642_7232# VSS 0.11709f
C4437 a_22140_6886# VSS 0.65817f
C4438 a_22274_7200# VSS 0.47592f
C4439 a_21170_7232# VSS 0.11712f
C4440 a_19668_6886# VSS 0.65817f
C4441 a_19802_7200# VSS 0.47592f
C4442 a_18698_7232# VSS 0.11712f
C4443 a_17196_6886# VSS 0.65817f
C4444 a_17330_7200# VSS 0.47592f
C4445 a_16226_7232# VSS 0.11709f
C4446 a_14724_6886# VSS 0.65817f
C4447 a_14858_7200# VSS 0.47592f
C4448 a_13754_7232# VSS 0.11712f
C4449 a_12252_6886# VSS 0.65817f
C4450 a_12386_7200# VSS 0.47592f
C4451 a_11282_7232# VSS 0.11712f
C4452 a_9780_6886# VSS 0.65817f
C4453 a_9914_7200# VSS 0.47592f
C4454 a_8810_7232# VSS 0.11709f
C4455 a_7308_6886# VSS 0.65817f
C4456 a_7442_7200# VSS 0.47592f
C4457 a_6338_7232# VSS 0.11712f
C4458 a_4836_6886# VSS 0.65817f
C4459 a_4970_7200# VSS 0.47592f
C4460 a_3866_7232# VSS 0.11712f
C4461 a_2364_6886# VSS 0.65817f
C4462 a_2498_7200# VSS 0.47592f
C4463 a_1394_7232# VSS 0.11709f
C4464 a_n108_6886# VSS 0.65817f
C4465 a_26_7200# VSS 0.47592f
C4466 a_n1652_7318# VSS 0.55816f
C4467 a_38474_7828# VSS 0.14468f
C4468 a_36002_7828# VSS 0.11712f
C4469 a_37741_7670# VSS 1.03998f
C4470 a_36784_7670# VSS 0.1323f
C4471 a_33530_7828# VSS 0.11712f
C4472 a_35269_7670# VSS 1.03998f
C4473 a_34312_7670# VSS 0.1323f
C4474 a_31058_7828# VSS 0.11712f
C4475 a_32797_7670# VSS 1.03998f
C4476 a_31840_7670# VSS 0.1323f
C4477 a_28586_7828# VSS 0.11712f
C4478 a_30325_7670# VSS 1.03998f
C4479 a_29368_7670# VSS 0.1323f
C4480 a_26114_7828# VSS 0.11712f
C4481 a_27853_7670# VSS 1.03998f
C4482 a_26896_7670# VSS 0.1323f
C4483 a_23642_7828# VSS 0.11712f
C4484 a_25381_7670# VSS 1.03998f
C4485 a_24424_7670# VSS 0.1323f
C4486 a_21170_7828# VSS 0.11712f
C4487 a_22909_7670# VSS 1.03998f
C4488 a_21952_7670# VSS 0.1323f
C4489 a_18698_7828# VSS 0.11712f
C4490 a_20437_7670# VSS 1.03998f
C4491 a_19480_7670# VSS 0.1323f
C4492 a_16226_7828# VSS 0.11712f
C4493 a_17965_7670# VSS 1.03998f
C4494 a_17008_7670# VSS 0.1323f
C4495 a_13754_7828# VSS 0.11712f
C4496 a_15493_7670# VSS 1.03998f
C4497 a_14536_7670# VSS 0.1323f
C4498 a_11282_7828# VSS 0.11712f
C4499 a_13021_7670# VSS 1.03998f
C4500 a_12064_7670# VSS 0.1323f
C4501 a_8810_7828# VSS 0.11712f
C4502 a_10549_7670# VSS 1.03998f
C4503 a_9592_7670# VSS 0.1323f
C4504 a_6338_7828# VSS 0.11712f
C4505 a_8077_7670# VSS 1.03998f
C4506 a_7120_7670# VSS 0.1323f
C4507 a_3866_7828# VSS 0.11712f
C4508 a_5605_7670# VSS 1.03998f
C4509 a_4648_7670# VSS 0.1323f
C4510 a_1394_7828# VSS 0.11712f
C4511 a_3133_7670# VSS 1.03998f
C4512 a_2176_7670# VSS 0.1323f
C4513 a_661_7670# VSS 1.03998f
C4514 a_n296_7670# VSS 0.12163f
C4515 a_36972_7670# VSS 0.65932f
C4516 a_37106_7860# VSS 0.47592f
C4517 a_34500_7670# VSS 0.65817f
C4518 a_34634_7860# VSS 0.47592f
C4519 a_32028_7670# VSS 0.65817f
C4520 a_32162_7860# VSS 0.47592f
C4521 a_29556_7670# VSS 0.65817f
C4522 a_29690_7860# VSS 0.47592f
C4523 a_27084_7670# VSS 0.65817f
C4524 a_27218_7860# VSS 0.47592f
C4525 a_24612_7670# VSS 0.65817f
C4526 a_24746_7860# VSS 0.47592f
C4527 a_22140_7670# VSS 0.65817f
C4528 a_22274_7860# VSS 0.47592f
C4529 a_19668_7670# VSS 0.65817f
C4530 a_19802_7860# VSS 0.47592f
C4531 a_17196_7670# VSS 0.65817f
C4532 a_17330_7860# VSS 0.47592f
C4533 a_14724_7670# VSS 0.65817f
C4534 a_14858_7860# VSS 0.47592f
C4535 a_12252_7670# VSS 0.65817f
C4536 a_12386_7860# VSS 0.47592f
C4537 a_9780_7670# VSS 0.65817f
C4538 a_9914_7860# VSS 0.47592f
C4539 a_7308_7670# VSS 0.65817f
C4540 a_7442_7860# VSS 0.47592f
C4541 a_4836_7670# VSS 0.65817f
C4542 a_4970_7860# VSS 0.47592f
C4543 a_2364_7670# VSS 0.65817f
C4544 a_2498_7860# VSS 0.47592f
C4545 a_n108_7670# VSS 0.65817f
C4546 a_26_7860# VSS 0.47592f
C4547 a_n1652_7670# VSS 0.55816f
C4548 a_37741_8454# VSS 1.03998f
C4549 a_36784_8454# VSS 0.1323f
C4550 a_35269_8454# VSS 1.03998f
C4551 a_34312_8454# VSS 0.1323f
C4552 a_32797_8454# VSS 1.03998f
C4553 a_31840_8454# VSS 0.1323f
C4554 a_30325_8454# VSS 1.03998f
C4555 a_29368_8454# VSS 0.1323f
C4556 a_27853_8454# VSS 1.03998f
C4557 a_26896_8454# VSS 0.1323f
C4558 a_25381_8454# VSS 1.03998f
C4559 a_24424_8454# VSS 0.1323f
C4560 a_22909_8454# VSS 1.03998f
C4561 a_21952_8454# VSS 0.1323f
C4562 a_20437_8454# VSS 1.03998f
C4563 a_19480_8454# VSS 0.1323f
C4564 a_17965_8454# VSS 1.03998f
C4565 a_17008_8454# VSS 0.1323f
C4566 a_15493_8454# VSS 1.03998f
C4567 a_14536_8454# VSS 0.1323f
C4568 a_13021_8454# VSS 1.03998f
C4569 a_12064_8454# VSS 0.1323f
C4570 a_10549_8454# VSS 1.03998f
C4571 a_9592_8454# VSS 0.1323f
C4572 a_8077_8454# VSS 1.03998f
C4573 a_7120_8454# VSS 0.1323f
C4574 a_5605_8454# VSS 1.03998f
C4575 a_4648_8454# VSS 0.1323f
C4576 a_3133_8454# VSS 1.03998f
C4577 a_2176_8454# VSS 0.1323f
C4578 a_661_8454# VSS 1.03998f
C4579 a_n296_8454# VSS 0.12163f
C4580 a_38474_8800# VSS 0.14468f
C4581 a_36972_8454# VSS 0.65932f
C4582 a_37106_8768# VSS 0.47592f
C4583 a_36002_8800# VSS 0.11709f
C4584 a_34500_8454# VSS 0.65817f
C4585 a_34634_8768# VSS 0.47592f
C4586 a_33530_8800# VSS 0.11712f
C4587 a_32028_8454# VSS 0.65817f
C4588 a_32162_8768# VSS 0.47592f
C4589 a_31058_8800# VSS 0.11709f
C4590 a_29556_8454# VSS 0.65817f
C4591 a_29690_8768# VSS 0.47592f
C4592 a_28586_8800# VSS 0.11712f
C4593 a_27084_8454# VSS 0.65817f
C4594 a_27218_8768# VSS 0.47592f
C4595 a_26114_8800# VSS 0.11712f
C4596 a_24612_8454# VSS 0.65817f
C4597 a_24746_8768# VSS 0.47592f
C4598 a_23642_8800# VSS 0.11709f
C4599 a_22140_8454# VSS 0.65817f
C4600 a_22274_8768# VSS 0.47592f
C4601 a_21170_8800# VSS 0.11712f
C4602 a_19668_8454# VSS 0.65817f
C4603 a_19802_8768# VSS 0.47592f
C4604 a_18698_8800# VSS 0.11712f
C4605 a_17196_8454# VSS 0.65817f
C4606 a_17330_8768# VSS 0.47592f
C4607 a_16226_8800# VSS 0.11709f
C4608 a_14724_8454# VSS 0.65817f
C4609 a_14858_8768# VSS 0.47592f
C4610 a_13754_8800# VSS 0.11712f
C4611 a_12252_8454# VSS 0.65817f
C4612 a_12386_8768# VSS 0.47592f
C4613 a_11282_8800# VSS 0.11712f
C4614 a_9780_8454# VSS 0.65817f
C4615 a_9914_8768# VSS 0.47592f
C4616 a_8810_8800# VSS 0.11709f
C4617 a_7308_8454# VSS 0.65817f
C4618 a_7442_8768# VSS 0.47592f
C4619 a_6338_8800# VSS 0.11712f
C4620 a_4836_8454# VSS 0.65817f
C4621 a_4970_8768# VSS 0.47592f
C4622 a_3866_8800# VSS 0.11712f
C4623 a_2364_8454# VSS 0.65817f
C4624 a_2498_8768# VSS 0.47592f
C4625 a_1394_8800# VSS 0.11709f
C4626 a_n108_8454# VSS 0.65817f
C4627 a_26_8768# VSS 0.47592f
C4628 a_n1652_8886# VSS 0.55816f
C4629 a_38474_9396# VSS 0.14468f
C4630 a_36002_9396# VSS 0.11712f
C4631 a_37741_9238# VSS 1.03998f
C4632 a_36784_9238# VSS 0.1323f
C4633 a_33530_9396# VSS 0.11712f
C4634 a_35269_9238# VSS 1.03998f
C4635 a_34312_9238# VSS 0.1323f
C4636 a_31058_9396# VSS 0.11712f
C4637 a_32797_9238# VSS 1.03998f
C4638 a_31840_9238# VSS 0.1323f
C4639 a_28586_9396# VSS 0.11712f
C4640 a_30325_9238# VSS 1.03998f
C4641 a_29368_9238# VSS 0.1323f
C4642 a_26114_9396# VSS 0.11712f
C4643 a_27853_9238# VSS 1.03998f
C4644 a_26896_9238# VSS 0.1323f
C4645 a_23642_9396# VSS 0.11712f
C4646 a_25381_9238# VSS 1.03998f
C4647 a_24424_9238# VSS 0.1323f
C4648 a_21170_9396# VSS 0.11712f
C4649 a_22909_9238# VSS 1.03998f
C4650 a_21952_9238# VSS 0.1323f
C4651 a_18698_9396# VSS 0.11712f
C4652 a_20437_9238# VSS 1.03998f
C4653 a_19480_9238# VSS 0.1323f
C4654 a_16226_9396# VSS 0.11712f
C4655 a_17965_9238# VSS 1.03998f
C4656 a_17008_9238# VSS 0.1323f
C4657 a_13754_9396# VSS 0.11712f
C4658 a_15493_9238# VSS 1.03998f
C4659 a_14536_9238# VSS 0.1323f
C4660 a_11282_9396# VSS 0.11712f
C4661 a_13021_9238# VSS 1.03998f
C4662 a_12064_9238# VSS 0.1323f
C4663 a_8810_9396# VSS 0.11712f
C4664 a_10549_9238# VSS 1.03998f
C4665 a_9592_9238# VSS 0.1323f
C4666 a_6338_9396# VSS 0.11712f
C4667 a_8077_9238# VSS 1.03998f
C4668 a_7120_9238# VSS 0.1323f
C4669 a_3866_9396# VSS 0.11712f
C4670 a_5605_9238# VSS 1.03998f
C4671 a_4648_9238# VSS 0.1323f
C4672 a_1394_9396# VSS 0.11712f
C4673 a_3133_9238# VSS 1.03998f
C4674 a_2176_9238# VSS 0.1323f
C4675 a_661_9238# VSS 1.03998f
C4676 a_n296_9238# VSS 0.12163f
C4677 a_36972_9238# VSS 0.65932f
C4678 a_37106_9428# VSS 0.47592f
C4679 a_34500_9238# VSS 0.65817f
C4680 a_34634_9428# VSS 0.47592f
C4681 a_32028_9238# VSS 0.65817f
C4682 a_32162_9428# VSS 0.47592f
C4683 a_29556_9238# VSS 0.65817f
C4684 a_29690_9428# VSS 0.47592f
C4685 a_27084_9238# VSS 0.65817f
C4686 a_27218_9428# VSS 0.47592f
C4687 a_24612_9238# VSS 0.65817f
C4688 a_24746_9428# VSS 0.47592f
C4689 a_22140_9238# VSS 0.65817f
C4690 a_22274_9428# VSS 0.47592f
C4691 a_19668_9238# VSS 0.65817f
C4692 a_19802_9428# VSS 0.47592f
C4693 a_17196_9238# VSS 0.65817f
C4694 a_17330_9428# VSS 0.47592f
C4695 a_14724_9238# VSS 0.65817f
C4696 a_14858_9428# VSS 0.47592f
C4697 a_12252_9238# VSS 0.65817f
C4698 a_12386_9428# VSS 0.47592f
C4699 a_9780_9238# VSS 0.65817f
C4700 a_9914_9428# VSS 0.47592f
C4701 a_7308_9238# VSS 0.65817f
C4702 a_7442_9428# VSS 0.47592f
C4703 a_4836_9238# VSS 0.65817f
C4704 a_4970_9428# VSS 0.47592f
C4705 a_2364_9238# VSS 0.65817f
C4706 a_2498_9428# VSS 0.47592f
C4707 a_n108_9238# VSS 0.65817f
C4708 a_26_9428# VSS 0.47592f
C4709 a_n1652_9238# VSS 0.55816f
C4710 a_37741_10022# VSS 1.03998f
C4711 a_36784_10022# VSS 0.13233f
C4712 a_35269_10022# VSS 1.03998f
C4713 a_34312_10022# VSS 0.1323f
C4714 a_32797_10022# VSS 1.03998f
C4715 a_31840_10022# VSS 0.13233f
C4716 a_30325_10022# VSS 1.03998f
C4717 a_29368_10022# VSS 0.1323f
C4718 a_27853_10022# VSS 1.03998f
C4719 a_26896_10022# VSS 0.1323f
C4720 a_25381_10022# VSS 1.03998f
C4721 a_24424_10022# VSS 0.13233f
C4722 a_22909_10022# VSS 1.03998f
C4723 a_21952_10022# VSS 0.1323f
C4724 a_20437_10022# VSS 1.03998f
C4725 a_19480_10022# VSS 0.1323f
C4726 a_17965_10022# VSS 1.03998f
C4727 a_17008_10022# VSS 0.13233f
C4728 a_15493_10022# VSS 1.03998f
C4729 a_14536_10022# VSS 0.1323f
C4730 a_13021_10022# VSS 1.03998f
C4731 a_12064_10022# VSS 0.1323f
C4732 a_10549_10022# VSS 1.03998f
C4733 a_9592_10022# VSS 0.13233f
C4734 a_8077_10022# VSS 1.03998f
C4735 a_7120_10022# VSS 0.1323f
C4736 a_5605_10022# VSS 1.03998f
C4737 a_4648_10022# VSS 0.1323f
C4738 a_3133_10022# VSS 1.03998f
C4739 a_2176_10022# VSS 0.13233f
C4740 a_661_10022# VSS 1.03998f
C4741 a_n296_10022# VSS 0.12163f
C4742 a_38474_10368# VSS 0.14468f
C4743 a_36972_10022# VSS 0.65932f
C4744 a_37106_10336# VSS 0.47592f
C4745 a_36002_10368# VSS 0.11709f
C4746 a_34500_10022# VSS 0.65819f
C4747 a_34634_10336# VSS 0.47592f
C4748 a_33530_10368# VSS 0.11712f
C4749 a_32028_10022# VSS 0.65817f
C4750 a_32162_10336# VSS 0.47592f
C4751 a_31058_10368# VSS 0.11709f
C4752 a_29556_10022# VSS 0.65819f
C4753 a_29690_10336# VSS 0.47592f
C4754 a_28586_10368# VSS 0.11712f
C4755 a_27084_10022# VSS 0.65817f
C4756 a_27218_10336# VSS 0.47592f
C4757 a_26114_10368# VSS 0.11712f
C4758 a_24612_10022# VSS 0.65817f
C4759 a_24746_10336# VSS 0.47592f
C4760 a_23642_10368# VSS 0.11709f
C4761 a_22140_10022# VSS 0.65819f
C4762 a_22274_10336# VSS 0.47592f
C4763 a_21170_10368# VSS 0.11712f
C4764 a_19668_10022# VSS 0.65817f
C4765 a_19802_10336# VSS 0.47592f
C4766 a_18698_10368# VSS 0.11712f
C4767 a_17196_10022# VSS 0.65817f
C4768 a_17330_10336# VSS 0.47592f
C4769 a_16226_10368# VSS 0.11709f
C4770 a_14724_10022# VSS 0.65819f
C4771 a_14858_10336# VSS 0.47592f
C4772 a_13754_10368# VSS 0.11712f
C4773 a_12252_10022# VSS 0.65817f
C4774 a_12386_10336# VSS 0.47592f
C4775 a_11282_10368# VSS 0.11712f
C4776 a_9780_10022# VSS 0.65817f
C4777 a_9914_10336# VSS 0.47592f
C4778 a_8810_10368# VSS 0.11709f
C4779 a_7308_10022# VSS 0.65819f
C4780 a_7442_10336# VSS 0.47592f
C4781 a_6338_10368# VSS 0.11712f
C4782 a_4836_10022# VSS 0.65817f
C4783 a_4970_10336# VSS 0.47592f
C4784 a_3866_10368# VSS 0.11712f
C4785 a_2364_10022# VSS 0.65817f
C4786 a_2498_10336# VSS 0.47592f
C4787 a_1394_10368# VSS 0.11709f
C4788 a_n108_10022# VSS 0.65819f
C4789 a_26_10336# VSS 0.47592f
C4790 a_n1652_10454# VSS 0.55816f
C4791 a_38474_10964# VSS 0.1448f
C4792 a_36002_10964# VSS 0.11724f
C4793 a_37741_10806# VSS 1.03998f
C4794 a_36784_10806# VSS 0.1323f
C4795 a_33530_10964# VSS 0.11724f
C4796 a_35269_10806# VSS 1.03998f
C4797 a_34312_10806# VSS 0.1323f
C4798 a_31058_10964# VSS 0.11724f
C4799 a_32797_10806# VSS 1.03998f
C4800 a_31840_10806# VSS 0.1323f
C4801 a_28586_10964# VSS 0.11724f
C4802 a_30325_10806# VSS 1.03998f
C4803 a_29368_10806# VSS 0.1323f
C4804 a_26114_10964# VSS 0.11724f
C4805 a_27853_10806# VSS 1.03998f
C4806 a_26896_10806# VSS 0.1323f
C4807 a_23642_10964# VSS 0.11724f
C4808 a_25381_10806# VSS 1.03998f
C4809 a_24424_10806# VSS 0.1323f
C4810 a_21170_10964# VSS 0.11724f
C4811 a_22909_10806# VSS 1.03998f
C4812 a_21952_10806# VSS 0.1323f
C4813 a_18698_10964# VSS 0.11724f
C4814 a_20437_10806# VSS 1.03998f
C4815 a_19480_10806# VSS 0.1323f
C4816 a_16226_10964# VSS 0.11724f
C4817 a_17965_10806# VSS 1.03998f
C4818 a_17008_10806# VSS 0.1323f
C4819 a_13754_10964# VSS 0.11724f
C4820 a_15493_10806# VSS 1.03998f
C4821 a_14536_10806# VSS 0.1323f
C4822 a_11282_10964# VSS 0.11724f
C4823 a_13021_10806# VSS 1.03998f
C4824 a_12064_10806# VSS 0.1323f
C4825 a_8810_10964# VSS 0.11724f
C4826 a_10549_10806# VSS 1.03998f
C4827 a_9592_10806# VSS 0.1323f
C4828 a_6338_10964# VSS 0.11724f
C4829 a_8077_10806# VSS 1.03998f
C4830 a_7120_10806# VSS 0.1323f
C4831 a_3866_10964# VSS 0.11724f
C4832 a_5605_10806# VSS 1.03998f
C4833 a_4648_10806# VSS 0.1323f
C4834 a_1394_10964# VSS 0.11724f
C4835 a_3133_10806# VSS 1.03998f
C4836 a_2176_10806# VSS 0.1323f
C4837 a_661_10806# VSS 1.03998f
C4838 a_n296_10806# VSS 0.12163f
C4839 a_36972_10806# VSS 0.67335f
C4840 a_37106_10996# VSS 0.48204f
C4841 a_34500_10806# VSS 0.67221f
C4842 a_34634_10996# VSS 0.48204f
C4843 a_32028_10806# VSS 0.67221f
C4844 a_32162_10996# VSS 0.48204f
C4845 a_29556_10806# VSS 0.67221f
C4846 a_29690_10996# VSS 0.48204f
C4847 a_27084_10806# VSS 0.67221f
C4848 a_27218_10996# VSS 0.48204f
C4849 a_24612_10806# VSS 0.67221f
C4850 a_24746_10996# VSS 0.48204f
C4851 a_22140_10806# VSS 0.67221f
C4852 a_22274_10996# VSS 0.48204f
C4853 a_19668_10806# VSS 0.67221f
C4854 a_19802_10996# VSS 0.48204f
C4855 a_17196_10806# VSS 0.67221f
C4856 a_17330_10996# VSS 0.48204f
C4857 a_14724_10806# VSS 0.67221f
C4858 a_14858_10996# VSS 0.48204f
C4859 a_12252_10806# VSS 0.67221f
C4860 a_12386_10996# VSS 0.48204f
C4861 a_9780_10806# VSS 0.67221f
C4862 a_9914_10996# VSS 0.48204f
C4863 a_7308_10806# VSS 0.67221f
C4864 a_7442_10996# VSS 0.48204f
C4865 a_4836_10806# VSS 0.67221f
C4866 a_4970_10996# VSS 0.48204f
C4867 a_2364_10806# VSS 0.67221f
C4868 a_2498_10996# VSS 0.48204f
C4869 a_n108_10806# VSS 0.67221f
C4870 a_26_10996# VSS 0.48204f
C4871 a_n1652_10806# VSS 0.57233f
C4872 a_n884_3750.t21 VSS 0.14829f
C4873 a_n884_3750.n1 VSS 2.19422f
C4874 a_n884_3750.t9 VSS 0.12129f
C4875 a_n884_3750.n2 VSS 0.99541f
C4876 a_n884_3750.n3 VSS 0.8403f
C4877 a_n884_3750.t35 VSS 0.12129f
C4878 a_n884_3750.n4 VSS 0.99541f
C4879 a_n884_3750.n5 VSS 0.8403f
C4880 a_n884_3750.t17 VSS 0.12129f
C4881 a_n884_3750.n6 VSS 0.99541f
C4882 a_n884_3750.n7 VSS 0.8403f
C4883 a_n884_3750.t18 VSS 0.12129f
C4884 a_n884_3750.n8 VSS 0.99541f
C4885 a_n884_3750.n9 VSS 0.8403f
C4886 a_n884_3750.t6 VSS 0.12129f
C4887 a_n884_3750.n10 VSS 0.99541f
C4888 a_n884_3750.n11 VSS 0.8403f
C4889 a_n884_3750.t32 VSS 0.12129f
C4890 a_n884_3750.n12 VSS 0.99541f
C4891 a_n884_3750.n13 VSS 0.8403f
C4892 a_n884_3750.t15 VSS 0.12129f
C4893 a_n884_3750.n14 VSS 0.99541f
C4894 a_n884_3750.n15 VSS 0.8403f
C4895 a_n884_3750.t16 VSS 0.12129f
C4896 a_n884_3750.n16 VSS 0.99541f
C4897 a_n884_3750.n17 VSS 0.8403f
C4898 a_n884_3750.t4 VSS 0.12129f
C4899 a_n884_3750.n18 VSS 0.99541f
C4900 a_n884_3750.n19 VSS 0.8403f
C4901 a_n884_3750.t30 VSS 0.12129f
C4902 a_n884_3750.n20 VSS 0.99541f
C4903 a_n884_3750.n21 VSS 0.8403f
C4904 a_n884_3750.t31 VSS 0.12129f
C4905 a_n884_3750.n22 VSS 0.99541f
C4906 a_n884_3750.n23 VSS 0.8403f
C4907 a_n884_3750.t19 VSS 0.12129f
C4908 a_n884_3750.n24 VSS 0.99541f
C4909 a_n884_3750.n25 VSS 0.8403f
C4910 a_n884_3750.t20 VSS 0.12129f
C4911 a_n884_3750.n26 VSS 0.99541f
C4912 a_n884_3750.n27 VSS 0.8403f
C4913 a_n884_3750.t33 VSS 0.12129f
C4914 a_n884_3750.n28 VSS 0.99541f
C4915 a_n884_3750.n29 VSS 0.8403f
C4916 a_n884_3750.t12 VSS 0.12129f
C4917 a_n884_3750.n30 VSS 0.99541f
C4918 a_n884_3750.n31 VSS 0.67354f
C4919 a_n884_3750.n32 VSS 0.35884f
C4920 a_n884_3750.n33 VSS 0.16325f
C4921 a_38209_n862.n0 VSS 0.30869f
C4922 a_38209_n862.n1 VSS 0.14432f
C4923 a_38209_n862.n3 VSS 0.48932f
C4924 a_38209_n862.n4 VSS 0.14432f
C4925 a_38209_n862.n5 VSS 0.14432f
C4926 a_38209_n862.n6 VSS 0.17142f
C4927 a_38209_n862.n7 VSS 0.17142f
C4928 a_38209_n862.n8 VSS 0.14432f
C4929 a_38209_n862.n9 VSS 0.14432f
C4930 a_38209_n862.n10 VSS 0.17142f
C4931 a_38209_n862.n11 VSS 0.17142f
C4932 a_38209_n862.n12 VSS 0.14432f
C4933 a_38209_n862.n13 VSS 0.14432f
C4934 a_38209_n862.n14 VSS 0.17142f
C4935 a_38209_n862.n15 VSS 0.17142f
C4936 a_38209_n862.n16 VSS 0.14432f
C4937 a_38209_n862.n17 VSS 0.14432f
C4938 a_38209_n862.n18 VSS 0.17142f
C4939 a_38209_n862.n19 VSS 0.17142f
C4940 a_38209_n862.n20 VSS 0.14432f
C4941 a_38209_n862.n21 VSS 0.14432f
C4942 a_38209_n862.n22 VSS 0.17142f
C4943 a_38209_n862.n23 VSS 0.17142f
C4944 a_38209_n862.n24 VSS 0.14432f
C4945 a_38209_n862.n25 VSS 0.14432f
C4946 a_38209_n862.n26 VSS 0.17142f
C4947 a_38209_n862.n27 VSS 0.17142f
C4948 a_38209_n862.n28 VSS 0.14432f
C4949 a_38209_n862.n29 VSS 0.14432f
C4950 a_38209_n862.n30 VSS 0.17142f
C4951 a_38209_n862.n31 VSS 0.17142f
C4952 a_n884_2966.t29 VSS 0.14829f
C4953 a_n884_2966.n1 VSS 2.19422f
C4954 a_n884_2966.t19 VSS 0.12129f
C4955 a_n884_2966.n2 VSS 0.99541f
C4956 a_n884_2966.n3 VSS 0.8403f
C4957 a_n884_2966.t11 VSS 0.12129f
C4958 a_n884_2966.n4 VSS 0.99541f
C4959 a_n884_2966.n5 VSS 0.8403f
C4960 a_n884_2966.t25 VSS 0.12129f
C4961 a_n884_2966.n6 VSS 0.99541f
C4962 a_n884_2966.n7 VSS 0.8403f
C4963 a_n884_2966.t26 VSS 0.12129f
C4964 a_n884_2966.n8 VSS 0.99541f
C4965 a_n884_2966.n9 VSS 0.8403f
C4966 a_n884_2966.t15 VSS 0.12129f
C4967 a_n884_2966.n10 VSS 0.99541f
C4968 a_n884_2966.n11 VSS 0.8403f
C4969 a_n884_2966.t9 VSS 0.12129f
C4970 a_n884_2966.n12 VSS 0.99541f
C4971 a_n884_2966.n13 VSS 0.8403f
C4972 a_n884_2966.t23 VSS 0.12129f
C4973 a_n884_2966.n14 VSS 0.99541f
C4974 a_n884_2966.n15 VSS 0.8403f
C4975 a_n884_2966.t24 VSS 0.12129f
C4976 a_n884_2966.n16 VSS 0.99541f
C4977 a_n884_2966.n17 VSS 0.8403f
C4978 a_n884_2966.t12 VSS 0.12129f
C4979 a_n884_2966.n18 VSS 0.99541f
C4980 a_n884_2966.n19 VSS 0.8403f
C4981 a_n884_2966.t6 VSS 0.12129f
C4982 a_n884_2966.n20 VSS 0.99541f
C4983 a_n884_2966.n21 VSS 0.8403f
C4984 a_n884_2966.t7 VSS 0.12129f
C4985 a_n884_2966.n22 VSS 0.99541f
C4986 a_n884_2966.n23 VSS 0.8403f
C4987 a_n884_2966.t27 VSS 0.12129f
C4988 a_n884_2966.n24 VSS 0.99541f
C4989 a_n884_2966.n25 VSS 0.8403f
C4990 a_n884_2966.t28 VSS 0.12129f
C4991 a_n884_2966.n26 VSS 0.99541f
C4992 a_n884_2966.n27 VSS 0.8403f
C4993 a_n884_2966.t10 VSS 0.12129f
C4994 a_n884_2966.n28 VSS 0.99541f
C4995 a_n884_2966.n29 VSS 0.8403f
C4996 a_n884_2966.t21 VSS 0.12129f
C4997 a_n884_2966.n30 VSS 0.99541f
C4998 a_n884_2966.n31 VSS 0.67354f
C4999 a_n884_2966.n32 VSS 0.35884f
C5000 a_n884_2966.n33 VSS 0.16325f
C5001 a_n884_1398.t15 VSS 0.14829f
C5002 a_n884_1398.n1 VSS 2.19422f
C5003 a_n884_1398.t33 VSS 0.12129f
C5004 a_n884_1398.n2 VSS 0.99541f
C5005 a_n884_1398.n3 VSS 0.8403f
C5006 a_n884_1398.t28 VSS 0.12129f
C5007 a_n884_1398.n4 VSS 0.99541f
C5008 a_n884_1398.n5 VSS 0.8403f
C5009 a_n884_1398.t11 VSS 0.12129f
C5010 a_n884_1398.n6 VSS 0.99541f
C5011 a_n884_1398.n7 VSS 0.8403f
C5012 a_n884_1398.t12 VSS 0.12129f
C5013 a_n884_1398.n8 VSS 0.99541f
C5014 a_n884_1398.n9 VSS 0.8403f
C5015 a_n884_1398.t32 VSS 0.12129f
C5016 a_n884_1398.n10 VSS 0.99541f
C5017 a_n884_1398.n11 VSS 0.8403f
C5018 a_n884_1398.t26 VSS 0.12129f
C5019 a_n884_1398.n12 VSS 0.99541f
C5020 a_n884_1398.n13 VSS 0.8403f
C5021 a_n884_1398.t6 VSS 0.12129f
C5022 a_n884_1398.n14 VSS 0.99541f
C5023 a_n884_1398.n15 VSS 0.8403f
C5024 a_n884_1398.t8 VSS 0.12129f
C5025 a_n884_1398.n16 VSS 0.99541f
C5026 a_n884_1398.n17 VSS 0.8403f
C5027 a_n884_1398.t30 VSS 0.12129f
C5028 a_n884_1398.n18 VSS 0.99541f
C5029 a_n884_1398.n19 VSS 0.8403f
C5030 a_n884_1398.t22 VSS 0.12129f
C5031 a_n884_1398.n20 VSS 0.99541f
C5032 a_n884_1398.n21 VSS 0.8403f
C5033 a_n884_1398.t24 VSS 0.12129f
C5034 a_n884_1398.n22 VSS 0.99541f
C5035 a_n884_1398.n23 VSS 0.8403f
C5036 a_n884_1398.t13 VSS 0.12129f
C5037 a_n884_1398.n24 VSS 0.99541f
C5038 a_n884_1398.n25 VSS 0.8403f
C5039 a_n884_1398.t14 VSS 0.12129f
C5040 a_n884_1398.n26 VSS 0.99541f
C5041 a_n884_1398.n27 VSS 0.8403f
C5042 a_n884_1398.t27 VSS 0.12129f
C5043 a_n884_1398.n28 VSS 0.99541f
C5044 a_n884_1398.n29 VSS 0.8403f
C5045 a_n884_1398.t35 VSS 0.12129f
C5046 a_n884_1398.n30 VSS 0.99541f
C5047 a_n884_1398.n31 VSS 0.67354f
C5048 a_n884_1398.n32 VSS 0.35884f
C5049 a_n884_1398.n33 VSS 0.16325f
C5050 a_n884_2182.t10 VSS 0.14829f
C5051 a_n884_2182.n1 VSS 2.19422f
C5052 a_n884_2182.t32 VSS 0.12129f
C5053 a_n884_2182.n2 VSS 0.99541f
C5054 a_n884_2182.n3 VSS 0.8403f
C5055 a_n884_2182.t24 VSS 0.12129f
C5056 a_n884_2182.n4 VSS 0.99541f
C5057 a_n884_2182.n5 VSS 0.8403f
C5058 a_n884_2182.t6 VSS 0.12129f
C5059 a_n884_2182.n6 VSS 0.99541f
C5060 a_n884_2182.n7 VSS 0.8403f
C5061 a_n884_2182.t7 VSS 0.12129f
C5062 a_n884_2182.n8 VSS 0.99541f
C5063 a_n884_2182.n9 VSS 0.8403f
C5064 a_n884_2182.t30 VSS 0.12129f
C5065 a_n884_2182.n10 VSS 0.99541f
C5066 a_n884_2182.n11 VSS 0.8403f
C5067 a_n884_2182.t22 VSS 0.12129f
C5068 a_n884_2182.n12 VSS 0.99541f
C5069 a_n884_2182.n13 VSS 0.8403f
C5070 a_n884_2182.t4 VSS 0.12129f
C5071 a_n884_2182.n14 VSS 0.99541f
C5072 a_n884_2182.n15 VSS 0.8403f
C5073 a_n884_2182.t5 VSS 0.12129f
C5074 a_n884_2182.n16 VSS 0.99541f
C5075 a_n884_2182.n17 VSS 0.8403f
C5076 a_n884_2182.t27 VSS 0.12129f
C5077 a_n884_2182.n18 VSS 0.99541f
C5078 a_n884_2182.n19 VSS 0.8403f
C5079 a_n884_2182.t19 VSS 0.12129f
C5080 a_n884_2182.n20 VSS 0.99541f
C5081 a_n884_2182.n21 VSS 0.8403f
C5082 a_n884_2182.t21 VSS 0.12129f
C5083 a_n884_2182.n22 VSS 0.99541f
C5084 a_n884_2182.n23 VSS 0.8403f
C5085 a_n884_2182.t8 VSS 0.12129f
C5086 a_n884_2182.n24 VSS 0.99541f
C5087 a_n884_2182.n25 VSS 0.8403f
C5088 a_n884_2182.t9 VSS 0.12129f
C5089 a_n884_2182.n26 VSS 0.99541f
C5090 a_n884_2182.n27 VSS 0.8403f
C5091 a_n884_2182.t23 VSS 0.12129f
C5092 a_n884_2182.n28 VSS 0.99541f
C5093 a_n884_2182.n29 VSS 0.8403f
C5094 a_n884_2182.t34 VSS 0.12129f
C5095 a_n884_2182.n30 VSS 0.99541f
C5096 a_n884_2182.n31 VSS 0.67354f
C5097 a_n884_2182.n32 VSS 0.35884f
C5098 a_n884_2182.n33 VSS 0.16325f
C5099 a_12000_n708.n3 VSS 0.26552f
C5100 a_12000_n708.n5 VSS 0.1392f
C5101 a_12000_n708.n7 VSS 0.1392f
C5102 a_12000_n708.n9 VSS 0.1392f
C5103 a_12000_n708.n11 VSS 0.1392f
C5104 a_12000_n708.n13 VSS 0.1392f
C5105 a_12000_n708.n15 VSS 0.1392f
C5106 a_12000_n708.n17 VSS 0.1392f
C5107 a_12000_n708.n19 VSS 0.1392f
C5108 a_12000_n708.n21 VSS 0.1392f
C5109 a_12000_n708.n23 VSS 0.1392f
C5110 a_12000_n708.n25 VSS 0.1392f
C5111 a_12000_n708.n27 VSS 0.1392f
C5112 a_12000_n708.n29 VSS 0.1392f
C5113 a_12000_n708.n31 VSS 0.18199f
C5114 a_8545_n862.n0 VSS 0.30869f
C5115 a_8545_n862.n1 VSS 0.14432f
C5116 a_8545_n862.n3 VSS 0.48932f
C5117 a_8545_n862.n4 VSS 0.14432f
C5118 a_8545_n862.n5 VSS 0.14432f
C5119 a_8545_n862.n6 VSS 0.17142f
C5120 a_8545_n862.n7 VSS 0.17142f
C5121 a_8545_n862.n8 VSS 0.14432f
C5122 a_8545_n862.n9 VSS 0.14432f
C5123 a_8545_n862.n10 VSS 0.17142f
C5124 a_8545_n862.n11 VSS 0.17142f
C5125 a_8545_n862.n12 VSS 0.14432f
C5126 a_8545_n862.n13 VSS 0.14432f
C5127 a_8545_n862.n14 VSS 0.17142f
C5128 a_8545_n862.n15 VSS 0.17142f
C5129 a_8545_n862.n16 VSS 0.14432f
C5130 a_8545_n862.n17 VSS 0.14432f
C5131 a_8545_n862.n18 VSS 0.17142f
C5132 a_8545_n862.n19 VSS 0.17142f
C5133 a_8545_n862.n20 VSS 0.14432f
C5134 a_8545_n862.n21 VSS 0.14432f
C5135 a_8545_n862.n22 VSS 0.17142f
C5136 a_8545_n862.n23 VSS 0.17142f
C5137 a_8545_n862.n24 VSS 0.14432f
C5138 a_8545_n862.n25 VSS 0.14432f
C5139 a_8545_n862.n26 VSS 0.17142f
C5140 a_8545_n862.n27 VSS 0.17142f
C5141 a_8545_n862.n28 VSS 0.14432f
C5142 a_8545_n862.n29 VSS 0.14432f
C5143 a_8545_n862.n30 VSS 0.17142f
C5144 a_8545_n862.n31 VSS 0.17142f
C5145 a_25849_n862.n0 VSS 0.30869f
C5146 a_25849_n862.n1 VSS 0.14432f
C5147 a_25849_n862.n3 VSS 0.48932f
C5148 a_25849_n862.n4 VSS 0.14432f
C5149 a_25849_n862.n5 VSS 0.14432f
C5150 a_25849_n862.n6 VSS 0.17142f
C5151 a_25849_n862.n7 VSS 0.17142f
C5152 a_25849_n862.n8 VSS 0.14432f
C5153 a_25849_n862.n9 VSS 0.14432f
C5154 a_25849_n862.n10 VSS 0.17142f
C5155 a_25849_n862.n11 VSS 0.17142f
C5156 a_25849_n862.n12 VSS 0.14432f
C5157 a_25849_n862.n13 VSS 0.14432f
C5158 a_25849_n862.n14 VSS 0.17142f
C5159 a_25849_n862.n15 VSS 0.17142f
C5160 a_25849_n862.n16 VSS 0.14432f
C5161 a_25849_n862.n17 VSS 0.14432f
C5162 a_25849_n862.n18 VSS 0.17142f
C5163 a_25849_n862.n19 VSS 0.17142f
C5164 a_25849_n862.n20 VSS 0.14432f
C5165 a_25849_n862.n21 VSS 0.14432f
C5166 a_25849_n862.n22 VSS 0.17142f
C5167 a_25849_n862.n23 VSS 0.17142f
C5168 a_25849_n862.n24 VSS 0.14432f
C5169 a_25849_n862.n25 VSS 0.14432f
C5170 a_25849_n862.n26 VSS 0.17142f
C5171 a_25849_n862.n27 VSS 0.17142f
C5172 a_25849_n862.n28 VSS 0.14432f
C5173 a_25849_n862.n29 VSS 0.14432f
C5174 a_25849_n862.n30 VSS 0.17142f
C5175 a_25849_n862.n31 VSS 0.17142f
C5176 RA5.t7 VSS 0.21849f
C5177 RA5.n0 VSS 0.55201f
C5178 RA5.t42 VSS 0.21849f
C5179 RA5.n1 VSS 0.21996f
C5180 RA5.n2 VSS 3.35439f
C5181 RA5.t44 VSS 0.21849f
C5182 RA5.n3 VSS 0.21996f
C5183 RA5.n4 VSS 1.92978f
C5184 RA5.t29 VSS 0.21849f
C5185 RA5.n5 VSS 0.21996f
C5186 RA5.n6 VSS 1.92978f
C5187 RA5.t22 VSS 0.21849f
C5188 RA5.n7 VSS 0.21996f
C5189 RA5.n8 VSS 1.92978f
C5190 RA5.t40 VSS 0.21849f
C5191 RA5.n9 VSS 0.21996f
C5192 RA5.n10 VSS 1.92978f
C5193 RA5.t41 VSS 0.21849f
C5194 RA5.n11 VSS 0.21996f
C5195 RA5.n12 VSS 1.92978f
C5196 RA5.t26 VSS 0.21849f
C5197 RA5.n13 VSS 0.21996f
C5198 RA5.n14 VSS 1.92978f
C5199 RA5.t21 VSS 0.21849f
C5200 RA5.n15 VSS 0.21996f
C5201 RA5.n16 VSS 1.92978f
C5202 RA5.t3 VSS 0.21849f
C5203 RA5.n17 VSS 0.21996f
C5204 RA5.n18 VSS 1.92978f
C5205 RA5.t39 VSS 0.21849f
C5206 RA5.n19 VSS 0.21996f
C5207 RA5.n20 VSS 1.92978f
C5208 RA5.t24 VSS 0.21849f
C5209 RA5.n21 VSS 0.21996f
C5210 RA5.n22 VSS 1.92978f
C5211 RA5.t23 VSS 0.21849f
C5212 RA5.n23 VSS 0.21996f
C5213 RA5.n24 VSS 1.92978f
C5214 RA5.t8 VSS 0.21849f
C5215 RA5.n25 VSS 0.21996f
C5216 RA5.n26 VSS 1.92978f
C5217 RA5.t9 VSS 0.21849f
C5218 RA5.n27 VSS 0.21996f
C5219 RA5.n28 VSS 1.92978f
C5220 RA5.t33 VSS 0.21849f
C5221 RA5.n29 VSS 0.21996f
C5222 RA5.n30 VSS 2.05275f
C5223 a_13489_n862.n0 VSS 0.30869f
C5224 a_13489_n862.n1 VSS 0.14432f
C5225 a_13489_n862.n3 VSS 0.48932f
C5226 a_13489_n862.n4 VSS 0.14432f
C5227 a_13489_n862.n5 VSS 0.14432f
C5228 a_13489_n862.n6 VSS 0.17142f
C5229 a_13489_n862.n7 VSS 0.17142f
C5230 a_13489_n862.n8 VSS 0.14432f
C5231 a_13489_n862.n9 VSS 0.14432f
C5232 a_13489_n862.n10 VSS 0.17142f
C5233 a_13489_n862.n11 VSS 0.17142f
C5234 a_13489_n862.n12 VSS 0.14432f
C5235 a_13489_n862.n13 VSS 0.14432f
C5236 a_13489_n862.n14 VSS 0.17142f
C5237 a_13489_n862.n15 VSS 0.17142f
C5238 a_13489_n862.n16 VSS 0.14432f
C5239 a_13489_n862.n17 VSS 0.14432f
C5240 a_13489_n862.n18 VSS 0.17142f
C5241 a_13489_n862.n19 VSS 0.17142f
C5242 a_13489_n862.n20 VSS 0.14432f
C5243 a_13489_n862.n21 VSS 0.14432f
C5244 a_13489_n862.n22 VSS 0.17142f
C5245 a_13489_n862.n23 VSS 0.17142f
C5246 a_13489_n862.n24 VSS 0.14432f
C5247 a_13489_n862.n25 VSS 0.14432f
C5248 a_13489_n862.n26 VSS 0.17142f
C5249 a_13489_n862.n27 VSS 0.17142f
C5250 a_13489_n862.n28 VSS 0.14432f
C5251 a_13489_n862.n29 VSS 0.14432f
C5252 a_13489_n862.n30 VSS 0.17142f
C5253 a_13489_n862.n31 VSS 0.17142f
C5254 RA6.t45 VSS 0.21849f
C5255 RA6.n0 VSS 0.55201f
C5256 RA6.t30 VSS 0.21849f
C5257 RA6.n1 VSS 0.21996f
C5258 RA6.n2 VSS 3.35439f
C5259 RA6.t32 VSS 0.21849f
C5260 RA6.n3 VSS 0.21996f
C5261 RA6.n4 VSS 1.92978f
C5262 RA6.t18 VSS 0.21849f
C5263 RA6.n5 VSS 0.21996f
C5264 RA6.n6 VSS 1.92978f
C5265 RA6.t12 VSS 0.21849f
C5266 RA6.n7 VSS 0.21996f
C5267 RA6.n8 VSS 1.92978f
C5268 RA6.t28 VSS 0.21849f
C5269 RA6.n9 VSS 0.21996f
C5270 RA6.n10 VSS 1.92978f
C5271 RA6.t29 VSS 0.21849f
C5272 RA6.n11 VSS 0.21996f
C5273 RA6.n12 VSS 1.92978f
C5274 RA6.t16 VSS 0.21849f
C5275 RA6.n13 VSS 0.21996f
C5276 RA6.n14 VSS 1.92978f
C5277 RA6.t10 VSS 0.21849f
C5278 RA6.n15 VSS 0.21996f
C5279 RA6.n16 VSS 1.92978f
C5280 RA6.t43 VSS 0.21849f
C5281 RA6.n17 VSS 0.21996f
C5282 RA6.n18 VSS 1.92978f
C5283 RA6.t27 VSS 0.21849f
C5284 RA6.n19 VSS 0.21996f
C5285 RA6.n20 VSS 1.92978f
C5286 RA6.t15 VSS 0.21849f
C5287 RA6.n21 VSS 0.21996f
C5288 RA6.n22 VSS 1.92978f
C5289 RA6.t13 VSS 0.21849f
C5290 RA6.n23 VSS 0.21996f
C5291 RA6.n24 VSS 1.92978f
C5292 RA6.t46 VSS 0.21849f
C5293 RA6.n25 VSS 0.21996f
C5294 RA6.n26 VSS 1.92978f
C5295 RA6.t47 VSS 0.21849f
C5296 RA6.n27 VSS 0.21996f
C5297 RA6.n28 VSS 1.92978f
C5298 RA6.t20 VSS 0.21849f
C5299 RA6.n29 VSS 0.21996f
C5300 RA6.n30 VSS 2.05275f
C5301 a_3871_n2146.n0 VSS 0.30875f
C5302 a_3871_n2146.n1 VSS 0.14431f
C5303 a_3871_n2146.n2 VSS 0.17149f
C5304 a_3871_n2146.n3 VSS 0.17149f
C5305 a_3871_n2146.n4 VSS 0.14431f
C5306 a_3871_n2146.n5 VSS 0.14431f
C5307 a_3871_n2146.n6 VSS 0.17149f
C5308 a_3871_n2146.n7 VSS 0.17149f
C5309 a_3871_n2146.n8 VSS 0.14431f
C5310 a_3871_n2146.n10 VSS 0.4905f
C5311 a_3871_n2146.n11 VSS 0.14431f
C5312 a_3871_n2146.n12 VSS 0.14431f
C5313 a_3871_n2146.n13 VSS 0.17149f
C5314 a_3871_n2146.n14 VSS 0.17149f
C5315 a_3871_n2146.n15 VSS 0.14431f
C5316 a_3871_n2146.n16 VSS 0.14431f
C5317 a_3871_n2146.n17 VSS 0.17149f
C5318 a_3871_n2146.n18 VSS 0.17149f
C5319 a_3871_n2146.n19 VSS 0.14431f
C5320 a_3871_n2146.n20 VSS 0.14431f
C5321 a_3871_n2146.n21 VSS 0.17149f
C5322 a_3871_n2146.n22 VSS 0.17149f
C5323 a_3871_n2146.n23 VSS 0.14431f
C5324 a_3871_n2146.n24 VSS 0.14431f
C5325 a_3871_n2146.n25 VSS 0.17149f
C5326 a_3871_n2146.n26 VSS 0.17149f
C5327 a_3871_n2146.n27 VSS 0.14431f
C5328 a_3871_n2146.n28 VSS 0.14431f
C5329 a_3871_n2146.n29 VSS 0.17149f
C5330 a_3871_n2146.n30 VSS 0.17149f
C5331 a_3871_n2146.n31 VSS 0.14431f
C5332 CLK.t0 VSS 0.36061f
C5333 CLK.t1 VSS 0.25495f
C5334 CLK.n0 VSS 0.86909f
C5335 RA4.t26 VSS 0.21849f
C5336 RA4.n0 VSS 0.55201f
C5337 RA4.t11 VSS 0.21849f
C5338 RA4.n1 VSS 0.21996f
C5339 RA4.n2 VSS 3.35439f
C5340 RA4.t13 VSS 0.21849f
C5341 RA4.n3 VSS 0.21996f
C5342 RA4.n4 VSS 1.92978f
C5343 RA4.t47 VSS 0.21849f
C5344 RA4.n5 VSS 0.21996f
C5345 RA4.n6 VSS 1.92978f
C5346 RA4.t42 VSS 0.21849f
C5347 RA4.n7 VSS 0.21996f
C5348 RA4.n8 VSS 1.92978f
C5349 RA4.t9 VSS 0.21849f
C5350 RA4.n9 VSS 0.21996f
C5351 RA4.n10 VSS 1.92978f
C5352 RA4.t10 VSS 0.21849f
C5353 RA4.n11 VSS 0.21996f
C5354 RA4.n12 VSS 1.92978f
C5355 RA4.t46 VSS 0.21849f
C5356 RA4.n13 VSS 0.21996f
C5357 RA4.n14 VSS 1.92978f
C5358 RA4.t41 VSS 0.21849f
C5359 RA4.n15 VSS 0.21996f
C5360 RA4.n16 VSS 1.92978f
C5361 RA4.t24 VSS 0.21849f
C5362 RA4.n17 VSS 0.21996f
C5363 RA4.n18 VSS 1.92978f
C5364 RA4.t8 VSS 0.21849f
C5365 RA4.n19 VSS 0.21996f
C5366 RA4.n20 VSS 1.92978f
C5367 RA4.t45 VSS 0.21849f
C5368 RA4.n21 VSS 0.21996f
C5369 RA4.n22 VSS 1.92978f
C5370 RA4.t43 VSS 0.21849f
C5371 RA4.n23 VSS 0.21996f
C5372 RA4.n24 VSS 1.92978f
C5373 RA4.t27 VSS 0.21849f
C5374 RA4.n25 VSS 0.21996f
C5375 RA4.n26 VSS 1.92978f
C5376 RA4.t28 VSS 0.21849f
C5377 RA4.n27 VSS 0.21996f
C5378 RA4.n28 VSS 1.92978f
C5379 RA4.t1 VSS 0.21849f
C5380 RA4.n29 VSS 0.21996f
C5381 RA4.n30 VSS 2.052f
C5382 a_11017_n862.n0 VSS 0.30869f
C5383 a_11017_n862.n1 VSS 0.14432f
C5384 a_11017_n862.n3 VSS 0.48932f
C5385 a_11017_n862.n4 VSS 0.14432f
C5386 a_11017_n862.n5 VSS 0.14432f
C5387 a_11017_n862.n6 VSS 0.17142f
C5388 a_11017_n862.n7 VSS 0.17142f
C5389 a_11017_n862.n8 VSS 0.14432f
C5390 a_11017_n862.n9 VSS 0.14432f
C5391 a_11017_n862.n10 VSS 0.17142f
C5392 a_11017_n862.n11 VSS 0.17142f
C5393 a_11017_n862.n12 VSS 0.14432f
C5394 a_11017_n862.n13 VSS 0.14432f
C5395 a_11017_n862.n14 VSS 0.17142f
C5396 a_11017_n862.n15 VSS 0.17142f
C5397 a_11017_n862.n16 VSS 0.14432f
C5398 a_11017_n862.n17 VSS 0.14432f
C5399 a_11017_n862.n18 VSS 0.17142f
C5400 a_11017_n862.n19 VSS 0.17142f
C5401 a_11017_n862.n20 VSS 0.14432f
C5402 a_11017_n862.n21 VSS 0.14432f
C5403 a_11017_n862.n22 VSS 0.17142f
C5404 a_11017_n862.n23 VSS 0.17142f
C5405 a_11017_n862.n24 VSS 0.14432f
C5406 a_11017_n862.n25 VSS 0.14432f
C5407 a_11017_n862.n26 VSS 0.17142f
C5408 a_11017_n862.n27 VSS 0.17142f
C5409 a_11017_n862.n28 VSS 0.14432f
C5410 a_11017_n862.n29 VSS 0.14432f
C5411 a_11017_n862.n30 VSS 0.17142f
C5412 a_11017_n862.n31 VSS 0.17142f
C5413 a_18433_n862.n0 VSS 0.30869f
C5414 a_18433_n862.n1 VSS 0.14432f
C5415 a_18433_n862.n2 VSS 0.17142f
C5416 a_18433_n862.n3 VSS 0.17142f
C5417 a_18433_n862.n4 VSS 0.14432f
C5418 a_18433_n862.n5 VSS 0.14432f
C5419 a_18433_n862.n6 VSS 0.17142f
C5420 a_18433_n862.n7 VSS 0.17142f
C5421 a_18433_n862.n8 VSS 0.14432f
C5422 a_18433_n862.n9 VSS 0.14432f
C5423 a_18433_n862.n10 VSS 0.17142f
C5424 a_18433_n862.n11 VSS 0.17142f
C5425 a_18433_n862.n12 VSS 0.14432f
C5426 a_18433_n862.n13 VSS 0.14432f
C5427 a_18433_n862.n14 VSS 0.17142f
C5428 a_18433_n862.n15 VSS 0.17142f
C5429 a_18433_n862.n16 VSS 0.14432f
C5430 a_18433_n862.n17 VSS 0.14432f
C5431 a_18433_n862.n18 VSS 0.17142f
C5432 a_18433_n862.n19 VSS 0.17142f
C5433 a_18433_n862.n20 VSS 0.14432f
C5434 a_18433_n862.n22 VSS 0.48932f
C5435 a_18433_n862.n23 VSS 0.14432f
C5436 a_18433_n862.n24 VSS 0.14432f
C5437 a_18433_n862.n25 VSS 0.17142f
C5438 a_18433_n862.n26 VSS 0.17142f
C5439 a_18433_n862.n27 VSS 0.14432f
C5440 a_18433_n862.n28 VSS 0.14432f
C5441 a_18433_n862.n29 VSS 0.17142f
C5442 a_18433_n862.n30 VSS 0.17142f
C5443 a_18433_n862.n31 VSS 0.14432f
C5444 a_38479_n2146.n0 VSS 0.30421f
C5445 a_38479_n2146.n1 VSS 0.14219f
C5446 a_38479_n2146.n2 VSS 0.16897f
C5447 a_38479_n2146.n4 VSS 0.48328f
C5448 a_38479_n2146.n5 VSS 0.14219f
C5449 a_38479_n2146.n6 VSS 0.14219f
C5450 a_38479_n2146.n7 VSS 0.16897f
C5451 a_38479_n2146.n8 VSS 0.16897f
C5452 a_38479_n2146.n9 VSS 0.14219f
C5453 a_38479_n2146.n10 VSS 0.14219f
C5454 a_38479_n2146.n11 VSS 0.16897f
C5455 a_38479_n2146.n12 VSS 0.16897f
C5456 a_38479_n2146.n13 VSS 0.14219f
C5457 a_38479_n2146.n14 VSS 0.14219f
C5458 a_38479_n2146.n15 VSS 0.16897f
C5459 a_38479_n2146.n16 VSS 0.16897f
C5460 a_38479_n2146.n17 VSS 0.14219f
C5461 a_38479_n2146.n18 VSS 0.14219f
C5462 a_38479_n2146.n19 VSS 0.16897f
C5463 a_38479_n2146.n20 VSS 0.16897f
C5464 a_38479_n2146.n21 VSS 0.14219f
C5465 a_38479_n2146.n22 VSS 0.14219f
C5466 a_38479_n2146.n23 VSS 0.16897f
C5467 a_38479_n2146.n24 VSS 0.16897f
C5468 a_38479_n2146.n25 VSS 0.14219f
C5469 a_38479_n2146.n26 VSS 0.14219f
C5470 a_38479_n2146.n27 VSS 0.16897f
C5471 a_38479_n2146.n28 VSS 0.16897f
C5472 a_38479_n2146.n29 VSS 0.14219f
C5473 a_38479_n2146.n30 VSS 0.14219f
C5474 a_38479_n2146.n31 VSS 0.16897f
C5475 a_36007_n2146.n0 VSS 0.30875f
C5476 a_36007_n2146.n1 VSS 0.14431f
C5477 a_36007_n2146.n2 VSS 0.17149f
C5478 a_36007_n2146.n4 VSS 0.4905f
C5479 a_36007_n2146.n5 VSS 0.14431f
C5480 a_36007_n2146.n6 VSS 0.14431f
C5481 a_36007_n2146.n7 VSS 0.17149f
C5482 a_36007_n2146.n8 VSS 0.17149f
C5483 a_36007_n2146.n9 VSS 0.14431f
C5484 a_36007_n2146.n10 VSS 0.14431f
C5485 a_36007_n2146.n11 VSS 0.17149f
C5486 a_36007_n2146.n12 VSS 0.17149f
C5487 a_36007_n2146.n13 VSS 0.14431f
C5488 a_36007_n2146.n14 VSS 0.14431f
C5489 a_36007_n2146.n15 VSS 0.17149f
C5490 a_36007_n2146.n16 VSS 0.17149f
C5491 a_36007_n2146.n17 VSS 0.14431f
C5492 a_36007_n2146.n18 VSS 0.14431f
C5493 a_36007_n2146.n19 VSS 0.17149f
C5494 a_36007_n2146.n20 VSS 0.17149f
C5495 a_36007_n2146.n21 VSS 0.14431f
C5496 a_36007_n2146.n22 VSS 0.14431f
C5497 a_36007_n2146.n23 VSS 0.17149f
C5498 a_36007_n2146.n24 VSS 0.17149f
C5499 a_36007_n2146.n25 VSS 0.14431f
C5500 a_36007_n2146.n26 VSS 0.14431f
C5501 a_36007_n2146.n27 VSS 0.17149f
C5502 a_36007_n2146.n28 VSS 0.17149f
C5503 a_36007_n2146.n29 VSS 0.14431f
C5504 a_36007_n2146.n30 VSS 0.14431f
C5505 a_36007_n2146.n31 VSS 0.17149f
C5506 a_n1204_6102.t27 VSS 0.13376f
C5507 a_n1204_6102.n1 VSS 2.07431f
C5508 a_n1204_6102.t11 VSS 0.11785f
C5509 a_n1204_6102.n2 VSS 0.92435f
C5510 a_n1204_6102.n3 VSS 0.77453f
C5511 a_n1204_6102.t39 VSS 0.11785f
C5512 a_n1204_6102.n4 VSS 0.92435f
C5513 a_n1204_6102.n5 VSS 0.77453f
C5514 a_n1204_6102.t20 VSS 0.11785f
C5515 a_n1204_6102.n6 VSS 0.92435f
C5516 a_n1204_6102.n7 VSS 0.77453f
C5517 a_n1204_6102.t22 VSS 0.11785f
C5518 a_n1204_6102.n8 VSS 0.92435f
C5519 a_n1204_6102.n9 VSS 0.77453f
C5520 a_n1204_6102.t10 VSS 0.11785f
C5521 a_n1204_6102.n10 VSS 0.92435f
C5522 a_n1204_6102.n11 VSS 0.77453f
C5523 a_n1204_6102.t37 VSS 0.11785f
C5524 a_n1204_6102.n12 VSS 0.92435f
C5525 a_n1204_6102.n13 VSS 0.77453f
C5526 a_n1204_6102.t17 VSS 0.11785f
C5527 a_n1204_6102.n14 VSS 0.92435f
C5528 a_n1204_6102.n15 VSS 0.77453f
C5529 a_n1204_6102.t18 VSS 0.11785f
C5530 a_n1204_6102.n16 VSS 0.92435f
C5531 a_n1204_6102.n17 VSS 0.77453f
C5532 a_n1204_6102.t9 VSS 0.11785f
C5533 a_n1204_6102.n18 VSS 0.92435f
C5534 a_n1204_6102.n19 VSS 0.77453f
C5535 a_n1204_6102.t35 VSS 0.11785f
C5536 a_n1204_6102.n20 VSS 0.92435f
C5537 a_n1204_6102.n21 VSS 0.77453f
C5538 a_n1204_6102.t36 VSS 0.11785f
C5539 a_n1204_6102.n22 VSS 0.92435f
C5540 a_n1204_6102.n23 VSS 0.77453f
C5541 a_n1204_6102.t23 VSS 0.11785f
C5542 a_n1204_6102.n24 VSS 0.92435f
C5543 a_n1204_6102.n25 VSS 0.77453f
C5544 a_n1204_6102.t25 VSS 0.11785f
C5545 a_n1204_6102.n26 VSS 0.92435f
C5546 a_n1204_6102.n27 VSS 0.77453f
C5547 a_n1204_6102.t38 VSS 0.11785f
C5548 a_n1204_6102.n28 VSS 0.92435f
C5549 a_n1204_6102.n29 VSS 0.77453f
C5550 a_n1204_6102.t14 VSS 0.11785f
C5551 a_n1204_6102.n30 VSS 0.92435f
C5552 a_n1204_6102.n31 VSS 0.60701f
C5553 a_n1204_6102.n32 VSS 0.25574f
C5554 a_n1204_6102.n33 VSS 0.12464f
C5555 a_n1204_6102.n34 VSS 0.13846f
C5556 a_n1204_6102.n35 VSS 0.23288f
C5557 a_n1204_6102.n36 VSS 0.16146f
C5558 a_23647_n2146.n0 VSS 0.30875f
C5559 a_23647_n2146.n1 VSS 0.14431f
C5560 a_23647_n2146.n2 VSS 0.17149f
C5561 a_23647_n2146.n4 VSS 0.4905f
C5562 a_23647_n2146.n5 VSS 0.14431f
C5563 a_23647_n2146.n6 VSS 0.14431f
C5564 a_23647_n2146.n7 VSS 0.17149f
C5565 a_23647_n2146.n8 VSS 0.17149f
C5566 a_23647_n2146.n9 VSS 0.14431f
C5567 a_23647_n2146.n10 VSS 0.14431f
C5568 a_23647_n2146.n11 VSS 0.17149f
C5569 a_23647_n2146.n12 VSS 0.17149f
C5570 a_23647_n2146.n13 VSS 0.14431f
C5571 a_23647_n2146.n14 VSS 0.14431f
C5572 a_23647_n2146.n15 VSS 0.17149f
C5573 a_23647_n2146.n16 VSS 0.17149f
C5574 a_23647_n2146.n17 VSS 0.14431f
C5575 a_23647_n2146.n18 VSS 0.14431f
C5576 a_23647_n2146.n19 VSS 0.17149f
C5577 a_23647_n2146.n20 VSS 0.17149f
C5578 a_23647_n2146.n21 VSS 0.14431f
C5579 a_23647_n2146.n22 VSS 0.14431f
C5580 a_23647_n2146.n23 VSS 0.17149f
C5581 a_23647_n2146.n24 VSS 0.17149f
C5582 a_23647_n2146.n25 VSS 0.14431f
C5583 a_23647_n2146.n26 VSS 0.14431f
C5584 a_23647_n2146.n27 VSS 0.17149f
C5585 a_23647_n2146.n28 VSS 0.17149f
C5586 a_23647_n2146.n29 VSS 0.14431f
C5587 a_23647_n2146.n30 VSS 0.14431f
C5588 a_23647_n2146.n31 VSS 0.17149f
C5589 a_30793_n862.n0 VSS 0.30869f
C5590 a_30793_n862.n1 VSS 0.14432f
C5591 a_30793_n862.n3 VSS 0.48932f
C5592 a_30793_n862.n4 VSS 0.14432f
C5593 a_30793_n862.n5 VSS 0.14432f
C5594 a_30793_n862.n6 VSS 0.17142f
C5595 a_30793_n862.n7 VSS 0.17142f
C5596 a_30793_n862.n8 VSS 0.14432f
C5597 a_30793_n862.n9 VSS 0.14432f
C5598 a_30793_n862.n10 VSS 0.17142f
C5599 a_30793_n862.n11 VSS 0.17142f
C5600 a_30793_n862.n12 VSS 0.14432f
C5601 a_30793_n862.n13 VSS 0.14432f
C5602 a_30793_n862.n14 VSS 0.17142f
C5603 a_30793_n862.n15 VSS 0.17142f
C5604 a_30793_n862.n16 VSS 0.14432f
C5605 a_30793_n862.n17 VSS 0.14432f
C5606 a_30793_n862.n18 VSS 0.17142f
C5607 a_30793_n862.n19 VSS 0.17142f
C5608 a_30793_n862.n20 VSS 0.14432f
C5609 a_30793_n862.n21 VSS 0.14432f
C5610 a_30793_n862.n22 VSS 0.17142f
C5611 a_30793_n862.n23 VSS 0.17142f
C5612 a_30793_n862.n24 VSS 0.14432f
C5613 a_30793_n862.n25 VSS 0.14432f
C5614 a_30793_n862.n26 VSS 0.17142f
C5615 a_30793_n862.n27 VSS 0.17142f
C5616 a_30793_n862.n28 VSS 0.14432f
C5617 a_30793_n862.n29 VSS 0.14432f
C5618 a_30793_n862.n30 VSS 0.17142f
C5619 a_30793_n862.n31 VSS 0.17142f
C5620 a_n884_6102.t15 VSS 0.14829f
C5621 a_n884_6102.n1 VSS 2.19422f
C5622 a_n884_6102.t34 VSS 0.12129f
C5623 a_n884_6102.n2 VSS 0.99541f
C5624 a_n884_6102.n3 VSS 0.8403f
C5625 a_n884_6102.t28 VSS 0.12129f
C5626 a_n884_6102.n4 VSS 0.99541f
C5627 a_n884_6102.n5 VSS 0.8403f
C5628 a_n884_6102.t9 VSS 0.12129f
C5629 a_n884_6102.n6 VSS 0.99541f
C5630 a_n884_6102.n7 VSS 0.8403f
C5631 a_n884_6102.t11 VSS 0.12129f
C5632 a_n884_6102.n8 VSS 0.99541f
C5633 a_n884_6102.n9 VSS 0.8403f
C5634 a_n884_6102.t33 VSS 0.12129f
C5635 a_n884_6102.n10 VSS 0.99541f
C5636 a_n884_6102.n11 VSS 0.8403f
C5637 a_n884_6102.t24 VSS 0.12129f
C5638 a_n884_6102.n12 VSS 0.99541f
C5639 a_n884_6102.n13 VSS 0.8403f
C5640 a_n884_6102.t6 VSS 0.12129f
C5641 a_n884_6102.n14 VSS 0.99541f
C5642 a_n884_6102.n15 VSS 0.8403f
C5643 a_n884_6102.t7 VSS 0.12129f
C5644 a_n884_6102.n16 VSS 0.99541f
C5645 a_n884_6102.n17 VSS 0.8403f
C5646 a_n884_6102.t31 VSS 0.12129f
C5647 a_n884_6102.n18 VSS 0.99541f
C5648 a_n884_6102.n19 VSS 0.8403f
C5649 a_n884_6102.t20 VSS 0.12129f
C5650 a_n884_6102.n20 VSS 0.99541f
C5651 a_n884_6102.n21 VSS 0.8403f
C5652 a_n884_6102.t21 VSS 0.12129f
C5653 a_n884_6102.n22 VSS 0.99541f
C5654 a_n884_6102.n23 VSS 0.8403f
C5655 a_n884_6102.t12 VSS 0.12129f
C5656 a_n884_6102.n24 VSS 0.99541f
C5657 a_n884_6102.n25 VSS 0.8403f
C5658 a_n884_6102.t14 VSS 0.12129f
C5659 a_n884_6102.n26 VSS 0.99541f
C5660 a_n884_6102.n27 VSS 0.8403f
C5661 a_n884_6102.t26 VSS 0.12129f
C5662 a_n884_6102.n28 VSS 0.99541f
C5663 a_n884_6102.n29 VSS 0.8403f
C5664 a_n884_6102.t5 VSS 0.12129f
C5665 a_n884_6102.n30 VSS 0.99541f
C5666 a_n884_6102.n31 VSS 0.67354f
C5667 a_n884_6102.n32 VSS 0.35884f
C5668 a_n884_6102.n33 VSS 0.16325f
C5669 RB13.t2 VSS 0.10604f
C5670 RB13.t3 VSS 0.17349f
C5671 RB13.n0 VSS 0.43324f
C5672 RB13.t41 VSS 0.10604f
C5673 RB13.t8 VSS 0.17349f
C5674 RB13.n1 VSS 0.21645f
C5675 RB13.n2 VSS 2.82816f
C5676 RB13.t28 VSS 0.10604f
C5677 RB13.t14 VSS 0.17349f
C5678 RB13.n3 VSS 0.21645f
C5679 RB13.n4 VSS 1.8981f
C5680 RB13.t13 VSS 0.10604f
C5681 RB13.t10 VSS 0.17349f
C5682 RB13.n5 VSS 0.21645f
C5683 RB13.n6 VSS 1.8981f
C5684 RB13.t0 VSS 0.10604f
C5685 RB13.t46 VSS 0.17349f
C5686 RB13.n7 VSS 0.21645f
C5687 RB13.n8 VSS 1.8981f
C5688 RB13.t38 VSS 0.10604f
C5689 RB13.t4 VSS 0.17349f
C5690 RB13.n9 VSS 0.21645f
C5691 RB13.n10 VSS 1.8981f
C5692 RB13.t25 VSS 0.10604f
C5693 RB13.t9 VSS 0.17349f
C5694 RB13.n11 VSS 0.21645f
C5695 RB13.n12 VSS 1.8981f
C5696 RB13.t26 VSS 0.10604f
C5697 RB13.t1 VSS 0.17349f
C5698 RB13.n13 VSS 0.21645f
C5699 RB13.n14 VSS 1.8981f
C5700 RB13.t5 VSS 0.10604f
C5701 RB13.t44 VSS 0.17349f
C5702 RB13.n15 VSS 0.21645f
C5703 RB13.n16 VSS 1.8981f
C5704 RB13.t36 VSS 0.10604f
C5705 RB13.t47 VSS 0.17349f
C5706 RB13.n17 VSS 0.21645f
C5707 RB13.n18 VSS 1.8981f
C5708 RB13.t37 VSS 0.10604f
C5709 RB13.t43 VSS 0.17349f
C5710 RB13.n19 VSS 0.21645f
C5711 RB13.n20 VSS 1.8981f
C5712 RB13.t20 VSS 0.10604f
C5713 RB13.t45 VSS 0.17349f
C5714 RB13.n21 VSS 0.21645f
C5715 RB13.n22 VSS 1.8981f
C5716 RB13.t18 VSS 0.10604f
C5717 RB13.t6 VSS 0.17349f
C5718 RB13.n23 VSS 0.21645f
C5719 RB13.n24 VSS 1.8981f
C5720 RB13.t39 VSS 0.10604f
C5721 RB13.t11 VSS 0.17349f
C5722 RB13.n25 VSS 0.21645f
C5723 RB13.n26 VSS 1.8981f
C5724 RB13.t40 VSS 0.10604f
C5725 RB13.t7 VSS 0.17349f
C5726 RB13.n27 VSS 0.21645f
C5727 RB13.n28 VSS 1.8981f
C5728 RB13.t12 VSS 0.10604f
C5729 RB13.t24 VSS 0.17349f
C5730 RB13.n29 VSS 0.21645f
C5731 RB13.n30 VSS 2.31028f
C5732 a_31776_n708.n3 VSS 0.26552f
C5733 a_31776_n708.n5 VSS 0.1392f
C5734 a_31776_n708.n7 VSS 0.1392f
C5735 a_31776_n708.n9 VSS 0.1392f
C5736 a_31776_n708.n11 VSS 0.1392f
C5737 a_31776_n708.n13 VSS 0.1392f
C5738 a_31776_n708.n15 VSS 0.1392f
C5739 a_31776_n708.n17 VSS 0.1392f
C5740 a_31776_n708.n19 VSS 0.1392f
C5741 a_31776_n708.n21 VSS 0.1392f
C5742 a_31776_n708.n23 VSS 0.1392f
C5743 a_31776_n708.n25 VSS 0.1392f
C5744 a_31776_n708.n27 VSS 0.1392f
C5745 a_31776_n708.n29 VSS 0.1392f
C5746 a_31776_n708.n31 VSS 0.18199f
C5747 a_1129_n862.n0 VSS 0.30869f
C5748 a_1129_n862.n1 VSS 0.14432f
C5749 a_1129_n862.n3 VSS 0.48932f
C5750 a_1129_n862.n4 VSS 0.14432f
C5751 a_1129_n862.n5 VSS 0.14432f
C5752 a_1129_n862.n6 VSS 0.17142f
C5753 a_1129_n862.n7 VSS 0.17142f
C5754 a_1129_n862.n8 VSS 0.14432f
C5755 a_1129_n862.n9 VSS 0.14432f
C5756 a_1129_n862.n10 VSS 0.17142f
C5757 a_1129_n862.n11 VSS 0.17142f
C5758 a_1129_n862.n12 VSS 0.14432f
C5759 a_1129_n862.n13 VSS 0.14432f
C5760 a_1129_n862.n14 VSS 0.17142f
C5761 a_1129_n862.n15 VSS 0.17142f
C5762 a_1129_n862.n16 VSS 0.14432f
C5763 a_1129_n862.n17 VSS 0.14432f
C5764 a_1129_n862.n18 VSS 0.17142f
C5765 a_1129_n862.n19 VSS 0.17142f
C5766 a_1129_n862.n20 VSS 0.14432f
C5767 a_1129_n862.n21 VSS 0.14432f
C5768 a_1129_n862.n22 VSS 0.17142f
C5769 a_1129_n862.n23 VSS 0.17142f
C5770 a_1129_n862.n24 VSS 0.14432f
C5771 a_1129_n862.n25 VSS 0.14432f
C5772 a_1129_n862.n26 VSS 0.17142f
C5773 a_1129_n862.n27 VSS 0.17142f
C5774 a_1129_n862.n28 VSS 0.14432f
C5775 a_1129_n862.n29 VSS 0.14432f
C5776 a_1129_n862.n30 VSS 0.17142f
C5777 a_1129_n862.n31 VSS 0.17142f
C5778 a_9528_n708.n3 VSS 0.26552f
C5779 a_9528_n708.n5 VSS 0.1392f
C5780 a_9528_n708.n7 VSS 0.1392f
C5781 a_9528_n708.n9 VSS 0.1392f
C5782 a_9528_n708.n11 VSS 0.1392f
C5783 a_9528_n708.n13 VSS 0.1392f
C5784 a_9528_n708.n15 VSS 0.1392f
C5785 a_9528_n708.n17 VSS 0.1392f
C5786 a_9528_n708.n19 VSS 0.1392f
C5787 a_9528_n708.n21 VSS 0.1392f
C5788 a_9528_n708.n23 VSS 0.1392f
C5789 a_9528_n708.n25 VSS 0.1392f
C5790 a_9528_n708.n27 VSS 0.1392f
C5791 a_9528_n708.n29 VSS 0.1392f
C5792 a_9528_n708.n31 VSS 0.18199f
C5793 RB1.t7 VSS 0.10604f
C5794 RB1.t13 VSS 0.17349f
C5795 RB1.n0 VSS 0.43324f
C5796 RB1.t35 VSS 0.10604f
C5797 RB1.t43 VSS 0.17349f
C5798 RB1.n1 VSS 0.21645f
C5799 RB1.n2 VSS 2.82816f
C5800 RB1.t16 VSS 0.10604f
C5801 RB1.t22 VSS 0.17349f
C5802 RB1.n3 VSS 0.21645f
C5803 RB1.n4 VSS 1.8981f
C5804 RB1.t41 VSS 0.10604f
C5805 RB1.t3 VSS 0.17349f
C5806 RB1.n5 VSS 0.21645f
C5807 RB1.n6 VSS 1.8981f
C5808 RB1.t46 VSS 0.10604f
C5809 RB1.t6 VSS 0.17349f
C5810 RB1.n7 VSS 0.21645f
C5811 RB1.n8 VSS 1.8981f
C5812 RB1.t31 VSS 0.10604f
C5813 RB1.t34 VSS 0.17349f
C5814 RB1.n9 VSS 0.21645f
C5815 RB1.n10 VSS 1.8981f
C5816 RB1.t10 VSS 0.10604f
C5817 RB1.t15 VSS 0.17349f
C5818 RB1.n11 VSS 0.21645f
C5819 RB1.n12 VSS 1.8981f
C5820 RB1.t25 VSS 0.10604f
C5821 RB1.t29 VSS 0.17349f
C5822 RB1.n13 VSS 0.21645f
C5823 RB1.n14 VSS 1.8981f
C5824 RB1.t4 VSS 0.10604f
C5825 RB1.t11 VSS 0.17349f
C5826 RB1.n15 VSS 0.21645f
C5827 RB1.n16 VSS 1.8981f
C5828 RB1.t26 VSS 0.10604f
C5829 RB1.t30 VSS 0.17349f
C5830 RB1.n17 VSS 0.21645f
C5831 RB1.n18 VSS 1.8981f
C5832 RB1.t40 VSS 0.10604f
C5833 RB1.t2 VSS 0.17349f
C5834 RB1.n19 VSS 0.21645f
C5835 RB1.n20 VSS 1.8981f
C5836 RB1.t19 VSS 0.10604f
C5837 RB1.t24 VSS 0.17349f
C5838 RB1.n21 VSS 0.21645f
C5839 RB1.n22 VSS 1.8981f
C5840 RB1.t39 VSS 0.10604f
C5841 RB1.t1 VSS 0.17349f
C5842 RB1.n23 VSS 0.21645f
C5843 RB1.n24 VSS 1.8981f
C5844 RB1.t28 VSS 0.10604f
C5845 RB1.t33 VSS 0.17349f
C5846 RB1.n25 VSS 0.21645f
C5847 RB1.n26 VSS 1.8981f
C5848 RB1.t0 VSS 0.10604f
C5849 RB1.t9 VSS 0.17349f
C5850 RB1.n27 VSS 0.21645f
C5851 RB1.n28 VSS 1.8981f
C5852 RB1.t36 VSS 0.10604f
C5853 RB1.t45 VSS 0.17349f
C5854 RB1.n29 VSS 0.21645f
C5855 RB1.n30 VSS 2.30991f
C5856 RA7.t45 VSS 0.21849f
C5857 RA7.n0 VSS 0.55201f
C5858 RA7.t30 VSS 0.21849f
C5859 RA7.n1 VSS 0.21996f
C5860 RA7.n2 VSS 3.35439f
C5861 RA7.t32 VSS 0.21849f
C5862 RA7.n3 VSS 0.21996f
C5863 RA7.n4 VSS 1.92978f
C5864 RA7.t18 VSS 0.21849f
C5865 RA7.n5 VSS 0.21996f
C5866 RA7.n6 VSS 1.92978f
C5867 RA7.t12 VSS 0.21849f
C5868 RA7.n7 VSS 0.21996f
C5869 RA7.n8 VSS 1.92978f
C5870 RA7.t28 VSS 0.21849f
C5871 RA7.n9 VSS 0.21996f
C5872 RA7.n10 VSS 1.92978f
C5873 RA7.t29 VSS 0.21849f
C5874 RA7.n11 VSS 0.21996f
C5875 RA7.n12 VSS 1.92978f
C5876 RA7.t16 VSS 0.21849f
C5877 RA7.n13 VSS 0.21996f
C5878 RA7.n14 VSS 1.92978f
C5879 RA7.t10 VSS 0.21849f
C5880 RA7.n15 VSS 0.21996f
C5881 RA7.n16 VSS 1.92978f
C5882 RA7.t43 VSS 0.21849f
C5883 RA7.n17 VSS 0.21996f
C5884 RA7.n18 VSS 1.92978f
C5885 RA7.t27 VSS 0.21849f
C5886 RA7.n19 VSS 0.21996f
C5887 RA7.n20 VSS 1.92978f
C5888 RA7.t15 VSS 0.21849f
C5889 RA7.n21 VSS 0.21996f
C5890 RA7.n22 VSS 1.92978f
C5891 RA7.t14 VSS 0.21849f
C5892 RA7.n23 VSS 0.21996f
C5893 RA7.n24 VSS 1.92978f
C5894 RA7.t46 VSS 0.21849f
C5895 RA7.n25 VSS 0.21996f
C5896 RA7.n26 VSS 1.92978f
C5897 RA7.t47 VSS 0.21849f
C5898 RA7.n27 VSS 0.21996f
C5899 RA7.n28 VSS 1.92978f
C5900 RA7.t20 VSS 0.21849f
C5901 RA7.n29 VSS 0.21996f
C5902 RA7.n30 VSS 2.05237f
C5903 a_14472_n708.n3 VSS 0.26552f
C5904 a_14472_n708.n5 VSS 0.1392f
C5905 a_14472_n708.n7 VSS 0.1392f
C5906 a_14472_n708.n9 VSS 0.1392f
C5907 a_14472_n708.n11 VSS 0.1392f
C5908 a_14472_n708.n13 VSS 0.1392f
C5909 a_14472_n708.n15 VSS 0.1392f
C5910 a_14472_n708.n17 VSS 0.1392f
C5911 a_14472_n708.n19 VSS 0.1392f
C5912 a_14472_n708.n21 VSS 0.1392f
C5913 a_14472_n708.n23 VSS 0.1392f
C5914 a_14472_n708.n25 VSS 0.1392f
C5915 a_14472_n708.n27 VSS 0.1392f
C5916 a_14472_n708.n29 VSS 0.1392f
C5917 a_14472_n708.n31 VSS 0.18199f
C5918 WEM.n0 VSS 1.17507f
C5919 WEM.n1 VSS 0.52438f
C5920 WEM.n2 VSS 0.62581f
C5921 WEM.n3 VSS 0.52438f
C5922 WEM.n4 VSS 0.62581f
C5923 WEM.n5 VSS 0.52438f
C5924 WEM.n6 VSS 0.62581f
C5925 WEM.n7 VSS 0.52438f
C5926 WEM.n8 VSS 0.62581f
C5927 WEM.n9 VSS 0.52438f
C5928 WEM.n10 VSS 0.62581f
C5929 WEM.n11 VSS 0.52438f
C5930 WEM.n12 VSS 0.62581f
C5931 WEM.n13 VSS 0.52438f
C5932 WEM.n14 VSS 0.62581f
C5933 WEM.n15 VSS 0.52438f
C5934 WEM.n16 VSS 0.62581f
C5935 WEM.n17 VSS 0.52438f
C5936 WEM.n18 VSS 0.62581f
C5937 WEM.n19 VSS 0.52438f
C5938 WEM.n20 VSS 0.62581f
C5939 WEM.n21 VSS 0.52438f
C5940 WEM.n22 VSS 0.62581f
C5941 WEM.n23 VSS 0.52438f
C5942 WEM.n24 VSS 0.62581f
C5943 WEM.n25 VSS 0.52438f
C5944 WEM.n26 VSS 0.62581f
C5945 WEM.n27 VSS 0.52438f
C5946 WEM.n28 VSS 0.62581f
C5947 WEM.n29 VSS 0.52438f
C5948 WEM.n30 VSS 0.47514f
C5949 WEM.n32 VSS 0.14211f
C5950 WEM.n33 VSS 0.36586f
C5951 a_n884_10022.t20 VSS 0.14829f
C5952 a_n884_10022.n1 VSS 2.19422f
C5953 a_n884_10022.t5 VSS 0.12129f
C5954 a_n884_10022.n2 VSS 0.99541f
C5955 a_n884_10022.n3 VSS 0.8403f
C5956 a_n884_10022.t25 VSS 0.12129f
C5957 a_n884_10022.n4 VSS 0.99541f
C5958 a_n884_10022.n5 VSS 0.8403f
C5959 a_n884_10022.t6 VSS 0.12129f
C5960 a_n884_10022.n6 VSS 0.99541f
C5961 a_n884_10022.n7 VSS 0.8403f
C5962 a_n884_10022.t15 VSS 0.12129f
C5963 a_n884_10022.n8 VSS 0.99541f
C5964 a_n884_10022.n9 VSS 0.8403f
C5965 a_n884_10022.t33 VSS 0.12129f
C5966 a_n884_10022.n10 VSS 0.99541f
C5967 a_n884_10022.n11 VSS 0.8403f
C5968 a_n884_10022.t24 VSS 0.12129f
C5969 a_n884_10022.n12 VSS 0.99541f
C5970 a_n884_10022.n13 VSS 0.8403f
C5971 a_n884_10022.t34 VSS 0.12129f
C5972 a_n884_10022.n14 VSS 0.99541f
C5973 a_n884_10022.n15 VSS 0.8403f
C5974 a_n884_10022.t10 VSS 0.12129f
C5975 a_n884_10022.n16 VSS 0.99541f
C5976 a_n884_10022.n17 VSS 0.8403f
C5977 a_n884_10022.t29 VSS 0.12129f
C5978 a_n884_10022.n18 VSS 0.99541f
C5979 a_n884_10022.n19 VSS 0.8403f
C5980 a_n884_10022.t18 VSS 0.12129f
C5981 a_n884_10022.n20 VSS 0.99541f
C5982 a_n884_10022.n21 VSS 0.8403f
C5983 a_n884_10022.t32 VSS 0.12129f
C5984 a_n884_10022.n22 VSS 0.99541f
C5985 a_n884_10022.n23 VSS 0.8403f
C5986 a_n884_10022.t14 VSS 0.12129f
C5987 a_n884_10022.n24 VSS 0.99541f
C5988 a_n884_10022.n25 VSS 0.8403f
C5989 a_n884_10022.t28 VSS 0.12129f
C5990 a_n884_10022.n26 VSS 0.99541f
C5991 a_n884_10022.n27 VSS 0.8403f
C5992 a_n884_10022.t21 VSS 0.12129f
C5993 a_n884_10022.n28 VSS 0.99541f
C5994 a_n884_10022.n29 VSS 0.8403f
C5995 a_n884_10022.t4 VSS 0.12129f
C5996 a_n884_10022.n30 VSS 0.99541f
C5997 a_n884_10022.n31 VSS 0.67354f
C5998 a_n884_10022.n32 VSS 0.35884f
C5999 a_n884_10022.n33 VSS 0.16325f
C6000 a_n884_614.t16 VSS 0.14829f
C6001 a_n884_614.n1 VSS 2.19422f
C6002 a_n884_614.t23 VSS 0.12129f
C6003 a_n884_614.n2 VSS 0.99541f
C6004 a_n884_614.n3 VSS 0.8403f
C6005 a_n884_614.t18 VSS 0.12129f
C6006 a_n884_614.n4 VSS 0.99541f
C6007 a_n884_614.n5 VSS 0.8403f
C6008 a_n884_614.t20 VSS 0.12129f
C6009 a_n884_614.n6 VSS 0.99541f
C6010 a_n884_614.n7 VSS 0.8403f
C6011 a_n884_614.t7 VSS 0.12129f
C6012 a_n884_614.n8 VSS 0.99541f
C6013 a_n884_614.n9 VSS 0.8403f
C6014 a_n884_614.t17 VSS 0.12129f
C6015 a_n884_614.n10 VSS 0.99541f
C6016 a_n884_614.n11 VSS 0.8403f
C6017 a_n884_614.t24 VSS 0.12129f
C6018 a_n884_614.n12 VSS 0.99541f
C6019 a_n884_614.n13 VSS 0.8403f
C6020 a_n884_614.t11 VSS 0.12129f
C6021 a_n884_614.n14 VSS 0.99541f
C6022 a_n884_614.n15 VSS 0.8403f
C6023 a_n884_614.t4 VSS 0.12129f
C6024 a_n884_614.n16 VSS 0.99541f
C6025 a_n884_614.n17 VSS 0.8403f
C6026 a_n884_614.t8 VSS 0.12129f
C6027 a_n884_614.n18 VSS 0.99541f
C6028 a_n884_614.n19 VSS 0.8403f
C6029 a_n884_614.t19 VSS 0.12129f
C6030 a_n884_614.n20 VSS 0.99541f
C6031 a_n884_614.n21 VSS 0.8403f
C6032 a_n884_614.t6 VSS 0.12129f
C6033 a_n884_614.n22 VSS 0.99541f
C6034 a_n884_614.n23 VSS 0.8403f
C6035 a_n884_614.t21 VSS 0.12129f
C6036 a_n884_614.n24 VSS 0.99541f
C6037 a_n884_614.n25 VSS 0.8403f
C6038 a_n884_614.t9 VSS 0.12129f
C6039 a_n884_614.n26 VSS 0.99541f
C6040 a_n884_614.n27 VSS 0.8403f
C6041 a_n884_614.t26 VSS 0.12129f
C6042 a_n884_614.n28 VSS 0.99541f
C6043 a_n884_614.n29 VSS 0.8403f
C6044 a_n884_614.t5 VSS 0.12129f
C6045 a_n884_614.n30 VSS 0.99541f
C6046 a_n884_614.n31 VSS 0.67354f
C6047 a_n884_614.n32 VSS 0.35884f
C6048 a_n884_614.n33 VSS 0.16325f
C6049 a_16231_n2146.n0 VSS 0.30875f
C6050 a_16231_n2146.n1 VSS 0.14431f
C6051 a_16231_n2146.n3 VSS 0.4905f
C6052 a_16231_n2146.n4 VSS 0.14431f
C6053 a_16231_n2146.n5 VSS 0.14431f
C6054 a_16231_n2146.n6 VSS 0.17149f
C6055 a_16231_n2146.n7 VSS 0.17149f
C6056 a_16231_n2146.n8 VSS 0.14431f
C6057 a_16231_n2146.n9 VSS 0.14431f
C6058 a_16231_n2146.n10 VSS 0.17149f
C6059 a_16231_n2146.n11 VSS 0.17149f
C6060 a_16231_n2146.n12 VSS 0.14431f
C6061 a_16231_n2146.n13 VSS 0.14431f
C6062 a_16231_n2146.n14 VSS 0.17149f
C6063 a_16231_n2146.n15 VSS 0.17149f
C6064 a_16231_n2146.n16 VSS 0.14431f
C6065 a_16231_n2146.n17 VSS 0.14431f
C6066 a_16231_n2146.n18 VSS 0.17149f
C6067 a_16231_n2146.n19 VSS 0.17149f
C6068 a_16231_n2146.n20 VSS 0.14431f
C6069 a_16231_n2146.n21 VSS 0.14431f
C6070 a_16231_n2146.n22 VSS 0.17149f
C6071 a_16231_n2146.n23 VSS 0.17149f
C6072 a_16231_n2146.n24 VSS 0.14431f
C6073 a_16231_n2146.n25 VSS 0.14431f
C6074 a_16231_n2146.n26 VSS 0.17149f
C6075 a_16231_n2146.n27 VSS 0.17149f
C6076 a_16231_n2146.n28 VSS 0.14431f
C6077 a_16231_n2146.n29 VSS 0.14431f
C6078 a_16231_n2146.n30 VSS 0.17149f
C6079 a_16231_n2146.n31 VSS 0.17149f
C6080 a_16944_n708.n3 VSS 0.26552f
C6081 a_16944_n708.n5 VSS 0.1392f
C6082 a_16944_n708.n7 VSS 0.1392f
C6083 a_16944_n708.n9 VSS 0.1392f
C6084 a_16944_n708.n11 VSS 0.1392f
C6085 a_16944_n708.n13 VSS 0.1392f
C6086 a_16944_n708.n15 VSS 0.1392f
C6087 a_16944_n708.n17 VSS 0.1392f
C6088 a_16944_n708.n19 VSS 0.1392f
C6089 a_16944_n708.n21 VSS 0.1392f
C6090 a_16944_n708.n23 VSS 0.1392f
C6091 a_16944_n708.n25 VSS 0.1392f
C6092 a_16944_n708.n27 VSS 0.1392f
C6093 a_16944_n708.n29 VSS 0.1392f
C6094 a_16944_n708.n31 VSS 0.18199f
C6095 a_n1204_5318.t33 VSS 0.13376f
C6096 a_n1204_5318.n1 VSS 2.07431f
C6097 a_n1204_5318.t19 VSS 0.11785f
C6098 a_n1204_5318.n2 VSS 0.92435f
C6099 a_n1204_5318.n3 VSS 0.77453f
C6100 a_n1204_5318.t11 VSS 0.11785f
C6101 a_n1204_5318.n4 VSS 0.92435f
C6102 a_n1204_5318.n5 VSS 0.77453f
C6103 a_n1204_5318.t29 VSS 0.11785f
C6104 a_n1204_5318.n6 VSS 0.92435f
C6105 a_n1204_5318.n7 VSS 0.77453f
C6106 a_n1204_5318.t30 VSS 0.11785f
C6107 a_n1204_5318.n8 VSS 0.92435f
C6108 a_n1204_5318.n9 VSS 0.77453f
C6109 a_n1204_5318.t16 VSS 0.11785f
C6110 a_n1204_5318.n10 VSS 0.92435f
C6111 a_n1204_5318.n11 VSS 0.77453f
C6112 a_n1204_5318.t9 VSS 0.11785f
C6113 a_n1204_5318.n12 VSS 0.92435f
C6114 a_n1204_5318.n13 VSS 0.77453f
C6115 a_n1204_5318.t27 VSS 0.11785f
C6116 a_n1204_5318.n14 VSS 0.92435f
C6117 a_n1204_5318.n15 VSS 0.77453f
C6118 a_n1204_5318.t28 VSS 0.11785f
C6119 a_n1204_5318.n16 VSS 0.92435f
C6120 a_n1204_5318.n17 VSS 0.77453f
C6121 a_n1204_5318.t13 VSS 0.11785f
C6122 a_n1204_5318.n18 VSS 0.92435f
C6123 a_n1204_5318.n19 VSS 0.77453f
C6124 a_n1204_5318.t6 VSS 0.11785f
C6125 a_n1204_5318.n20 VSS 0.92435f
C6126 a_n1204_5318.n21 VSS 0.77453f
C6127 a_n1204_5318.t7 VSS 0.11785f
C6128 a_n1204_5318.n22 VSS 0.92435f
C6129 a_n1204_5318.n23 VSS 0.77453f
C6130 a_n1204_5318.t31 VSS 0.11785f
C6131 a_n1204_5318.n24 VSS 0.92435f
C6132 a_n1204_5318.n25 VSS 0.77453f
C6133 a_n1204_5318.t32 VSS 0.11785f
C6134 a_n1204_5318.n26 VSS 0.92435f
C6135 a_n1204_5318.n27 VSS 0.77453f
C6136 a_n1204_5318.t10 VSS 0.11785f
C6137 a_n1204_5318.n28 VSS 0.92435f
C6138 a_n1204_5318.n29 VSS 0.77453f
C6139 a_n1204_5318.t23 VSS 0.11785f
C6140 a_n1204_5318.n30 VSS 0.92435f
C6141 a_n1204_5318.n31 VSS 0.60701f
C6142 a_n1204_5318.n32 VSS 0.25574f
C6143 a_n1204_5318.n33 VSS 0.12464f
C6144 a_n1204_5318.n34 VSS 0.13846f
C6145 a_n1204_5318.n35 VSS 0.23288f
C6146 a_n1204_5318.n36 VSS 0.16146f
C6147 a_n1204_8454.t23 VSS 0.13376f
C6148 a_n1204_8454.n1 VSS 2.07431f
C6149 a_n1204_8454.t8 VSS 0.11785f
C6150 a_n1204_8454.n2 VSS 0.92435f
C6151 a_n1204_8454.n3 VSS 0.77453f
C6152 a_n1204_8454.t39 VSS 0.11785f
C6153 a_n1204_8454.n4 VSS 0.92435f
C6154 a_n1204_8454.n5 VSS 0.77453f
C6155 a_n1204_8454.t18 VSS 0.11785f
C6156 a_n1204_8454.n6 VSS 0.92435f
C6157 a_n1204_8454.n7 VSS 0.77453f
C6158 a_n1204_8454.t19 VSS 0.11785f
C6159 a_n1204_8454.n8 VSS 0.92435f
C6160 a_n1204_8454.n9 VSS 0.77453f
C6161 a_n1204_8454.t7 VSS 0.11785f
C6162 a_n1204_8454.n10 VSS 0.92435f
C6163 a_n1204_8454.n11 VSS 0.77453f
C6164 a_n1204_8454.t37 VSS 0.11785f
C6165 a_n1204_8454.n12 VSS 0.92435f
C6166 a_n1204_8454.n13 VSS 0.77453f
C6167 a_n1204_8454.t13 VSS 0.11785f
C6168 a_n1204_8454.n14 VSS 0.92435f
C6169 a_n1204_8454.n15 VSS 0.77453f
C6170 a_n1204_8454.t15 VSS 0.11785f
C6171 a_n1204_8454.n16 VSS 0.92435f
C6172 a_n1204_8454.n17 VSS 0.77453f
C6173 a_n1204_8454.t5 VSS 0.11785f
C6174 a_n1204_8454.n18 VSS 0.92435f
C6175 a_n1204_8454.n19 VSS 0.77453f
C6176 a_n1204_8454.t33 VSS 0.11785f
C6177 a_n1204_8454.n20 VSS 0.92435f
C6178 a_n1204_8454.n21 VSS 0.77453f
C6179 a_n1204_8454.t35 VSS 0.11785f
C6180 a_n1204_8454.n22 VSS 0.92435f
C6181 a_n1204_8454.n23 VSS 0.77453f
C6182 a_n1204_8454.t21 VSS 0.11785f
C6183 a_n1204_8454.n24 VSS 0.92435f
C6184 a_n1204_8454.n25 VSS 0.77453f
C6185 a_n1204_8454.t22 VSS 0.11785f
C6186 a_n1204_8454.n26 VSS 0.92435f
C6187 a_n1204_8454.n27 VSS 0.77453f
C6188 a_n1204_8454.t38 VSS 0.11785f
C6189 a_n1204_8454.n28 VSS 0.92435f
C6190 a_n1204_8454.n29 VSS 0.77453f
C6191 a_n1204_8454.t10 VSS 0.11785f
C6192 a_n1204_8454.n30 VSS 0.92435f
C6193 a_n1204_8454.n31 VSS 0.60701f
C6194 a_n1204_8454.n32 VSS 0.25574f
C6195 a_n1204_8454.n33 VSS 0.12464f
C6196 a_n1204_8454.n34 VSS 0.13846f
C6197 a_n1204_8454.n35 VSS 0.23288f
C6198 a_n1204_8454.n36 VSS 0.16146f
C6199 a_21888_n708.n3 VSS 0.26552f
C6200 a_21888_n708.n5 VSS 0.1392f
C6201 a_21888_n708.n7 VSS 0.1392f
C6202 a_21888_n708.n9 VSS 0.1392f
C6203 a_21888_n708.n11 VSS 0.1392f
C6204 a_21888_n708.n13 VSS 0.1392f
C6205 a_21888_n708.n15 VSS 0.1392f
C6206 a_21888_n708.n17 VSS 0.1392f
C6207 a_21888_n708.n19 VSS 0.1392f
C6208 a_21888_n708.n21 VSS 0.1392f
C6209 a_21888_n708.n23 VSS 0.1392f
C6210 a_21888_n708.n25 VSS 0.1392f
C6211 a_21888_n708.n27 VSS 0.1392f
C6212 a_21888_n708.n29 VSS 0.1392f
C6213 a_21888_n708.n31 VSS 0.18199f
C6214 a_33535_n2146.n0 VSS 0.30875f
C6215 a_33535_n2146.n1 VSS 0.14431f
C6216 a_33535_n2146.n3 VSS 0.4905f
C6217 a_33535_n2146.n4 VSS 0.14431f
C6218 a_33535_n2146.n5 VSS 0.14431f
C6219 a_33535_n2146.n6 VSS 0.17149f
C6220 a_33535_n2146.n7 VSS 0.17149f
C6221 a_33535_n2146.n8 VSS 0.14431f
C6222 a_33535_n2146.n9 VSS 0.14431f
C6223 a_33535_n2146.n10 VSS 0.17149f
C6224 a_33535_n2146.n11 VSS 0.17149f
C6225 a_33535_n2146.n12 VSS 0.14431f
C6226 a_33535_n2146.n13 VSS 0.14431f
C6227 a_33535_n2146.n14 VSS 0.17149f
C6228 a_33535_n2146.n15 VSS 0.17149f
C6229 a_33535_n2146.n16 VSS 0.14431f
C6230 a_33535_n2146.n17 VSS 0.14431f
C6231 a_33535_n2146.n18 VSS 0.17149f
C6232 a_33535_n2146.n19 VSS 0.17149f
C6233 a_33535_n2146.n20 VSS 0.14431f
C6234 a_33535_n2146.n21 VSS 0.14431f
C6235 a_33535_n2146.n22 VSS 0.17149f
C6236 a_33535_n2146.n23 VSS 0.17149f
C6237 a_33535_n2146.n24 VSS 0.14431f
C6238 a_33535_n2146.n25 VSS 0.14431f
C6239 a_33535_n2146.n26 VSS 0.17149f
C6240 a_33535_n2146.n27 VSS 0.17149f
C6241 a_33535_n2146.n28 VSS 0.14431f
C6242 a_33535_n2146.n29 VSS 0.14431f
C6243 a_33535_n2146.n30 VSS 0.17149f
C6244 a_33535_n2146.n31 VSS 0.17149f
C6245 a_18703_n2146.n0 VSS 0.30875f
C6246 a_18703_n2146.n1 VSS 0.14431f
C6247 a_18703_n2146.n3 VSS 0.4905f
C6248 a_18703_n2146.n4 VSS 0.14431f
C6249 a_18703_n2146.n5 VSS 0.14431f
C6250 a_18703_n2146.n6 VSS 0.17149f
C6251 a_18703_n2146.n7 VSS 0.17149f
C6252 a_18703_n2146.n8 VSS 0.14431f
C6253 a_18703_n2146.n9 VSS 0.14431f
C6254 a_18703_n2146.n10 VSS 0.17149f
C6255 a_18703_n2146.n11 VSS 0.17149f
C6256 a_18703_n2146.n12 VSS 0.14431f
C6257 a_18703_n2146.n13 VSS 0.14431f
C6258 a_18703_n2146.n14 VSS 0.17149f
C6259 a_18703_n2146.n15 VSS 0.17149f
C6260 a_18703_n2146.n16 VSS 0.14431f
C6261 a_18703_n2146.n17 VSS 0.14431f
C6262 a_18703_n2146.n18 VSS 0.17149f
C6263 a_18703_n2146.n19 VSS 0.17149f
C6264 a_18703_n2146.n20 VSS 0.14431f
C6265 a_18703_n2146.n21 VSS 0.14431f
C6266 a_18703_n2146.n22 VSS 0.17149f
C6267 a_18703_n2146.n23 VSS 0.17149f
C6268 a_18703_n2146.n24 VSS 0.14431f
C6269 a_18703_n2146.n25 VSS 0.14431f
C6270 a_18703_n2146.n26 VSS 0.17149f
C6271 a_18703_n2146.n27 VSS 0.17149f
C6272 a_18703_n2146.n28 VSS 0.14431f
C6273 a_18703_n2146.n29 VSS 0.14431f
C6274 a_18703_n2146.n30 VSS 0.17149f
C6275 a_18703_n2146.n31 VSS 0.17149f
C6276 a_n884_n954.t11 VSS 0.14873f
C6277 a_n884_n954.n1 VSS 2.20071f
C6278 a_n884_n954.t30 VSS 0.12165f
C6279 a_n884_n954.n2 VSS 0.99836f
C6280 a_n884_n954.n3 VSS 0.84279f
C6281 a_n884_n954.t24 VSS 0.12165f
C6282 a_n884_n954.n4 VSS 0.99836f
C6283 a_n884_n954.n5 VSS 0.84279f
C6284 a_n884_n954.t7 VSS 0.12165f
C6285 a_n884_n954.n6 VSS 0.99836f
C6286 a_n884_n954.n7 VSS 0.84279f
C6287 a_n884_n954.t8 VSS 0.12165f
C6288 a_n884_n954.n8 VSS 0.99836f
C6289 a_n884_n954.n9 VSS 0.84279f
C6290 a_n884_n954.t27 VSS 0.12165f
C6291 a_n884_n954.n10 VSS 0.99836f
C6292 a_n884_n954.n11 VSS 0.84279f
C6293 a_n884_n954.t22 VSS 0.12165f
C6294 a_n884_n954.n12 VSS 0.99836f
C6295 a_n884_n954.n13 VSS 0.84279f
C6296 a_n884_n954.t5 VSS 0.12165f
C6297 a_n884_n954.n14 VSS 0.99836f
C6298 a_n884_n954.n15 VSS 0.84279f
C6299 a_n884_n954.t6 VSS 0.12165f
C6300 a_n884_n954.n16 VSS 0.99836f
C6301 a_n884_n954.n17 VSS 0.84279f
C6302 a_n884_n954.t26 VSS 0.12165f
C6303 a_n884_n954.n18 VSS 0.99836f
C6304 a_n884_n954.n19 VSS 0.84279f
C6305 a_n884_n954.t19 VSS 0.12165f
C6306 a_n884_n954.n20 VSS 0.99836f
C6307 a_n884_n954.n21 VSS 0.84279f
C6308 a_n884_n954.t20 VSS 0.12165f
C6309 a_n884_n954.n22 VSS 0.99836f
C6310 a_n884_n954.n23 VSS 0.84279f
C6311 a_n884_n954.t9 VSS 0.12165f
C6312 a_n884_n954.n24 VSS 0.99836f
C6313 a_n884_n954.n25 VSS 0.84279f
C6314 a_n884_n954.t10 VSS 0.12165f
C6315 a_n884_n954.n26 VSS 0.99836f
C6316 a_n884_n954.n27 VSS 0.84279f
C6317 a_n884_n954.t23 VSS 0.12165f
C6318 a_n884_n954.n28 VSS 0.99836f
C6319 a_n884_n954.n29 VSS 0.84279f
C6320 a_n884_n954.t34 VSS 0.12165f
C6321 a_n884_n954.n30 VSS 0.99836f
C6322 a_n884_n954.n31 VSS 0.67553f
C6323 a_n884_n954.n32 VSS 0.35991f
C6324 a_n884_n954.n33 VSS 0.16374f
C6325 a_6343_n2146.n0 VSS 0.30875f
C6326 a_6343_n2146.n1 VSS 0.14431f
C6327 a_6343_n2146.n3 VSS 0.4905f
C6328 a_6343_n2146.n4 VSS 0.14431f
C6329 a_6343_n2146.n5 VSS 0.14431f
C6330 a_6343_n2146.n6 VSS 0.17149f
C6331 a_6343_n2146.n7 VSS 0.17149f
C6332 a_6343_n2146.n8 VSS 0.14431f
C6333 a_6343_n2146.n9 VSS 0.14431f
C6334 a_6343_n2146.n10 VSS 0.17149f
C6335 a_6343_n2146.n11 VSS 0.17149f
C6336 a_6343_n2146.n12 VSS 0.14431f
C6337 a_6343_n2146.n13 VSS 0.14431f
C6338 a_6343_n2146.n14 VSS 0.17149f
C6339 a_6343_n2146.n15 VSS 0.17149f
C6340 a_6343_n2146.n16 VSS 0.14431f
C6341 a_6343_n2146.n17 VSS 0.14431f
C6342 a_6343_n2146.n18 VSS 0.17149f
C6343 a_6343_n2146.n19 VSS 0.17149f
C6344 a_6343_n2146.n20 VSS 0.14431f
C6345 a_6343_n2146.n21 VSS 0.14431f
C6346 a_6343_n2146.n22 VSS 0.17149f
C6347 a_6343_n2146.n23 VSS 0.17149f
C6348 a_6343_n2146.n24 VSS 0.14431f
C6349 a_6343_n2146.n25 VSS 0.14431f
C6350 a_6343_n2146.n26 VSS 0.17149f
C6351 a_6343_n2146.n27 VSS 0.17149f
C6352 a_6343_n2146.n28 VSS 0.14431f
C6353 a_6343_n2146.n29 VSS 0.14431f
C6354 a_6343_n2146.n30 VSS 0.17149f
C6355 a_6343_n2146.n31 VSS 0.17149f
C6356 RB6.t27 VSS 0.17349f
C6357 RB6.t22 VSS 0.10604f
C6358 RB6.n0 VSS 0.43324f
C6359 RB6.t19 VSS 0.17349f
C6360 RB6.t10 VSS 0.10604f
C6361 RB6.n1 VSS 0.21645f
C6362 RB6.n2 VSS 2.82816f
C6363 RB6.t47 VSS 0.17349f
C6364 RB6.t42 VSS 0.10604f
C6365 RB6.n3 VSS 0.21645f
C6366 RB6.n4 VSS 1.8981f
C6367 RB6.t33 VSS 0.17349f
C6368 RB6.t30 VSS 0.10604f
C6369 RB6.n5 VSS 0.21645f
C6370 RB6.n6 VSS 1.8981f
C6371 RB6.t25 VSS 0.17349f
C6372 RB6.t20 VSS 0.10604f
C6373 RB6.n7 VSS 0.21645f
C6374 RB6.n8 VSS 1.8981f
C6375 RB6.t16 VSS 0.17349f
C6376 RB6.t5 VSS 0.10604f
C6377 RB6.n9 VSS 0.21645f
C6378 RB6.n10 VSS 1.8981f
C6379 RB6.t45 VSS 0.17349f
C6380 RB6.t40 VSS 0.10604f
C6381 RB6.n11 VSS 0.21645f
C6382 RB6.n12 VSS 1.8981f
C6383 RB6.t46 VSS 0.17349f
C6384 RB6.t41 VSS 0.10604f
C6385 RB6.n13 VSS 0.21645f
C6386 RB6.n14 VSS 1.8981f
C6387 RB6.t28 VSS 0.17349f
C6388 RB6.t24 VSS 0.10604f
C6389 RB6.n15 VSS 0.21645f
C6390 RB6.n16 VSS 1.8981f
C6391 RB6.t14 VSS 0.17349f
C6392 RB6.t2 VSS 0.10604f
C6393 RB6.n17 VSS 0.21645f
C6394 RB6.n18 VSS 1.8981f
C6395 RB6.t15 VSS 0.17349f
C6396 RB6.t3 VSS 0.10604f
C6397 RB6.n19 VSS 0.21645f
C6398 RB6.n20 VSS 1.8981f
C6399 RB6.t44 VSS 0.17349f
C6400 RB6.t39 VSS 0.10604f
C6401 RB6.n21 VSS 0.21645f
C6402 RB6.n22 VSS 1.8981f
C6403 RB6.t43 VSS 0.17349f
C6404 RB6.t35 VSS 0.10604f
C6405 RB6.n23 VSS 0.21645f
C6406 RB6.n24 VSS 1.8981f
C6407 RB6.t17 VSS 0.17349f
C6408 RB6.t6 VSS 0.10604f
C6409 RB6.n25 VSS 0.21645f
C6410 RB6.n26 VSS 1.8981f
C6411 RB6.t18 VSS 0.17349f
C6412 RB6.t8 VSS 0.10604f
C6413 RB6.n27 VSS 0.21645f
C6414 RB6.n28 VSS 1.8981f
C6415 RB6.t31 VSS 0.17349f
C6416 RB6.t29 VSS 0.10604f
C6417 RB6.n29 VSS 0.21645f
C6418 RB6.n30 VSS 2.30991f
C6419 a_n1204_614.t27 VSS 0.13376f
C6420 a_n1204_614.n1 VSS 2.07431f
C6421 a_n1204_614.t10 VSS 0.11785f
C6422 a_n1204_614.n2 VSS 0.92435f
C6423 a_n1204_614.n3 VSS 0.77453f
C6424 a_n1204_614.t35 VSS 0.11785f
C6425 a_n1204_614.n4 VSS 0.92435f
C6426 a_n1204_614.n5 VSS 0.77453f
C6427 a_n1204_614.t21 VSS 0.11785f
C6428 a_n1204_614.n6 VSS 0.92435f
C6429 a_n1204_614.n7 VSS 0.77453f
C6430 a_n1204_614.t22 VSS 0.11785f
C6431 a_n1204_614.n8 VSS 0.92435f
C6432 a_n1204_614.n9 VSS 0.77453f
C6433 a_n1204_614.t6 VSS 0.11785f
C6434 a_n1204_614.n10 VSS 0.92435f
C6435 a_n1204_614.n11 VSS 0.77453f
C6436 a_n1204_614.t33 VSS 0.11785f
C6437 a_n1204_614.n12 VSS 0.92435f
C6438 a_n1204_614.n13 VSS 0.77453f
C6439 a_n1204_614.t19 VSS 0.11785f
C6440 a_n1204_614.n14 VSS 0.92435f
C6441 a_n1204_614.n15 VSS 0.77453f
C6442 a_n1204_614.t20 VSS 0.11785f
C6443 a_n1204_614.n16 VSS 0.92435f
C6444 a_n1204_614.n17 VSS 0.77453f
C6445 a_n1204_614.t4 VSS 0.11785f
C6446 a_n1204_614.n18 VSS 0.92435f
C6447 a_n1204_614.n19 VSS 0.77453f
C6448 a_n1204_614.t31 VSS 0.11785f
C6449 a_n1204_614.n20 VSS 0.92435f
C6450 a_n1204_614.n21 VSS 0.77453f
C6451 a_n1204_614.t32 VSS 0.11785f
C6452 a_n1204_614.n22 VSS 0.92435f
C6453 a_n1204_614.n23 VSS 0.77453f
C6454 a_n1204_614.t23 VSS 0.11785f
C6455 a_n1204_614.n24 VSS 0.92435f
C6456 a_n1204_614.n25 VSS 0.77453f
C6457 a_n1204_614.t26 VSS 0.11785f
C6458 a_n1204_614.n26 VSS 0.92435f
C6459 a_n1204_614.n27 VSS 0.77453f
C6460 a_n1204_614.t34 VSS 0.11785f
C6461 a_n1204_614.n28 VSS 0.92435f
C6462 a_n1204_614.n29 VSS 0.77453f
C6463 a_n1204_614.t14 VSS 0.11785f
C6464 a_n1204_614.n30 VSS 0.92435f
C6465 a_n1204_614.n31 VSS 0.60701f
C6466 a_n1204_614.n32 VSS 0.25574f
C6467 a_n1204_614.n33 VSS 0.12464f
C6468 a_n1204_614.n34 VSS 0.13846f
C6469 a_n1204_614.n35 VSS 0.23288f
C6470 a_n1204_614.n36 VSS 0.16146f
C6471 a_n1204_3750.t23 VSS 0.13376f
C6472 a_n1204_3750.n1 VSS 2.07431f
C6473 a_n1204_3750.t7 VSS 0.11785f
C6474 a_n1204_3750.n2 VSS 0.92435f
C6475 a_n1204_3750.n3 VSS 0.77453f
C6476 a_n1204_3750.t37 VSS 0.11785f
C6477 a_n1204_3750.n4 VSS 0.92435f
C6478 a_n1204_3750.n5 VSS 0.77453f
C6479 a_n1204_3750.t19 VSS 0.11785f
C6480 a_n1204_3750.n6 VSS 0.92435f
C6481 a_n1204_3750.n7 VSS 0.77453f
C6482 a_n1204_3750.t20 VSS 0.11785f
C6483 a_n1204_3750.n8 VSS 0.92435f
C6484 a_n1204_3750.n9 VSS 0.77453f
C6485 a_n1204_3750.t6 VSS 0.11785f
C6486 a_n1204_3750.n10 VSS 0.92435f
C6487 a_n1204_3750.n11 VSS 0.77453f
C6488 a_n1204_3750.t35 VSS 0.11785f
C6489 a_n1204_3750.n12 VSS 0.92435f
C6490 a_n1204_3750.n13 VSS 0.77453f
C6491 a_n1204_3750.t17 VSS 0.11785f
C6492 a_n1204_3750.n14 VSS 0.92435f
C6493 a_n1204_3750.n15 VSS 0.77453f
C6494 a_n1204_3750.t18 VSS 0.11785f
C6495 a_n1204_3750.n16 VSS 0.92435f
C6496 a_n1204_3750.n17 VSS 0.77453f
C6497 a_n1204_3750.t4 VSS 0.11785f
C6498 a_n1204_3750.n18 VSS 0.92435f
C6499 a_n1204_3750.n19 VSS 0.77453f
C6500 a_n1204_3750.t33 VSS 0.11785f
C6501 a_n1204_3750.n20 VSS 0.92435f
C6502 a_n1204_3750.n21 VSS 0.77453f
C6503 a_n1204_3750.t34 VSS 0.11785f
C6504 a_n1204_3750.n22 VSS 0.92435f
C6505 a_n1204_3750.n23 VSS 0.77453f
C6506 a_n1204_3750.t21 VSS 0.11785f
C6507 a_n1204_3750.n24 VSS 0.92435f
C6508 a_n1204_3750.n25 VSS 0.77453f
C6509 a_n1204_3750.t22 VSS 0.11785f
C6510 a_n1204_3750.n26 VSS 0.92435f
C6511 a_n1204_3750.n27 VSS 0.77453f
C6512 a_n1204_3750.t36 VSS 0.11785f
C6513 a_n1204_3750.n28 VSS 0.92435f
C6514 a_n1204_3750.n29 VSS 0.77453f
C6515 a_n1204_3750.t8 VSS 0.11785f
C6516 a_n1204_3750.n30 VSS 0.92435f
C6517 a_n1204_3750.n31 VSS 0.60701f
C6518 a_n1204_3750.n32 VSS 0.25574f
C6519 a_n1204_3750.n33 VSS 0.12464f
C6520 a_n1204_3750.n34 VSS 0.13846f
C6521 a_n1204_3750.n35 VSS 0.23288f
C6522 a_n1204_3750.n36 VSS 0.16146f
C6523 RB2.t26 VSS 0.17349f
C6524 RB2.t3 VSS 0.10604f
C6525 RB2.n0 VSS 0.43324f
C6526 RB2.t16 VSS 0.17349f
C6527 RB2.t43 VSS 0.10604f
C6528 RB2.n1 VSS 0.21645f
C6529 RB2.n2 VSS 2.82816f
C6530 RB2.t47 VSS 0.17349f
C6531 RB2.t28 VSS 0.10604f
C6532 RB2.n3 VSS 0.21645f
C6533 RB2.n4 VSS 1.8981f
C6534 RB2.t32 VSS 0.17349f
C6535 RB2.t18 VSS 0.10604f
C6536 RB2.n5 VSS 0.21645f
C6537 RB2.n6 VSS 1.8981f
C6538 RB2.t22 VSS 0.17349f
C6539 RB2.t2 VSS 0.10604f
C6540 RB2.n7 VSS 0.21645f
C6541 RB2.n8 VSS 1.8981f
C6542 RB2.t13 VSS 0.17349f
C6543 RB2.t39 VSS 0.10604f
C6544 RB2.n9 VSS 0.21645f
C6545 RB2.n10 VSS 1.8981f
C6546 RB2.t45 VSS 0.17349f
C6547 RB2.t24 VSS 0.10604f
C6548 RB2.n11 VSS 0.21645f
C6549 RB2.n12 VSS 1.8981f
C6550 RB2.t46 VSS 0.17349f
C6551 RB2.t27 VSS 0.10604f
C6552 RB2.n13 VSS 0.21645f
C6553 RB2.n14 VSS 1.8981f
C6554 RB2.t29 VSS 0.17349f
C6555 RB2.t4 VSS 0.10604f
C6556 RB2.n15 VSS 0.21645f
C6557 RB2.n16 VSS 1.8981f
C6558 RB2.t11 VSS 0.17349f
C6559 RB2.t37 VSS 0.10604f
C6560 RB2.n17 VSS 0.21645f
C6561 RB2.n18 VSS 1.8981f
C6562 RB2.t12 VSS 0.17349f
C6563 RB2.t38 VSS 0.10604f
C6564 RB2.n19 VSS 0.21645f
C6565 RB2.n20 VSS 1.8981f
C6566 RB2.t44 VSS 0.17349f
C6567 RB2.t23 VSS 0.10604f
C6568 RB2.n21 VSS 0.21645f
C6569 RB2.n22 VSS 1.8981f
C6570 RB2.t40 VSS 0.17349f
C6571 RB2.t21 VSS 0.10604f
C6572 RB2.n23 VSS 0.21645f
C6573 RB2.n24 VSS 1.8981f
C6574 RB2.t14 VSS 0.17349f
C6575 RB2.t41 VSS 0.10604f
C6576 RB2.n25 VSS 0.21645f
C6577 RB2.n26 VSS 1.8981f
C6578 RB2.t15 VSS 0.17349f
C6579 RB2.t42 VSS 0.10604f
C6580 RB2.n27 VSS 0.21645f
C6581 RB2.n28 VSS 1.8981f
C6582 RB2.t30 VSS 0.17349f
C6583 RB2.t17 VSS 0.10604f
C6584 RB2.n29 VSS 0.21645f
C6585 RB2.n30 VSS 2.30881f
C6586 RA10.t5 VSS 0.21317f
C6587 RA10.n0 VSS 0.53858f
C6588 RA10.t38 VSS 0.21317f
C6589 RA10.n1 VSS 0.21461f
C6590 RA10.n2 VSS 3.27278f
C6591 RA10.t40 VSS 0.21317f
C6592 RA10.n3 VSS 0.21461f
C6593 RA10.n4 VSS 1.88283f
C6594 RA10.t26 VSS 0.21317f
C6595 RA10.n5 VSS 0.21461f
C6596 RA10.n6 VSS 1.88283f
C6597 RA10.t21 VSS 0.21317f
C6598 RA10.n7 VSS 0.21461f
C6599 RA10.n8 VSS 1.88283f
C6600 RA10.t36 VSS 0.21317f
C6601 RA10.n9 VSS 0.21461f
C6602 RA10.n10 VSS 1.88283f
C6603 RA10.t37 VSS 0.21317f
C6604 RA10.n11 VSS 0.21461f
C6605 RA10.n12 VSS 1.88283f
C6606 RA10.t25 VSS 0.21317f
C6607 RA10.n13 VSS 0.21461f
C6608 RA10.n14 VSS 1.88283f
C6609 RA10.t20 VSS 0.21317f
C6610 RA10.n15 VSS 0.21461f
C6611 RA10.n16 VSS 1.88283f
C6612 RA10.t3 VSS 0.21317f
C6613 RA10.n17 VSS 0.21461f
C6614 RA10.n18 VSS 1.88283f
C6615 RA10.t35 VSS 0.21317f
C6616 RA10.n19 VSS 0.21461f
C6617 RA10.n20 VSS 1.88283f
C6618 RA10.t24 VSS 0.21317f
C6619 RA10.n21 VSS 0.21461f
C6620 RA10.n22 VSS 1.88283f
C6621 RA10.t22 VSS 0.21317f
C6622 RA10.n23 VSS 0.21461f
C6623 RA10.n24 VSS 1.88283f
C6624 RA10.t6 VSS 0.21317f
C6625 RA10.n25 VSS 0.21461f
C6626 RA10.n26 VSS 1.88283f
C6627 RA10.t7 VSS 0.21317f
C6628 RA10.n27 VSS 0.21461f
C6629 RA10.n28 VSS 1.88283f
C6630 RA10.t28 VSS 0.21317f
C6631 RA10.n29 VSS 0.21461f
C6632 RA10.n30 VSS 2.0028f
C6633 RB10.t39 VSS 0.16919f
C6634 RB10.t33 VSS 0.10342f
C6635 RB10.n0 VSS 0.42251f
C6636 RB10.t31 VSS 0.16919f
C6637 RB10.t19 VSS 0.10342f
C6638 RB10.n1 VSS 0.21109f
C6639 RB10.n2 VSS 2.75815f
C6640 RB10.t11 VSS 0.16919f
C6641 RB10.t6 VSS 0.10342f
C6642 RB10.n3 VSS 0.21109f
C6643 RB10.n4 VSS 1.85112f
C6644 RB10.t46 VSS 0.16919f
C6645 RB10.t41 VSS 0.10342f
C6646 RB10.n5 VSS 0.21109f
C6647 RB10.n6 VSS 1.85112f
C6648 RB10.t37 VSS 0.16919f
C6649 RB10.t32 VSS 0.10342f
C6650 RB10.n7 VSS 0.21109f
C6651 RB10.n8 VSS 1.85112f
C6652 RB10.t28 VSS 0.16919f
C6653 RB10.t16 VSS 0.10342f
C6654 RB10.n9 VSS 0.21109f
C6655 RB10.n10 VSS 1.85112f
C6656 RB10.t9 VSS 0.16919f
C6657 RB10.t4 VSS 0.10342f
C6658 RB10.n11 VSS 0.21109f
C6659 RB10.n12 VSS 1.85112f
C6660 RB10.t10 VSS 0.16919f
C6661 RB10.t5 VSS 0.10342f
C6662 RB10.n13 VSS 0.21109f
C6663 RB10.n14 VSS 1.85112f
C6664 RB10.t42 VSS 0.16919f
C6665 RB10.t34 VSS 0.10342f
C6666 RB10.n15 VSS 0.21109f
C6667 RB10.n16 VSS 1.85112f
C6668 RB10.t26 VSS 0.16919f
C6669 RB10.t14 VSS 0.10342f
C6670 RB10.n17 VSS 0.21109f
C6671 RB10.n18 VSS 1.85112f
C6672 RB10.t27 VSS 0.16919f
C6673 RB10.t15 VSS 0.10342f
C6674 RB10.n19 VSS 0.21109f
C6675 RB10.n20 VSS 1.85112f
C6676 RB10.t8 VSS 0.16919f
C6677 RB10.t0 VSS 0.10342f
C6678 RB10.n21 VSS 0.21109f
C6679 RB10.n22 VSS 1.85112f
C6680 RB10.t7 VSS 0.16919f
C6681 RB10.t43 VSS 0.10342f
C6682 RB10.n23 VSS 0.21109f
C6683 RB10.n24 VSS 1.85112f
C6684 RB10.t29 VSS 0.16919f
C6685 RB10.t17 VSS 0.10342f
C6686 RB10.n25 VSS 0.21109f
C6687 RB10.n26 VSS 1.85112f
C6688 RB10.t30 VSS 0.16919f
C6689 RB10.t18 VSS 0.10342f
C6690 RB10.n27 VSS 0.21109f
C6691 RB10.n28 VSS 1.85112f
C6692 RB10.t44 VSS 0.16919f
C6693 RB10.t40 VSS 0.10342f
C6694 RB10.n29 VSS 0.21109f
C6695 RB10.n30 VSS 2.25202f
C6696 a_n1204_4534.t11 VSS 0.13376f
C6697 a_n1204_4534.n1 VSS 2.07431f
C6698 a_n1204_4534.t35 VSS 0.11785f
C6699 a_n1204_4534.n2 VSS 0.92435f
C6700 a_n1204_4534.n3 VSS 0.77453f
C6701 a_n1204_4534.t27 VSS 0.11785f
C6702 a_n1204_4534.n4 VSS 0.92435f
C6703 a_n1204_4534.n5 VSS 0.77453f
C6704 a_n1204_4534.t7 VSS 0.11785f
C6705 a_n1204_4534.n6 VSS 0.92435f
C6706 a_n1204_4534.n7 VSS 0.77453f
C6707 a_n1204_4534.t8 VSS 0.11785f
C6708 a_n1204_4534.n8 VSS 0.92435f
C6709 a_n1204_4534.n9 VSS 0.77453f
C6710 a_n1204_4534.t34 VSS 0.11785f
C6711 a_n1204_4534.n10 VSS 0.92435f
C6712 a_n1204_4534.n11 VSS 0.77453f
C6713 a_n1204_4534.t25 VSS 0.11785f
C6714 a_n1204_4534.n12 VSS 0.92435f
C6715 a_n1204_4534.n13 VSS 0.77453f
C6716 a_n1204_4534.t5 VSS 0.11785f
C6717 a_n1204_4534.n14 VSS 0.92435f
C6718 a_n1204_4534.n15 VSS 0.77453f
C6719 a_n1204_4534.t6 VSS 0.11785f
C6720 a_n1204_4534.n16 VSS 0.92435f
C6721 a_n1204_4534.n17 VSS 0.77453f
C6722 a_n1204_4534.t30 VSS 0.11785f
C6723 a_n1204_4534.n18 VSS 0.92435f
C6724 a_n1204_4534.n19 VSS 0.77453f
C6725 a_n1204_4534.t23 VSS 0.11785f
C6726 a_n1204_4534.n20 VSS 0.92435f
C6727 a_n1204_4534.n21 VSS 0.77453f
C6728 a_n1204_4534.t24 VSS 0.11785f
C6729 a_n1204_4534.n22 VSS 0.92435f
C6730 a_n1204_4534.n23 VSS 0.77453f
C6731 a_n1204_4534.t9 VSS 0.11785f
C6732 a_n1204_4534.n24 VSS 0.92435f
C6733 a_n1204_4534.n25 VSS 0.77453f
C6734 a_n1204_4534.t10 VSS 0.11785f
C6735 a_n1204_4534.n26 VSS 0.92435f
C6736 a_n1204_4534.n27 VSS 0.77453f
C6737 a_n1204_4534.t26 VSS 0.11785f
C6738 a_n1204_4534.n28 VSS 0.92435f
C6739 a_n1204_4534.n29 VSS 0.77453f
C6740 a_n1204_4534.t37 VSS 0.11785f
C6741 a_n1204_4534.n30 VSS 0.92435f
C6742 a_n1204_4534.n31 VSS 0.60701f
C6743 a_n1204_4534.n32 VSS 0.25574f
C6744 a_n1204_4534.n33 VSS 0.12464f
C6745 a_n1204_4534.n34 VSS 0.13846f
C6746 a_n1204_4534.n35 VSS 0.23288f
C6747 a_n1204_4534.n36 VSS 0.16146f
C6748 a_11287_n2146.n0 VSS 0.30875f
C6749 a_11287_n2146.n1 VSS 0.14431f
C6750 a_11287_n2146.n3 VSS 0.4905f
C6751 a_11287_n2146.n4 VSS 0.14431f
C6752 a_11287_n2146.n5 VSS 0.14431f
C6753 a_11287_n2146.n6 VSS 0.17149f
C6754 a_11287_n2146.n7 VSS 0.17149f
C6755 a_11287_n2146.n8 VSS 0.14431f
C6756 a_11287_n2146.n9 VSS 0.14431f
C6757 a_11287_n2146.n10 VSS 0.17149f
C6758 a_11287_n2146.n11 VSS 0.17149f
C6759 a_11287_n2146.n12 VSS 0.14431f
C6760 a_11287_n2146.n13 VSS 0.14431f
C6761 a_11287_n2146.n14 VSS 0.17149f
C6762 a_11287_n2146.n15 VSS 0.17149f
C6763 a_11287_n2146.n16 VSS 0.14431f
C6764 a_11287_n2146.n17 VSS 0.14431f
C6765 a_11287_n2146.n18 VSS 0.17149f
C6766 a_11287_n2146.n19 VSS 0.17149f
C6767 a_11287_n2146.n20 VSS 0.14431f
C6768 a_11287_n2146.n21 VSS 0.14431f
C6769 a_11287_n2146.n22 VSS 0.17149f
C6770 a_11287_n2146.n23 VSS 0.17149f
C6771 a_11287_n2146.n24 VSS 0.14431f
C6772 a_11287_n2146.n25 VSS 0.14431f
C6773 a_11287_n2146.n26 VSS 0.17149f
C6774 a_11287_n2146.n27 VSS 0.17149f
C6775 a_11287_n2146.n28 VSS 0.14431f
C6776 a_11287_n2146.n29 VSS 0.14431f
C6777 a_11287_n2146.n30 VSS 0.17149f
C6778 a_11287_n2146.n31 VSS 0.17149f
C6779 a_35737_n862.n0 VSS 0.30869f
C6780 a_35737_n862.n1 VSS 0.14432f
C6781 a_35737_n862.n2 VSS 0.17142f
C6782 a_35737_n862.n3 VSS 0.17142f
C6783 a_35737_n862.n4 VSS 0.14432f
C6784 a_35737_n862.n5 VSS 0.14432f
C6785 a_35737_n862.n6 VSS 0.17142f
C6786 a_35737_n862.n7 VSS 0.17142f
C6787 a_35737_n862.n8 VSS 0.14432f
C6788 a_35737_n862.n9 VSS 0.14432f
C6789 a_35737_n862.n10 VSS 0.17142f
C6790 a_35737_n862.n11 VSS 0.17142f
C6791 a_35737_n862.n12 VSS 0.14432f
C6792 a_35737_n862.n13 VSS 0.14432f
C6793 a_35737_n862.n15 VSS 0.48932f
C6794 a_35737_n862.n16 VSS 0.14432f
C6795 a_35737_n862.n17 VSS 0.14432f
C6796 a_35737_n862.n18 VSS 0.17142f
C6797 a_35737_n862.n19 VSS 0.17142f
C6798 a_35737_n862.n20 VSS 0.14432f
C6799 a_35737_n862.n21 VSS 0.14432f
C6800 a_35737_n862.n22 VSS 0.17142f
C6801 a_35737_n862.n23 VSS 0.17142f
C6802 a_35737_n862.n24 VSS 0.14432f
C6803 a_35737_n862.n25 VSS 0.14432f
C6804 a_35737_n862.n26 VSS 0.17142f
C6805 a_35737_n862.n27 VSS 0.17142f
C6806 a_35737_n862.n28 VSS 0.14432f
C6807 a_35737_n862.n29 VSS 0.14432f
C6808 a_35737_n862.n30 VSS 0.17142f
C6809 a_35737_n862.n31 VSS 0.17142f
C6810 a_n1204_7670.t12 VSS 0.13376f
C6811 a_n1204_7670.n1 VSS 2.07431f
C6812 a_n1204_7670.t34 VSS 0.11785f
C6813 a_n1204_7670.n2 VSS 0.92435f
C6814 a_n1204_7670.n3 VSS 0.77453f
C6815 a_n1204_7670.t26 VSS 0.11785f
C6816 a_n1204_7670.n4 VSS 0.92435f
C6817 a_n1204_7670.n5 VSS 0.77453f
C6818 a_n1204_7670.t8 VSS 0.11785f
C6819 a_n1204_7670.n6 VSS 0.92435f
C6820 a_n1204_7670.n7 VSS 0.77453f
C6821 a_n1204_7670.t9 VSS 0.11785f
C6822 a_n1204_7670.n8 VSS 0.92435f
C6823 a_n1204_7670.n9 VSS 0.77453f
C6824 a_n1204_7670.t33 VSS 0.11785f
C6825 a_n1204_7670.n10 VSS 0.92435f
C6826 a_n1204_7670.n11 VSS 0.77453f
C6827 a_n1204_7670.t24 VSS 0.11785f
C6828 a_n1204_7670.n12 VSS 0.92435f
C6829 a_n1204_7670.n13 VSS 0.77453f
C6830 a_n1204_7670.t6 VSS 0.11785f
C6831 a_n1204_7670.n14 VSS 0.92435f
C6832 a_n1204_7670.n15 VSS 0.77453f
C6833 a_n1204_7670.t7 VSS 0.11785f
C6834 a_n1204_7670.n16 VSS 0.92435f
C6835 a_n1204_7670.n17 VSS 0.77453f
C6836 a_n1204_7670.t29 VSS 0.11785f
C6837 a_n1204_7670.n18 VSS 0.92435f
C6838 a_n1204_7670.n19 VSS 0.77453f
C6839 a_n1204_7670.t22 VSS 0.11785f
C6840 a_n1204_7670.n20 VSS 0.92435f
C6841 a_n1204_7670.n21 VSS 0.77453f
C6842 a_n1204_7670.t23 VSS 0.11785f
C6843 a_n1204_7670.n22 VSS 0.92435f
C6844 a_n1204_7670.n23 VSS 0.77453f
C6845 a_n1204_7670.t10 VSS 0.11785f
C6846 a_n1204_7670.n24 VSS 0.92435f
C6847 a_n1204_7670.n25 VSS 0.77453f
C6848 a_n1204_7670.t11 VSS 0.11785f
C6849 a_n1204_7670.n26 VSS 0.92435f
C6850 a_n1204_7670.n27 VSS 0.77453f
C6851 a_n1204_7670.t25 VSS 0.11785f
C6852 a_n1204_7670.n28 VSS 0.92435f
C6853 a_n1204_7670.n29 VSS 0.77453f
C6854 a_n1204_7670.t36 VSS 0.11785f
C6855 a_n1204_7670.n30 VSS 0.92435f
C6856 a_n1204_7670.n31 VSS 0.60701f
C6857 a_n1204_7670.n32 VSS 0.25574f
C6858 a_n1204_7670.n33 VSS 0.12464f
C6859 a_n1204_7670.n34 VSS 0.13846f
C6860 a_n1204_7670.n35 VSS 0.23288f
C6861 a_n1204_7670.n36 VSS 0.16146f
C6862 WE0CLK.t6 VSS 0.10875f
C6863 WE0CLK.n1 VSS 1.68659f
C6864 WE0CLK.n2 VSS 0.75158f
C6865 WE0CLK.n3 VSS 0.62976f
C6866 WE0CLK.n4 VSS 0.75158f
C6867 WE0CLK.n5 VSS 0.62976f
C6868 WE0CLK.n6 VSS 0.75158f
C6869 WE0CLK.n7 VSS 0.62976f
C6870 WE0CLK.n8 VSS 0.75158f
C6871 WE0CLK.n9 VSS 0.62976f
C6872 WE0CLK.n10 VSS 0.75158f
C6873 WE0CLK.n11 VSS 0.62976f
C6874 WE0CLK.n12 VSS 0.75158f
C6875 WE0CLK.n13 VSS 0.62976f
C6876 WE0CLK.n14 VSS 0.75158f
C6877 WE0CLK.n15 VSS 0.62976f
C6878 WE0CLK.n16 VSS 0.75158f
C6879 WE0CLK.n17 VSS 0.62976f
C6880 WE0CLK.n18 VSS 0.75158f
C6881 WE0CLK.n19 VSS 0.62976f
C6882 WE0CLK.n20 VSS 0.75158f
C6883 WE0CLK.n21 VSS 0.62976f
C6884 WE0CLK.n22 VSS 0.75158f
C6885 WE0CLK.n23 VSS 0.62976f
C6886 WE0CLK.n24 VSS 0.75158f
C6887 WE0CLK.n25 VSS 0.62976f
C6888 WE0CLK.n26 VSS 0.75158f
C6889 WE0CLK.n27 VSS 0.62976f
C6890 WE0CLK.n28 VSS 0.75158f
C6891 WE0CLK.n29 VSS 0.62976f
C6892 WE0CLK.n30 VSS 0.75158f
C6893 WE0CLK.n31 VSS 0.49355f
C6894 WE0CLK.n32 VSS 0.20794f
C6895 WE0CLK.n33 VSS 0.10134f
C6896 WE0CLK.n34 VSS 0.11258f
C6897 WE0CLK.n35 VSS 0.13128f
C6898 a_n360_n708.n3 VSS 0.27913f
C6899 a_n360_n708.n5 VSS 0.14634f
C6900 a_n360_n708.n7 VSS 0.14634f
C6901 a_n360_n708.n9 VSS 0.14634f
C6902 a_n360_n708.n11 VSS 0.14634f
C6903 a_n360_n708.n13 VSS 0.14634f
C6904 a_n360_n708.n15 VSS 0.14634f
C6905 a_n360_n708.n17 VSS 0.14634f
C6906 a_n360_n708.n19 VSS 0.14634f
C6907 a_n360_n708.n21 VSS 0.14634f
C6908 a_n360_n708.n23 VSS 0.14634f
C6909 a_n360_n708.n25 VSS 0.14634f
C6910 a_n360_n708.n27 VSS 0.14634f
C6911 a_n360_n708.n29 VSS 0.14634f
C6912 a_n360_n708.n31 VSS 0.19132f
C6913 a_33265_n862.n0 VSS 0.30869f
C6914 a_33265_n862.n1 VSS 0.14432f
C6915 a_33265_n862.n2 VSS 0.17142f
C6916 a_33265_n862.n3 VSS 0.17142f
C6917 a_33265_n862.n4 VSS 0.14432f
C6918 a_33265_n862.n5 VSS 0.14432f
C6919 a_33265_n862.n6 VSS 0.17142f
C6920 a_33265_n862.n7 VSS 0.17142f
C6921 a_33265_n862.n8 VSS 0.14432f
C6922 a_33265_n862.n9 VSS 0.14432f
C6923 a_33265_n862.n10 VSS 0.17142f
C6924 a_33265_n862.n11 VSS 0.17142f
C6925 a_33265_n862.n12 VSS 0.14432f
C6926 a_33265_n862.n13 VSS 0.14432f
C6927 a_33265_n862.n15 VSS 0.48932f
C6928 a_33265_n862.n16 VSS 0.14432f
C6929 a_33265_n862.n17 VSS 0.14432f
C6930 a_33265_n862.n18 VSS 0.17142f
C6931 a_33265_n862.n19 VSS 0.17142f
C6932 a_33265_n862.n20 VSS 0.14432f
C6933 a_33265_n862.n21 VSS 0.14432f
C6934 a_33265_n862.n22 VSS 0.17142f
C6935 a_33265_n862.n23 VSS 0.17142f
C6936 a_33265_n862.n24 VSS 0.14432f
C6937 a_33265_n862.n25 VSS 0.14432f
C6938 a_33265_n862.n26 VSS 0.17142f
C6939 a_33265_n862.n27 VSS 0.17142f
C6940 a_33265_n862.n28 VSS 0.14432f
C6941 a_33265_n862.n29 VSS 0.14432f
C6942 a_33265_n862.n30 VSS 0.17142f
C6943 a_33265_n862.n31 VSS 0.17142f
C6944 RB5.t27 VSS 0.10604f
C6945 RB5.t41 VSS 0.17349f
C6946 RB5.n0 VSS 0.43324f
C6947 RB5.t17 VSS 0.10604f
C6948 RB5.t34 VSS 0.17349f
C6949 RB5.n1 VSS 0.21645f
C6950 RB5.n2 VSS 2.82816f
C6951 RB5.t47 VSS 0.10604f
C6952 RB5.t15 VSS 0.17349f
C6953 RB5.n3 VSS 0.21645f
C6954 RB5.n4 VSS 1.8981f
C6955 RB5.t37 VSS 0.10604f
C6956 RB5.t2 VSS 0.17349f
C6957 RB5.n5 VSS 0.21645f
C6958 RB5.n6 VSS 1.8981f
C6959 RB5.t23 VSS 0.10604f
C6960 RB5.t39 VSS 0.17349f
C6961 RB5.n7 VSS 0.21645f
C6962 RB5.n8 VSS 1.8981f
C6963 RB5.t13 VSS 0.10604f
C6964 RB5.t31 VSS 0.17349f
C6965 RB5.n9 VSS 0.21645f
C6966 RB5.n10 VSS 1.8981f
C6967 RB5.t45 VSS 0.10604f
C6968 RB5.t11 VSS 0.17349f
C6969 RB5.n11 VSS 0.21645f
C6970 RB5.n12 VSS 1.8981f
C6971 RB5.t46 VSS 0.10604f
C6972 RB5.t12 VSS 0.17349f
C6973 RB5.n13 VSS 0.21645f
C6974 RB5.n14 VSS 1.8981f
C6975 RB5.t30 VSS 0.10604f
C6976 RB5.t43 VSS 0.17349f
C6977 RB5.n15 VSS 0.21645f
C6978 RB5.n16 VSS 1.8981f
C6979 RB5.t9 VSS 0.10604f
C6980 RB5.t28 VSS 0.17349f
C6981 RB5.n17 VSS 0.21645f
C6982 RB5.n18 VSS 1.8981f
C6983 RB5.t10 VSS 0.10604f
C6984 RB5.t29 VSS 0.17349f
C6985 RB5.n19 VSS 0.21645f
C6986 RB5.n20 VSS 1.8981f
C6987 RB5.t44 VSS 0.10604f
C6988 RB5.t8 VSS 0.17349f
C6989 RB5.n21 VSS 0.21645f
C6990 RB5.n22 VSS 1.8981f
C6991 RB5.t42 VSS 0.10604f
C6992 RB5.t7 VSS 0.17349f
C6993 RB5.n23 VSS 0.21645f
C6994 RB5.n24 VSS 1.8981f
C6995 RB5.t14 VSS 0.10604f
C6996 RB5.t32 VSS 0.17349f
C6997 RB5.n25 VSS 0.21645f
C6998 RB5.n26 VSS 1.8981f
C6999 RB5.t16 VSS 0.10604f
C7000 RB5.t33 VSS 0.17349f
C7001 RB5.n27 VSS 0.21645f
C7002 RB5.n28 VSS 1.8981f
C7003 RB5.t35 VSS 0.10604f
C7004 RB5.t0 VSS 0.17349f
C7005 RB5.n29 VSS 0.21645f
C7006 RB5.n30 VSS 2.30954f
C7007 RA2.t43 VSS 0.21849f
C7008 RA2.n0 VSS 0.55201f
C7009 RA2.t28 VSS 0.21849f
C7010 RA2.n1 VSS 0.21996f
C7011 RA2.n2 VSS 3.35439f
C7012 RA2.t30 VSS 0.21849f
C7013 RA2.n3 VSS 0.21996f
C7014 RA2.n4 VSS 1.92978f
C7015 RA2.t17 VSS 0.21849f
C7016 RA2.n5 VSS 0.21996f
C7017 RA2.n6 VSS 1.92978f
C7018 RA2.t9 VSS 0.21849f
C7019 RA2.n7 VSS 0.21996f
C7020 RA2.n8 VSS 1.92978f
C7021 RA2.t26 VSS 0.21849f
C7022 RA2.n9 VSS 0.21996f
C7023 RA2.n10 VSS 1.92978f
C7024 RA2.t27 VSS 0.21849f
C7025 RA2.n11 VSS 0.21996f
C7026 RA2.n12 VSS 1.92978f
C7027 RA2.t16 VSS 0.21849f
C7028 RA2.n13 VSS 0.21996f
C7029 RA2.n14 VSS 1.92978f
C7030 RA2.t7 VSS 0.21849f
C7031 RA2.n15 VSS 0.21996f
C7032 RA2.n16 VSS 1.92978f
C7033 RA2.t40 VSS 0.21849f
C7034 RA2.n17 VSS 0.21996f
C7035 RA2.n18 VSS 1.92978f
C7036 RA2.t25 VSS 0.21849f
C7037 RA2.n19 VSS 0.21996f
C7038 RA2.n20 VSS 1.92978f
C7039 RA2.t15 VSS 0.21849f
C7040 RA2.n21 VSS 0.21996f
C7041 RA2.n22 VSS 1.92978f
C7042 RA2.t11 VSS 0.21849f
C7043 RA2.n23 VSS 0.21996f
C7044 RA2.n24 VSS 1.92978f
C7045 RA2.t44 VSS 0.21849f
C7046 RA2.n25 VSS 0.21996f
C7047 RA2.n26 VSS 1.92978f
C7048 RA2.t46 VSS 0.21849f
C7049 RA2.n27 VSS 0.21996f
C7050 RA2.n28 VSS 1.92978f
C7051 RA2.t19 VSS 0.21849f
C7052 RA2.n29 VSS 0.21996f
C7053 RA2.n30 VSS 2.05052f
C7054 a_n884_10806.t13 VSS 0.14829f
C7055 a_n884_10806.n1 VSS 2.19422f
C7056 a_n884_10806.t30 VSS 0.12129f
C7057 a_n884_10806.n2 VSS 0.99541f
C7058 a_n884_10806.n3 VSS 0.8403f
C7059 a_n884_10806.t18 VSS 0.12129f
C7060 a_n884_10806.n4 VSS 0.99541f
C7061 a_n884_10806.n5 VSS 0.8403f
C7062 a_n884_10806.t31 VSS 0.12129f
C7063 a_n884_10806.n6 VSS 0.99541f
C7064 a_n884_10806.n7 VSS 0.8403f
C7065 a_n884_10806.t8 VSS 0.12129f
C7066 a_n884_10806.n8 VSS 0.99541f
C7067 a_n884_10806.n9 VSS 0.8403f
C7068 a_n884_10806.t26 VSS 0.12129f
C7069 a_n884_10806.n10 VSS 0.99541f
C7070 a_n884_10806.n11 VSS 0.8403f
C7071 a_n884_10806.t15 VSS 0.12129f
C7072 a_n884_10806.n12 VSS 0.99541f
C7073 a_n884_10806.n13 VSS 0.8403f
C7074 a_n884_10806.t27 VSS 0.12129f
C7075 a_n884_10806.n14 VSS 0.99541f
C7076 a_n884_10806.n15 VSS 0.8403f
C7077 a_n884_10806.t34 VSS 0.12129f
C7078 a_n884_10806.n16 VSS 0.99541f
C7079 a_n884_10806.n17 VSS 0.8403f
C7080 a_n884_10806.t22 VSS 0.12129f
C7081 a_n884_10806.n18 VSS 0.99541f
C7082 a_n884_10806.n19 VSS 0.8403f
C7083 a_n884_10806.t9 VSS 0.12129f
C7084 a_n884_10806.n20 VSS 0.99541f
C7085 a_n884_10806.n21 VSS 0.8403f
C7086 a_n884_10806.t23 VSS 0.12129f
C7087 a_n884_10806.n22 VSS 0.99541f
C7088 a_n884_10806.n23 VSS 0.8403f
C7089 a_n884_10806.t5 VSS 0.12129f
C7090 a_n884_10806.n24 VSS 0.99541f
C7091 a_n884_10806.n25 VSS 0.8403f
C7092 a_n884_10806.t19 VSS 0.12129f
C7093 a_n884_10806.n26 VSS 0.99541f
C7094 a_n884_10806.n27 VSS 0.8403f
C7095 a_n884_10806.t14 VSS 0.12129f
C7096 a_n884_10806.n28 VSS 0.99541f
C7097 a_n884_10806.n29 VSS 0.8403f
C7098 a_n884_10806.t29 VSS 0.12129f
C7099 a_n884_10806.n30 VSS 0.99541f
C7100 a_n884_10806.n31 VSS 0.67354f
C7101 a_n884_10806.n32 VSS 0.35884f
C7102 a_n884_10806.n33 VSS 0.16325f
C7103 a_6073_n862.n0 VSS 0.30869f
C7104 a_6073_n862.n1 VSS 0.14432f
C7105 a_6073_n862.n2 VSS 0.17142f
C7106 a_6073_n862.n4 VSS 0.48932f
C7107 a_6073_n862.n5 VSS 0.14432f
C7108 a_6073_n862.n6 VSS 0.14432f
C7109 a_6073_n862.n7 VSS 0.17142f
C7110 a_6073_n862.n8 VSS 0.17142f
C7111 a_6073_n862.n9 VSS 0.14432f
C7112 a_6073_n862.n10 VSS 0.14432f
C7113 a_6073_n862.n11 VSS 0.17142f
C7114 a_6073_n862.n12 VSS 0.17142f
C7115 a_6073_n862.n13 VSS 0.14432f
C7116 a_6073_n862.n14 VSS 0.14432f
C7117 a_6073_n862.n15 VSS 0.17142f
C7118 a_6073_n862.n16 VSS 0.17142f
C7119 a_6073_n862.n17 VSS 0.14432f
C7120 a_6073_n862.n18 VSS 0.14432f
C7121 a_6073_n862.n19 VSS 0.17142f
C7122 a_6073_n862.n20 VSS 0.17142f
C7123 a_6073_n862.n21 VSS 0.14432f
C7124 a_6073_n862.n22 VSS 0.14432f
C7125 a_6073_n862.n23 VSS 0.17142f
C7126 a_6073_n862.n24 VSS 0.17142f
C7127 a_6073_n862.n25 VSS 0.14432f
C7128 a_6073_n862.n26 VSS 0.14432f
C7129 a_6073_n862.n27 VSS 0.17142f
C7130 a_6073_n862.n28 VSS 0.17142f
C7131 a_6073_n862.n29 VSS 0.14432f
C7132 a_6073_n862.n30 VSS 0.14432f
C7133 a_6073_n862.n31 VSS 0.17142f
C7134 a_n1204_1398.t16 VSS 0.13376f
C7135 a_n1204_1398.n1 VSS 2.07431f
C7136 a_n1204_1398.t4 VSS 0.11785f
C7137 a_n1204_1398.n2 VSS 0.92435f
C7138 a_n1204_1398.n3 VSS 0.77453f
C7139 a_n1204_1398.t32 VSS 0.11785f
C7140 a_n1204_1398.n4 VSS 0.92435f
C7141 a_n1204_1398.n5 VSS 0.77453f
C7142 a_n1204_1398.t12 VSS 0.11785f
C7143 a_n1204_1398.n6 VSS 0.92435f
C7144 a_n1204_1398.n7 VSS 0.77453f
C7145 a_n1204_1398.t13 VSS 0.11785f
C7146 a_n1204_1398.n8 VSS 0.92435f
C7147 a_n1204_1398.n9 VSS 0.77453f
C7148 a_n1204_1398.t38 VSS 0.11785f
C7149 a_n1204_1398.n10 VSS 0.92435f
C7150 a_n1204_1398.n11 VSS 0.77453f
C7151 a_n1204_1398.t30 VSS 0.11785f
C7152 a_n1204_1398.n12 VSS 0.92435f
C7153 a_n1204_1398.n13 VSS 0.77453f
C7154 a_n1204_1398.t10 VSS 0.11785f
C7155 a_n1204_1398.n14 VSS 0.92435f
C7156 a_n1204_1398.n15 VSS 0.77453f
C7157 a_n1204_1398.t11 VSS 0.11785f
C7158 a_n1204_1398.n16 VSS 0.92435f
C7159 a_n1204_1398.n17 VSS 0.77453f
C7160 a_n1204_1398.t35 VSS 0.11785f
C7161 a_n1204_1398.n18 VSS 0.92435f
C7162 a_n1204_1398.n19 VSS 0.77453f
C7163 a_n1204_1398.t27 VSS 0.11785f
C7164 a_n1204_1398.n20 VSS 0.92435f
C7165 a_n1204_1398.n21 VSS 0.77453f
C7166 a_n1204_1398.t29 VSS 0.11785f
C7167 a_n1204_1398.n22 VSS 0.92435f
C7168 a_n1204_1398.n23 VSS 0.77453f
C7169 a_n1204_1398.t14 VSS 0.11785f
C7170 a_n1204_1398.n24 VSS 0.92435f
C7171 a_n1204_1398.n25 VSS 0.77453f
C7172 a_n1204_1398.t15 VSS 0.11785f
C7173 a_n1204_1398.n26 VSS 0.92435f
C7174 a_n1204_1398.n27 VSS 0.77453f
C7175 a_n1204_1398.t31 VSS 0.11785f
C7176 a_n1204_1398.n28 VSS 0.92435f
C7177 a_n1204_1398.n29 VSS 0.77453f
C7178 a_n1204_1398.t6 VSS 0.11785f
C7179 a_n1204_1398.n30 VSS 0.92435f
C7180 a_n1204_1398.n31 VSS 0.60701f
C7181 a_n1204_1398.n32 VSS 0.25574f
C7182 a_n1204_1398.n33 VSS 0.12464f
C7183 a_n1204_1398.n34 VSS 0.13846f
C7184 a_n1204_1398.n35 VSS 0.23288f
C7185 a_n1204_1398.n36 VSS 0.16146f
C7186 RA3.t27 VSS 0.21849f
C7187 RA3.n0 VSS 0.55201f
C7188 RA3.t12 VSS 0.21849f
C7189 RA3.n1 VSS 0.21996f
C7190 RA3.n2 VSS 3.35439f
C7191 RA3.t14 VSS 0.21849f
C7192 RA3.n3 VSS 0.21996f
C7193 RA3.n4 VSS 1.92978f
C7194 RA3.t0 VSS 0.21849f
C7195 RA3.n5 VSS 0.21996f
C7196 RA3.n6 VSS 1.92978f
C7197 RA3.t42 VSS 0.21849f
C7198 RA3.n7 VSS 0.21996f
C7199 RA3.n8 VSS 1.92978f
C7200 RA3.t10 VSS 0.21849f
C7201 RA3.n9 VSS 0.21996f
C7202 RA3.n10 VSS 1.92978f
C7203 RA3.t11 VSS 0.21849f
C7204 RA3.n11 VSS 0.21996f
C7205 RA3.n12 VSS 1.92978f
C7206 RA3.t46 VSS 0.21849f
C7207 RA3.n13 VSS 0.21996f
C7208 RA3.n14 VSS 1.92978f
C7209 RA3.t40 VSS 0.21849f
C7210 RA3.n15 VSS 0.21996f
C7211 RA3.n16 VSS 1.92978f
C7212 RA3.t25 VSS 0.21849f
C7213 RA3.n17 VSS 0.21996f
C7214 RA3.n18 VSS 1.92978f
C7215 RA3.t9 VSS 0.21849f
C7216 RA3.n19 VSS 0.21996f
C7217 RA3.n20 VSS 1.92978f
C7218 RA3.t45 VSS 0.21849f
C7219 RA3.n21 VSS 0.21996f
C7220 RA3.n22 VSS 1.92978f
C7221 RA3.t44 VSS 0.21849f
C7222 RA3.n23 VSS 0.21996f
C7223 RA3.n24 VSS 1.92978f
C7224 RA3.t28 VSS 0.21849f
C7225 RA3.n25 VSS 0.21996f
C7226 RA3.n26 VSS 1.92978f
C7227 RA3.t29 VSS 0.21849f
C7228 RA3.n27 VSS 0.21996f
C7229 RA3.n28 VSS 1.92978f
C7230 RA3.t2 VSS 0.21849f
C7231 RA3.n29 VSS 0.21996f
C7232 RA3.n30 VSS 2.05163f
C7233 RB12.t23 VSS 0.17349f
C7234 RB12.t17 VSS 0.10604f
C7235 RB12.n0 VSS 0.43324f
C7236 RB12.t15 VSS 0.17349f
C7237 RB12.t3 VSS 0.10604f
C7238 RB12.n1 VSS 0.21645f
C7239 RB12.n2 VSS 2.82816f
C7240 RB12.t43 VSS 0.17349f
C7241 RB12.t38 VSS 0.10604f
C7242 RB12.n3 VSS 0.21645f
C7243 RB12.n4 VSS 1.8981f
C7244 RB12.t30 VSS 0.17349f
C7245 RB12.t25 VSS 0.10604f
C7246 RB12.n5 VSS 0.21645f
C7247 RB12.n6 VSS 1.8981f
C7248 RB12.t21 VSS 0.17349f
C7249 RB12.t16 VSS 0.10604f
C7250 RB12.n7 VSS 0.21645f
C7251 RB12.n8 VSS 1.8981f
C7252 RB12.t12 VSS 0.17349f
C7253 RB12.t0 VSS 0.10604f
C7254 RB12.n9 VSS 0.21645f
C7255 RB12.n10 VSS 1.8981f
C7256 RB12.t41 VSS 0.17349f
C7257 RB12.t35 VSS 0.10604f
C7258 RB12.n11 VSS 0.21645f
C7259 RB12.n12 VSS 1.8981f
C7260 RB12.t42 VSS 0.17349f
C7261 RB12.t37 VSS 0.10604f
C7262 RB12.n13 VSS 0.21645f
C7263 RB12.n14 VSS 1.8981f
C7264 RB12.t26 VSS 0.17349f
C7265 RB12.t18 VSS 0.10604f
C7266 RB12.n15 VSS 0.21645f
C7267 RB12.n16 VSS 1.8981f
C7268 RB12.t10 VSS 0.17349f
C7269 RB12.t46 VSS 0.10604f
C7270 RB12.n17 VSS 0.21645f
C7271 RB12.n18 VSS 1.8981f
C7272 RB12.t11 VSS 0.17349f
C7273 RB12.t47 VSS 0.10604f
C7274 RB12.n19 VSS 0.21645f
C7275 RB12.n20 VSS 1.8981f
C7276 RB12.t40 VSS 0.17349f
C7277 RB12.t32 VSS 0.10604f
C7278 RB12.n21 VSS 0.21645f
C7279 RB12.n22 VSS 1.8981f
C7280 RB12.t39 VSS 0.17349f
C7281 RB12.t27 VSS 0.10604f
C7282 RB12.n23 VSS 0.21645f
C7283 RB12.n24 VSS 1.8981f
C7284 RB12.t13 VSS 0.17349f
C7285 RB12.t1 VSS 0.10604f
C7286 RB12.n25 VSS 0.21645f
C7287 RB12.n26 VSS 1.8981f
C7288 RB12.t14 VSS 0.17349f
C7289 RB12.t2 VSS 0.10604f
C7290 RB12.n27 VSS 0.21645f
C7291 RB12.n28 VSS 1.8981f
C7292 RB12.t28 VSS 0.17349f
C7293 RB12.t24 VSS 0.10604f
C7294 RB12.n29 VSS 0.21645f
C7295 RB12.n30 VSS 2.31028f
C7296 a_29304_n708.n3 VSS 0.26552f
C7297 a_29304_n708.n5 VSS 0.1392f
C7298 a_29304_n708.n7 VSS 0.1392f
C7299 a_29304_n708.n9 VSS 0.1392f
C7300 a_29304_n708.n11 VSS 0.1392f
C7301 a_29304_n708.n13 VSS 0.1392f
C7302 a_29304_n708.n15 VSS 0.1392f
C7303 a_29304_n708.n17 VSS 0.1392f
C7304 a_29304_n708.n19 VSS 0.1392f
C7305 a_29304_n708.n21 VSS 0.1392f
C7306 a_29304_n708.n23 VSS 0.1392f
C7307 a_29304_n708.n25 VSS 0.1392f
C7308 a_29304_n708.n27 VSS 0.1392f
C7309 a_29304_n708.n29 VSS 0.1392f
C7310 a_29304_n708.n31 VSS 0.18199f
C7311 RB15.t27 VSS 0.1063f
C7312 RB15.t23 VSS 0.17392f
C7313 RB15.n0 VSS 0.43431f
C7314 RB15.t20 VSS 0.1063f
C7315 RB15.t12 VSS 0.17392f
C7316 RB15.n1 VSS 0.21699f
C7317 RB15.n2 VSS 2.83516f
C7318 RB15.t0 VSS 0.1063f
C7319 RB15.t41 VSS 0.17392f
C7320 RB15.n3 VSS 0.21699f
C7321 RB15.n4 VSS 1.9028f
C7322 RB15.t37 VSS 0.1063f
C7323 RB15.t29 VSS 0.17392f
C7324 RB15.n5 VSS 0.21699f
C7325 RB15.n6 VSS 1.9028f
C7326 RB15.t25 VSS 0.1063f
C7327 RB15.t21 VSS 0.17392f
C7328 RB15.n7 VSS 0.21699f
C7329 RB15.n8 VSS 1.9028f
C7330 RB15.t16 VSS 0.1063f
C7331 RB15.t9 VSS 0.17392f
C7332 RB15.n9 VSS 0.21699f
C7333 RB15.n10 VSS 1.9028f
C7334 RB15.t46 VSS 0.1063f
C7335 RB15.t39 VSS 0.17392f
C7336 RB15.n11 VSS 0.21699f
C7337 RB15.n12 VSS 1.9028f
C7338 RB15.t47 VSS 0.1063f
C7339 RB15.t40 VSS 0.17392f
C7340 RB15.n13 VSS 0.21699f
C7341 RB15.n14 VSS 1.9028f
C7342 RB15.t31 VSS 0.1063f
C7343 RB15.t24 VSS 0.17392f
C7344 RB15.n15 VSS 0.21699f
C7345 RB15.n16 VSS 1.9028f
C7346 RB15.t14 VSS 0.1063f
C7347 RB15.t7 VSS 0.17392f
C7348 RB15.n17 VSS 0.21699f
C7349 RB15.n18 VSS 1.9028f
C7350 RB15.t15 VSS 0.1063f
C7351 RB15.t8 VSS 0.17392f
C7352 RB15.n19 VSS 0.21699f
C7353 RB15.n20 VSS 1.9028f
C7354 RB15.t45 VSS 0.1063f
C7355 RB15.t38 VSS 0.17392f
C7356 RB15.n21 VSS 0.21699f
C7357 RB15.n22 VSS 1.9028f
C7358 RB15.t44 VSS 0.1063f
C7359 RB15.t35 VSS 0.17392f
C7360 RB15.n23 VSS 0.21699f
C7361 RB15.n24 VSS 1.9028f
C7362 RB15.t18 VSS 0.1063f
C7363 RB15.t10 VSS 0.17392f
C7364 RB15.n25 VSS 0.21699f
C7365 RB15.n26 VSS 1.9028f
C7366 RB15.t19 VSS 0.1063f
C7367 RB15.t11 VSS 0.17392f
C7368 RB15.n27 VSS 0.21699f
C7369 RB15.n28 VSS 1.9028f
C7370 RB15.t36 VSS 0.1063f
C7371 RB15.t26 VSS 0.17392f
C7372 RB15.n29 VSS 0.21699f
C7373 RB15.n30 VSS 2.31599f
C7374 a_8815_n2146.n0 VSS 0.30875f
C7375 a_8815_n2146.n1 VSS 0.14431f
C7376 a_8815_n2146.n2 VSS 0.17149f
C7377 a_8815_n2146.n3 VSS 0.17149f
C7378 a_8815_n2146.n4 VSS 0.14431f
C7379 a_8815_n2146.n5 VSS 0.14431f
C7380 a_8815_n2146.n6 VSS 0.17149f
C7381 a_8815_n2146.n7 VSS 0.17149f
C7382 a_8815_n2146.n8 VSS 0.14431f
C7383 a_8815_n2146.n9 VSS 0.14431f
C7384 a_8815_n2146.n11 VSS 0.4905f
C7385 a_8815_n2146.n12 VSS 0.14431f
C7386 a_8815_n2146.n13 VSS 0.14431f
C7387 a_8815_n2146.n14 VSS 0.17149f
C7388 a_8815_n2146.n15 VSS 0.17149f
C7389 a_8815_n2146.n16 VSS 0.14431f
C7390 a_8815_n2146.n17 VSS 0.14431f
C7391 a_8815_n2146.n18 VSS 0.17149f
C7392 a_8815_n2146.n19 VSS 0.17149f
C7393 a_8815_n2146.n20 VSS 0.14431f
C7394 a_8815_n2146.n21 VSS 0.14431f
C7395 a_8815_n2146.n22 VSS 0.17149f
C7396 a_8815_n2146.n23 VSS 0.17149f
C7397 a_8815_n2146.n24 VSS 0.14431f
C7398 a_8815_n2146.n25 VSS 0.14431f
C7399 a_8815_n2146.n26 VSS 0.17149f
C7400 a_8815_n2146.n27 VSS 0.17149f
C7401 a_8815_n2146.n28 VSS 0.14431f
C7402 a_8815_n2146.n29 VSS 0.14431f
C7403 a_8815_n2146.n30 VSS 0.17149f
C7404 a_8815_n2146.n31 VSS 0.17149f
C7405 a_n884_6886.t16 VSS 0.14829f
C7406 a_n884_6886.n1 VSS 2.19422f
C7407 a_n884_6886.t34 VSS 0.12129f
C7408 a_n884_6886.n2 VSS 0.99541f
C7409 a_n884_6886.n3 VSS 0.8403f
C7410 a_n884_6886.t29 VSS 0.12129f
C7411 a_n884_6886.n4 VSS 0.99541f
C7412 a_n884_6886.n5 VSS 0.8403f
C7413 a_n884_6886.t9 VSS 0.12129f
C7414 a_n884_6886.n6 VSS 0.99541f
C7415 a_n884_6886.n7 VSS 0.8403f
C7416 a_n884_6886.t11 VSS 0.12129f
C7417 a_n884_6886.n8 VSS 0.99541f
C7418 a_n884_6886.n9 VSS 0.8403f
C7419 a_n884_6886.t32 VSS 0.12129f
C7420 a_n884_6886.n10 VSS 0.99541f
C7421 a_n884_6886.n11 VSS 0.8403f
C7422 a_n884_6886.t24 VSS 0.12129f
C7423 a_n884_6886.n12 VSS 0.99541f
C7424 a_n884_6886.n13 VSS 0.8403f
C7425 a_n884_6886.t5 VSS 0.12129f
C7426 a_n884_6886.n14 VSS 0.99541f
C7427 a_n884_6886.n15 VSS 0.8403f
C7428 a_n884_6886.t7 VSS 0.12129f
C7429 a_n884_6886.n16 VSS 0.99541f
C7430 a_n884_6886.n17 VSS 0.8403f
C7431 a_n884_6886.t31 VSS 0.12129f
C7432 a_n884_6886.n18 VSS 0.99541f
C7433 a_n884_6886.n19 VSS 0.8403f
C7434 a_n884_6886.t20 VSS 0.12129f
C7435 a_n884_6886.n20 VSS 0.99541f
C7436 a_n884_6886.n21 VSS 0.8403f
C7437 a_n884_6886.t22 VSS 0.12129f
C7438 a_n884_6886.n22 VSS 0.99541f
C7439 a_n884_6886.n23 VSS 0.8403f
C7440 a_n884_6886.t13 VSS 0.12129f
C7441 a_n884_6886.n24 VSS 0.99541f
C7442 a_n884_6886.n25 VSS 0.8403f
C7443 a_n884_6886.t15 VSS 0.12129f
C7444 a_n884_6886.n26 VSS 0.99541f
C7445 a_n884_6886.n27 VSS 0.8403f
C7446 a_n884_6886.t27 VSS 0.12129f
C7447 a_n884_6886.n28 VSS 0.99541f
C7448 a_n884_6886.n29 VSS 0.8403f
C7449 a_n884_6886.t4 VSS 0.12129f
C7450 a_n884_6886.n30 VSS 0.99541f
C7451 a_n884_6886.n31 VSS 0.67354f
C7452 a_n884_6886.n32 VSS 0.35884f
C7453 a_n884_6886.n33 VSS 0.16325f
C7454 RB8.t7 VSS 0.17349f
C7455 RB8.t2 VSS 0.10604f
C7456 RB8.n0 VSS 0.43324f
C7457 RB8.t47 VSS 0.17349f
C7458 RB8.t38 VSS 0.10604f
C7459 RB8.n1 VSS 0.21645f
C7460 RB8.n2 VSS 2.82816f
C7461 RB8.t27 VSS 0.17349f
C7462 RB8.t22 VSS 0.10604f
C7463 RB8.n3 VSS 0.21645f
C7464 RB8.n4 VSS 1.8981f
C7465 RB8.t13 VSS 0.17349f
C7466 RB8.t10 VSS 0.10604f
C7467 RB8.n5 VSS 0.21645f
C7468 RB8.n6 VSS 1.8981f
C7469 RB8.t5 VSS 0.17349f
C7470 RB8.t0 VSS 0.10604f
C7471 RB8.n7 VSS 0.21645f
C7472 RB8.n8 VSS 1.8981f
C7473 RB8.t44 VSS 0.17349f
C7474 RB8.t33 VSS 0.10604f
C7475 RB8.n9 VSS 0.21645f
C7476 RB8.n10 VSS 1.8981f
C7477 RB8.t25 VSS 0.17349f
C7478 RB8.t20 VSS 0.10604f
C7479 RB8.n11 VSS 0.21645f
C7480 RB8.n12 VSS 1.8981f
C7481 RB8.t26 VSS 0.17349f
C7482 RB8.t21 VSS 0.10604f
C7483 RB8.n13 VSS 0.21645f
C7484 RB8.n14 VSS 1.8981f
C7485 RB8.t8 VSS 0.17349f
C7486 RB8.t4 VSS 0.10604f
C7487 RB8.n15 VSS 0.21645f
C7488 RB8.n16 VSS 1.8981f
C7489 RB8.t42 VSS 0.17349f
C7490 RB8.t30 VSS 0.10604f
C7491 RB8.n17 VSS 0.21645f
C7492 RB8.n18 VSS 1.8981f
C7493 RB8.t43 VSS 0.17349f
C7494 RB8.t31 VSS 0.10604f
C7495 RB8.n19 VSS 0.21645f
C7496 RB8.n20 VSS 1.8981f
C7497 RB8.t24 VSS 0.17349f
C7498 RB8.t19 VSS 0.10604f
C7499 RB8.n21 VSS 0.21645f
C7500 RB8.n22 VSS 1.8981f
C7501 RB8.t23 VSS 0.17349f
C7502 RB8.t15 VSS 0.10604f
C7503 RB8.n23 VSS 0.21645f
C7504 RB8.n24 VSS 1.8981f
C7505 RB8.t45 VSS 0.17349f
C7506 RB8.t34 VSS 0.10604f
C7507 RB8.n25 VSS 0.21645f
C7508 RB8.n26 VSS 1.8981f
C7509 RB8.t46 VSS 0.17349f
C7510 RB8.t36 VSS 0.10604f
C7511 RB8.n27 VSS 0.21645f
C7512 RB8.n28 VSS 1.8981f
C7513 RB8.t11 VSS 0.17349f
C7514 RB8.t9 VSS 0.10604f
C7515 RB8.n29 VSS 0.21645f
C7516 RB8.n30 VSS 2.30881f
C7517 RB4.t7 VSS 0.17349f
C7518 RB4.t1 VSS 0.10604f
C7519 RB4.n0 VSS 0.43324f
C7520 RB4.t47 VSS 0.17349f
C7521 RB4.t35 VSS 0.10604f
C7522 RB4.n1 VSS 0.21645f
C7523 RB4.n2 VSS 2.82816f
C7524 RB4.t27 VSS 0.17349f
C7525 RB4.t22 VSS 0.10604f
C7526 RB4.n3 VSS 0.21645f
C7527 RB4.n4 VSS 1.8981f
C7528 RB4.t14 VSS 0.17349f
C7529 RB4.t9 VSS 0.10604f
C7530 RB4.n5 VSS 0.21645f
C7531 RB4.n6 VSS 1.8981f
C7532 RB4.t5 VSS 0.17349f
C7533 RB4.t0 VSS 0.10604f
C7534 RB4.n7 VSS 0.21645f
C7535 RB4.n8 VSS 1.8981f
C7536 RB4.t44 VSS 0.17349f
C7537 RB4.t32 VSS 0.10604f
C7538 RB4.n9 VSS 0.21645f
C7539 RB4.n10 VSS 1.8981f
C7540 RB4.t25 VSS 0.17349f
C7541 RB4.t20 VSS 0.10604f
C7542 RB4.n11 VSS 0.21645f
C7543 RB4.n12 VSS 1.8981f
C7544 RB4.t26 VSS 0.17349f
C7545 RB4.t21 VSS 0.10604f
C7546 RB4.n13 VSS 0.21645f
C7547 RB4.n14 VSS 1.8981f
C7548 RB4.t10 VSS 0.17349f
C7549 RB4.t2 VSS 0.10604f
C7550 RB4.n15 VSS 0.21645f
C7551 RB4.n16 VSS 1.8981f
C7552 RB4.t42 VSS 0.17349f
C7553 RB4.t30 VSS 0.10604f
C7554 RB4.n17 VSS 0.21645f
C7555 RB4.n18 VSS 1.8981f
C7556 RB4.t43 VSS 0.17349f
C7557 RB4.t31 VSS 0.10604f
C7558 RB4.n19 VSS 0.21645f
C7559 RB4.n20 VSS 1.8981f
C7560 RB4.t24 VSS 0.17349f
C7561 RB4.t16 VSS 0.10604f
C7562 RB4.n21 VSS 0.21645f
C7563 RB4.n22 VSS 1.8981f
C7564 RB4.t23 VSS 0.17349f
C7565 RB4.t11 VSS 0.10604f
C7566 RB4.n23 VSS 0.21645f
C7567 RB4.n24 VSS 1.8981f
C7568 RB4.t45 VSS 0.17349f
C7569 RB4.t33 VSS 0.10604f
C7570 RB4.n25 VSS 0.21645f
C7571 RB4.n26 VSS 1.8981f
C7572 RB4.t46 VSS 0.17349f
C7573 RB4.t34 VSS 0.10604f
C7574 RB4.n27 VSS 0.21645f
C7575 RB4.n28 VSS 1.8981f
C7576 RB4.t12 VSS 0.17349f
C7577 RB4.t8 VSS 0.10604f
C7578 RB4.n29 VSS 0.21645f
C7579 RB4.n30 VSS 2.30918f
C7580 RA0.t35 VSS 0.21849f
C7581 RA0.n0 VSS 0.55201f
C7582 RA0.t20 VSS 0.21849f
C7583 RA0.n1 VSS 0.21996f
C7584 RA0.n2 VSS 3.35439f
C7585 RA0.t38 VSS 0.21849f
C7586 RA0.n3 VSS 0.21996f
C7587 RA0.n4 VSS 1.92978f
C7588 RA0.t8 VSS 0.21849f
C7589 RA0.n5 VSS 0.21996f
C7590 RA0.n6 VSS 1.92978f
C7591 RA0.t27 VSS 0.21849f
C7592 RA0.n7 VSS 0.21996f
C7593 RA0.n8 VSS 1.92978f
C7594 RA0.t9 VSS 0.21849f
C7595 RA0.n9 VSS 0.21996f
C7596 RA0.n10 VSS 1.92978f
C7597 RA0.t32 VSS 0.21849f
C7598 RA0.n11 VSS 0.21996f
C7599 RA0.n12 VSS 1.92978f
C7600 RA0.t3 VSS 0.21849f
C7601 RA0.n13 VSS 0.21996f
C7602 RA0.n14 VSS 1.92978f
C7603 RA0.t19 VSS 0.21849f
C7604 RA0.n15 VSS 0.21996f
C7605 RA0.n16 VSS 1.92978f
C7606 RA0.t43 VSS 0.21849f
C7607 RA0.n17 VSS 0.21996f
C7608 RA0.n18 VSS 1.92978f
C7609 RA0.t26 VSS 0.21849f
C7610 RA0.n19 VSS 0.21996f
C7611 RA0.n20 VSS 1.92978f
C7612 RA0.t47 VSS 0.21849f
C7613 RA0.n21 VSS 0.21996f
C7614 RA0.n22 VSS 1.92978f
C7615 RA0.t25 VSS 0.21849f
C7616 RA0.n23 VSS 0.21996f
C7617 RA0.n24 VSS 1.92978f
C7618 RA0.t46 VSS 0.21849f
C7619 RA0.n25 VSS 0.21996f
C7620 RA0.n26 VSS 1.92978f
C7621 RA0.t15 VSS 0.21849f
C7622 RA0.n27 VSS 0.21996f
C7623 RA0.n28 VSS 1.92978f
C7624 RA0.t24 VSS 0.21849f
C7625 RA0.n29 VSS 0.21996f
C7626 RA0.n30 VSS 2.05089f
C7627 RA15.t35 VSS 0.21902f
C7628 RA15.n0 VSS 0.55336f
C7629 RA15.t19 VSS 0.21902f
C7630 RA15.n1 VSS 0.2205f
C7631 RA15.n2 VSS 3.36255f
C7632 RA15.t21 VSS 0.21902f
C7633 RA15.n3 VSS 0.2205f
C7634 RA15.n4 VSS 1.93448f
C7635 RA15.t5 VSS 0.21902f
C7636 RA15.n5 VSS 0.2205f
C7637 RA15.n6 VSS 1.93448f
C7638 RA15.t1 VSS 0.21902f
C7639 RA15.n7 VSS 0.2205f
C7640 RA15.n8 VSS 1.93448f
C7641 RA15.t17 VSS 0.21902f
C7642 RA15.n9 VSS 0.2205f
C7643 RA15.n10 VSS 1.93448f
C7644 RA15.t18 VSS 0.21902f
C7645 RA15.n11 VSS 0.2205f
C7646 RA15.n12 VSS 1.93448f
C7647 RA15.t4 VSS 0.21902f
C7648 RA15.n13 VSS 0.2205f
C7649 RA15.n14 VSS 1.93448f
C7650 RA15.t0 VSS 0.21902f
C7651 RA15.n15 VSS 0.2205f
C7652 RA15.n16 VSS 1.93448f
C7653 RA15.t33 VSS 0.21902f
C7654 RA15.n17 VSS 0.2205f
C7655 RA15.n18 VSS 1.93448f
C7656 RA15.t15 VSS 0.21902f
C7657 RA15.n19 VSS 0.2205f
C7658 RA15.n20 VSS 1.93448f
C7659 RA15.t3 VSS 0.21902f
C7660 RA15.n21 VSS 0.2205f
C7661 RA15.n22 VSS 1.93448f
C7662 RA15.t2 VSS 0.21902f
C7663 RA15.n23 VSS 0.2205f
C7664 RA15.n24 VSS 1.93448f
C7665 RA15.t36 VSS 0.21902f
C7666 RA15.n25 VSS 0.2205f
C7667 RA15.n26 VSS 1.93448f
C7668 RA15.t37 VSS 0.21902f
C7669 RA15.n27 VSS 0.2205f
C7670 RA15.n28 VSS 1.93448f
C7671 RA15.t11 VSS 0.21902f
C7672 RA15.n29 VSS 0.2205f
C7673 RA15.n30 VSS 2.05849f
C7674 RB11.t18 VSS 0.10604f
C7675 RB11.t38 VSS 0.17349f
C7676 RB11.n0 VSS 0.43324f
C7677 RB11.t10 VSS 0.10604f
C7678 RB11.t30 VSS 0.17349f
C7679 RB11.n1 VSS 0.21645f
C7680 RB11.n2 VSS 2.82816f
C7681 RB11.t43 VSS 0.10604f
C7682 RB11.t13 VSS 0.17349f
C7683 RB11.n3 VSS 0.21645f
C7684 RB11.n4 VSS 1.8981f
C7685 RB11.t32 VSS 0.10604f
C7686 RB11.t46 VSS 0.17349f
C7687 RB11.n5 VSS 0.21645f
C7688 RB11.n6 VSS 1.8981f
C7689 RB11.t16 VSS 0.10604f
C7690 RB11.t36 VSS 0.17349f
C7691 RB11.n7 VSS 0.21645f
C7692 RB11.n8 VSS 1.8981f
C7693 RB11.t6 VSS 0.10604f
C7694 RB11.t27 VSS 0.17349f
C7695 RB11.n9 VSS 0.21645f
C7696 RB11.n10 VSS 1.8981f
C7697 RB11.t41 VSS 0.10604f
C7698 RB11.t11 VSS 0.17349f
C7699 RB11.n11 VSS 0.21645f
C7700 RB11.n12 VSS 1.8981f
C7701 RB11.t42 VSS 0.10604f
C7702 RB11.t12 VSS 0.17349f
C7703 RB11.n13 VSS 0.21645f
C7704 RB11.n14 VSS 1.8981f
C7705 RB11.t21 VSS 0.10604f
C7706 RB11.t40 VSS 0.17349f
C7707 RB11.n15 VSS 0.21645f
C7708 RB11.n16 VSS 1.8981f
C7709 RB11.t4 VSS 0.10604f
C7710 RB11.t25 VSS 0.17349f
C7711 RB11.n17 VSS 0.21645f
C7712 RB11.n18 VSS 1.8981f
C7713 RB11.t5 VSS 0.10604f
C7714 RB11.t26 VSS 0.17349f
C7715 RB11.n19 VSS 0.21645f
C7716 RB11.n20 VSS 1.8981f
C7717 RB11.t39 VSS 0.10604f
C7718 RB11.t8 VSS 0.17349f
C7719 RB11.n21 VSS 0.21645f
C7720 RB11.n22 VSS 1.8981f
C7721 RB11.t35 VSS 0.10604f
C7722 RB11.t3 VSS 0.17349f
C7723 RB11.n23 VSS 0.21645f
C7724 RB11.n24 VSS 1.8981f
C7725 RB11.t7 VSS 0.10604f
C7726 RB11.t28 VSS 0.17349f
C7727 RB11.n25 VSS 0.21645f
C7728 RB11.n26 VSS 1.8981f
C7729 RB11.t9 VSS 0.10604f
C7730 RB11.t29 VSS 0.17349f
C7731 RB11.n27 VSS 0.21645f
C7732 RB11.n28 VSS 1.8981f
C7733 RB11.t31 VSS 0.10604f
C7734 RB11.t44 VSS 0.17349f
C7735 RB11.n29 VSS 0.21645f
C7736 RB11.n30 VSS 2.30954f
C7737 a_26119_n2146.n0 VSS 0.30875f
C7738 a_26119_n2146.n1 VSS 0.14431f
C7739 a_26119_n2146.n2 VSS 0.17149f
C7740 a_26119_n2146.n3 VSS 0.17149f
C7741 a_26119_n2146.n4 VSS 0.14431f
C7742 a_26119_n2146.n5 VSS 0.14431f
C7743 a_26119_n2146.n6 VSS 0.17149f
C7744 a_26119_n2146.n7 VSS 0.17149f
C7745 a_26119_n2146.n8 VSS 0.14431f
C7746 a_26119_n2146.n9 VSS 0.14431f
C7747 a_26119_n2146.n11 VSS 0.4905f
C7748 a_26119_n2146.n12 VSS 0.14431f
C7749 a_26119_n2146.n13 VSS 0.14431f
C7750 a_26119_n2146.n14 VSS 0.17149f
C7751 a_26119_n2146.n15 VSS 0.17149f
C7752 a_26119_n2146.n16 VSS 0.14431f
C7753 a_26119_n2146.n17 VSS 0.14431f
C7754 a_26119_n2146.n18 VSS 0.17149f
C7755 a_26119_n2146.n19 VSS 0.17149f
C7756 a_26119_n2146.n20 VSS 0.14431f
C7757 a_26119_n2146.n21 VSS 0.14431f
C7758 a_26119_n2146.n22 VSS 0.17149f
C7759 a_26119_n2146.n23 VSS 0.17149f
C7760 a_26119_n2146.n24 VSS 0.14431f
C7761 a_26119_n2146.n25 VSS 0.14431f
C7762 a_26119_n2146.n26 VSS 0.17149f
C7763 a_26119_n2146.n27 VSS 0.17149f
C7764 a_26119_n2146.n28 VSS 0.14431f
C7765 a_26119_n2146.n29 VSS 0.14431f
C7766 a_26119_n2146.n30 VSS 0.17149f
C7767 a_26119_n2146.n31 VSS 0.17149f
C7768 RA14.t26 VSS 0.21849f
C7769 RA14.n0 VSS 0.55201f
C7770 RA14.t35 VSS 0.21849f
C7771 RA14.n1 VSS 0.21996f
C7772 RA14.n2 VSS 3.35439f
C7773 RA14.t23 VSS 0.21849f
C7774 RA14.n3 VSS 0.21996f
C7775 RA14.n4 VSS 1.92978f
C7776 RA14.t34 VSS 0.21849f
C7777 RA14.n5 VSS 0.21996f
C7778 RA14.n6 VSS 1.92978f
C7779 RA14.t19 VSS 0.21849f
C7780 RA14.n7 VSS 0.21996f
C7781 RA14.n8 VSS 1.92978f
C7782 RA14.t27 VSS 0.21849f
C7783 RA14.n9 VSS 0.21996f
C7784 RA14.n10 VSS 1.92978f
C7785 RA14.t21 VSS 0.21849f
C7786 RA14.n11 VSS 0.21996f
C7787 RA14.n12 VSS 1.92978f
C7788 RA14.t24 VSS 0.21849f
C7789 RA14.n13 VSS 0.21996f
C7790 RA14.n14 VSS 1.92978f
C7791 RA14.t12 VSS 0.21849f
C7792 RA14.n15 VSS 0.21996f
C7793 RA14.n16 VSS 1.92978f
C7794 RA14.t20 VSS 0.21849f
C7795 RA14.n17 VSS 0.21996f
C7796 RA14.n18 VSS 1.92978f
C7797 RA14.t13 VSS 0.21849f
C7798 RA14.n19 VSS 0.21996f
C7799 RA14.n20 VSS 1.92978f
C7800 RA14.t22 VSS 0.21849f
C7801 RA14.n21 VSS 0.21996f
C7802 RA14.n22 VSS 1.92978f
C7803 RA14.t28 VSS 0.21849f
C7804 RA14.n23 VSS 0.21996f
C7805 RA14.n24 VSS 1.92978f
C7806 RA14.t36 VSS 0.21849f
C7807 RA14.n25 VSS 0.21996f
C7808 RA14.n26 VSS 1.92978f
C7809 RA14.t25 VSS 0.21849f
C7810 RA14.n27 VSS 0.21996f
C7811 RA14.n28 VSS 1.92978f
C7812 RA14.t30 VSS 0.21849f
C7813 RA14.n29 VSS 0.21996f
C7814 RA14.n30 VSS 2.05163f
C7815 a_3601_n862.n0 VSS 0.30869f
C7816 a_3601_n862.n1 VSS 0.14432f
C7817 a_3601_n862.n2 VSS 0.17142f
C7818 a_3601_n862.n4 VSS 0.48932f
C7819 a_3601_n862.n5 VSS 0.14432f
C7820 a_3601_n862.n6 VSS 0.14432f
C7821 a_3601_n862.n7 VSS 0.17142f
C7822 a_3601_n862.n8 VSS 0.17142f
C7823 a_3601_n862.n9 VSS 0.14432f
C7824 a_3601_n862.n10 VSS 0.14432f
C7825 a_3601_n862.n11 VSS 0.17142f
C7826 a_3601_n862.n12 VSS 0.17142f
C7827 a_3601_n862.n13 VSS 0.14432f
C7828 a_3601_n862.n14 VSS 0.14432f
C7829 a_3601_n862.n15 VSS 0.17142f
C7830 a_3601_n862.n16 VSS 0.17142f
C7831 a_3601_n862.n17 VSS 0.14432f
C7832 a_3601_n862.n18 VSS 0.14432f
C7833 a_3601_n862.n19 VSS 0.17142f
C7834 a_3601_n862.n20 VSS 0.17142f
C7835 a_3601_n862.n21 VSS 0.14432f
C7836 a_3601_n862.n22 VSS 0.14432f
C7837 a_3601_n862.n23 VSS 0.17142f
C7838 a_3601_n862.n24 VSS 0.17142f
C7839 a_3601_n862.n25 VSS 0.14432f
C7840 a_3601_n862.n26 VSS 0.14432f
C7841 a_3601_n862.n27 VSS 0.17142f
C7842 a_3601_n862.n28 VSS 0.17142f
C7843 a_3601_n862.n29 VSS 0.14432f
C7844 a_3601_n862.n30 VSS 0.14432f
C7845 a_3601_n862.n31 VSS 0.17142f
C7846 a_28591_n2146.n0 VSS 0.30875f
C7847 a_28591_n2146.n1 VSS 0.14431f
C7848 a_28591_n2146.n2 VSS 0.17149f
C7849 a_28591_n2146.n3 VSS 0.17149f
C7850 a_28591_n2146.n4 VSS 0.14431f
C7851 a_28591_n2146.n5 VSS 0.14431f
C7852 a_28591_n2146.n6 VSS 0.17149f
C7853 a_28591_n2146.n7 VSS 0.17149f
C7854 a_28591_n2146.n8 VSS 0.14431f
C7855 a_28591_n2146.n9 VSS 0.14431f
C7856 a_28591_n2146.n11 VSS 0.4905f
C7857 a_28591_n2146.n12 VSS 0.14431f
C7858 a_28591_n2146.n13 VSS 0.14431f
C7859 a_28591_n2146.n14 VSS 0.17149f
C7860 a_28591_n2146.n15 VSS 0.17149f
C7861 a_28591_n2146.n16 VSS 0.14431f
C7862 a_28591_n2146.n17 VSS 0.14431f
C7863 a_28591_n2146.n18 VSS 0.17149f
C7864 a_28591_n2146.n19 VSS 0.17149f
C7865 a_28591_n2146.n20 VSS 0.14431f
C7866 a_28591_n2146.n21 VSS 0.14431f
C7867 a_28591_n2146.n22 VSS 0.17149f
C7868 a_28591_n2146.n23 VSS 0.17149f
C7869 a_28591_n2146.n24 VSS 0.14431f
C7870 a_28591_n2146.n25 VSS 0.14431f
C7871 a_28591_n2146.n26 VSS 0.17149f
C7872 a_28591_n2146.n27 VSS 0.17149f
C7873 a_28591_n2146.n28 VSS 0.14431f
C7874 a_28591_n2146.n29 VSS 0.14431f
C7875 a_28591_n2146.n30 VSS 0.17149f
C7876 a_28591_n2146.n31 VSS 0.17149f
C7877 RB7.t22 VSS 0.10604f
C7878 RB7.t27 VSS 0.17349f
C7879 RB7.n0 VSS 0.43324f
C7880 RB7.t8 VSS 0.10604f
C7881 RB7.t19 VSS 0.17349f
C7882 RB7.n1 VSS 0.21645f
C7883 RB7.n2 VSS 2.82816f
C7884 RB7.t42 VSS 0.10604f
C7885 RB7.t47 VSS 0.17349f
C7886 RB7.n3 VSS 0.21645f
C7887 RB7.n4 VSS 1.8981f
C7888 RB7.t30 VSS 0.10604f
C7889 RB7.t33 VSS 0.17349f
C7890 RB7.n5 VSS 0.21645f
C7891 RB7.n6 VSS 1.8981f
C7892 RB7.t20 VSS 0.10604f
C7893 RB7.t25 VSS 0.17349f
C7894 RB7.n7 VSS 0.21645f
C7895 RB7.n8 VSS 1.8981f
C7896 RB7.t4 VSS 0.10604f
C7897 RB7.t16 VSS 0.17349f
C7898 RB7.n9 VSS 0.21645f
C7899 RB7.n10 VSS 1.8981f
C7900 RB7.t40 VSS 0.10604f
C7901 RB7.t45 VSS 0.17349f
C7902 RB7.n11 VSS 0.21645f
C7903 RB7.n12 VSS 1.8981f
C7904 RB7.t41 VSS 0.10604f
C7905 RB7.t46 VSS 0.17349f
C7906 RB7.n13 VSS 0.21645f
C7907 RB7.n14 VSS 1.8981f
C7908 RB7.t23 VSS 0.10604f
C7909 RB7.t28 VSS 0.17349f
C7910 RB7.n15 VSS 0.21645f
C7911 RB7.n16 VSS 1.8981f
C7912 RB7.t2 VSS 0.10604f
C7913 RB7.t14 VSS 0.17349f
C7914 RB7.n17 VSS 0.21645f
C7915 RB7.n18 VSS 1.8981f
C7916 RB7.t3 VSS 0.10604f
C7917 RB7.t15 VSS 0.17349f
C7918 RB7.n19 VSS 0.21645f
C7919 RB7.n20 VSS 1.8981f
C7920 RB7.t39 VSS 0.10604f
C7921 RB7.t44 VSS 0.17349f
C7922 RB7.n21 VSS 0.21645f
C7923 RB7.n22 VSS 1.8981f
C7924 RB7.t35 VSS 0.10604f
C7925 RB7.t43 VSS 0.17349f
C7926 RB7.n23 VSS 0.21645f
C7927 RB7.n24 VSS 1.8981f
C7928 RB7.t5 VSS 0.10604f
C7929 RB7.t17 VSS 0.17349f
C7930 RB7.n25 VSS 0.21645f
C7931 RB7.n26 VSS 1.8981f
C7932 RB7.t7 VSS 0.10604f
C7933 RB7.t18 VSS 0.17349f
C7934 RB7.n27 VSS 0.21645f
C7935 RB7.n28 VSS 1.8981f
C7936 RB7.t29 VSS 0.10604f
C7937 RB7.t31 VSS 0.17349f
C7938 RB7.n29 VSS 0.21645f
C7939 RB7.n30 VSS 2.30918f
C7940 a_7056_n708.n3 VSS 0.26552f
C7941 a_7056_n708.n5 VSS 0.1392f
C7942 a_7056_n708.n7 VSS 0.1392f
C7943 a_7056_n708.n9 VSS 0.1392f
C7944 a_7056_n708.n11 VSS 0.1392f
C7945 a_7056_n708.n13 VSS 0.1392f
C7946 a_7056_n708.n15 VSS 0.1392f
C7947 a_7056_n708.n17 VSS 0.1392f
C7948 a_7056_n708.n19 VSS 0.1392f
C7949 a_7056_n708.n21 VSS 0.1392f
C7950 a_7056_n708.n23 VSS 0.1392f
C7951 a_7056_n708.n25 VSS 0.1392f
C7952 a_7056_n708.n27 VSS 0.1392f
C7953 a_7056_n708.n29 VSS 0.1392f
C7954 a_7056_n708.n31 VSS 0.18199f
C7955 RB0.t14 VSS 0.17349f
C7956 RB0.t6 VSS 0.10604f
C7957 RB0.n0 VSS 0.43324f
C7958 RB0.t45 VSS 0.17349f
C7959 RB0.t35 VSS 0.10604f
C7960 RB0.n1 VSS 0.21645f
C7961 RB0.n2 VSS 2.82816f
C7962 RB0.t23 VSS 0.17349f
C7963 RB0.t15 VSS 0.10604f
C7964 RB0.n3 VSS 0.21645f
C7965 RB0.n4 VSS 1.8981f
C7966 RB0.t5 VSS 0.17349f
C7967 RB0.t42 VSS 0.10604f
C7968 RB0.n5 VSS 0.21645f
C7969 RB0.n6 VSS 1.8981f
C7970 RB0.t8 VSS 0.17349f
C7971 RB0.t44 VSS 0.10604f
C7972 RB0.n7 VSS 0.21645f
C7973 RB0.n8 VSS 1.8981f
C7974 RB0.t37 VSS 0.17349f
C7975 RB0.t30 VSS 0.10604f
C7976 RB0.n9 VSS 0.21645f
C7977 RB0.n10 VSS 1.8981f
C7978 RB0.t17 VSS 0.17349f
C7979 RB0.t10 VSS 0.10604f
C7980 RB0.n11 VSS 0.21645f
C7981 RB0.n12 VSS 1.8981f
C7982 RB0.t31 VSS 0.17349f
C7983 RB0.t25 VSS 0.10604f
C7984 RB0.n13 VSS 0.21645f
C7985 RB0.n14 VSS 1.8981f
C7986 RB0.t12 VSS 0.17349f
C7987 RB0.t2 VSS 0.10604f
C7988 RB0.n15 VSS 0.21645f
C7989 RB0.n16 VSS 1.8981f
C7990 RB0.t32 VSS 0.17349f
C7991 RB0.t26 VSS 0.10604f
C7992 RB0.n17 VSS 0.21645f
C7993 RB0.n18 VSS 1.8981f
C7994 RB0.t4 VSS 0.17349f
C7995 RB0.t41 VSS 0.10604f
C7996 RB0.n19 VSS 0.21645f
C7997 RB0.n20 VSS 1.8981f
C7998 RB0.t27 VSS 0.17349f
C7999 RB0.t19 VSS 0.10604f
C8000 RB0.n21 VSS 0.21645f
C8001 RB0.n22 VSS 1.8981f
C8002 RB0.t3 VSS 0.17349f
C8003 RB0.t40 VSS 0.10604f
C8004 RB0.n23 VSS 0.21645f
C8005 RB0.n24 VSS 1.8981f
C8006 RB0.t34 VSS 0.17349f
C8007 RB0.t29 VSS 0.10604f
C8008 RB0.n25 VSS 0.21645f
C8009 RB0.n26 VSS 1.8981f
C8010 RB0.t11 VSS 0.17349f
C8011 RB0.t0 VSS 0.10604f
C8012 RB0.n27 VSS 0.21645f
C8013 RB0.n28 VSS 1.8981f
C8014 RB0.t47 VSS 0.17349f
C8015 RB0.t36 VSS 0.10604f
C8016 RB0.n29 VSS 0.21645f
C8017 RB0.n30 VSS 2.30991f
C8018 a_2112_n708.n3 VSS 0.26552f
C8019 a_2112_n708.n5 VSS 0.1392f
C8020 a_2112_n708.n7 VSS 0.1392f
C8021 a_2112_n708.n9 VSS 0.1392f
C8022 a_2112_n708.n11 VSS 0.1392f
C8023 a_2112_n708.n13 VSS 0.1392f
C8024 a_2112_n708.n15 VSS 0.1392f
C8025 a_2112_n708.n17 VSS 0.1392f
C8026 a_2112_n708.n19 VSS 0.1392f
C8027 a_2112_n708.n21 VSS 0.1392f
C8028 a_2112_n708.n23 VSS 0.1392f
C8029 a_2112_n708.n25 VSS 0.1392f
C8030 a_2112_n708.n27 VSS 0.1392f
C8031 a_2112_n708.n29 VSS 0.1392f
C8032 a_2112_n708.n31 VSS 0.18199f
C8033 a_n1204_n954.t9 VSS 0.13292f
C8034 a_n1204_n954.n1 VSS 2.06139f
C8035 a_n1204_n954.t28 VSS 0.11711f
C8036 a_n1204_n954.n2 VSS 0.91859f
C8037 a_n1204_n954.n3 VSS 0.7697f
C8038 a_n1204_n954.t22 VSS 0.11711f
C8039 a_n1204_n954.n4 VSS 0.91859f
C8040 a_n1204_n954.n5 VSS 0.7697f
C8041 a_n1204_n954.t4 VSS 0.11711f
C8042 a_n1204_n954.n6 VSS 0.91859f
C8043 a_n1204_n954.n7 VSS 0.7697f
C8044 a_n1204_n954.t5 VSS 0.11711f
C8045 a_n1204_n954.n8 VSS 0.91859f
C8046 a_n1204_n954.n9 VSS 0.7697f
C8047 a_n1204_n954.t27 VSS 0.11711f
C8048 a_n1204_n954.n10 VSS 0.91859f
C8049 a_n1204_n954.n11 VSS 0.7697f
C8050 a_n1204_n954.t20 VSS 0.11711f
C8051 a_n1204_n954.n12 VSS 0.91859f
C8052 a_n1204_n954.n13 VSS 0.7697f
C8053 a_n1204_n954.t37 VSS 0.11711f
C8054 a_n1204_n954.n14 VSS 0.91859f
C8055 a_n1204_n954.n15 VSS 0.7697f
C8056 a_n1204_n954.t38 VSS 0.11711f
C8057 a_n1204_n954.n16 VSS 0.91859f
C8058 a_n1204_n954.n17 VSS 0.7697f
C8059 a_n1204_n954.t25 VSS 0.11711f
C8060 a_n1204_n954.n18 VSS 0.91859f
C8061 a_n1204_n954.n19 VSS 0.7697f
C8062 a_n1204_n954.t18 VSS 0.11711f
C8063 a_n1204_n954.n20 VSS 0.91859f
C8064 a_n1204_n954.n21 VSS 0.7697f
C8065 a_n1204_n954.t19 VSS 0.11711f
C8066 a_n1204_n954.n22 VSS 0.91859f
C8067 a_n1204_n954.n23 VSS 0.7697f
C8068 a_n1204_n954.t6 VSS 0.11711f
C8069 a_n1204_n954.n24 VSS 0.91859f
C8070 a_n1204_n954.n25 VSS 0.7697f
C8071 a_n1204_n954.t8 VSS 0.11711f
C8072 a_n1204_n954.n26 VSS 0.91859f
C8073 a_n1204_n954.n27 VSS 0.7697f
C8074 a_n1204_n954.t21 VSS 0.11711f
C8075 a_n1204_n954.n28 VSS 0.91859f
C8076 a_n1204_n954.n29 VSS 0.7697f
C8077 a_n1204_n954.t29 VSS 0.11711f
C8078 a_n1204_n954.n30 VSS 0.91859f
C8079 a_n1204_n954.n31 VSS 0.60322f
C8080 a_n1204_n954.n32 VSS 0.25415f
C8081 a_n1204_n954.n33 VSS 0.12386f
C8082 a_n1204_n954.n34 VSS 0.1376f
C8083 a_n1204_n954.n35 VSS 0.23142f
C8084 a_n1204_n954.n36 VSS 0.16045f
C8085 a_34248_n708.n3 VSS 0.26552f
C8086 a_34248_n708.n5 VSS 0.1392f
C8087 a_34248_n708.n7 VSS 0.1392f
C8088 a_34248_n708.n9 VSS 0.1392f
C8089 a_34248_n708.n11 VSS 0.1392f
C8090 a_34248_n708.n13 VSS 0.1392f
C8091 a_34248_n708.n15 VSS 0.1392f
C8092 a_34248_n708.n17 VSS 0.1392f
C8093 a_34248_n708.n19 VSS 0.1392f
C8094 a_34248_n708.n21 VSS 0.1392f
C8095 a_34248_n708.n23 VSS 0.1392f
C8096 a_34248_n708.n25 VSS 0.1392f
C8097 a_34248_n708.n27 VSS 0.1392f
C8098 a_34248_n708.n29 VSS 0.1392f
C8099 a_34248_n708.n31 VSS 0.18199f
C8100 a_n884_n1738.n0 VSS 1.00493f
C8101 a_n884_n1738.n1 VSS 0.44244f
C8102 a_n884_n1738.n2 VSS 0.52411f
C8103 a_n884_n1738.n3 VSS 0.44244f
C8104 a_n884_n1738.n4 VSS 0.52411f
C8105 a_n884_n1738.n5 VSS 0.44244f
C8106 a_n884_n1738.n6 VSS 0.52411f
C8107 a_n884_n1738.n7 VSS 0.44244f
C8108 a_n884_n1738.n8 VSS 0.52411f
C8109 a_n884_n1738.n9 VSS 0.44244f
C8110 a_n884_n1738.n10 VSS 0.52411f
C8111 a_n884_n1738.n11 VSS 0.44244f
C8112 a_n884_n1738.n12 VSS 0.52411f
C8113 a_n884_n1738.n13 VSS 0.44244f
C8114 a_n884_n1738.n14 VSS 0.52411f
C8115 a_n884_n1738.n15 VSS 0.44244f
C8116 a_n884_n1738.n16 VSS 0.52411f
C8117 a_n884_n1738.n17 VSS 0.44244f
C8118 a_n884_n1738.n18 VSS 0.52411f
C8119 a_n884_n1738.n19 VSS 0.44244f
C8120 a_n884_n1738.n20 VSS 0.52411f
C8121 a_n884_n1738.n21 VSS 0.44244f
C8122 a_n884_n1738.n22 VSS 0.52411f
C8123 a_n884_n1738.n23 VSS 0.44244f
C8124 a_n884_n1738.n24 VSS 0.52411f
C8125 a_n884_n1738.n25 VSS 0.44244f
C8126 a_n884_n1738.n26 VSS 0.52411f
C8127 a_n884_n1738.n27 VSS 0.44244f
C8128 a_n884_n1738.n28 VSS 0.52411f
C8129 a_n884_n1738.n29 VSS 0.44244f
C8130 a_n884_n1738.n30 VSS 0.62239f
C8131 a_n884_n1738.n32 VSS 0.17797f
C8132 a_20905_n862.n0 VSS 0.30869f
C8133 a_20905_n862.n1 VSS 0.14432f
C8134 a_20905_n862.n2 VSS 0.17142f
C8135 a_20905_n862.n4 VSS 0.48932f
C8136 a_20905_n862.n5 VSS 0.14432f
C8137 a_20905_n862.n6 VSS 0.14432f
C8138 a_20905_n862.n7 VSS 0.17142f
C8139 a_20905_n862.n8 VSS 0.17142f
C8140 a_20905_n862.n9 VSS 0.14432f
C8141 a_20905_n862.n10 VSS 0.14432f
C8142 a_20905_n862.n11 VSS 0.17142f
C8143 a_20905_n862.n12 VSS 0.17142f
C8144 a_20905_n862.n13 VSS 0.14432f
C8145 a_20905_n862.n14 VSS 0.14432f
C8146 a_20905_n862.n15 VSS 0.17142f
C8147 a_20905_n862.n16 VSS 0.17142f
C8148 a_20905_n862.n17 VSS 0.14432f
C8149 a_20905_n862.n18 VSS 0.14432f
C8150 a_20905_n862.n19 VSS 0.17142f
C8151 a_20905_n862.n20 VSS 0.17142f
C8152 a_20905_n862.n21 VSS 0.14432f
C8153 a_20905_n862.n22 VSS 0.14432f
C8154 a_20905_n862.n23 VSS 0.17142f
C8155 a_20905_n862.n24 VSS 0.17142f
C8156 a_20905_n862.n25 VSS 0.14432f
C8157 a_20905_n862.n26 VSS 0.14432f
C8158 a_20905_n862.n27 VSS 0.17142f
C8159 a_20905_n862.n28 VSS 0.17142f
C8160 a_20905_n862.n29 VSS 0.14432f
C8161 a_20905_n862.n30 VSS 0.14432f
C8162 a_20905_n862.n31 VSS 0.17142f
C8163 RA11.t8 VSS 0.21849f
C8164 RA11.n0 VSS 0.55201f
C8165 RA11.t42 VSS 0.21849f
C8166 RA11.n1 VSS 0.21996f
C8167 RA11.n2 VSS 3.35439f
C8168 RA11.t44 VSS 0.21849f
C8169 RA11.n3 VSS 0.21996f
C8170 RA11.n4 VSS 1.92978f
C8171 RA11.t31 VSS 0.21849f
C8172 RA11.n5 VSS 0.21996f
C8173 RA11.n6 VSS 1.92978f
C8174 RA11.t22 VSS 0.21849f
C8175 RA11.n7 VSS 0.21996f
C8176 RA11.n8 VSS 1.92978f
C8177 RA11.t40 VSS 0.21849f
C8178 RA11.n9 VSS 0.21996f
C8179 RA11.n10 VSS 1.92978f
C8180 RA11.t41 VSS 0.21849f
C8181 RA11.n11 VSS 0.21996f
C8182 RA11.n12 VSS 1.92978f
C8183 RA11.t30 VSS 0.21849f
C8184 RA11.n13 VSS 0.21996f
C8185 RA11.n14 VSS 1.92978f
C8186 RA11.t21 VSS 0.21849f
C8187 RA11.n15 VSS 0.21996f
C8188 RA11.n16 VSS 1.92978f
C8189 RA11.t5 VSS 0.21849f
C8190 RA11.n17 VSS 0.21996f
C8191 RA11.n18 VSS 1.92978f
C8192 RA11.t39 VSS 0.21849f
C8193 RA11.n19 VSS 0.21996f
C8194 RA11.n20 VSS 1.92978f
C8195 RA11.t27 VSS 0.21849f
C8196 RA11.n21 VSS 0.21996f
C8197 RA11.n22 VSS 1.92978f
C8198 RA11.t23 VSS 0.21849f
C8199 RA11.n23 VSS 0.21996f
C8200 RA11.n24 VSS 1.92978f
C8201 RA11.t9 VSS 0.21849f
C8202 RA11.n25 VSS 0.21996f
C8203 RA11.n26 VSS 1.92978f
C8204 RA11.t10 VSS 0.21849f
C8205 RA11.n27 VSS 0.21996f
C8206 RA11.n28 VSS 1.92978f
C8207 RA11.t33 VSS 0.21849f
C8208 RA11.n29 VSS 0.21996f
C8209 RA11.n30 VSS 2.05275f
C8210 RA13.t27 VSS 0.21849f
C8211 RA13.n0 VSS 0.55201f
C8212 RA13.t35 VSS 0.21849f
C8213 RA13.n1 VSS 0.21996f
C8214 RA13.n2 VSS 3.35439f
C8215 RA13.t24 VSS 0.21849f
C8216 RA13.n3 VSS 0.21996f
C8217 RA13.n4 VSS 1.92978f
C8218 RA13.t32 VSS 0.21849f
C8219 RA13.n5 VSS 0.21996f
C8220 RA13.n6 VSS 1.92978f
C8221 RA13.t20 VSS 0.21849f
C8222 RA13.n7 VSS 0.21996f
C8223 RA13.n8 VSS 1.92978f
C8224 RA13.t28 VSS 0.21849f
C8225 RA13.n9 VSS 0.21996f
C8226 RA13.n10 VSS 1.92978f
C8227 RA13.t22 VSS 0.21849f
C8228 RA13.n11 VSS 0.21996f
C8229 RA13.n12 VSS 1.92978f
C8230 RA13.t25 VSS 0.21849f
C8231 RA13.n13 VSS 0.21996f
C8232 RA13.n14 VSS 1.92978f
C8233 RA13.t15 VSS 0.21849f
C8234 RA13.n15 VSS 0.21996f
C8235 RA13.n16 VSS 1.92978f
C8236 RA13.t21 VSS 0.21849f
C8237 RA13.n17 VSS 0.21996f
C8238 RA13.n18 VSS 1.92978f
C8239 RA13.t16 VSS 0.21849f
C8240 RA13.n19 VSS 0.21996f
C8241 RA13.n20 VSS 1.92978f
C8242 RA13.t23 VSS 0.21849f
C8243 RA13.n21 VSS 0.21996f
C8244 RA13.n22 VSS 1.92978f
C8245 RA13.t29 VSS 0.21849f
C8246 RA13.n23 VSS 0.21996f
C8247 RA13.n24 VSS 1.92978f
C8248 RA13.t36 VSS 0.21849f
C8249 RA13.n25 VSS 0.21996f
C8250 RA13.n26 VSS 1.92978f
C8251 RA13.t26 VSS 0.21849f
C8252 RA13.n27 VSS 0.21996f
C8253 RA13.n28 VSS 1.92978f
C8254 RA13.t30 VSS 0.21849f
C8255 RA13.n29 VSS 0.21996f
C8256 RA13.n30 VSS 2.05349f
C8257 a_28321_n862.n0 VSS 0.30869f
C8258 a_28321_n862.n1 VSS 0.14432f
C8259 a_28321_n862.n2 VSS 0.17142f
C8260 a_28321_n862.n3 VSS 0.17142f
C8261 a_28321_n862.n4 VSS 0.14432f
C8262 a_28321_n862.n5 VSS 0.14432f
C8263 a_28321_n862.n6 VSS 0.17142f
C8264 a_28321_n862.n7 VSS 0.17142f
C8265 a_28321_n862.n8 VSS 0.14432f
C8266 a_28321_n862.n9 VSS 0.14432f
C8267 a_28321_n862.n10 VSS 0.17142f
C8268 a_28321_n862.n11 VSS 0.17142f
C8269 a_28321_n862.n12 VSS 0.14432f
C8270 a_28321_n862.n13 VSS 0.14432f
C8271 a_28321_n862.n14 VSS 0.17142f
C8272 a_28321_n862.n15 VSS 0.17142f
C8273 a_28321_n862.n16 VSS 0.14432f
C8274 a_28321_n862.n17 VSS 0.14432f
C8275 a_28321_n862.n18 VSS 0.17142f
C8276 a_28321_n862.n19 VSS 0.17142f
C8277 a_28321_n862.n20 VSS 0.14432f
C8278 a_28321_n862.n21 VSS 0.14432f
C8279 a_28321_n862.n22 VSS 0.17142f
C8280 a_28321_n862.n23 VSS 0.17142f
C8281 a_28321_n862.n24 VSS 0.14432f
C8282 a_28321_n862.n25 VSS 0.14432f
C8283 a_28321_n862.n27 VSS 0.48932f
C8284 a_28321_n862.n28 VSS 0.14432f
C8285 a_28321_n862.n29 VSS 0.14432f
C8286 a_28321_n862.n30 VSS 0.17142f
C8287 a_28321_n862.n31 VSS 0.17142f
C8288 a_13759_n2146.n0 VSS 0.30875f
C8289 a_13759_n2146.n1 VSS 0.14431f
C8290 a_13759_n2146.n2 VSS 0.17149f
C8291 a_13759_n2146.n3 VSS 0.17149f
C8292 a_13759_n2146.n4 VSS 0.14431f
C8293 a_13759_n2146.n5 VSS 0.14431f
C8294 a_13759_n2146.n6 VSS 0.17149f
C8295 a_13759_n2146.n7 VSS 0.17149f
C8296 a_13759_n2146.n8 VSS 0.14431f
C8297 a_13759_n2146.n9 VSS 0.14431f
C8298 a_13759_n2146.n11 VSS 0.4905f
C8299 a_13759_n2146.n12 VSS 0.14431f
C8300 a_13759_n2146.n13 VSS 0.14431f
C8301 a_13759_n2146.n14 VSS 0.17149f
C8302 a_13759_n2146.n15 VSS 0.17149f
C8303 a_13759_n2146.n16 VSS 0.14431f
C8304 a_13759_n2146.n17 VSS 0.14431f
C8305 a_13759_n2146.n18 VSS 0.17149f
C8306 a_13759_n2146.n19 VSS 0.17149f
C8307 a_13759_n2146.n20 VSS 0.14431f
C8308 a_13759_n2146.n21 VSS 0.14431f
C8309 a_13759_n2146.n22 VSS 0.17149f
C8310 a_13759_n2146.n23 VSS 0.17149f
C8311 a_13759_n2146.n24 VSS 0.14431f
C8312 a_13759_n2146.n25 VSS 0.14431f
C8313 a_13759_n2146.n26 VSS 0.17149f
C8314 a_13759_n2146.n27 VSS 0.17149f
C8315 a_13759_n2146.n28 VSS 0.14431f
C8316 a_13759_n2146.n29 VSS 0.14431f
C8317 a_13759_n2146.n30 VSS 0.17149f
C8318 a_13759_n2146.n31 VSS 0.17149f
C8319 RB9.t3 VSS 0.10604f
C8320 RB9.t7 VSS 0.17349f
C8321 RB9.n0 VSS 0.43324f
C8322 RB9.t41 VSS 0.10604f
C8323 RB9.t47 VSS 0.17349f
C8324 RB9.n1 VSS 0.21645f
C8325 RB9.n2 VSS 2.82816f
C8326 RB9.t23 VSS 0.10604f
C8327 RB9.t27 VSS 0.17349f
C8328 RB9.n3 VSS 0.21645f
C8329 RB9.n4 VSS 1.8981f
C8330 RB9.t10 VSS 0.10604f
C8331 RB9.t13 VSS 0.17349f
C8332 RB9.n5 VSS 0.21645f
C8333 RB9.n6 VSS 1.8981f
C8334 RB9.t1 VSS 0.10604f
C8335 RB9.t5 VSS 0.17349f
C8336 RB9.n7 VSS 0.21645f
C8337 RB9.n8 VSS 1.8981f
C8338 RB9.t35 VSS 0.10604f
C8339 RB9.t44 VSS 0.17349f
C8340 RB9.n9 VSS 0.21645f
C8341 RB9.n10 VSS 1.8981f
C8342 RB9.t20 VSS 0.10604f
C8343 RB9.t25 VSS 0.17349f
C8344 RB9.n11 VSS 0.21645f
C8345 RB9.n12 VSS 1.8981f
C8346 RB9.t22 VSS 0.10604f
C8347 RB9.t26 VSS 0.17349f
C8348 RB9.n13 VSS 0.21645f
C8349 RB9.n14 VSS 1.8981f
C8350 RB9.t4 VSS 0.10604f
C8351 RB9.t8 VSS 0.17349f
C8352 RB9.n15 VSS 0.21645f
C8353 RB9.n16 VSS 1.8981f
C8354 RB9.t31 VSS 0.10604f
C8355 RB9.t42 VSS 0.17349f
C8356 RB9.n17 VSS 0.21645f
C8357 RB9.n18 VSS 1.8981f
C8358 RB9.t32 VSS 0.10604f
C8359 RB9.t43 VSS 0.17349f
C8360 RB9.n19 VSS 0.21645f
C8361 RB9.n20 VSS 1.8981f
C8362 RB9.t19 VSS 0.10604f
C8363 RB9.t24 VSS 0.17349f
C8364 RB9.n21 VSS 0.21645f
C8365 RB9.n22 VSS 1.8981f
C8366 RB9.t18 VSS 0.10604f
C8367 RB9.t21 VSS 0.17349f
C8368 RB9.n23 VSS 0.21645f
C8369 RB9.n24 VSS 1.8981f
C8370 RB9.t36 VSS 0.10604f
C8371 RB9.t45 VSS 0.17349f
C8372 RB9.n25 VSS 0.21645f
C8373 RB9.n26 VSS 1.8981f
C8374 RB9.t39 VSS 0.10604f
C8375 RB9.t46 VSS 0.17349f
C8376 RB9.n27 VSS 0.21645f
C8377 RB9.n28 VSS 1.8981f
C8378 RB9.t9 VSS 0.10604f
C8379 RB9.t11 VSS 0.17349f
C8380 RB9.n29 VSS 0.21645f
C8381 RB9.n30 VSS 2.30808f
C8382 RA9.t25 VSS 0.21849f
C8383 RA9.n0 VSS 0.55201f
C8384 RA9.t10 VSS 0.21849f
C8385 RA9.n1 VSS 0.21996f
C8386 RA9.n2 VSS 3.35439f
C8387 RA9.t12 VSS 0.21849f
C8388 RA9.n3 VSS 0.21996f
C8389 RA9.n4 VSS 1.92978f
C8390 RA9.t45 VSS 0.21849f
C8391 RA9.n5 VSS 0.21996f
C8392 RA9.n6 VSS 1.92978f
C8393 RA9.t39 VSS 0.21849f
C8394 RA9.n7 VSS 0.21996f
C8395 RA9.n8 VSS 1.92978f
C8396 RA9.t8 VSS 0.21849f
C8397 RA9.n9 VSS 0.21996f
C8398 RA9.n10 VSS 1.92978f
C8399 RA9.t9 VSS 0.21849f
C8400 RA9.n11 VSS 0.21996f
C8401 RA9.n12 VSS 1.92978f
C8402 RA9.t44 VSS 0.21849f
C8403 RA9.n13 VSS 0.21996f
C8404 RA9.n14 VSS 1.92978f
C8405 RA9.t37 VSS 0.21849f
C8406 RA9.n15 VSS 0.21996f
C8407 RA9.n16 VSS 1.92978f
C8408 RA9.t23 VSS 0.21849f
C8409 RA9.n17 VSS 0.21996f
C8410 RA9.n18 VSS 1.92978f
C8411 RA9.t7 VSS 0.21849f
C8412 RA9.n19 VSS 0.21996f
C8413 RA9.n20 VSS 1.92978f
C8414 RA9.t43 VSS 0.21849f
C8415 RA9.n21 VSS 0.21996f
C8416 RA9.n22 VSS 1.92978f
C8417 RA9.t40 VSS 0.21849f
C8418 RA9.n23 VSS 0.21996f
C8419 RA9.n24 VSS 1.92978f
C8420 RA9.t26 VSS 0.21849f
C8421 RA9.n25 VSS 0.21996f
C8422 RA9.n26 VSS 1.92978f
C8423 RA9.t27 VSS 0.21849f
C8424 RA9.n27 VSS 0.21996f
C8425 RA9.n28 VSS 1.92978f
C8426 RA9.t0 VSS 0.21849f
C8427 RA9.n29 VSS 0.21996f
C8428 RA9.n30 VSS 2.05126f
C8429 a_26832_n708.n3 VSS 0.26552f
C8430 a_26832_n708.n5 VSS 0.1392f
C8431 a_26832_n708.n7 VSS 0.1392f
C8432 a_26832_n708.n9 VSS 0.1392f
C8433 a_26832_n708.n11 VSS 0.1392f
C8434 a_26832_n708.n13 VSS 0.1392f
C8435 a_26832_n708.n15 VSS 0.1392f
C8436 a_26832_n708.n17 VSS 0.1392f
C8437 a_26832_n708.n19 VSS 0.1392f
C8438 a_26832_n708.n21 VSS 0.1392f
C8439 a_26832_n708.n23 VSS 0.1392f
C8440 a_26832_n708.n25 VSS 0.1392f
C8441 a_26832_n708.n27 VSS 0.1392f
C8442 a_26832_n708.n29 VSS 0.1392f
C8443 a_26832_n708.n31 VSS 0.18199f
C8444 a_n884_4534.t35 VSS 0.14829f
C8445 a_n884_4534.n1 VSS 2.19422f
C8446 a_n884_4534.t21 VSS 0.12129f
C8447 a_n884_4534.n2 VSS 0.99541f
C8448 a_n884_4534.n3 VSS 0.8403f
C8449 a_n884_4534.t16 VSS 0.12129f
C8450 a_n884_4534.n4 VSS 0.99541f
C8451 a_n884_4534.n5 VSS 0.8403f
C8452 a_n884_4534.t30 VSS 0.12129f
C8453 a_n884_4534.n6 VSS 0.99541f
C8454 a_n884_4534.n7 VSS 0.8403f
C8455 a_n884_4534.t32 VSS 0.12129f
C8456 a_n884_4534.n8 VSS 0.99541f
C8457 a_n884_4534.n9 VSS 0.8403f
C8458 a_n884_4534.t20 VSS 0.12129f
C8459 a_n884_4534.n10 VSS 0.99541f
C8460 a_n884_4534.n11 VSS 0.8403f
C8461 a_n884_4534.t14 VSS 0.12129f
C8462 a_n884_4534.n12 VSS 0.99541f
C8463 a_n884_4534.n13 VSS 0.8403f
C8464 a_n884_4534.t26 VSS 0.12129f
C8465 a_n884_4534.n14 VSS 0.99541f
C8466 a_n884_4534.n15 VSS 0.8403f
C8467 a_n884_4534.t27 VSS 0.12129f
C8468 a_n884_4534.n16 VSS 0.99541f
C8469 a_n884_4534.n17 VSS 0.8403f
C8470 a_n884_4534.t18 VSS 0.12129f
C8471 a_n884_4534.n18 VSS 0.99541f
C8472 a_n884_4534.n19 VSS 0.8403f
C8473 a_n884_4534.t9 VSS 0.12129f
C8474 a_n884_4534.n20 VSS 0.99541f
C8475 a_n884_4534.n21 VSS 0.8403f
C8476 a_n884_4534.t11 VSS 0.12129f
C8477 a_n884_4534.n22 VSS 0.99541f
C8478 a_n884_4534.n23 VSS 0.8403f
C8479 a_n884_4534.t33 VSS 0.12129f
C8480 a_n884_4534.n24 VSS 0.99541f
C8481 a_n884_4534.n25 VSS 0.8403f
C8482 a_n884_4534.t34 VSS 0.12129f
C8483 a_n884_4534.n26 VSS 0.99541f
C8484 a_n884_4534.n27 VSS 0.8403f
C8485 a_n884_4534.t15 VSS 0.12129f
C8486 a_n884_4534.n28 VSS 0.99541f
C8487 a_n884_4534.n29 VSS 0.8403f
C8488 a_n884_4534.t23 VSS 0.12129f
C8489 a_n884_4534.n30 VSS 0.99541f
C8490 a_n884_4534.n31 VSS 0.67354f
C8491 a_n884_4534.n32 VSS 0.35884f
C8492 a_n884_4534.n33 VSS 0.16325f
C8493 a_n884_7670.n0 VSS 0.16325f
C8494 a_n884_7670.t35 VSS 0.14829f
C8495 a_n884_7670.n1 VSS 2.19422f
C8496 a_n884_7670.t21 VSS 0.12129f
C8497 a_n884_7670.n2 VSS 0.99541f
C8498 a_n884_7670.n3 VSS 0.8403f
C8499 a_n884_7670.t16 VSS 0.12129f
C8500 a_n884_7670.n4 VSS 0.99541f
C8501 a_n884_7670.n5 VSS 0.8403f
C8502 a_n884_7670.t30 VSS 0.12129f
C8503 a_n884_7670.n6 VSS 0.99541f
C8504 a_n884_7670.n7 VSS 0.8403f
C8505 a_n884_7670.t32 VSS 0.12129f
C8506 a_n884_7670.n8 VSS 0.99541f
C8507 a_n884_7670.n9 VSS 0.8403f
C8508 a_n884_7670.t20 VSS 0.12129f
C8509 a_n884_7670.n10 VSS 0.99541f
C8510 a_n884_7670.n11 VSS 0.8403f
C8511 a_n884_7670.t14 VSS 0.12129f
C8512 a_n884_7670.n12 VSS 0.99541f
C8513 a_n884_7670.n13 VSS 0.8403f
C8514 a_n884_7670.t26 VSS 0.12129f
C8515 a_n884_7670.n14 VSS 0.99541f
C8516 a_n884_7670.n15 VSS 0.8403f
C8517 a_n884_7670.t27 VSS 0.12129f
C8518 a_n884_7670.n16 VSS 0.99541f
C8519 a_n884_7670.n17 VSS 0.8403f
C8520 a_n884_7670.t18 VSS 0.12129f
C8521 a_n884_7670.n18 VSS 0.99541f
C8522 a_n884_7670.n19 VSS 0.8403f
C8523 a_n884_7670.t9 VSS 0.12129f
C8524 a_n884_7670.n20 VSS 0.99541f
C8525 a_n884_7670.n21 VSS 0.8403f
C8526 a_n884_7670.t11 VSS 0.12129f
C8527 a_n884_7670.n22 VSS 0.99541f
C8528 a_n884_7670.n23 VSS 0.8403f
C8529 a_n884_7670.t33 VSS 0.12129f
C8530 a_n884_7670.n24 VSS 0.99541f
C8531 a_n884_7670.n25 VSS 0.8403f
C8532 a_n884_7670.t34 VSS 0.12129f
C8533 a_n884_7670.n26 VSS 0.99541f
C8534 a_n884_7670.n27 VSS 0.8403f
C8535 a_n884_7670.t15 VSS 0.12129f
C8536 a_n884_7670.n28 VSS 0.99541f
C8537 a_n884_7670.n29 VSS 0.8403f
C8538 a_n884_7670.t23 VSS 0.12129f
C8539 a_n884_7670.n30 VSS 0.99541f
C8540 a_n884_7670.n31 VSS 0.67354f
C8541 a_n884_7670.n32 VSS 0.35884f
C8542 a_19416_n708.n3 VSS 0.26552f
C8543 a_19416_n708.n5 VSS 0.1392f
C8544 a_19416_n708.n7 VSS 0.1392f
C8545 a_19416_n708.n9 VSS 0.1392f
C8546 a_19416_n708.n11 VSS 0.1392f
C8547 a_19416_n708.n13 VSS 0.1392f
C8548 a_19416_n708.n15 VSS 0.1392f
C8549 a_19416_n708.n17 VSS 0.1392f
C8550 a_19416_n708.n19 VSS 0.1392f
C8551 a_19416_n708.n21 VSS 0.1392f
C8552 a_19416_n708.n23 VSS 0.1392f
C8553 a_19416_n708.n25 VSS 0.1392f
C8554 a_19416_n708.n27 VSS 0.1392f
C8555 a_19416_n708.n29 VSS 0.1392f
C8556 a_19416_n708.n31 VSS 0.18199f
C8557 RA1.t35 VSS 0.21849f
C8558 RA1.n0 VSS 0.55201f
C8559 RA1.t19 VSS 0.21849f
C8560 RA1.n1 VSS 0.21996f
C8561 RA1.n2 VSS 3.35439f
C8562 RA1.t38 VSS 0.21849f
C8563 RA1.n3 VSS 0.21996f
C8564 RA1.n4 VSS 1.92978f
C8565 RA1.t6 VSS 0.21849f
C8566 RA1.n5 VSS 0.21996f
C8567 RA1.n6 VSS 1.92978f
C8568 RA1.t27 VSS 0.21849f
C8569 RA1.n7 VSS 0.21996f
C8570 RA1.n8 VSS 1.92978f
C8571 RA1.t7 VSS 0.21849f
C8572 RA1.n9 VSS 0.21996f
C8573 RA1.n10 VSS 1.92978f
C8574 RA1.t31 VSS 0.21849f
C8575 RA1.n11 VSS 0.21996f
C8576 RA1.n12 VSS 1.92978f
C8577 RA1.t1 VSS 0.21849f
C8578 RA1.n13 VSS 0.21996f
C8579 RA1.n14 VSS 1.92978f
C8580 RA1.t18 VSS 0.21849f
C8581 RA1.n15 VSS 0.21996f
C8582 RA1.n16 VSS 1.92978f
C8583 RA1.t43 VSS 0.21849f
C8584 RA1.n17 VSS 0.21996f
C8585 RA1.n18 VSS 1.92978f
C8586 RA1.t25 VSS 0.21849f
C8587 RA1.n19 VSS 0.21996f
C8588 RA1.n20 VSS 1.92978f
C8589 RA1.t46 VSS 0.21849f
C8590 RA1.n21 VSS 0.21996f
C8591 RA1.n22 VSS 1.92978f
C8592 RA1.t24 VSS 0.21849f
C8593 RA1.n23 VSS 0.21996f
C8594 RA1.n24 VSS 1.92978f
C8595 RA1.t45 VSS 0.21849f
C8596 RA1.n25 VSS 0.21996f
C8597 RA1.n26 VSS 1.92978f
C8598 RA1.t12 VSS 0.21849f
C8599 RA1.n27 VSS 0.21996f
C8600 RA1.n28 VSS 1.92978f
C8601 RA1.t23 VSS 0.21849f
C8602 RA1.n29 VSS 0.21996f
C8603 RA1.n30 VSS 2.05312f
C8604 a_21175_n2146.n0 VSS 0.30875f
C8605 a_21175_n2146.n1 VSS 0.14431f
C8606 a_21175_n2146.n2 VSS 0.17149f
C8607 a_21175_n2146.n3 VSS 0.17149f
C8608 a_21175_n2146.n4 VSS 0.14431f
C8609 a_21175_n2146.n5 VSS 0.14431f
C8610 a_21175_n2146.n6 VSS 0.17149f
C8611 a_21175_n2146.n7 VSS 0.17149f
C8612 a_21175_n2146.n8 VSS 0.14431f
C8613 a_21175_n2146.n9 VSS 0.14431f
C8614 a_21175_n2146.n10 VSS 0.17149f
C8615 a_21175_n2146.n11 VSS 0.17149f
C8616 a_21175_n2146.n12 VSS 0.14431f
C8617 a_21175_n2146.n13 VSS 0.14431f
C8618 a_21175_n2146.n14 VSS 0.17149f
C8619 a_21175_n2146.n15 VSS 0.17149f
C8620 a_21175_n2146.n16 VSS 0.14431f
C8621 a_21175_n2146.n17 VSS 0.14431f
C8622 a_21175_n2146.n19 VSS 0.4905f
C8623 a_21175_n2146.n20 VSS 0.14431f
C8624 a_21175_n2146.n21 VSS 0.14431f
C8625 a_21175_n2146.n22 VSS 0.17149f
C8626 a_21175_n2146.n23 VSS 0.17149f
C8627 a_21175_n2146.n24 VSS 0.14431f
C8628 a_21175_n2146.n25 VSS 0.14431f
C8629 a_21175_n2146.n26 VSS 0.17149f
C8630 a_21175_n2146.n27 VSS 0.17149f
C8631 a_21175_n2146.n28 VSS 0.14431f
C8632 a_21175_n2146.n29 VSS 0.14431f
C8633 a_21175_n2146.n30 VSS 0.17149f
C8634 a_21175_n2146.n31 VSS 0.17149f
C8635 a_n1204_10022.t16 VSS 0.13376f
C8636 a_n1204_10022.n1 VSS 2.07431f
C8637 a_n1204_10022.t35 VSS 0.11785f
C8638 a_n1204_10022.n2 VSS 0.92435f
C8639 a_n1204_10022.n3 VSS 0.77453f
C8640 a_n1204_10022.t21 VSS 0.11785f
C8641 a_n1204_10022.n4 VSS 0.92435f
C8642 a_n1204_10022.n5 VSS 0.77453f
C8643 a_n1204_10022.t36 VSS 0.11785f
C8644 a_n1204_10022.n6 VSS 0.92435f
C8645 a_n1204_10022.n7 VSS 0.77453f
C8646 a_n1204_10022.t12 VSS 0.11785f
C8647 a_n1204_10022.n8 VSS 0.92435f
C8648 a_n1204_10022.n9 VSS 0.77453f
C8649 a_n1204_10022.t30 VSS 0.11785f
C8650 a_n1204_10022.n10 VSS 0.92435f
C8651 a_n1204_10022.n11 VSS 0.77453f
C8652 a_n1204_10022.t19 VSS 0.11785f
C8653 a_n1204_10022.n12 VSS 0.92435f
C8654 a_n1204_10022.n13 VSS 0.77453f
C8655 a_n1204_10022.t31 VSS 0.11785f
C8656 a_n1204_10022.n14 VSS 0.92435f
C8657 a_n1204_10022.n15 VSS 0.77453f
C8658 a_n1204_10022.t8 VSS 0.11785f
C8659 a_n1204_10022.n16 VSS 0.92435f
C8660 a_n1204_10022.n17 VSS 0.77453f
C8661 a_n1204_10022.t25 VSS 0.11785f
C8662 a_n1204_10022.n18 VSS 0.92435f
C8663 a_n1204_10022.n19 VSS 0.77453f
C8664 a_n1204_10022.t14 VSS 0.11785f
C8665 a_n1204_10022.n20 VSS 0.92435f
C8666 a_n1204_10022.n21 VSS 0.77453f
C8667 a_n1204_10022.t29 VSS 0.11785f
C8668 a_n1204_10022.n22 VSS 0.92435f
C8669 a_n1204_10022.n23 VSS 0.77453f
C8670 a_n1204_10022.t11 VSS 0.11785f
C8671 a_n1204_10022.n24 VSS 0.92435f
C8672 a_n1204_10022.n25 VSS 0.77453f
C8673 a_n1204_10022.t24 VSS 0.11785f
C8674 a_n1204_10022.n26 VSS 0.92435f
C8675 a_n1204_10022.n27 VSS 0.77453f
C8676 a_n1204_10022.t17 VSS 0.11785f
C8677 a_n1204_10022.n28 VSS 0.92435f
C8678 a_n1204_10022.n29 VSS 0.77453f
C8679 a_n1204_10022.t34 VSS 0.11785f
C8680 a_n1204_10022.n30 VSS 0.92435f
C8681 a_n1204_10022.n31 VSS 0.60701f
C8682 a_n1204_10022.n32 VSS 0.25574f
C8683 a_n1204_10022.n33 VSS 0.12464f
C8684 a_n1204_10022.n34 VSS 0.13846f
C8685 a_n1204_10022.n35 VSS 0.23288f
C8686 a_n1204_10022.n36 VSS 0.16146f
C8687 a_n1204_2182.t5 VSS 0.13376f
C8688 a_n1204_2182.n1 VSS 2.07431f
C8689 a_n1204_2182.t26 VSS 0.11785f
C8690 a_n1204_2182.n2 VSS 0.92435f
C8691 a_n1204_2182.n3 VSS 0.77453f
C8692 a_n1204_2182.t21 VSS 0.11785f
C8693 a_n1204_2182.n4 VSS 0.92435f
C8694 a_n1204_2182.n5 VSS 0.77453f
C8695 a_n1204_2182.t36 VSS 0.11785f
C8696 a_n1204_2182.n6 VSS 0.92435f
C8697 a_n1204_2182.n7 VSS 0.77453f
C8698 a_n1204_2182.t37 VSS 0.11785f
C8699 a_n1204_2182.n8 VSS 0.92435f
C8700 a_n1204_2182.n9 VSS 0.77453f
C8701 a_n1204_2182.t25 VSS 0.11785f
C8702 a_n1204_2182.n10 VSS 0.92435f
C8703 a_n1204_2182.n11 VSS 0.77453f
C8704 a_n1204_2182.t19 VSS 0.11785f
C8705 a_n1204_2182.n12 VSS 0.92435f
C8706 a_n1204_2182.n13 VSS 0.77453f
C8707 a_n1204_2182.t31 VSS 0.11785f
C8708 a_n1204_2182.n14 VSS 0.92435f
C8709 a_n1204_2182.n15 VSS 0.77453f
C8710 a_n1204_2182.t33 VSS 0.11785f
C8711 a_n1204_2182.n16 VSS 0.92435f
C8712 a_n1204_2182.n17 VSS 0.77453f
C8713 a_n1204_2182.t23 VSS 0.11785f
C8714 a_n1204_2182.n18 VSS 0.92435f
C8715 a_n1204_2182.n19 VSS 0.77453f
C8716 a_n1204_2182.t15 VSS 0.11785f
C8717 a_n1204_2182.n20 VSS 0.92435f
C8718 a_n1204_2182.n21 VSS 0.77453f
C8719 a_n1204_2182.t17 VSS 0.11785f
C8720 a_n1204_2182.n22 VSS 0.92435f
C8721 a_n1204_2182.n23 VSS 0.77453f
C8722 a_n1204_2182.t39 VSS 0.11785f
C8723 a_n1204_2182.n24 VSS 0.92435f
C8724 a_n1204_2182.n25 VSS 0.77453f
C8725 a_n1204_2182.t4 VSS 0.11785f
C8726 a_n1204_2182.n26 VSS 0.92435f
C8727 a_n1204_2182.n27 VSS 0.77453f
C8728 a_n1204_2182.t20 VSS 0.11785f
C8729 a_n1204_2182.n28 VSS 0.92435f
C8730 a_n1204_2182.n29 VSS 0.77453f
C8731 a_n1204_2182.t28 VSS 0.11785f
C8732 a_n1204_2182.n30 VSS 0.92435f
C8733 a_n1204_2182.n31 VSS 0.60701f
C8734 a_n1204_2182.n32 VSS 0.25574f
C8735 a_n1204_2182.n33 VSS 0.12464f
C8736 a_n1204_2182.n34 VSS 0.13846f
C8737 a_n1204_2182.n35 VSS 0.23288f
C8738 a_n1204_2182.n36 VSS 0.16146f
C8739 RA12.t39 VSS 0.21849f
C8740 RA12.n0 VSS 0.55201f
C8741 RA12.t24 VSS 0.21849f
C8742 RA12.n1 VSS 0.21996f
C8743 RA12.n2 VSS 3.35439f
C8744 RA12.t26 VSS 0.21849f
C8745 RA12.n3 VSS 0.21996f
C8746 RA12.n4 VSS 1.92978f
C8747 RA12.t12 VSS 0.21849f
C8748 RA12.n5 VSS 0.21996f
C8749 RA12.n6 VSS 1.92978f
C8750 RA12.t7 VSS 0.21849f
C8751 RA12.n7 VSS 0.21996f
C8752 RA12.n8 VSS 1.92978f
C8753 RA12.t22 VSS 0.21849f
C8754 RA12.n9 VSS 0.21996f
C8755 RA12.n10 VSS 1.92978f
C8756 RA12.t23 VSS 0.21849f
C8757 RA12.n11 VSS 0.21996f
C8758 RA12.n12 VSS 1.92978f
C8759 RA12.t11 VSS 0.21849f
C8760 RA12.n13 VSS 0.21996f
C8761 RA12.n14 VSS 1.92978f
C8762 RA12.t6 VSS 0.21849f
C8763 RA12.n15 VSS 0.21996f
C8764 RA12.n16 VSS 1.92978f
C8765 RA12.t37 VSS 0.21849f
C8766 RA12.n17 VSS 0.21996f
C8767 RA12.n18 VSS 1.92978f
C8768 RA12.t21 VSS 0.21849f
C8769 RA12.n19 VSS 0.21996f
C8770 RA12.n20 VSS 1.92978f
C8771 RA12.t10 VSS 0.21849f
C8772 RA12.n21 VSS 0.21996f
C8773 RA12.n22 VSS 1.92978f
C8774 RA12.t8 VSS 0.21849f
C8775 RA12.n23 VSS 0.21996f
C8776 RA12.n24 VSS 1.92978f
C8777 RA12.t40 VSS 0.21849f
C8778 RA12.n25 VSS 0.21996f
C8779 RA12.n26 VSS 1.92978f
C8780 RA12.t41 VSS 0.21849f
C8781 RA12.n27 VSS 0.21996f
C8782 RA12.n28 VSS 1.92978f
C8783 RA12.t14 VSS 0.21849f
C8784 RA12.n29 VSS 0.21996f
C8785 RA12.n30 VSS 2.05275f
C8786 RB14.t4 VSS 0.17349f
C8787 RB14.t19 VSS 0.10604f
C8788 RB14.n0 VSS 0.43324f
C8789 RB14.t11 VSS 0.17349f
C8790 RB14.t10 VSS 0.10604f
C8791 RB14.n1 VSS 0.21645f
C8792 RB14.n2 VSS 2.82816f
C8793 RB14.t15 VSS 0.17349f
C8794 RB14.t41 VSS 0.10604f
C8795 RB14.n3 VSS 0.21645f
C8796 RB14.n4 VSS 1.8981f
C8797 RB14.t13 VSS 0.17349f
C8798 RB14.t29 VSS 0.10604f
C8799 RB14.n5 VSS 0.21645f
C8800 RB14.n6 VSS 1.8981f
C8801 RB14.t46 VSS 0.17349f
C8802 RB14.t16 VSS 0.10604f
C8803 RB14.n7 VSS 0.21645f
C8804 RB14.n8 VSS 1.8981f
C8805 RB14.t5 VSS 0.17349f
C8806 RB14.t3 VSS 0.10604f
C8807 RB14.n9 VSS 0.21645f
C8808 RB14.n10 VSS 1.8981f
C8809 RB14.t12 VSS 0.17349f
C8810 RB14.t39 VSS 0.10604f
C8811 RB14.n11 VSS 0.21645f
C8812 RB14.n12 VSS 1.8981f
C8813 RB14.t1 VSS 0.17349f
C8814 RB14.t40 VSS 0.10604f
C8815 RB14.n13 VSS 0.21645f
C8816 RB14.n14 VSS 1.8981f
C8817 RB14.t44 VSS 0.17349f
C8818 RB14.t21 VSS 0.10604f
C8819 RB14.n15 VSS 0.21645f
C8820 RB14.n16 VSS 1.8981f
C8821 RB14.t47 VSS 0.17349f
C8822 RB14.t0 VSS 0.10604f
C8823 RB14.n17 VSS 0.21645f
C8824 RB14.n18 VSS 1.8981f
C8825 RB14.t43 VSS 0.17349f
C8826 RB14.t2 VSS 0.10604f
C8827 RB14.n19 VSS 0.21645f
C8828 RB14.n20 VSS 1.8981f
C8829 RB14.t45 VSS 0.17349f
C8830 RB14.t37 VSS 0.10604f
C8831 RB14.n21 VSS 0.21645f
C8832 RB14.n22 VSS 1.8981f
C8833 RB14.t7 VSS 0.17349f
C8834 RB14.t34 VSS 0.10604f
C8835 RB14.n23 VSS 0.21645f
C8836 RB14.n24 VSS 1.8981f
C8837 RB14.t14 VSS 0.17349f
C8838 RB14.t6 VSS 0.10604f
C8839 RB14.n25 VSS 0.21645f
C8840 RB14.n26 VSS 1.8981f
C8841 RB14.t8 VSS 0.17349f
C8842 RB14.t9 VSS 0.10604f
C8843 RB14.n27 VSS 0.21645f
C8844 RB14.n28 VSS 1.8981f
C8845 RB14.t26 VSS 0.17349f
C8846 RB14.t28 VSS 0.10604f
C8847 RB14.n29 VSS 0.21645f
C8848 RB14.n30 VSS 2.30808f
C8849 a_n1204_2966.t37 VSS 0.13376f
C8850 a_n1204_2966.n1 VSS 2.07431f
C8851 a_n1204_2966.t20 VSS 0.11785f
C8852 a_n1204_2966.n2 VSS 0.92435f
C8853 a_n1204_2966.n3 VSS 0.77453f
C8854 a_n1204_2966.t14 VSS 0.11785f
C8855 a_n1204_2966.n4 VSS 0.92435f
C8856 a_n1204_2966.n5 VSS 0.77453f
C8857 a_n1204_2966.t33 VSS 0.11785f
C8858 a_n1204_2966.n6 VSS 0.92435f
C8859 a_n1204_2966.n7 VSS 0.77453f
C8860 a_n1204_2966.t34 VSS 0.11785f
C8861 a_n1204_2966.n8 VSS 0.92435f
C8862 a_n1204_2966.n9 VSS 0.77453f
C8863 a_n1204_2966.t18 VSS 0.11785f
C8864 a_n1204_2966.n10 VSS 0.92435f
C8865 a_n1204_2966.n11 VSS 0.77453f
C8866 a_n1204_2966.t12 VSS 0.11785f
C8867 a_n1204_2966.n12 VSS 0.92435f
C8868 a_n1204_2966.n13 VSS 0.77453f
C8869 a_n1204_2966.t30 VSS 0.11785f
C8870 a_n1204_2966.n14 VSS 0.92435f
C8871 a_n1204_2966.n15 VSS 0.77453f
C8872 a_n1204_2966.t32 VSS 0.11785f
C8873 a_n1204_2966.n16 VSS 0.92435f
C8874 a_n1204_2966.n17 VSS 0.77453f
C8875 a_n1204_2966.t17 VSS 0.11785f
C8876 a_n1204_2966.n18 VSS 0.92435f
C8877 a_n1204_2966.n19 VSS 0.77453f
C8878 a_n1204_2966.t10 VSS 0.11785f
C8879 a_n1204_2966.n20 VSS 0.92435f
C8880 a_n1204_2966.n21 VSS 0.77453f
C8881 a_n1204_2966.t11 VSS 0.11785f
C8882 a_n1204_2966.n22 VSS 0.92435f
C8883 a_n1204_2966.n23 VSS 0.77453f
C8884 a_n1204_2966.t35 VSS 0.11785f
C8885 a_n1204_2966.n24 VSS 0.92435f
C8886 a_n1204_2966.n25 VSS 0.77453f
C8887 a_n1204_2966.t36 VSS 0.11785f
C8888 a_n1204_2966.n26 VSS 0.92435f
C8889 a_n1204_2966.n27 VSS 0.77453f
C8890 a_n1204_2966.t13 VSS 0.11785f
C8891 a_n1204_2966.n28 VSS 0.92435f
C8892 a_n1204_2966.n29 VSS 0.77453f
C8893 a_n1204_2966.t21 VSS 0.11785f
C8894 a_n1204_2966.n30 VSS 0.92435f
C8895 a_n1204_2966.n31 VSS 0.60701f
C8896 a_n1204_2966.n32 VSS 0.25574f
C8897 a_n1204_2966.n33 VSS 0.12464f
C8898 a_n1204_2966.n34 VSS 0.13846f
C8899 a_n1204_2966.n35 VSS 0.23288f
C8900 a_n1204_2966.n36 VSS 0.16146f
C8901 a_1399_n2146.n0 VSS 0.30875f
C8902 a_1399_n2146.n1 VSS 0.14431f
C8903 a_1399_n2146.n2 VSS 0.17149f
C8904 a_1399_n2146.n3 VSS 0.17149f
C8905 a_1399_n2146.n4 VSS 0.14431f
C8906 a_1399_n2146.n5 VSS 0.14431f
C8907 a_1399_n2146.n6 VSS 0.17149f
C8908 a_1399_n2146.n7 VSS 0.17149f
C8909 a_1399_n2146.n8 VSS 0.14431f
C8910 a_1399_n2146.n9 VSS 0.14431f
C8911 a_1399_n2146.n10 VSS 0.17149f
C8912 a_1399_n2146.n11 VSS 0.17149f
C8913 a_1399_n2146.n12 VSS 0.14431f
C8914 a_1399_n2146.n13 VSS 0.14431f
C8915 a_1399_n2146.n14 VSS 0.17149f
C8916 a_1399_n2146.n15 VSS 0.17149f
C8917 a_1399_n2146.n16 VSS 0.14431f
C8918 a_1399_n2146.n17 VSS 0.14431f
C8919 a_1399_n2146.n19 VSS 0.4905f
C8920 a_1399_n2146.n20 VSS 0.14431f
C8921 a_1399_n2146.n21 VSS 0.14431f
C8922 a_1399_n2146.n22 VSS 0.17149f
C8923 a_1399_n2146.n23 VSS 0.17149f
C8924 a_1399_n2146.n24 VSS 0.14431f
C8925 a_1399_n2146.n25 VSS 0.14431f
C8926 a_1399_n2146.n26 VSS 0.17149f
C8927 a_1399_n2146.n27 VSS 0.17149f
C8928 a_1399_n2146.n28 VSS 0.14431f
C8929 a_1399_n2146.n29 VSS 0.14431f
C8930 a_1399_n2146.n30 VSS 0.17149f
C8931 a_1399_n2146.n31 VSS 0.17149f
C8932 a_n884_n170.t20 VSS 0.14829f
C8933 a_n884_n170.n1 VSS 2.19422f
C8934 a_n884_n170.t30 VSS 0.12129f
C8935 a_n884_n170.n2 VSS 0.99541f
C8936 a_n884_n170.n3 VSS 0.8403f
C8937 a_n884_n170.t22 VSS 0.12129f
C8938 a_n884_n170.n4 VSS 0.99541f
C8939 a_n884_n170.n5 VSS 0.8403f
C8940 a_n884_n170.t27 VSS 0.12129f
C8941 a_n884_n170.n6 VSS 0.99541f
C8942 a_n884_n170.n7 VSS 0.8403f
C8943 a_n884_n170.t14 VSS 0.12129f
C8944 a_n884_n170.n8 VSS 0.99541f
C8945 a_n884_n170.n9 VSS 0.8403f
C8946 a_n884_n170.t21 VSS 0.12129f
C8947 a_n884_n170.n10 VSS 0.99541f
C8948 a_n884_n170.n11 VSS 0.8403f
C8949 a_n884_n170.t31 VSS 0.12129f
C8950 a_n884_n170.n12 VSS 0.99541f
C8951 a_n884_n170.n13 VSS 0.8403f
C8952 a_n884_n170.t17 VSS 0.12129f
C8953 a_n884_n170.n14 VSS 0.99541f
C8954 a_n884_n170.n15 VSS 0.8403f
C8955 a_n884_n170.t11 VSS 0.12129f
C8956 a_n884_n170.n16 VSS 0.99541f
C8957 a_n884_n170.n17 VSS 0.8403f
C8958 a_n884_n170.t15 VSS 0.12129f
C8959 a_n884_n170.n18 VSS 0.99541f
C8960 a_n884_n170.n19 VSS 0.8403f
C8961 a_n884_n170.t24 VSS 0.12129f
C8962 a_n884_n170.n20 VSS 0.99541f
C8963 a_n884_n170.n21 VSS 0.8403f
C8964 a_n884_n170.t13 VSS 0.12129f
C8965 a_n884_n170.n22 VSS 0.99541f
C8966 a_n884_n170.n23 VSS 0.8403f
C8967 a_n884_n170.t29 VSS 0.12129f
C8968 a_n884_n170.n24 VSS 0.99541f
C8969 a_n884_n170.n25 VSS 0.8403f
C8970 a_n884_n170.t16 VSS 0.12129f
C8971 a_n884_n170.n26 VSS 0.99541f
C8972 a_n884_n170.n27 VSS 0.8403f
C8973 a_n884_n170.t33 VSS 0.12129f
C8974 a_n884_n170.n28 VSS 0.99541f
C8975 a_n884_n170.n29 VSS 0.8403f
C8976 a_n884_n170.t12 VSS 0.12129f
C8977 a_n884_n170.n30 VSS 0.99541f
C8978 a_n884_n170.n31 VSS 0.67354f
C8979 a_n884_n170.n32 VSS 0.35884f
C8980 a_n884_n170.n33 VSS 0.16325f
C8981 a_n1204_n170.t20 VSS 0.13376f
C8982 a_n1204_n170.n1 VSS 2.07431f
C8983 a_n1204_n170.t6 VSS 0.11785f
C8984 a_n1204_n170.n2 VSS 0.92435f
C8985 a_n1204_n170.n3 VSS 0.77453f
C8986 a_n1204_n170.t38 VSS 0.11785f
C8987 a_n1204_n170.n4 VSS 0.92435f
C8988 a_n1204_n170.n5 VSS 0.77453f
C8989 a_n1204_n170.t15 VSS 0.11785f
C8990 a_n1204_n170.n6 VSS 0.92435f
C8991 a_n1204_n170.n7 VSS 0.77453f
C8992 a_n1204_n170.t16 VSS 0.11785f
C8993 a_n1204_n170.n8 VSS 0.92435f
C8994 a_n1204_n170.n9 VSS 0.77453f
C8995 a_n1204_n170.t5 VSS 0.11785f
C8996 a_n1204_n170.n10 VSS 0.92435f
C8997 a_n1204_n170.n11 VSS 0.77453f
C8998 a_n1204_n170.t35 VSS 0.11785f
C8999 a_n1204_n170.n12 VSS 0.92435f
C9000 a_n1204_n170.n13 VSS 0.77453f
C9001 a_n1204_n170.t13 VSS 0.11785f
C9002 a_n1204_n170.n14 VSS 0.92435f
C9003 a_n1204_n170.n15 VSS 0.77453f
C9004 a_n1204_n170.t14 VSS 0.11785f
C9005 a_n1204_n170.n16 VSS 0.92435f
C9006 a_n1204_n170.n17 VSS 0.77453f
C9007 a_n1204_n170.t39 VSS 0.11785f
C9008 a_n1204_n170.n18 VSS 0.92435f
C9009 a_n1204_n170.n19 VSS 0.77453f
C9010 a_n1204_n170.t32 VSS 0.11785f
C9011 a_n1204_n170.n20 VSS 0.92435f
C9012 a_n1204_n170.n21 VSS 0.77453f
C9013 a_n1204_n170.t33 VSS 0.11785f
C9014 a_n1204_n170.n22 VSS 0.92435f
C9015 a_n1204_n170.n23 VSS 0.77453f
C9016 a_n1204_n170.t17 VSS 0.11785f
C9017 a_n1204_n170.n24 VSS 0.92435f
C9018 a_n1204_n170.n25 VSS 0.77453f
C9019 a_n1204_n170.t18 VSS 0.11785f
C9020 a_n1204_n170.n26 VSS 0.92435f
C9021 a_n1204_n170.n27 VSS 0.77453f
C9022 a_n1204_n170.t37 VSS 0.11785f
C9023 a_n1204_n170.n28 VSS 0.92435f
C9024 a_n1204_n170.n29 VSS 0.77453f
C9025 a_n1204_n170.t7 VSS 0.11785f
C9026 a_n1204_n170.n30 VSS 0.92435f
C9027 a_n1204_n170.n31 VSS 0.60701f
C9028 a_n1204_n170.n32 VSS 0.25574f
C9029 a_n1204_n170.n33 VSS 0.12464f
C9030 a_n1204_n170.n34 VSS 0.13846f
C9031 a_n1204_n170.n35 VSS 0.23288f
C9032 a_n1204_n170.n36 VSS 0.16146f
C9033 a_n884_5318.n0 VSS 0.16325f
C9034 a_n884_5318.t27 VSS 0.14829f
C9035 a_n884_5318.n1 VSS 2.19422f
C9036 a_n884_5318.t14 VSS 0.12129f
C9037 a_n884_5318.n2 VSS 0.99541f
C9038 a_n884_5318.n3 VSS 0.8403f
C9039 a_n884_5318.t8 VSS 0.12129f
C9040 a_n884_5318.n4 VSS 0.99541f
C9041 a_n884_5318.n5 VSS 0.8403f
C9042 a_n884_5318.t23 VSS 0.12129f
C9043 a_n884_5318.n6 VSS 0.99541f
C9044 a_n884_5318.n7 VSS 0.8403f
C9045 a_n884_5318.t24 VSS 0.12129f
C9046 a_n884_5318.n8 VSS 0.99541f
C9047 a_n884_5318.n9 VSS 0.8403f
C9048 a_n884_5318.t12 VSS 0.12129f
C9049 a_n884_5318.n10 VSS 0.99541f
C9050 a_n884_5318.n11 VSS 0.8403f
C9051 a_n884_5318.t6 VSS 0.12129f
C9052 a_n884_5318.n12 VSS 0.99541f
C9053 a_n884_5318.n13 VSS 0.8403f
C9054 a_n884_5318.t19 VSS 0.12129f
C9055 a_n884_5318.n14 VSS 0.99541f
C9056 a_n884_5318.n15 VSS 0.8403f
C9057 a_n884_5318.t21 VSS 0.12129f
C9058 a_n884_5318.n16 VSS 0.99541f
C9059 a_n884_5318.n17 VSS 0.8403f
C9060 a_n884_5318.t10 VSS 0.12129f
C9061 a_n884_5318.n18 VSS 0.99541f
C9062 a_n884_5318.n19 VSS 0.8403f
C9063 a_n884_5318.t35 VSS 0.12129f
C9064 a_n884_5318.n20 VSS 0.99541f
C9065 a_n884_5318.n21 VSS 0.8403f
C9066 a_n884_5318.t5 VSS 0.12129f
C9067 a_n884_5318.n22 VSS 0.99541f
C9068 a_n884_5318.n23 VSS 0.8403f
C9069 a_n884_5318.t25 VSS 0.12129f
C9070 a_n884_5318.n24 VSS 0.99541f
C9071 a_n884_5318.n25 VSS 0.8403f
C9072 a_n884_5318.t26 VSS 0.12129f
C9073 a_n884_5318.n26 VSS 0.99541f
C9074 a_n884_5318.n27 VSS 0.8403f
C9075 a_n884_5318.t7 VSS 0.12129f
C9076 a_n884_5318.n28 VSS 0.99541f
C9077 a_n884_5318.n29 VSS 0.8403f
C9078 a_n884_5318.t15 VSS 0.12129f
C9079 a_n884_5318.n30 VSS 0.99541f
C9080 a_n884_5318.n31 VSS 0.67354f
C9081 a_n884_5318.n32 VSS 0.35884f
C9082 a_15961_n862.n0 VSS 0.30869f
C9083 a_15961_n862.n1 VSS 0.14432f
C9084 a_15961_n862.n2 VSS 0.17142f
C9085 a_15961_n862.n3 VSS 0.17142f
C9086 a_15961_n862.n4 VSS 0.14432f
C9087 a_15961_n862.n5 VSS 0.14432f
C9088 a_15961_n862.n6 VSS 0.17142f
C9089 a_15961_n862.n7 VSS 0.17142f
C9090 a_15961_n862.n8 VSS 0.14432f
C9091 a_15961_n862.n9 VSS 0.14432f
C9092 a_15961_n862.n10 VSS 0.17142f
C9093 a_15961_n862.n11 VSS 0.17142f
C9094 a_15961_n862.n12 VSS 0.14432f
C9095 a_15961_n862.n13 VSS 0.14432f
C9096 a_15961_n862.n14 VSS 0.17142f
C9097 a_15961_n862.n15 VSS 0.17142f
C9098 a_15961_n862.n16 VSS 0.14432f
C9099 a_15961_n862.n17 VSS 0.14432f
C9100 a_15961_n862.n18 VSS 0.17142f
C9101 a_15961_n862.n19 VSS 0.17142f
C9102 a_15961_n862.n20 VSS 0.14432f
C9103 a_15961_n862.n21 VSS 0.14432f
C9104 a_15961_n862.n23 VSS 0.48932f
C9105 a_15961_n862.n24 VSS 0.14432f
C9106 a_15961_n862.n25 VSS 0.14432f
C9107 a_15961_n862.n26 VSS 0.17142f
C9108 a_15961_n862.n27 VSS 0.17142f
C9109 a_15961_n862.n28 VSS 0.14432f
C9110 a_15961_n862.n29 VSS 0.14432f
C9111 a_15961_n862.n30 VSS 0.17142f
C9112 a_15961_n862.n31 VSS 0.17142f
C9113 RA8.t26 VSS 0.21849f
C9114 RA8.n0 VSS 0.55201f
C9115 RA8.t11 VSS 0.21849f
C9116 RA8.n1 VSS 0.21996f
C9117 RA8.n2 VSS 3.35439f
C9118 RA8.t13 VSS 0.21849f
C9119 RA8.n3 VSS 0.21996f
C9120 RA8.n4 VSS 1.92978f
C9121 RA8.t47 VSS 0.21849f
C9122 RA8.n5 VSS 0.21996f
C9123 RA8.n6 VSS 1.92978f
C9124 RA8.t41 VSS 0.21849f
C9125 RA8.n7 VSS 0.21996f
C9126 RA8.n8 VSS 1.92978f
C9127 RA8.t9 VSS 0.21849f
C9128 RA8.n9 VSS 0.21996f
C9129 RA8.n10 VSS 1.92978f
C9130 RA8.t10 VSS 0.21849f
C9131 RA8.n11 VSS 0.21996f
C9132 RA8.n12 VSS 1.92978f
C9133 RA8.t45 VSS 0.21849f
C9134 RA8.n13 VSS 0.21996f
C9135 RA8.n14 VSS 1.92978f
C9136 RA8.t39 VSS 0.21849f
C9137 RA8.n15 VSS 0.21996f
C9138 RA8.n16 VSS 1.92978f
C9139 RA8.t24 VSS 0.21849f
C9140 RA8.n17 VSS 0.21996f
C9141 RA8.n18 VSS 1.92978f
C9142 RA8.t8 VSS 0.21849f
C9143 RA8.n19 VSS 0.21996f
C9144 RA8.n20 VSS 1.92978f
C9145 RA8.t44 VSS 0.21849f
C9146 RA8.n21 VSS 0.21996f
C9147 RA8.n22 VSS 1.92978f
C9148 RA8.t42 VSS 0.21849f
C9149 RA8.n23 VSS 0.21996f
C9150 RA8.n24 VSS 1.92978f
C9151 RA8.t27 VSS 0.21849f
C9152 RA8.n25 VSS 0.21996f
C9153 RA8.n26 VSS 1.92978f
C9154 RA8.t28 VSS 0.21849f
C9155 RA8.n27 VSS 0.21996f
C9156 RA8.n28 VSS 1.92978f
C9157 RA8.t1 VSS 0.21849f
C9158 RA8.n29 VSS 0.21996f
C9159 RA8.n30 VSS 2.05089f
C9160 RB3.t4 VSS 0.10604f
C9161 RB3.t9 VSS 0.17349f
C9162 RB3.n0 VSS 0.43324f
C9163 RB3.t38 VSS 0.10604f
C9164 RB3.t1 VSS 0.17349f
C9165 RB3.n1 VSS 0.21645f
C9166 RB3.n2 VSS 2.82816f
C9167 RB3.t24 VSS 0.10604f
C9168 RB3.t29 VSS 0.17349f
C9169 RB3.n3 VSS 0.21645f
C9170 RB3.n4 VSS 1.8981f
C9171 RB3.t12 VSS 0.10604f
C9172 RB3.t15 VSS 0.17349f
C9173 RB3.n5 VSS 0.21645f
C9174 RB3.n6 VSS 1.8981f
C9175 RB3.t2 VSS 0.10604f
C9176 RB3.t7 VSS 0.17349f
C9177 RB3.n7 VSS 0.21645f
C9178 RB3.n8 VSS 1.8981f
C9179 RB3.t34 VSS 0.10604f
C9180 RB3.t46 VSS 0.17349f
C9181 RB3.n9 VSS 0.21645f
C9182 RB3.n10 VSS 1.8981f
C9183 RB3.t22 VSS 0.10604f
C9184 RB3.t27 VSS 0.17349f
C9185 RB3.n11 VSS 0.21645f
C9186 RB3.n12 VSS 1.8981f
C9187 RB3.t23 VSS 0.10604f
C9188 RB3.t28 VSS 0.17349f
C9189 RB3.n13 VSS 0.21645f
C9190 RB3.n14 VSS 1.8981f
C9191 RB3.t5 VSS 0.10604f
C9192 RB3.t10 VSS 0.17349f
C9193 RB3.n15 VSS 0.21645f
C9194 RB3.n16 VSS 1.8981f
C9195 RB3.t32 VSS 0.10604f
C9196 RB3.t44 VSS 0.17349f
C9197 RB3.n17 VSS 0.21645f
C9198 RB3.n18 VSS 1.8981f
C9199 RB3.t33 VSS 0.10604f
C9200 RB3.t45 VSS 0.17349f
C9201 RB3.n19 VSS 0.21645f
C9202 RB3.n20 VSS 1.8981f
C9203 RB3.t21 VSS 0.10604f
C9204 RB3.t26 VSS 0.17349f
C9205 RB3.n21 VSS 0.21645f
C9206 RB3.n22 VSS 1.8981f
C9207 RB3.t17 VSS 0.10604f
C9208 RB3.t25 VSS 0.17349f
C9209 RB3.n23 VSS 0.21645f
C9210 RB3.n24 VSS 1.8981f
C9211 RB3.t35 VSS 0.10604f
C9212 RB3.t47 VSS 0.17349f
C9213 RB3.n25 VSS 0.21645f
C9214 RB3.n26 VSS 1.8981f
C9215 RB3.t37 VSS 0.10604f
C9216 RB3.t0 VSS 0.17349f
C9217 RB3.n27 VSS 0.21645f
C9218 RB3.n28 VSS 1.8981f
C9219 RB3.t11 VSS 0.10604f
C9220 RB3.t13 VSS 0.17349f
C9221 RB3.n29 VSS 0.21645f
C9222 RB3.n30 VSS 2.30845f
C9223 a_31063_n2146.n0 VSS 0.30875f
C9224 a_31063_n2146.n1 VSS 0.14431f
C9225 a_31063_n2146.n2 VSS 0.17149f
C9226 a_31063_n2146.n3 VSS 0.17149f
C9227 a_31063_n2146.n4 VSS 0.14431f
C9228 a_31063_n2146.n5 VSS 0.14431f
C9229 a_31063_n2146.n6 VSS 0.17149f
C9230 a_31063_n2146.n7 VSS 0.17149f
C9231 a_31063_n2146.n8 VSS 0.14431f
C9232 a_31063_n2146.n9 VSS 0.14431f
C9233 a_31063_n2146.n10 VSS 0.17149f
C9234 a_31063_n2146.n11 VSS 0.17149f
C9235 a_31063_n2146.n12 VSS 0.14431f
C9236 a_31063_n2146.n13 VSS 0.14431f
C9237 a_31063_n2146.n14 VSS 0.17149f
C9238 a_31063_n2146.n15 VSS 0.17149f
C9239 a_31063_n2146.n16 VSS 0.14431f
C9240 a_31063_n2146.n17 VSS 0.14431f
C9241 a_31063_n2146.n19 VSS 0.4905f
C9242 a_31063_n2146.n20 VSS 0.14431f
C9243 a_31063_n2146.n21 VSS 0.14431f
C9244 a_31063_n2146.n22 VSS 0.17149f
C9245 a_31063_n2146.n23 VSS 0.17149f
C9246 a_31063_n2146.n24 VSS 0.14431f
C9247 a_31063_n2146.n25 VSS 0.14431f
C9248 a_31063_n2146.n26 VSS 0.17149f
C9249 a_31063_n2146.n27 VSS 0.17149f
C9250 a_31063_n2146.n28 VSS 0.14431f
C9251 a_31063_n2146.n29 VSS 0.14431f
C9252 a_31063_n2146.n30 VSS 0.17149f
C9253 a_31063_n2146.n31 VSS 0.17149f
C9254 a_n1204_6886.t25 VSS 0.13376f
C9255 a_n1204_6886.n1 VSS 2.07431f
C9256 a_n1204_6886.t10 VSS 0.11785f
C9257 a_n1204_6886.n2 VSS 0.92435f
C9258 a_n1204_6886.n3 VSS 0.77453f
C9259 a_n1204_6886.t37 VSS 0.11785f
C9260 a_n1204_6886.n4 VSS 0.92435f
C9261 a_n1204_6886.n5 VSS 0.77453f
C9262 a_n1204_6886.t19 VSS 0.11785f
C9263 a_n1204_6886.n6 VSS 0.92435f
C9264 a_n1204_6886.n7 VSS 0.77453f
C9265 a_n1204_6886.t20 VSS 0.11785f
C9266 a_n1204_6886.n8 VSS 0.92435f
C9267 a_n1204_6886.n9 VSS 0.77453f
C9268 a_n1204_6886.t9 VSS 0.11785f
C9269 a_n1204_6886.n10 VSS 0.92435f
C9270 a_n1204_6886.n11 VSS 0.77453f
C9271 a_n1204_6886.t35 VSS 0.11785f
C9272 a_n1204_6886.n12 VSS 0.92435f
C9273 a_n1204_6886.n13 VSS 0.77453f
C9274 a_n1204_6886.t17 VSS 0.11785f
C9275 a_n1204_6886.n14 VSS 0.92435f
C9276 a_n1204_6886.n15 VSS 0.77453f
C9277 a_n1204_6886.t18 VSS 0.11785f
C9278 a_n1204_6886.n16 VSS 0.92435f
C9279 a_n1204_6886.n17 VSS 0.77453f
C9280 a_n1204_6886.t6 VSS 0.11785f
C9281 a_n1204_6886.n18 VSS 0.92435f
C9282 a_n1204_6886.n19 VSS 0.77453f
C9283 a_n1204_6886.t33 VSS 0.11785f
C9284 a_n1204_6886.n20 VSS 0.92435f
C9285 a_n1204_6886.n21 VSS 0.77453f
C9286 a_n1204_6886.t34 VSS 0.11785f
C9287 a_n1204_6886.n22 VSS 0.92435f
C9288 a_n1204_6886.n23 VSS 0.77453f
C9289 a_n1204_6886.t22 VSS 0.11785f
C9290 a_n1204_6886.n24 VSS 0.92435f
C9291 a_n1204_6886.n25 VSS 0.77453f
C9292 a_n1204_6886.t24 VSS 0.11785f
C9293 a_n1204_6886.n26 VSS 0.92435f
C9294 a_n1204_6886.n27 VSS 0.77453f
C9295 a_n1204_6886.t36 VSS 0.11785f
C9296 a_n1204_6886.n28 VSS 0.92435f
C9297 a_n1204_6886.n29 VSS 0.77453f
C9298 a_n1204_6886.t14 VSS 0.11785f
C9299 a_n1204_6886.n30 VSS 0.92435f
C9300 a_n1204_6886.n31 VSS 0.60701f
C9301 a_n1204_6886.n32 VSS 0.25574f
C9302 a_n1204_6886.n33 VSS 0.12464f
C9303 a_n1204_6886.n34 VSS 0.13846f
C9304 a_n1204_6886.n35 VSS 0.23288f
C9305 a_n1204_6886.n36 VSS 0.16146f
C9306 a_n1204_9238.t19 VSS 0.13376f
C9307 a_n1204_9238.n1 VSS 2.07431f
C9308 a_n1204_9238.t39 VSS 0.11785f
C9309 a_n1204_9238.n2 VSS 0.92435f
C9310 a_n1204_9238.n3 VSS 0.77453f
C9311 a_n1204_9238.t33 VSS 0.11785f
C9312 a_n1204_9238.n4 VSS 0.92435f
C9313 a_n1204_9238.n5 VSS 0.77453f
C9314 a_n1204_9238.t14 VSS 0.11785f
C9315 a_n1204_9238.n6 VSS 0.92435f
C9316 a_n1204_9238.n7 VSS 0.77453f
C9317 a_n1204_9238.t15 VSS 0.11785f
C9318 a_n1204_9238.n8 VSS 0.92435f
C9319 a_n1204_9238.n9 VSS 0.77453f
C9320 a_n1204_9238.t38 VSS 0.11785f
C9321 a_n1204_9238.n10 VSS 0.92435f
C9322 a_n1204_9238.n11 VSS 0.77453f
C9323 a_n1204_9238.t30 VSS 0.11785f
C9324 a_n1204_9238.n12 VSS 0.92435f
C9325 a_n1204_9238.n13 VSS 0.77453f
C9326 a_n1204_9238.t12 VSS 0.11785f
C9327 a_n1204_9238.n14 VSS 0.92435f
C9328 a_n1204_9238.n15 VSS 0.77453f
C9329 a_n1204_9238.t13 VSS 0.11785f
C9330 a_n1204_9238.n16 VSS 0.92435f
C9331 a_n1204_9238.n17 VSS 0.77453f
C9332 a_n1204_9238.t36 VSS 0.11785f
C9333 a_n1204_9238.n18 VSS 0.92435f
C9334 a_n1204_9238.n19 VSS 0.77453f
C9335 a_n1204_9238.t28 VSS 0.11785f
C9336 a_n1204_9238.n20 VSS 0.92435f
C9337 a_n1204_9238.n21 VSS 0.77453f
C9338 a_n1204_9238.t29 VSS 0.11785f
C9339 a_n1204_9238.n22 VSS 0.92435f
C9340 a_n1204_9238.n23 VSS 0.77453f
C9341 a_n1204_9238.t16 VSS 0.11785f
C9342 a_n1204_9238.n24 VSS 0.92435f
C9343 a_n1204_9238.n25 VSS 0.77453f
C9344 a_n1204_9238.t18 VSS 0.11785f
C9345 a_n1204_9238.n26 VSS 0.92435f
C9346 a_n1204_9238.n27 VSS 0.77453f
C9347 a_n1204_9238.t32 VSS 0.11785f
C9348 a_n1204_9238.n28 VSS 0.92435f
C9349 a_n1204_9238.n29 VSS 0.77453f
C9350 a_n1204_9238.t4 VSS 0.11785f
C9351 a_n1204_9238.n30 VSS 0.92435f
C9352 a_n1204_9238.n31 VSS 0.60701f
C9353 a_n1204_9238.n32 VSS 0.25574f
C9354 a_n1204_9238.n33 VSS 0.12464f
C9355 a_n1204_9238.n34 VSS 0.13846f
C9356 a_n1204_9238.n35 VSS 0.23288f
C9357 a_n1204_9238.n36 VSS 0.16146f
C9358 a_4584_n708.n3 VSS 0.26552f
C9359 a_4584_n708.n5 VSS 0.1392f
C9360 a_4584_n708.n7 VSS 0.1392f
C9361 a_4584_n708.n9 VSS 0.1392f
C9362 a_4584_n708.n11 VSS 0.1392f
C9363 a_4584_n708.n13 VSS 0.1392f
C9364 a_4584_n708.n15 VSS 0.1392f
C9365 a_4584_n708.n17 VSS 0.1392f
C9366 a_4584_n708.n19 VSS 0.1392f
C9367 a_4584_n708.n21 VSS 0.1392f
C9368 a_4584_n708.n23 VSS 0.1392f
C9369 a_4584_n708.n25 VSS 0.1392f
C9370 a_4584_n708.n27 VSS 0.1392f
C9371 a_4584_n708.n29 VSS 0.1392f
C9372 a_4584_n708.n31 VSS 0.18199f
C9373 a_24360_n708.n3 VSS 0.26552f
C9374 a_24360_n708.n5 VSS 0.1392f
C9375 a_24360_n708.n7 VSS 0.1392f
C9376 a_24360_n708.n9 VSS 0.1392f
C9377 a_24360_n708.n11 VSS 0.1392f
C9378 a_24360_n708.n13 VSS 0.1392f
C9379 a_24360_n708.n15 VSS 0.1392f
C9380 a_24360_n708.n17 VSS 0.1392f
C9381 a_24360_n708.n19 VSS 0.1392f
C9382 a_24360_n708.n21 VSS 0.1392f
C9383 a_24360_n708.n23 VSS 0.1392f
C9384 a_24360_n708.n25 VSS 0.1392f
C9385 a_24360_n708.n27 VSS 0.1392f
C9386 a_24360_n708.n29 VSS 0.1392f
C9387 a_24360_n708.n31 VSS 0.18199f
C9388 a_n884_8454.n0 VSS 0.16325f
C9389 a_n884_8454.t26 VSS 0.14829f
C9390 a_n884_8454.n1 VSS 2.19422f
C9391 a_n884_8454.t16 VSS 0.12129f
C9392 a_n884_8454.n2 VSS 0.99541f
C9393 a_n884_8454.n3 VSS 0.8403f
C9394 a_n884_8454.t8 VSS 0.12129f
C9395 a_n884_8454.n4 VSS 0.99541f
C9396 a_n884_8454.n5 VSS 0.8403f
C9397 a_n884_8454.t22 VSS 0.12129f
C9398 a_n884_8454.n6 VSS 0.99541f
C9399 a_n884_8454.n7 VSS 0.8403f
C9400 a_n884_8454.t23 VSS 0.12129f
C9401 a_n884_8454.n8 VSS 0.99541f
C9402 a_n884_8454.n9 VSS 0.8403f
C9403 a_n884_8454.t14 VSS 0.12129f
C9404 a_n884_8454.n10 VSS 0.99541f
C9405 a_n884_8454.n11 VSS 0.8403f
C9406 a_n884_8454.t6 VSS 0.12129f
C9407 a_n884_8454.n12 VSS 0.99541f
C9408 a_n884_8454.n13 VSS 0.8403f
C9409 a_n884_8454.t20 VSS 0.12129f
C9410 a_n884_8454.n14 VSS 0.99541f
C9411 a_n884_8454.n15 VSS 0.8403f
C9412 a_n884_8454.t21 VSS 0.12129f
C9413 a_n884_8454.n16 VSS 0.99541f
C9414 a_n884_8454.n17 VSS 0.8403f
C9415 a_n884_8454.t11 VSS 0.12129f
C9416 a_n884_8454.n18 VSS 0.99541f
C9417 a_n884_8454.n19 VSS 0.8403f
C9418 a_n884_8454.t35 VSS 0.12129f
C9419 a_n884_8454.n20 VSS 0.99541f
C9420 a_n884_8454.n21 VSS 0.8403f
C9421 a_n884_8454.t5 VSS 0.12129f
C9422 a_n884_8454.n22 VSS 0.99541f
C9423 a_n884_8454.n23 VSS 0.8403f
C9424 a_n884_8454.t24 VSS 0.12129f
C9425 a_n884_8454.n24 VSS 0.99541f
C9426 a_n884_8454.n25 VSS 0.8403f
C9427 a_n884_8454.t25 VSS 0.12129f
C9428 a_n884_8454.n26 VSS 0.99541f
C9429 a_n884_8454.n27 VSS 0.8403f
C9430 a_n884_8454.t7 VSS 0.12129f
C9431 a_n884_8454.n28 VSS 0.99541f
C9432 a_n884_8454.n29 VSS 0.8403f
C9433 a_n884_8454.t18 VSS 0.12129f
C9434 a_n884_8454.n30 VSS 0.99541f
C9435 a_n884_8454.n31 VSS 0.67354f
C9436 a_n884_8454.n32 VSS 0.35884f
C9437 a_36720_n708.n3 VSS 0.26552f
C9438 a_36720_n708.n5 VSS 0.1392f
C9439 a_36720_n708.n7 VSS 0.1392f
C9440 a_36720_n708.n9 VSS 0.1392f
C9441 a_36720_n708.n11 VSS 0.1392f
C9442 a_36720_n708.n13 VSS 0.1392f
C9443 a_36720_n708.n15 VSS 0.1392f
C9444 a_36720_n708.n17 VSS 0.1392f
C9445 a_36720_n708.n19 VSS 0.1392f
C9446 a_36720_n708.n21 VSS 0.1392f
C9447 a_36720_n708.n23 VSS 0.1392f
C9448 a_36720_n708.n25 VSS 0.1392f
C9449 a_36720_n708.n27 VSS 0.1392f
C9450 a_36720_n708.n29 VSS 0.1392f
C9451 a_36720_n708.n31 VSS 0.18199f
C9452 a_n884_9238.t15 VSS 0.14829f
C9453 a_n884_9238.n1 VSS 2.19422f
C9454 a_n884_9238.t34 VSS 0.12129f
C9455 a_n884_9238.n2 VSS 0.99541f
C9456 a_n884_9238.n3 VSS 0.8403f
C9457 a_n884_9238.t28 VSS 0.12129f
C9458 a_n884_9238.n4 VSS 0.99541f
C9459 a_n884_9238.n5 VSS 0.8403f
C9460 a_n884_9238.t11 VSS 0.12129f
C9461 a_n884_9238.n6 VSS 0.99541f
C9462 a_n884_9238.n7 VSS 0.8403f
C9463 a_n884_9238.t12 VSS 0.12129f
C9464 a_n884_9238.n8 VSS 0.99541f
C9465 a_n884_9238.n9 VSS 0.8403f
C9466 a_n884_9238.t31 VSS 0.12129f
C9467 a_n884_9238.n10 VSS 0.99541f
C9468 a_n884_9238.n11 VSS 0.8403f
C9469 a_n884_9238.t26 VSS 0.12129f
C9470 a_n884_9238.n12 VSS 0.99541f
C9471 a_n884_9238.n13 VSS 0.8403f
C9472 a_n884_9238.t9 VSS 0.12129f
C9473 a_n884_9238.n14 VSS 0.99541f
C9474 a_n884_9238.n15 VSS 0.8403f
C9475 a_n884_9238.t10 VSS 0.12129f
C9476 a_n884_9238.n16 VSS 0.99541f
C9477 a_n884_9238.n17 VSS 0.8403f
C9478 a_n884_9238.t30 VSS 0.12129f
C9479 a_n884_9238.n18 VSS 0.99541f
C9480 a_n884_9238.n19 VSS 0.8403f
C9481 a_n884_9238.t23 VSS 0.12129f
C9482 a_n884_9238.n20 VSS 0.99541f
C9483 a_n884_9238.n21 VSS 0.8403f
C9484 a_n884_9238.t24 VSS 0.12129f
C9485 a_n884_9238.n22 VSS 0.99541f
C9486 a_n884_9238.n23 VSS 0.8403f
C9487 a_n884_9238.t13 VSS 0.12129f
C9488 a_n884_9238.n24 VSS 0.99541f
C9489 a_n884_9238.n25 VSS 0.8403f
C9490 a_n884_9238.t14 VSS 0.12129f
C9491 a_n884_9238.n26 VSS 0.99541f
C9492 a_n884_9238.n27 VSS 0.8403f
C9493 a_n884_9238.t27 VSS 0.12129f
C9494 a_n884_9238.n28 VSS 0.99541f
C9495 a_n884_9238.n29 VSS 0.8403f
C9496 a_n884_9238.t6 VSS 0.12129f
C9497 a_n884_9238.n30 VSS 0.99541f
C9498 a_n884_9238.n31 VSS 0.67354f
C9499 a_n884_9238.n32 VSS 0.35884f
C9500 a_n884_9238.n33 VSS 0.16325f
C9501 a_23377_n862.n0 VSS 0.30869f
C9502 a_23377_n862.n1 VSS 0.14432f
C9503 a_23377_n862.n2 VSS 0.17142f
C9504 a_23377_n862.n3 VSS 0.17142f
C9505 a_23377_n862.n4 VSS 0.14432f
C9506 a_23377_n862.n5 VSS 0.14432f
C9507 a_23377_n862.n6 VSS 0.17142f
C9508 a_23377_n862.n7 VSS 0.17142f
C9509 a_23377_n862.n8 VSS 0.14432f
C9510 a_23377_n862.n9 VSS 0.14432f
C9511 a_23377_n862.n10 VSS 0.17142f
C9512 a_23377_n862.n11 VSS 0.17142f
C9513 a_23377_n862.n12 VSS 0.14432f
C9514 a_23377_n862.n13 VSS 0.14432f
C9515 a_23377_n862.n14 VSS 0.17142f
C9516 a_23377_n862.n15 VSS 0.17142f
C9517 a_23377_n862.n16 VSS 0.14432f
C9518 a_23377_n862.n17 VSS 0.14432f
C9519 a_23377_n862.n18 VSS 0.17142f
C9520 a_23377_n862.n19 VSS 0.17142f
C9521 a_23377_n862.n20 VSS 0.14432f
C9522 a_23377_n862.n21 VSS 0.14432f
C9523 a_23377_n862.n23 VSS 0.48932f
C9524 a_23377_n862.n24 VSS 0.14432f
C9525 a_23377_n862.n25 VSS 0.14432f
C9526 a_23377_n862.n26 VSS 0.17142f
C9527 a_23377_n862.n27 VSS 0.17142f
C9528 a_23377_n862.n28 VSS 0.14432f
C9529 a_23377_n862.n29 VSS 0.14432f
C9530 a_23377_n862.n30 VSS 0.17142f
C9531 a_23377_n862.n31 VSS 0.17142f
C9532 VDD.t3142 VSS 0.1007f
C9533 VDD.t3217 VSS 0.1007f
C9534 VDD.t3245 VSS 0.1007f
C9535 VDD.t3264 VSS 0.1007f
C9536 VDD.t3171 VSS 0.17808f
C9537 VDD.t1368 VSS 0.17808f
C9538 VDD.n0 VSS 0.15634f
C9539 VDD.n1 VSS 0.15634f
C9540 VDD.t1557 VSS 0.18976f
C9541 VDD.t1253 VSS 0.18976f
C9542 VDD.t235 VSS 0.1007f
C9543 VDD.t244 VSS 0.1007f
C9544 VDD.t1079 VSS 0.10379f
C9545 VDD.t446 VSS 0.10379f
C9546 VDD.t1490 VSS 0.10041f
C9547 VDD.t741 VSS 0.10041f
C9548 VDD.t3141 VSS 2.68965f
C9549 VDD.t3244 VSS 2.09195f
C9550 VDD.t1367 VSS 2.09195f
C9551 VDD.t1365 VSS 1.49425f
C9552 VDD.t1246 VSS 1.55029f
C9553 VDD.t1252 VSS 2.74569f
C9554 VDD.t234 VSS 2.41397f
C9555 VDD.t1354 VSS 1.5427f
C9556 VDD.t2002 VSS 1.26693f
C9557 VDD.t1244 VSS 1.62663f
C9558 VDD.t2675 VSS 1.80648f
C9559 VDD.t2677 VSS 1.87042f
C9560 VDD.t445 VSS 2.44594f
C9561 VDD.t2954 VSS 1.96634f
C9562 VDD.t3204 VSS 1.94636f
C9563 VDD.t740 VSS 2.04228f
C9564 VDD.n4 VSS 1.62067f
C9565 VDD.t1202 VSS 0.1007f
C9566 VDD.t1211 VSS 0.1007f
C9567 VDD.t1088 VSS 0.10379f
C9568 VDD.t464 VSS 0.10379f
C9569 VDD.t1485 VSS 0.10041f
C9570 VDD.t731 VSS 0.10041f
C9571 VDD.t1588 VSS 0.1007f
C9572 VDD.t1645 VSS 0.1007f
C9573 VDD.t1087 VSS 0.10379f
C9574 VDD.t462 VSS 0.10379f
C9575 VDD.t1484 VSS 0.10041f
C9576 VDD.t729 VSS 0.10041f
C9577 VDD.t1140 VSS 0.1007f
C9578 VDD.t1123 VSS 0.1007f
C9579 VDD.t1091 VSS 0.10379f
C9580 VDD.t440 VSS 0.10379f
C9581 VDD.t1492 VSS 0.10041f
C9582 VDD.t745 VSS 0.10041f
C9583 VDD.t1201 VSS 1.58267f
C9584 VDD.t1347 VSS 1.5427f
C9585 VDD.t2032 VSS 1.26693f
C9586 VDD.t1234 VSS 1.62663f
C9587 VDD.t2322 VSS 1.80648f
C9588 VDD.t2324 VSS 1.87042f
C9589 VDD.t463 VSS 2.44594f
C9590 VDD.t3360 VSS 1.96634f
C9591 VDD.t2400 VSS 1.94636f
C9592 VDD.t730 VSS 2.87358f
C9593 VDD.t1587 VSS 2.41397f
C9594 VDD.t1355 VSS 1.5427f
C9595 VDD.t2526 VSS 1.26693f
C9596 VDD.t1224 VSS 1.62663f
C9597 VDD.t2524 VSS 1.80648f
C9598 VDD.t2522 VSS 1.87042f
C9599 VDD.t461 VSS 2.44594f
C9600 VDD.t2467 VSS 1.96634f
C9601 VDD.t3049 VSS 1.94636f
C9602 VDD.t728 VSS 2.87358f
C9603 VDD.t1122 VSS 2.41397f
C9604 VDD.t1361 VSS 1.5427f
C9605 VDD.t2953 VSS 1.26693f
C9606 VDD.t1222 VSS 1.62663f
C9607 VDD.t2862 VSS 1.80648f
C9608 VDD.t2860 VSS 1.87042f
C9609 VDD.t439 VSS 2.44594f
C9610 VDD.t2309 VSS 1.96634f
C9611 VDD.t2490 VSS 1.94636f
C9612 VDD.t744 VSS 2.04228f
C9613 VDD.n11 VSS 1.62067f
C9614 VDD.t189 VSS 0.1007f
C9615 VDD.t168 VSS 0.1007f
C9616 VDD.t434 VSS 0.10379f
C9617 VDD.t441 VSS 0.10379f
C9618 VDD.t1493 VSS 0.10041f
C9619 VDD.t747 VSS 0.10041f
C9620 VDD.t2116 VSS 0.1007f
C9621 VDD.t2099 VSS 0.1007f
C9622 VDD.t1080 VSS 0.10379f
C9623 VDD.t448 VSS 0.10379f
C9624 VDD.t1482 VSS 0.10041f
C9625 VDD.t725 VSS 0.10041f
C9626 VDD.t947 VSS 0.1007f
C9627 VDD.t956 VSS 0.1007f
C9628 VDD.t1085 VSS 0.10379f
C9629 VDD.t458 VSS 0.10379f
C9630 VDD.t1481 VSS 0.10041f
C9631 VDD.t723 VSS 0.10041f
C9632 VDD.t167 VSS 1.58267f
C9633 VDD.t1360 VSS 1.5427f
C9634 VDD.t2819 VSS 1.26693f
C9635 VDD.t1230 VSS 1.62663f
C9636 VDD.t2771 VSS 1.80648f
C9637 VDD.t2773 VSS 1.87042f
C9638 VDD.t433 VSS 2.44594f
C9639 VDD.t2560 VSS 1.96634f
C9640 VDD.t2041 VSS 1.94636f
C9641 VDD.t746 VSS 2.87358f
C9642 VDD.t2098 VSS 2.41397f
C9643 VDD.t1349 VSS 1.5427f
C9644 VDD.t2804 VSS 1.26693f
C9645 VDD.t1228 VSS 1.62663f
C9646 VDD.t3323 VSS 1.80648f
C9647 VDD.t3325 VSS 1.87042f
C9648 VDD.t447 VSS 2.44594f
C9649 VDD.t2065 VSS 1.96634f
C9650 VDD.t2007 VSS 1.94636f
C9651 VDD.t724 VSS 2.87358f
C9652 VDD.t946 VSS 2.41397f
C9653 VDD.t1348 VSS 1.5427f
C9654 VDD.t2803 VSS 1.26693f
C9655 VDD.t1238 VSS 1.62663f
C9656 VDD.t3117 VSS 1.80648f
C9657 VDD.t3119 VSS 1.87042f
C9658 VDD.t457 VSS 2.44594f
C9659 VDD.t3048 VSS 1.96634f
C9660 VDD.t2051 VSS 1.94636f
C9661 VDD.t722 VSS 2.04228f
C9662 VDD.n18 VSS 1.62067f
C9663 VDD.t976 VSS 0.1007f
C9664 VDD.t985 VSS 0.1007f
C9665 VDD.t1089 VSS 0.10379f
C9666 VDD.t436 VSS 0.10379f
C9667 VDD.t1489 VSS 0.10041f
C9668 VDD.t739 VSS 0.10041f
C9669 VDD.t1808 VSS 0.1007f
C9670 VDD.t1787 VSS 0.1007f
C9671 VDD.t396 VSS 0.10379f
C9672 VDD.t442 VSS 0.10379f
C9673 VDD.t1495 VSS 0.10041f
C9674 VDD.t751 VSS 0.10041f
C9675 VDD.t1336 VSS 0.1007f
C9676 VDD.t1319 VSS 0.1007f
C9677 VDD.t1082 VSS 0.10379f
C9678 VDD.t452 VSS 0.10379f
C9679 VDD.t1494 VSS 0.10041f
C9680 VDD.t749 VSS 0.10041f
C9681 VDD.t975 VSS 1.58267f
C9682 VDD.t1358 VSS 1.5427f
C9683 VDD.t2056 VSS 1.26693f
C9684 VDD.t1250 VSS 1.62663f
C9685 VDD.t2372 VSS 1.80648f
C9686 VDD.t2374 VSS 1.87042f
C9687 VDD.t435 VSS 2.44594f
C9688 VDD.t2018 VSS 1.96634f
C9689 VDD.t2971 VSS 1.94636f
C9690 VDD.t738 VSS 2.87358f
C9691 VDD.t1786 VSS 2.41397f
C9692 VDD.t1357 VSS 1.5427f
C9693 VDD.t3026 VSS 1.26693f
C9694 VDD.t1248 VSS 1.62663f
C9695 VDD.t2368 VSS 1.80648f
C9696 VDD.t2370 VSS 1.87042f
C9697 VDD.t395 VSS 2.44594f
C9698 VDD.t3177 VSS 1.96634f
C9699 VDD.t2146 VSS 1.94636f
C9700 VDD.t750 VSS 2.87358f
C9701 VDD.t1318 VSS 2.41397f
C9702 VDD.t1351 VSS 1.5427f
C9703 VDD.t2598 VSS 1.26693f
C9704 VDD.t1232 VSS 1.62663f
C9705 VDD.t2380 VSS 1.80648f
C9706 VDD.t2382 VSS 1.87042f
C9707 VDD.t451 VSS 2.44594f
C9708 VDD.t2603 VSS 1.96634f
C9709 VDD.t2547 VSS 1.94636f
C9710 VDD.t748 VSS 2.04228f
C9711 VDD.n25 VSS 1.62067f
C9712 VDD.t1731 VSS 0.1007f
C9713 VDD.t1738 VSS 0.1007f
C9714 VDD.t1081 VSS 0.10379f
C9715 VDD.t450 VSS 0.10379f
C9716 VDD.t1483 VSS 0.10041f
C9717 VDD.t727 VSS 0.10041f
C9718 VDD.t151 VSS 0.1007f
C9719 VDD.t160 VSS 0.1007f
C9720 VDD.t1090 VSS 0.10379f
C9721 VDD.t438 VSS 0.10379f
C9722 VDD.t1487 VSS 0.10041f
C9723 VDD.t735 VSS 0.10041f
C9724 VDD.t713 VSS 0.1007f
C9725 VDD.t692 VSS 0.1007f
C9726 VDD.t1078 VSS 0.10379f
C9727 VDD.t444 VSS 0.10379f
C9728 VDD.t1491 VSS 0.10041f
C9729 VDD.t743 VSS 0.10041f
C9730 VDD.t1730 VSS 1.58267f
C9731 VDD.t1350 VSS 1.5427f
C9732 VDD.t2595 VSS 1.26693f
C9733 VDD.t1240 VSS 1.62663f
C9734 VDD.t2791 VSS 1.80648f
C9735 VDD.t2789 VSS 1.87042f
C9736 VDD.t449 VSS 2.44594f
C9737 VDD.t2628 VSS 1.96634f
C9738 VDD.t2405 VSS 1.94636f
C9739 VDD.t726 VSS 2.87358f
C9740 VDD.t150 VSS 2.41397f
C9741 VDD.t1356 VSS 1.5427f
C9742 VDD.t2466 VSS 1.26693f
C9743 VDD.t1220 VSS 1.62663f
C9744 VDD.t2464 VSS 1.80648f
C9745 VDD.t2462 VSS 1.87042f
C9746 VDD.t437 VSS 2.44594f
C9747 VDD.t2866 VSS 1.96634f
C9748 VDD.t2137 VSS 1.94636f
C9749 VDD.t734 VSS 2.87358f
C9750 VDD.t691 VSS 2.41397f
C9751 VDD.t1359 VSS 1.5427f
C9752 VDD.t3047 VSS 1.26693f
C9753 VDD.t1218 VSS 1.62663f
C9754 VDD.t3161 VSS 1.80648f
C9755 VDD.t3159 VSS 1.87042f
C9756 VDD.t443 VSS 2.44594f
C9757 VDD.t3062 VSS 1.96634f
C9758 VDD.t3351 VSS 1.94636f
C9759 VDD.t742 VSS 2.04228f
C9760 VDD.n32 VSS 1.62067f
C9761 VDD.t1315 VSS 0.1007f
C9762 VDD.t1294 VSS 0.1007f
C9763 VDD.t1084 VSS 0.10379f
C9764 VDD.t456 VSS 0.10379f
C9765 VDD.t1496 VSS 0.10041f
C9766 VDD.t721 VSS 0.10041f
C9767 VDD.t1269 VSS 0.1007f
C9768 VDD.t1278 VSS 0.1007f
C9769 VDD.t1083 VSS 0.10379f
C9770 VDD.t454 VSS 0.10379f
C9771 VDD.t1486 VSS 0.10041f
C9772 VDD.t733 VSS 0.10041f
C9773 VDD.t736 VSS 2.87358f
C9774 VDD.t2810 VSS 1.94636f
C9775 VDD.t2206 VSS 1.96634f
C9776 VDD.t459 VSS 2.44594f
C9777 VDD.t2552 VSS 1.87042f
C9778 VDD.t2554 VSS 1.80648f
C9779 VDD.t1226 VSS 1.62663f
C9780 VDD.t2497 VSS 1.26693f
C9781 VDD.t1352 VSS 1.5427f
C9782 VDD.t1763 VSS 1.58267f
C9783 VDD.t1293 VSS 1.58267f
C9784 VDD.t1362 VSS 1.5427f
C9785 VDD.t2185 VSS 1.26693f
C9786 VDD.t1236 VSS 1.62663f
C9787 VDD.t2759 VSS 1.80648f
C9788 VDD.t2761 VSS 1.87042f
C9789 VDD.t455 VSS 2.44594f
C9790 VDD.t2042 VSS 1.96634f
C9791 VDD.t2019 VSS 1.94636f
C9792 VDD.t720 VSS 2.87358f
C9793 VDD.t1268 VSS 2.41397f
C9794 VDD.t1353 VSS 1.5427f
C9795 VDD.t1997 VSS 1.26693f
C9796 VDD.t1242 VSS 1.62663f
C9797 VDD.t2450 VSS 1.80648f
C9798 VDD.t2452 VSS 1.87042f
C9799 VDD.t453 VSS 2.44594f
C9800 VDD.t3437 VSS 1.96634f
C9801 VDD.t2809 VSS 1.94636f
C9802 VDD.t732 VSS 2.04228f
C9803 VDD.n37 VSS 1.62067f
C9804 VDD.t1764 VSS 0.1007f
C9805 VDD.t1779 VSS 0.1007f
C9806 VDD.t1086 VSS 0.10379f
C9807 VDD.t460 VSS 0.10379f
C9808 VDD.t1488 VSS 0.10041f
C9809 VDD.t737 VSS 0.10041f
C9810 VDD.n40 VSS 0.94363f
C9811 VDD.n41 VSS 0.978f
C9812 VDD.n42 VSS 0.50322f
C9813 VDD.n43 VSS 0.76932f
C9814 VDD.n44 VSS 0.64902f
C9815 VDD.n45 VSS 0.16831f
C9816 VDD.n46 VSS 0.86533f
C9817 VDD.n47 VSS 0.978f
C9818 VDD.n48 VSS 0.50322f
C9819 VDD.n49 VSS 0.76932f
C9820 VDD.n50 VSS 0.72732f
C9821 VDD.n51 VSS 0.94363f
C9822 VDD.n52 VSS 0.978f
C9823 VDD.n53 VSS 0.50322f
C9824 VDD.n54 VSS 0.76932f
C9825 VDD.n55 VSS 0.64902f
C9826 VDD.n56 VSS 0.16831f
C9827 VDD.n57 VSS 0.86533f
C9828 VDD.n58 VSS 0.978f
C9829 VDD.n59 VSS 0.50322f
C9830 VDD.n60 VSS 0.76932f
C9831 VDD.n61 VSS 0.72732f
C9832 VDD.n62 VSS 0.94363f
C9833 VDD.n63 VSS 0.978f
C9834 VDD.n64 VSS 0.50322f
C9835 VDD.n65 VSS 0.76932f
C9836 VDD.n66 VSS 0.72732f
C9837 VDD.n67 VSS 0.94363f
C9838 VDD.n68 VSS 0.978f
C9839 VDD.n69 VSS 0.50322f
C9840 VDD.n70 VSS 0.76932f
C9841 VDD.n71 VSS 0.64902f
C9842 VDD.n72 VSS 0.16831f
C9843 VDD.n73 VSS 0.86533f
C9844 VDD.n74 VSS 0.978f
C9845 VDD.n75 VSS 0.50322f
C9846 VDD.n76 VSS 0.76932f
C9847 VDD.n77 VSS 0.72732f
C9848 VDD.n78 VSS 0.94363f
C9849 VDD.n79 VSS 0.978f
C9850 VDD.n80 VSS 0.50322f
C9851 VDD.n81 VSS 0.76932f
C9852 VDD.n82 VSS 0.72732f
C9853 VDD.n83 VSS 0.94363f
C9854 VDD.n84 VSS 0.978f
C9855 VDD.n85 VSS 0.50322f
C9856 VDD.n86 VSS 0.76932f
C9857 VDD.n87 VSS 0.64902f
C9858 VDD.n88 VSS 0.16831f
C9859 VDD.n89 VSS 0.86533f
C9860 VDD.n90 VSS 0.978f
C9861 VDD.n91 VSS 0.50322f
C9862 VDD.n92 VSS 0.76932f
C9863 VDD.n93 VSS 0.72732f
C9864 VDD.n94 VSS 0.94363f
C9865 VDD.n95 VSS 0.978f
C9866 VDD.n96 VSS 0.50322f
C9867 VDD.n97 VSS 0.76932f
C9868 VDD.n98 VSS 0.72732f
C9869 VDD.n99 VSS 0.94363f
C9870 VDD.n100 VSS 0.978f
C9871 VDD.n101 VSS 0.50322f
C9872 VDD.n102 VSS 0.76932f
C9873 VDD.n103 VSS 0.64902f
C9874 VDD.n104 VSS 0.16831f
C9875 VDD.n105 VSS 0.86533f
C9876 VDD.n106 VSS 0.978f
C9877 VDD.n107 VSS 0.50322f
C9878 VDD.n108 VSS 0.76932f
C9879 VDD.n109 VSS 0.72732f
C9880 VDD.n110 VSS 0.94363f
C9881 VDD.n111 VSS 0.978f
C9882 VDD.n112 VSS 0.50322f
C9883 VDD.n113 VSS 0.76932f
C9884 VDD.n114 VSS 0.72732f
C9885 VDD.n115 VSS 0.94363f
C9886 VDD.n116 VSS 0.978f
C9887 VDD.n117 VSS 0.50322f
C9888 VDD.n118 VSS 0.76932f
C9889 VDD.n119 VSS 0.64902f
C9890 VDD.n120 VSS 0.16831f
C9891 VDD.n121 VSS 0.86533f
C9892 VDD.n122 VSS 0.978f
C9893 VDD.n123 VSS 0.50322f
C9894 VDD.n124 VSS 0.76932f
C9895 VDD.n125 VSS 0.72732f
C9896 VDD.n126 VSS 0.65618f
C9897 VDD.n127 VSS 0.58213f
C9898 VDD.n128 VSS 0.56877f
C9899 VDD.n129 VSS 0.43797f
C9900 VDD.n130 VSS 0.4239f
.ends
