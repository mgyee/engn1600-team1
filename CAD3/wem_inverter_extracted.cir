* Extracted by KLayout with GF180MCU LVS runset on : 26/02/2026 19:35

.SUBCKT wem_inverter VSS WEMb WEM VDD
M$1 WEMb WEM VDD VDD pfet_03v3 L=0.28U W=2.52U AS=0.9198P AD=0.9198P PS=5.24U
+ PD=5.24U
M$3 WEMb WEM VSS VSS nfet_03v3 L=0.28U W=1.26U AS=0.4599P AD=0.4599P PS=3.35U
+ PD=3.35U
.ENDS wem_inverter
