** sch_path: /foss/designs/engn1600-team1/CAD3/rf.sch
.subckt rf WE0 RA0 RB0 WE1 RA1 RB1 WE2 RA2 RB2 WE3 RA3 RB3 WE4 RA4 RB4 WE5 RA5 RB5 WE6 RA6 RB6 WE7 RA7 RB7 WE8 RA8 RB8 WE9 RA9 RB9
+ WE10 RA10 RB10 WE11 RA11 RB11 WE12 RA12 RB12 WE13 RA13 RB13 WE14 RA14 RB14 WE15 RA15 RB15 CLK WEM VDD QA12 QA10 QA15 QA14 QA13 QA11
+ QA9 QA8 QA7 QA6 QA5 QA4 QA3 QA2 QA1 QA0 QB14 QB15 QB13 QB12 QB11 QB10 QB9 QB8 QB7 QB6 QB5 QB4 QB3 QB2 QB1 QB0 VSS D12 D11 D10 D9 D8
+ D7 D6 D5 D4 D3 D2 D1 D15 D14 D13 D0
*.PININFO RA0:I RB0:I WE0:I RA1:I RB1:I WE1:I RA2:I RB2:I WE2:I RA3:I RB3:I WE3:I RA4:I RB4:I WE4:I RA5:I RB5:I WE5:I RA6:I RB6:I
*+ WE6:I RA7:I RB7:I WE7:I RA8:I RB8:I WE8:I RA9:I RB9:I WE9:I RA10:I RB10:I WE10:I RA11:I RB11:I WE11:I RA12:I RB12:I WE12:I RA13:I
*+ RB13:I WE13:I RA14:I RB14:I WE14:I RA15:I RB15:I WE15:I CLK:I WEM:I D0:I D1:I D2:I D3:I D4:I D5:I D6:I D7:I D8:I D9:I D10:I D11:I D12:I
*+ D13:I D14:I D15:I QA0:O QB0:O QA1:O QB1:O QA2:O QB2:O QA3:O QB3:O QA4:O QB4:O QA5:O QB5:O QA6:O QB6:O QA7:O QB7:O QA8:O QB8:O QA9:O
*+ QB9:O QA10:O QB10:O QA11:O QB11:O QA12:O QB12:O QA13:O QB13:O QA14:O QB14:O QA15:O QB15:O VDD:B VSS:B
x0_0 VDD VSS QA0b WE0CLK WE0CLKb RA0 RB0 QB0b N0 slave_latch kQb=1
x0_1 VDD VSS QA1b WE0CLK WE0CLKb RA0 RB0 QB1b N1 slave_latch kQb=1
x0_2 VDD VSS QA2b WE0CLK WE0CLKb RA0 RB0 QB2b N2 slave_latch kQb=1
x0_3 VDD VSS QA3b WE0CLK WE0CLKb RA0 RB0 QB3b N3 slave_latch kQb=1
x0_4 VDD VSS QA4b WE0CLK WE0CLKb RA0 RB0 QB4b N4 slave_latch kQb=1
x0_5 VDD VSS QA5b WE0CLK WE0CLKb RA0 RB0 QB5b N5 slave_latch kQb=1
x0_6 VDD VSS QA6b WE0CLK WE0CLKb RA0 RB0 QB6b N6 slave_latch kQb=1
x0_7 VDD VSS QA7b WE0CLK WE0CLKb RA0 RB0 QB7b N7 slave_latch kQb=1
x0_8 VDD VSS QA8b WE0CLK WE0CLKb RA0 RB0 QB8b N8 slave_latch kQb=1
x0_9 VDD VSS QA9b WE0CLK WE0CLKb RA0 RB0 QB9b N9 slave_latch kQb=1
x0_10 VDD VSS QA10b WE0CLK WE0CLKb RA0 RB0 QB10b N10 slave_latch kQb=1
x0_11 VDD VSS QA11b WE0CLK WE0CLKb RA0 RB0 QB11b N11 slave_latch kQb=1
x0_12 VDD VSS QA12b WE0CLK WE0CLKb RA0 RB0 QB12b N12 slave_latch kQb=1
x0_13 VDD VSS QA13b WE0CLK WE0CLKb RA0 RB0 QB13b N13 slave_latch kQb=1
x0_14 VDD VSS QA14b WE0CLK WE0CLKb RA0 RB0 QB14b N14 slave_latch kQb=1
x0_15 VDD VSS QA15b WE0CLK WE0CLKb RA0 RB0 QB15b N15 slave_latch kQb=1
x1_0 VDD VSS QA0b WE1CLK WE1CLKb RA1 RB1 QB0b N0 slave_latch kQb=1
x1_1 VDD VSS QA1b WE1CLK WE1CLKb RA1 RB1 QB1b N1 slave_latch kQb=1
x1_2 VDD VSS QA2b WE1CLK WE1CLKb RA1 RB1 QB2b N2 slave_latch kQb=1
x1_3 VDD VSS QA3b WE1CLK WE1CLKb RA1 RB1 QB3b N3 slave_latch kQb=1
x1_4 VDD VSS QA4b WE1CLK WE1CLKb RA1 RB1 QB4b N4 slave_latch kQb=1
x1_5 VDD VSS QA5b WE1CLK WE1CLKb RA1 RB1 QB5b N5 slave_latch kQb=1
x1_6 VDD VSS QA6b WE1CLK WE1CLKb RA1 RB1 QB6b N6 slave_latch kQb=1
x1_7 VDD VSS QA7b WE1CLK WE1CLKb RA1 RB1 QB7b N7 slave_latch kQb=1
x1_8 VDD VSS QA8b WE1CLK WE1CLKb RA1 RB1 QB8b N8 slave_latch kQb=1
x1_9 VDD VSS QA9b WE1CLK WE1CLKb RA1 RB1 QB9b N9 slave_latch kQb=1
x1_10 VDD VSS QA10b WE1CLK WE1CLKb RA1 RB1 QB10b N10 slave_latch kQb=1
x1_11 VDD VSS QA11b WE1CLK WE1CLKb RA1 RB1 QB11b N11 slave_latch kQb=1
x1_12 VDD VSS QA12b WE1CLK WE1CLKb RA1 RB1 QB12b N12 slave_latch kQb=1
x1_13 VDD VSS QA13b WE1CLK WE1CLKb RA1 RB1 QB13b N13 slave_latch kQb=1
x1_14 VDD VSS QA14b WE1CLK WE1CLKb RA1 RB1 QB14b N14 slave_latch kQb=1
x1_15 VDD VSS QA15b WE1CLK WE1CLKb RA1 RB1 QB15b N15 slave_latch kQb=1
x2_0 VDD VSS QA0b WE2CLK WE2CLKb RA2 RB2 QB0b N0 slave_latch kQb=1
x2_1 VDD VSS QA1b WE2CLK WE2CLKb RA2 RB2 QB1b N1 slave_latch kQb=1
x2_2 VDD VSS QA2b WE2CLK WE2CLKb RA2 RB2 QB2b N2 slave_latch kQb=1
x2_3 VDD VSS QA3b WE2CLK WE2CLKb RA2 RB2 QB3b N3 slave_latch kQb=1
x2_4 VDD VSS QA4b WE2CLK WE2CLKb RA2 RB2 QB4b N4 slave_latch kQb=1
x2_5 VDD VSS QA5b WE2CLK WE2CLKb RA2 RB2 QB5b N5 slave_latch kQb=1
x2_6 VDD VSS QA6b WE2CLK WE2CLKb RA2 RB2 QB6b N6 slave_latch kQb=1
x2_7 VDD VSS QA7b WE2CLK WE2CLKb RA2 RB2 QB7b N7 slave_latch kQb=1
x2_8 VDD VSS QA8b WE2CLK WE2CLKb RA2 RB2 QB8b N8 slave_latch kQb=1
x2_9 VDD VSS QA9b WE2CLK WE2CLKb RA2 RB2 QB9b N9 slave_latch kQb=1
x2_10 VDD VSS QA10b WE2CLK WE2CLKb RA2 RB2 QB10b N10 slave_latch kQb=1
x2_11 VDD VSS QA11b WE2CLK WE2CLKb RA2 RB2 QB11b N11 slave_latch kQb=1
x2_12 VDD VSS QA12b WE2CLK WE2CLKb RA2 RB2 QB12b N12 slave_latch kQb=1
x2_13 VDD VSS QA13b WE2CLK WE2CLKb RA2 RB2 QB13b N13 slave_latch kQb=1
x2_14 VDD VSS QA14b WE2CLK WE2CLKb RA2 RB2 QB14b N14 slave_latch kQb=1
x2_15 VDD VSS QA15b WE2CLK WE2CLKb RA2 RB2 QB15b N15 slave_latch kQb=1
x3_0 VDD VSS QA0b WE3CLK WE3CLKb RA3 RB3 QB0b N0 slave_latch kQb=1
x3_1 VDD VSS QA1b WE3CLK WE3CLKb RA3 RB3 QB1b N1 slave_latch kQb=1
x3_2 VDD VSS QA2b WE3CLK WE3CLKb RA3 RB3 QB2b N2 slave_latch kQb=1
x3_3 VDD VSS QA3b WE3CLK WE3CLKb RA3 RB3 QB3b N3 slave_latch kQb=1
x3_4 VDD VSS QA4b WE3CLK WE3CLKb RA3 RB3 QB4b N4 slave_latch kQb=1
x3_5 VDD VSS QA5b WE3CLK WE3CLKb RA3 RB3 QB5b N5 slave_latch kQb=1
x3_6 VDD VSS QA6b WE3CLK WE3CLKb RA3 RB3 QB6b N6 slave_latch kQb=1
x3_7 VDD VSS QA7b WE3CLK WE3CLKb RA3 RB3 QB7b N7 slave_latch kQb=1
x3_8 VDD VSS QA8b WE3CLK WE3CLKb RA3 RB3 QB8b N8 slave_latch kQb=1
x3_9 VDD VSS QA9b WE3CLK WE3CLKb RA3 RB3 QB9b N9 slave_latch kQb=1
x3_10 VDD VSS QA10b WE3CLK WE3CLKb RA3 RB3 QB10b N10 slave_latch kQb=1
x3_11 VDD VSS QA11b WE3CLK WE3CLKb RA3 RB3 QB11b N11 slave_latch kQb=1
x3_12 VDD VSS QA12b WE3CLK WE3CLKb RA3 RB3 QB12b N12 slave_latch kQb=1
x3_13 VDD VSS QA13b WE3CLK WE3CLKb RA3 RB3 QB13b N13 slave_latch kQb=1
x3_14 VDD VSS QA14b WE3CLK WE3CLKb RA3 RB3 QB14b N14 slave_latch kQb=1
x3_15 VDD VSS QA15b WE3CLK WE3CLKb RA3 RB3 QB15b N15 slave_latch kQb=1
x4_0 VDD VSS QA0b WE4CLK WE4CLKb RA4 RB4 QB0b N0 slave_latch kQb=1
x4_1 VDD VSS QA1b WE4CLK WE4CLKb RA4 RB4 QB1b N1 slave_latch kQb=1
x4_2 VDD VSS QA2b WE4CLK WE4CLKb RA4 RB4 QB2b N2 slave_latch kQb=1
x4_3 VDD VSS QA3b WE4CLK WE4CLKb RA4 RB4 QB3b N3 slave_latch kQb=1
x4_4 VDD VSS QA4b WE4CLK WE4CLKb RA4 RB4 QB4b N4 slave_latch kQb=1
x4_5 VDD VSS QA5b WE4CLK WE4CLKb RA4 RB4 QB5b N5 slave_latch kQb=1
x4_6 VDD VSS QA6b WE4CLK WE4CLKb RA4 RB4 QB6b N6 slave_latch kQb=1
x4_7 VDD VSS QA7b WE4CLK WE4CLKb RA4 RB4 QB7b N7 slave_latch kQb=1
x4_8 VDD VSS QA8b WE4CLK WE4CLKb RA4 RB4 QB8b N8 slave_latch kQb=1
x4_9 VDD VSS QA9b WE4CLK WE4CLKb RA4 RB4 QB9b N9 slave_latch kQb=1
x4_10 VDD VSS QA10b WE4CLK WE4CLKb RA4 RB4 QB10b N10 slave_latch kQb=1
x4_11 VDD VSS QA11b WE4CLK WE4CLKb RA4 RB4 QB11b N11 slave_latch kQb=1
x4_12 VDD VSS QA12b WE4CLK WE4CLKb RA4 RB4 QB12b N12 slave_latch kQb=1
x4_13 VDD VSS QA13b WE4CLK WE4CLKb RA4 RB4 QB13b N13 slave_latch kQb=1
x4_14 VDD VSS QA14b WE4CLK WE4CLKb RA4 RB4 QB14b N14 slave_latch kQb=1
x4_15 VDD VSS QA15b WE4CLK WE4CLKb RA4 RB4 QB15b N15 slave_latch kQb=1
x5_0 VDD VSS QA0b WE5CLK WE5CLKb RA5 RB5 QB0b N0 slave_latch kQb=1
x5_1 VDD VSS QA1b WE5CLK WE5CLKb RA5 RB5 QB1b N1 slave_latch kQb=1
x5_2 VDD VSS QA2b WE5CLK WE5CLKb RA5 RB5 QB2b N2 slave_latch kQb=1
x5_3 VDD VSS QA3b WE5CLK WE5CLKb RA5 RB5 QB3b N3 slave_latch kQb=1
x5_4 VDD VSS QA4b WE5CLK WE5CLKb RA5 RB5 QB4b N4 slave_latch kQb=1
x5_5 VDD VSS QA5b WE5CLK WE5CLKb RA5 RB5 QB5b N5 slave_latch kQb=1
x5_6 VDD VSS QA6b WE5CLK WE5CLKb RA5 RB5 QB6b N6 slave_latch kQb=1
x5_7 VDD VSS QA7b WE5CLK WE5CLKb RA5 RB5 QB7b N7 slave_latch kQb=1
x5_8 VDD VSS QA8b WE5CLK WE5CLKb RA5 RB5 QB8b N8 slave_latch kQb=1
x5_9 VDD VSS QA9b WE5CLK WE5CLKb RA5 RB5 QB9b N9 slave_latch kQb=1
x5_10 VDD VSS QA10b WE5CLK WE5CLKb RA5 RB5 QB10b N10 slave_latch kQb=1
x5_11 VDD VSS QA11b WE5CLK WE5CLKb RA5 RB5 QB11b N11 slave_latch kQb=1
x5_12 VDD VSS QA12b WE5CLK WE5CLKb RA5 RB5 QB12b N12 slave_latch kQb=1
x5_13 VDD VSS QA13b WE5CLK WE5CLKb RA5 RB5 QB13b N13 slave_latch kQb=1
x5_14 VDD VSS QA14b WE5CLK WE5CLKb RA5 RB5 QB14b N14 slave_latch kQb=1
x5_15 VDD VSS QA15b WE5CLK WE5CLKb RA5 RB5 QB15b N15 slave_latch kQb=1
x6_0 VDD VSS QA0b WE6CLK WE6CLKb RA6 RB6 QB0b N0 slave_latch kQb=1
x6_1 VDD VSS QA1b WE6CLK WE6CLKb RA6 RB6 QB1b N1 slave_latch kQb=1
x6_2 VDD VSS QA2b WE6CLK WE6CLKb RA6 RB6 QB2b N2 slave_latch kQb=1
x6_3 VDD VSS QA3b WE6CLK WE6CLKb RA6 RB6 QB3b N3 slave_latch kQb=1
x6_4 VDD VSS QA4b WE6CLK WE6CLKb RA6 RB6 QB4b N4 slave_latch kQb=1
x6_5 VDD VSS QA5b WE6CLK WE6CLKb RA6 RB6 QB5b N5 slave_latch kQb=1
x6_6 VDD VSS QA6b WE6CLK WE6CLKb RA6 RB6 QB6b N6 slave_latch kQb=1
x6_7 VDD VSS QA7b WE6CLK WE6CLKb RA6 RB6 QB7b N7 slave_latch kQb=1
x6_8 VDD VSS QA8b WE6CLK WE6CLKb RA6 RB6 QB8b N8 slave_latch kQb=1
x6_9 VDD VSS QA9b WE6CLK WE6CLKb RA6 RB6 QB9b N9 slave_latch kQb=1
x6_10 VDD VSS QA10b WE6CLK WE6CLKb RA6 RB6 QB10b N10 slave_latch kQb=1
x6_11 VDD VSS QA11b WE6CLK WE6CLKb RA6 RB6 QB11b N11 slave_latch kQb=1
x6_12 VDD VSS QA12b WE6CLK WE6CLKb RA6 RB6 QB12b N12 slave_latch kQb=1
x6_13 VDD VSS QA13b WE6CLK WE6CLKb RA6 RB6 QB13b N13 slave_latch kQb=1
x6_14 VDD VSS QA14b WE6CLK WE6CLKb RA6 RB6 QB14b N14 slave_latch kQb=1
x6_15 VDD VSS QA15b WE6CLK WE6CLKb RA6 RB6 QB15b N15 slave_latch kQb=1
x7_0 VDD VSS QA0b WE7CLK WE7CLKb RA7 RB7 QB0b N0 slave_latch kQb=1
x7_1 VDD VSS QA1b WE7CLK WE7CLKb RA7 RB7 QB1b N1 slave_latch kQb=1
x7_2 VDD VSS QA2b WE7CLK WE7CLKb RA7 RB7 QB2b N2 slave_latch kQb=1
x7_3 VDD VSS QA3b WE7CLK WE7CLKb RA7 RB7 QB3b N3 slave_latch kQb=1
x7_4 VDD VSS QA4b WE7CLK WE7CLKb RA7 RB7 QB4b N4 slave_latch kQb=1
x7_5 VDD VSS QA5b WE7CLK WE7CLKb RA7 RB7 QB5b N5 slave_latch kQb=1
x7_6 VDD VSS QA6b WE7CLK WE7CLKb RA7 RB7 QB6b N6 slave_latch kQb=1
x7_7 VDD VSS QA7b WE7CLK WE7CLKb RA7 RB7 QB7b N7 slave_latch kQb=1
x7_8 VDD VSS QA8b WE7CLK WE7CLKb RA7 RB7 QB8b N8 slave_latch kQb=1
x7_9 VDD VSS QA9b WE7CLK WE7CLKb RA7 RB7 QB9b N9 slave_latch kQb=1
x7_10 VDD VSS QA10b WE7CLK WE7CLKb RA7 RB7 QB10b N10 slave_latch kQb=1
x7_11 VDD VSS QA11b WE7CLK WE7CLKb RA7 RB7 QB11b N11 slave_latch kQb=1
x7_12 VDD VSS QA12b WE7CLK WE7CLKb RA7 RB7 QB12b N12 slave_latch kQb=1
x7_13 VDD VSS QA13b WE7CLK WE7CLKb RA7 RB7 QB13b N13 slave_latch kQb=1
x7_14 VDD VSS QA14b WE7CLK WE7CLKb RA7 RB7 QB14b N14 slave_latch kQb=1
x7_15 VDD VSS QA15b WE7CLK WE7CLKb RA7 RB7 QB15b N15 slave_latch kQb=1
x8_0 VDD VSS QA0b WE8CLK WE8CLKb RA8 RB8 QB0b N0 slave_latch kQb=1
x8_1 VDD VSS QA1b WE8CLK WE8CLKb RA8 RB8 QB1b N1 slave_latch kQb=1
x8_2 VDD VSS QA2b WE8CLK WE8CLKb RA8 RB8 QB2b N2 slave_latch kQb=1
x8_3 VDD VSS QA3b WE8CLK WE8CLKb RA8 RB8 QB3b N3 slave_latch kQb=1
x8_4 VDD VSS QA4b WE8CLK WE8CLKb RA8 RB8 QB4b N4 slave_latch kQb=1
x8_5 VDD VSS QA5b WE8CLK WE8CLKb RA8 RB8 QB5b N5 slave_latch kQb=1
x8_6 VDD VSS QA6b WE8CLK WE8CLKb RA8 RB8 QB6b N6 slave_latch kQb=1
x8_7 VDD VSS QA7b WE8CLK WE8CLKb RA8 RB8 QB7b N7 slave_latch kQb=1
x8_8 VDD VSS QA8b WE8CLK WE8CLKb RA8 RB8 QB8b N8 slave_latch kQb=1
x8_9 VDD VSS QA9b WE8CLK WE8CLKb RA8 RB8 QB9b N9 slave_latch kQb=1
x8_10 VDD VSS QA10b WE8CLK WE8CLKb RA8 RB8 QB10b N10 slave_latch kQb=1
x8_11 VDD VSS QA11b WE8CLK WE8CLKb RA8 RB8 QB11b N11 slave_latch kQb=1
x8_12 VDD VSS QA12b WE8CLK WE8CLKb RA8 RB8 QB12b N12 slave_latch kQb=1
x8_13 VDD VSS QA13b WE8CLK WE8CLKb RA8 RB8 QB13b N13 slave_latch kQb=1
x8_14 VDD VSS QA14b WE8CLK WE8CLKb RA8 RB8 QB14b N14 slave_latch kQb=1
x8_15 VDD VSS QA15b WE8CLK WE8CLKb RA8 RB8 QB15b N15 slave_latch kQb=1
x9_0 VDD VSS QA0b WE9CLK WE9CLKb RA9 RB9 QB0b N0 slave_latch kQb=1
x9_1 VDD VSS QA1b WE9CLK WE9CLKb RA9 RB9 QB1b N1 slave_latch kQb=1
x9_2 VDD VSS QA2b WE9CLK WE9CLKb RA9 RB9 QB2b N2 slave_latch kQb=1
x9_3 VDD VSS QA3b WE9CLK WE9CLKb RA9 RB9 QB3b N3 slave_latch kQb=1
x9_4 VDD VSS QA4b WE9CLK WE9CLKb RA9 RB9 QB4b N4 slave_latch kQb=1
x9_5 VDD VSS QA5b WE9CLK WE9CLKb RA9 RB9 QB5b N5 slave_latch kQb=1
x9_6 VDD VSS QA6b WE9CLK WE9CLKb RA9 RB9 QB6b N6 slave_latch kQb=1
x9_7 VDD VSS QA7b WE9CLK WE9CLKb RA9 RB9 QB7b N7 slave_latch kQb=1
x9_8 VDD VSS QA8b WE9CLK WE9CLKb RA9 RB9 QB8b N8 slave_latch kQb=1
x9_9 VDD VSS QA9b WE9CLK WE9CLKb RA9 RB9 QB9b N9 slave_latch kQb=1
x9_10 VDD VSS QA10b WE9CLK WE9CLKb RA9 RB9 QB10b N10 slave_latch kQb=1
x9_11 VDD VSS QA11b WE9CLK WE9CLKb RA9 RB9 QB11b N11 slave_latch kQb=1
x9_12 VDD VSS QA12b WE9CLK WE9CLKb RA9 RB9 QB12b N12 slave_latch kQb=1
x9_13 VDD VSS QA13b WE9CLK WE9CLKb RA9 RB9 QB13b N13 slave_latch kQb=1
x9_14 VDD VSS QA14b WE9CLK WE9CLKb RA9 RB9 QB14b N14 slave_latch kQb=1
x9_15 VDD VSS QA15b WE9CLK WE9CLKb RA9 RB9 QB15b N15 slave_latch kQb=1
x10_0 VDD VSS QA0b WE10CLK WE10CLKb RA10 RB10 QB0b N0 slave_latch kQb=1
x10_1 VDD VSS QA1b WE10CLK WE10CLKb RA10 RB10 QB1b N1 slave_latch kQb=1
x10_2 VDD VSS QA2b WE10CLK WE10CLKb RA10 RB10 QB2b N2 slave_latch kQb=1
x10_3 VDD VSS QA3b WE10CLK WE10CLKb RA10 RB10 QB3b N3 slave_latch kQb=1
x10_4 VDD VSS QA4b WE10CLK WE10CLKb RA10 RB10 QB4b N4 slave_latch kQb=1
x10_5 VDD VSS QA5b WE10CLK WE10CLKb RA10 RB10 QB5b N5 slave_latch kQb=1
x10_6 VDD VSS QA6b WE10CLK WE10CLKb RA10 RB10 QB6b N6 slave_latch kQb=1
x10_7 VDD VSS QA7b WE10CLK WE10CLKb RA10 RB10 QB7b N7 slave_latch kQb=1
x10_8 VDD VSS QA8b WE10CLK WE10CLKb RA10 RB10 QB8b N8 slave_latch kQb=1
x10_9 VDD VSS QA9b WE10CLK WE10CLKb RA10 RB10 QB9b N9 slave_latch kQb=1
x10_10 VDD VSS QA10b WE10CLK WE10CLKb RA10 RB10 QB10b N10 slave_latch kQb=1
x10_11 VDD VSS QA11b WE10CLK WE10CLKb RA10 RB10 QB11b N11 slave_latch kQb=1
x10_12 VDD VSS QA12b WE10CLK WE10CLKb RA10 RB10 QB12b N12 slave_latch kQb=1
x10_13 VDD VSS QA13b WE10CLK WE10CLKb RA10 RB10 QB13b N13 slave_latch kQb=1
x10_14 VDD VSS QA14b WE10CLK WE10CLKb RA10 RB10 QB14b N14 slave_latch kQb=1
x10_15 VDD VSS QA15b WE10CLK WE10CLKb RA10 RB10 QB15b N15 slave_latch kQb=1
x11_0 VDD VSS QA0b WE11CLK WE11CLKb RA11 RB11 QB0b N0 slave_latch kQb=1
x11_1 VDD VSS QA1b WE11CLK WE11CLKb RA11 RB11 QB1b N1 slave_latch kQb=1
x11_2 VDD VSS QA2b WE11CLK WE11CLKb RA11 RB11 QB2b N2 slave_latch kQb=1
x11_3 VDD VSS QA3b WE11CLK WE11CLKb RA11 RB11 QB3b N3 slave_latch kQb=1
x11_4 VDD VSS QA4b WE11CLK WE11CLKb RA11 RB11 QB4b N4 slave_latch kQb=1
x11_5 VDD VSS QA5b WE11CLK WE11CLKb RA11 RB11 QB5b N5 slave_latch kQb=1
x11_6 VDD VSS QA6b WE11CLK WE11CLKb RA11 RB11 QB6b N6 slave_latch kQb=1
x11_7 VDD VSS QA7b WE11CLK WE11CLKb RA11 RB11 QB7b N7 slave_latch kQb=1
x11_8 VDD VSS QA8b WE11CLK WE11CLKb RA11 RB11 QB8b N8 slave_latch kQb=1
x11_9 VDD VSS QA9b WE11CLK WE11CLKb RA11 RB11 QB9b N9 slave_latch kQb=1
x11_10 VDD VSS QA10b WE11CLK WE11CLKb RA11 RB11 QB10b N10 slave_latch kQb=1
x11_11 VDD VSS QA11b WE11CLK WE11CLKb RA11 RB11 QB11b N11 slave_latch kQb=1
x11_12 VDD VSS QA12b WE11CLK WE11CLKb RA11 RB11 QB12b N12 slave_latch kQb=1
x11_13 VDD VSS QA13b WE11CLK WE11CLKb RA11 RB11 QB13b N13 slave_latch kQb=1
x11_14 VDD VSS QA14b WE11CLK WE11CLKb RA11 RB11 QB14b N14 slave_latch kQb=1
x11_15 VDD VSS QA15b WE11CLK WE11CLKb RA11 RB11 QB15b N15 slave_latch kQb=1
x12_0 VDD VSS QA0b WE12CLK WE12CLKb RA12 RB12 QB0b N0 slave_latch kQb=1
x12_1 VDD VSS QA1b WE12CLK WE12CLKb RA12 RB12 QB1b N1 slave_latch kQb=1
x12_2 VDD VSS QA2b WE12CLK WE12CLKb RA12 RB12 QB2b N2 slave_latch kQb=1
x12_3 VDD VSS QA3b WE12CLK WE12CLKb RA12 RB12 QB3b N3 slave_latch kQb=1
x12_4 VDD VSS QA4b WE12CLK WE12CLKb RA12 RB12 QB4b N4 slave_latch kQb=1
x12_5 VDD VSS QA5b WE12CLK WE12CLKb RA12 RB12 QB5b N5 slave_latch kQb=1
x12_6 VDD VSS QA6b WE12CLK WE12CLKb RA12 RB12 QB6b N6 slave_latch kQb=1
x12_7 VDD VSS QA7b WE12CLK WE12CLKb RA12 RB12 QB7b N7 slave_latch kQb=1
x12_8 VDD VSS QA8b WE12CLK WE12CLKb RA12 RB12 QB8b N8 slave_latch kQb=1
x12_9 VDD VSS QA9b WE12CLK WE12CLKb RA12 RB12 QB9b N9 slave_latch kQb=1
x12_10 VDD VSS QA10b WE12CLK WE12CLKb RA12 RB12 QB10b N10 slave_latch kQb=1
x12_11 VDD VSS QA11b WE12CLK WE12CLKb RA12 RB12 QB11b N11 slave_latch kQb=1
x12_12 VDD VSS QA12b WE12CLK WE12CLKb RA12 RB12 QB12b N12 slave_latch kQb=1
x12_13 VDD VSS QA13b WE12CLK WE12CLKb RA12 RB12 QB13b N13 slave_latch kQb=1
x12_14 VDD VSS QA14b WE12CLK WE12CLKb RA12 RB12 QB14b N14 slave_latch kQb=1
x12_15 VDD VSS QA15b WE12CLK WE12CLKb RA12 RB12 QB15b N15 slave_latch kQb=1
x13_0 VDD VSS QA0b WE13CLK WE13CLKb RA13 RB13 QB0b N0 slave_latch kQb=1
x13_1 VDD VSS QA1b WE13CLK WE13CLKb RA13 RB13 QB1b N1 slave_latch kQb=1
x13_2 VDD VSS QA2b WE13CLK WE13CLKb RA13 RB13 QB2b N2 slave_latch kQb=1
x13_3 VDD VSS QA3b WE13CLK WE13CLKb RA13 RB13 QB3b N3 slave_latch kQb=1
x13_4 VDD VSS QA4b WE13CLK WE13CLKb RA13 RB13 QB4b N4 slave_latch kQb=1
x13_5 VDD VSS QA5b WE13CLK WE13CLKb RA13 RB13 QB5b N5 slave_latch kQb=1
x13_6 VDD VSS QA6b WE13CLK WE13CLKb RA13 RB13 QB6b N6 slave_latch kQb=1
x13_7 VDD VSS QA7b WE13CLK WE13CLKb RA13 RB13 QB7b N7 slave_latch kQb=1
x13_8 VDD VSS QA8b WE13CLK WE13CLKb RA13 RB13 QB8b N8 slave_latch kQb=1
x13_9 VDD VSS QA9b WE13CLK WE13CLKb RA13 RB13 QB9b N9 slave_latch kQb=1
x13_10 VDD VSS QA10b WE13CLK WE13CLKb RA13 RB13 QB10b N10 slave_latch kQb=1
x13_11 VDD VSS QA11b WE13CLK WE13CLKb RA13 RB13 QB11b N11 slave_latch kQb=1
x13_12 VDD VSS QA12b WE13CLK WE13CLKb RA13 RB13 QB12b N12 slave_latch kQb=1
x13_13 VDD VSS QA13b WE13CLK WE13CLKb RA13 RB13 QB13b N13 slave_latch kQb=1
x13_14 VDD VSS QA14b WE13CLK WE13CLKb RA13 RB13 QB14b N14 slave_latch kQb=1
x13_15 VDD VSS QA15b WE13CLK WE13CLKb RA13 RB13 QB15b N15 slave_latch kQb=1
x14_0 VDD VSS QA0b WE14CLK WE14CLKb RA14 RB14 QB0b N0 slave_latch kQb=1
x14_1 VDD VSS QA1b WE14CLK WE14CLKb RA14 RB14 QB1b N1 slave_latch kQb=1
x14_2 VDD VSS QA2b WE14CLK WE14CLKb RA14 RB14 QB2b N2 slave_latch kQb=1
x14_3 VDD VSS QA3b WE14CLK WE14CLKb RA14 RB14 QB3b N3 slave_latch kQb=1
x14_4 VDD VSS QA4b WE14CLK WE14CLKb RA14 RB14 QB4b N4 slave_latch kQb=1
x14_5 VDD VSS QA5b WE14CLK WE14CLKb RA14 RB14 QB5b N5 slave_latch kQb=1
x14_6 VDD VSS QA6b WE14CLK WE14CLKb RA14 RB14 QB6b N6 slave_latch kQb=1
x14_7 VDD VSS QA7b WE14CLK WE14CLKb RA14 RB14 QB7b N7 slave_latch kQb=1
x14_8 VDD VSS QA8b WE14CLK WE14CLKb RA14 RB14 QB8b N8 slave_latch kQb=1
x14_9 VDD VSS QA9b WE14CLK WE14CLKb RA14 RB14 QB9b N9 slave_latch kQb=1
x14_10 VDD VSS QA10b WE14CLK WE14CLKb RA14 RB14 QB10b N10 slave_latch kQb=1
x14_11 VDD VSS QA11b WE14CLK WE14CLKb RA14 RB14 QB11b N11 slave_latch kQb=1
x14_12 VDD VSS QA12b WE14CLK WE14CLKb RA14 RB14 QB12b N12 slave_latch kQb=1
x14_13 VDD VSS QA13b WE14CLK WE14CLKb RA14 RB14 QB13b N13 slave_latch kQb=1
x14_14 VDD VSS QA14b WE14CLK WE14CLKb RA14 RB14 QB14b N14 slave_latch kQb=1
x14_15 VDD VSS QA15b WE14CLK WE14CLKb RA14 RB14 QB15b N15 slave_latch kQb=1
x15_0 VDD VSS QA0b WE15CLK WE15CLKb RA15 RB15 QB0b N0 slave_latch kQb=1
x15_1 VDD VSS QA1b WE15CLK WE15CLKb RA15 RB15 QB1b N1 slave_latch kQb=1
x15_2 VDD VSS QA2b WE15CLK WE15CLKb RA15 RB15 QB2b N2 slave_latch kQb=1
x15_3 VDD VSS QA3b WE15CLK WE15CLKb RA15 RB15 QB3b N3 slave_latch kQb=1
x15_4 VDD VSS QA4b WE15CLK WE15CLKb RA15 RB15 QB4b N4 slave_latch kQb=1
x15_5 VDD VSS QA5b WE15CLK WE15CLKb RA15 RB15 QB5b N5 slave_latch kQb=1
x15_6 VDD VSS QA6b WE15CLK WE15CLKb RA15 RB15 QB6b N6 slave_latch kQb=1
x15_7 VDD VSS QA7b WE15CLK WE15CLKb RA15 RB15 QB7b N7 slave_latch kQb=1
x15_8 VDD VSS QA8b WE15CLK WE15CLKb RA15 RB15 QB8b N8 slave_latch kQb=1
x15_9 VDD VSS QA9b WE15CLK WE15CLKb RA15 RB15 QB9b N9 slave_latch kQb=1
x15_10 VDD VSS QA10b WE15CLK WE15CLKb RA15 RB15 QB10b N10 slave_latch kQb=1
x15_11 VDD VSS QA11b WE15CLK WE15CLKb RA15 RB15 QB11b N11 slave_latch kQb=1
x15_12 VDD VSS QA12b WE15CLK WE15CLKb RA15 RB15 QB12b N12 slave_latch kQb=1
x15_13 VDD VSS QA13b WE15CLK WE15CLKb RA15 RB15 QB13b N13 slave_latch kQb=1
x15_14 VDD VSS QA14b WE15CLK WE15CLKb RA15 RB15 QB14b N14 slave_latch kQb=1
x15_15 VDD VSS QA15b WE15CLK WE15CLKb RA15 RB15 QB15b N15 slave_latch kQb=1
x1 VDD VSS N0 WEM WEMb D0 master_latch kN=1
x2 VDD VSS N1 WEM WEMb D1 master_latch kN=1
x3 VDD VSS N2 WEM WEMb D2 master_latch kN=1
x4 VDD VSS N3 WEM WEMb D3 master_latch kN=1
x5 VDD VSS N4 WEM WEMb D4 master_latch kN=1
x6 VDD VSS N5 WEM WEMb D5 master_latch kN=1
x7 VDD VSS N6 WEM WEMb D6 master_latch kN=1
x8 VDD VSS N7 WEM WEMb D7 master_latch kN=1
x9 VDD VSS N8 WEM WEMb D8 master_latch kN=1
x10 VDD VSS N9 WEM WEMb D9 master_latch kN=1
x11 net1 net2 N10 WEM WEMb D10 master_latch kN=1
x12 VDD VSS N11 WEM WEMb D11 master_latch kN=1
x13 VDD VSS N12 WEM WEMb D12 master_latch kN=1
x14 VDD VSS N13 WEM WEMb D13 master_latch kN=1
x15 VDD VSS N14 WEM WEMb D14 master_latch kN=1
x16 VDD VSS N15 WEM WEMb D15 master_latch kN=1
x17 CLK WE15 WE15CLKb VDD VSS WE15CLK driver_cell kWECLK=1 kWECLKb=1
x18 CLK WE14 WE14CLKb VDD VSS WE14CLK driver_cell kWECLK=1 kWECLKb=1
x19 CLK WE13 WE13CLKb VDD VSS WE13CLK driver_cell kWECLK=1 kWECLKb=1
x20 CLK WE12 WE12CLKb VDD VSS WE12CLK driver_cell kWECLK=1 kWECLKb=1
x21 CLK WE11 WE11CLKb VDD VSS WE11CLK driver_cell kWECLK=1 kWECLKb=1
x22 CLK WE10 WE10CLKb VDD VSS WE10CLK driver_cell kWECLK=1 kWECLKb=1
x23 CLK WE9 WE9CLKb VDD VSS WE9CLK driver_cell kWECLK=1 kWECLKb=1
x24 CLK WE8 WE8CLKb VDD VSS WE8CLK driver_cell kWECLK=1 kWECLKb=1
x25 CLK WE7 WE7CLKb VDD VSS WE7CLK driver_cell kWECLK=1 kWECLKb=1
x26 CLK WE6 WE6CLKb VDD VSS WE6CLK driver_cell kWECLK=1 kWECLKb=1
x27 CLK WE5 WE5CLKb VDD VSS WE5CLK driver_cell kWECLK=1 kWECLKb=1
x28 CLK WE4 WE4CLKb VDD VSS WE4CLK driver_cell kWECLK=1 kWECLKb=1
x29 CLK WE3 WE3CLKb VDD VSS WE3CLK driver_cell kWECLK=1 kWECLKb=1
x30 CLK WE2 WE2CLKb VDD VSS WE2CLK driver_cell kWECLK=1 kWECLKb=1
x31 CLK WE1 WE1CLKb VDD VSS WE1CLK driver_cell kWECLK=1 kWECLKb=1
x32 CLK WE0 WE0CLKb VDD VSS WE0CLK driver_cell kWECLK=1 kWECLKb=1
x33 VDD VSS QA0 QA0b QB0b QB0 output_inverter
x34 VDD VSS QA1 QA1b QB1b QB1 output_inverter
x35 VDD VSS QA2 QA2b QB2b QB2 output_inverter
x36 VDD VSS QA3 QA3b QB3b QB3 output_inverter
x37 VDD VSS QA4 QA4b QB4b QB4 output_inverter
x38 VDD VSS QA5 QA5b QB5b QB5 output_inverter
x39 VDD VSS QA6 QA6b QB6b QB6 output_inverter
x40 VDD VSS QA7 QA7b QB7b QB7 output_inverter
x41 VDD VSS QA8 QA8b QB8b QB8 output_inverter
x42 VDD VSS QA9 QA9b QB9b QB9 output_inverter
x43 VDD VSS QA10 QA10b QB10b QB10 output_inverter
x44 VDD VSS QA11 QA11b QB11b QB11 output_inverter
x45 VDD VSS QA12 QA12b QB12b QB12 output_inverter
x46 VDD VSS QA13 QA13b QB13b QB13 output_inverter
x47 VDD VSS QA14 QA14b QB14b QB14 output_inverter
x48 VDD VSS QA15 QA15b QB15b QB15 output_inverter
x49 VDD WEM WEMb VSS wem_inverter kWEMb=1
.ends

* expanding   symbol:  engn1600-team1/CAD3/slave_latch.sym # of pins=9
** sym_path: /foss/designs/engn1600-team1/CAD3/slave_latch.sym
** sch_path: /foss/designs/engn1600-team1/CAD3/slave_latch.sch
.subckt slave_latch VDD VSS QAb WECLK WECLKb RA RB QBb D  kQb=1
*.PININFO D:I RA:I RB:I WECLKb:I WECLK:I QAb:O QBb:O VDD:B VSS:B
M1 net1 WECLKb net2 VDD pfet_03v3 L=0.28u W=0.36u nf=1 m=1
M2 net1 D VDD VDD pfet_03v3 L=0.28u W=0.72u nf=1 m=1
M3 net3 net2 VDD VDD pfet_03v3 L=0.28u W=0.72u nf=1 m=1
M4 net4 net2 VDD VDD pfet_03v3 L=0.28u W=0.36u nf=1 m=1
M5 VDD WECLK net8 VDD pfet_03v3 L=0.28u W=0.36u nf=1 m=1
M6 net8 net4 net2 VDD pfet_03v3 L=0.28u W=0.36u nf=1 m=1
M7 net1 D VSS VSS nfet_03v3 L=0.28u W=0.36u nf=1 m=1
M8 net1 WECLK net2 VSS nfet_03v3 L=0.28u W=0.36u nf=1 m=1
M9 net3 net2 VSS VSS nfet_03v3 L=0.28u W=0.36u nf=1 m=1
M10 net4 net2 VSS VSS nfet_03v3 L=0.28u W=0.36u nf=1 m=1
M11 net7 net4 net2 VSS nfet_03v3 L=0.28u W=0.36u nf=1 m=1
M12 VSS WECLKb net7 VSS nfet_03v3 L=0.28u W=0.36u nf=1 m=1
M13 net3 net5 QBb VDD pfet_03v3 L=0.28u W='kQb*0.36u' nf=1 m=1
M14 net3 RB QBb VSS nfet_03v3 L=0.28u W='kQb*0.36u' nf=1 m=1
M15 net5 RB VDD VDD pfet_03v3 L=0.28u W=0.72u nf=1 m=1
M16 net5 RB VSS VSS nfet_03v3 L=0.28u W=0.36u nf=1 m=1
M21 net3 net6 QAb VDD pfet_03v3 L=0.28u W='kQb*0.36u' nf=1 m=1
M22 net3 RA QAb VSS nfet_03v3 L=0.28u W='kQb*0.36u' nf=1 m=1
M23 net6 RA VDD VDD pfet_03v3 L=0.28u W=0.72u nf=1 m=1
M24 net6 RA VSS VSS nfet_03v3 L=0.28u W=0.36u nf=1 m=1
**** begin user architecture code

.param kQb=1

**** end user architecture code
.ends

* expanding   symbol:  engn1600-team1/CAD3/master_latch.sym # of pins=6
** sym_path: /foss/designs/engn1600-team1/CAD3/master_latch.sym
** sch_path: /foss/designs/engn1600-team1/CAD3/master_latch.sch
.subckt master_latch VDD VSS Q WEM WEMb D  kN=1
*.PININFO D:I WEMb:I WEM:I VSS:B VDD:B Q:O
M3 net1 WEMb net2 VDD pfet_03v3 L=0.28u W=0.36u nf=1 m=1
M7 net1 D VDD VDD pfet_03v3 L=0.28u W=0.72u nf=1 m=1
M8 Q net2 VDD VDD pfet_03v3 L=0.28u W=2.48u nf=1 m=1
M9 net3 net2 VDD VDD pfet_03v3 L=0.28u W=0.36u nf=1 m=1
M10 VDD WEM net5 VDD pfet_03v3 L=0.28u W=0.36u nf=1 m=1
M12 net5 net3 net2 VDD pfet_03v3 L=0.28u W=0.36u nf=1 m=1
M19 net1 D VSS VSS nfet_03v3 L=0.28u W=0.36u nf=1 m=1
M20 net1 WEM net2 VSS nfet_03v3 L=0.28u W=0.36u nf=1 m=1
M21 Q net2 VSS VSS nfet_03v3 L=0.28u W=1.24u nf=1 m=1
M22 net3 net2 VSS VSS nfet_03v3 L=0.28u W=0.36u nf=1 m=1
M23 net4 net3 net2 VSS nfet_03v3 L=0.28u W=0.36u nf=1 m=1
M24 VSS WEMb net4 VSS nfet_03v3 L=0.28u W=0.36u nf=1 m=1
.ends

* expanding   symbol:  engn1600-team1/CAD3/driver_cell.sym # of pins=6
** sym_path: /foss/designs/engn1600-team1/CAD3/driver_cell.sym
** sch_path: /foss/designs/engn1600-team1/CAD3/driver_cell.sch
.subckt driver_cell CLK WE WECLKb VDD VSS WECLK  kWECLK=1 kWECLKb=1
*.PININFO CLK:I WE:I VSS:B VDD:B WECLKb:O WECLK:O
M13 WECLK net1 VDD VDD pfet_03v3 L=0.28u W=2.54u nf=1 m=1
M14 WECLK net1 VSS VSS nfet_03v3 L=0.28u W=1.27u nf=1 m=1
M1 WECLKb WECLK VDD VDD pfet_03v3 L=0.28u W=2.68u nf=1 m=1
M2 WECLKb WECLK VSS VSS nfet_03v3 L=0.28u W=1.34u nf=1 m=1
M3 net1 CLK VDD VDD pfet_03v3 L=0.28u W=0.72u nf=1 m=1
M4 net1 WE VDD VDD pfet_03v3 L=0.28u W=0.72u nf=1 m=1
M5 net2 WE VSS VSS nfet_03v3 L=0.28u W=0.72u nf=1 m=1
M6 net1 CLK net2 VSS nfet_03v3 L=0.28u W=0.72u nf=1 m=1
.ends

* expanding   symbol:  engn1600-team1/CAD3/output_inverter.sym # of pins=6
** sym_path: /foss/designs/engn1600-team1/CAD3/output_inverter.sym
** sch_path: /foss/designs/engn1600-team1/CAD3/output_inverter.sch
.subckt output_inverter VDD VSS QA QAb QBb QB
*.PININFO QB:O QA:O VDD:B VSS:B QAb:I QBb:I
M3 QB QBb VDD VDD pfet_03v3 L=0.28u W=0.72u nf=1 m=1
M4 QB QBb VSS VSS nfet_03v3 L=0.28u W=0.36u nf=1 m=1
M35 QA QAb VDD VDD pfet_03v3 L=0.28u W=0.72u nf=1 m=1
M36 QA QAb VSS VSS nfet_03v3 L=0.28u W=0.36u nf=1 m=1
.ends

* expanding   symbol:  engn1600-team1/CAD3/wem_inverter.sym # of pins=4
** sym_path: /foss/designs/engn1600-team1/CAD3/wem_inverter.sym
** sch_path: /foss/designs/engn1600-team1/CAD3/wem_inverter.sch
.subckt wem_inverter VDD WEM WEMb VSS  kWEMb=1
*.PININFO WEM:I WEMb:O VDD:B VSS:B
M1 WEMb WEM VDD VDD pfet_03v3 L=0.28u W=2.52u nf=1 m=1
M2 WEMb WEM VSS VSS nfet_03v3 L=0.28u W=1.26u nf=1 m=1
.ends
