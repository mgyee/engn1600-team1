** sch_path: /foss/designs/engn1600-team1/CAD3/rf.sch
.subckt rf CLK WEM D0 D1 D2 D3 D4 D5 D6 D7 D8 D9 D10 D11 D12 D13 D14 D15 RA0 RA1 RA2 RA3 RA4 RA5 RA6 RA7 RA8 RA9 RA10 RA11 RA12
+ RA13 RA14 RA15 RB0 RB1 RB2 RB3 RB4 RB5 RB6 RB7 RB8 RB9 RB10 RB11 RB12 RB13 RB14 RB15 VDD VSS QA0b QA1b QA2b QA3b QA4b QA5b QA6b QA7b QA8b QA9b
+ QA10b QA11b QA12b QA13b QA14b QA15b QB0b QB1b QB2b QB3b QB4b QB5b QB6b QB7b QB8b QB9b QB10b QB11b QB12b QB13b QB14b QB15b WE0 WE1 WE2 WE3 WE4 WE5 WE6 WE7
+ WE8 WE9 WE10 WE11 WE12 WE13 WE14 WE15
*.PININFO RA0:I RB0:I WE0:I RA1:I RB1:I WE1:I RA2:I RB2:I WE2:I RA3:I RB3:I WE3:I RA4:I RB4:I WE4:I RA5:I RB5:I WE5:I RA6:I RB6:I
*+ WE6:I RA7:I RB7:I WE7:I RA8:I RB8:I WE8:I RA9:I RB9:I WE9:I RA10:I RB10:I WE10:I RA11:I RB11:I WE11:I RA12:I RB12:I WE12:I RA13:I
*+ RB13:I WE13:I RA14:I RB14:I WE14:I RA15:I RB15:I WE15:I CLK:I WEM:I D0:I D1:I D2:I D3:I D4:I D5:I D6:I D7:I D8:I D9:I D10:I D11:I D12:I
*+ D13:I D14:I D15:I QA0b:O QB0b:O QA1b:O QB1b:O QA2b:O QB2b:O QA3b:O QB3b:O QA4b:O QB4b:O QA5b:O QB5b:O QA6b:O QB6b:O QA7b:O QB7b:O QA8b:O QB8b:O QA9b:O
*+ QB9b:O QA10b:O QB10b:O QA11b:O QB11b:O QA12b:O QB12b:O QA13b:O QB13b:O QA14b:O QB14b:O QA15b:O QB15b:O VDD:B VSS:B
x0_0 VDD VSS QA0 WE0CLK WE0CLKb RA0 RB0 QB0 N0 slave_latch kQb='kQb'
x0_1 VDD VSS QA1 WE0CLK WE0CLKb RA0 RB0 QB1 N1 slave_latch kQb='kQb'
x0_2 VDD VSS QA2 WE0CLK WE0CLKb RA0 RB0 QB2 N2 slave_latch kQb='kQb'
x0_3 VDD VSS QA3 WE0CLK WE0CLKb RA0 RB0 QB3 N3 slave_latch kQb='kQb'
x0_4 VDD VSS QA4 WE0CLK WE0CLKb RA0 RB0 QB4 N4 slave_latch kQb='kQb'
x0_5 VDD VSS QA5 WE0CLK WE0CLKb RA0 RB0 QB5 N5 slave_latch kQb='kQb'
x0_6 VDD VSS QA6 WE0CLK WE0CLKb RA0 RB0 QB6 N6 slave_latch kQb='kQb'
x0_7 VDD VSS QA7 WE0CLK WE0CLKb RA0 RB0 QB7 N7 slave_latch kQb='kQb'
x0_8 VDD VSS QA8 WE0CLK WE0CLKb RA0 RB0 QB8 N8 slave_latch kQb='kQb'
x0_9 VDD VSS QA9 WE0CLK WE0CLKb RA0 RB0 QB9 N9 slave_latch kQb='kQb'
x0_10 VDD VSS QA10 WE0CLK WE0CLKb RA0 RB0 QB10 N10 slave_latch kQb='kQb'
x0_11 VDD VSS QA11 WE0CLK WE0CLKb RA0 RB0 QB11 N11 slave_latch kQb='kQb'
x0_12 VDD VSS QA12 WE0CLK WE0CLKb RA0 RB0 QB12 N12 slave_latch kQb='kQb'
x0_13 VDD VSS QA13 WE0CLK WE0CLKb RA0 RB0 QB13 N13 slave_latch kQb='kQb'
x0_14 VDD VSS QA14 WE0CLK WE0CLKb RA0 RB0 QB14 N14 slave_latch kQb='kQb'
x0_15 VDD VSS QA15 WE0CLK WE0CLKb RA0 RB0 QB15 N15 slave_latch kQb='kQb'
x1_0 VDD VSS QA0 WE1CLK WE1CLKb RA1 RB1 QB0 N0 slave_latch kQb='kQb'
x1_1 VDD VSS QA1 WE1CLK WE1CLKb RA1 RB1 QB1 N1 slave_latch kQb='kQb'
x1_2 VDD VSS QA2 WE1CLK WE1CLKb RA1 RB1 QB2 N2 slave_latch kQb='kQb'
x1_3 VDD VSS QA3 WE1CLK WE1CLKb RA1 RB1 QB3 N3 slave_latch kQb='kQb'
x1_4 VDD VSS QA4 WE1CLK WE1CLKb RA1 RB1 QB4 N4 slave_latch kQb='kQb'
x1_5 VDD VSS QA5 WE1CLK WE1CLKb RA1 RB1 QB5 N5 slave_latch kQb='kQb'
x1_6 VDD VSS QA6 WE1CLK WE1CLKb RA1 RB1 QB6 N6 slave_latch kQb='kQb'
x1_7 VDD VSS QA7 WE1CLK WE1CLKb RA1 RB1 QB7 N7 slave_latch kQb='kQb'
x1_8 VDD VSS QA8 WE1CLK WE1CLKb RA1 RB1 QB8 N8 slave_latch kQb='kQb'
x1_9 VDD VSS QA9 WE1CLK WE1CLKb RA1 RB1 QB9 N9 slave_latch kQb='kQb'
x1_10 VDD VSS QA10 WE1CLK WE1CLKb RA1 RB1 QB10 N10 slave_latch kQb='kQb'
x1_11 VDD VSS QA11 WE1CLK WE1CLKb RA1 RB1 QB11 N11 slave_latch kQb='kQb'
x1_12 VDD VSS QA12 WE1CLK WE1CLKb RA1 RB1 QB12 N12 slave_latch kQb='kQb'
x1_13 VDD VSS QA13 WE1CLK WE1CLKb RA1 RB1 QB13 N13 slave_latch kQb='kQb'
x1_14 VDD VSS QA14 WE1CLK WE1CLKb RA1 RB1 QB14 N14 slave_latch kQb='kQb'
x1_15 VDD VSS QA15 WE1CLK WE1CLKb RA1 RB1 QB15 N15 slave_latch kQb='kQb'
x2_0 VDD VSS QA0 WE2CLK WE2CLKb RA2 RB2 QB0 N0 slave_latch kQb='kQb'
x2_1 VDD VSS QA1 WE2CLK WE2CLKb RA2 RB2 QB1 N1 slave_latch kQb='kQb'
x2_2 VDD VSS QA2 WE2CLK WE2CLKb RA2 RB2 QB2 N2 slave_latch kQb='kQb'
x2_3 VDD VSS QA3 WE2CLK WE2CLKb RA2 RB2 QB3 N3 slave_latch kQb='kQb'
x2_4 VDD VSS QA4 WE2CLK WE2CLKb RA2 RB2 QB4 N4 slave_latch kQb='kQb'
x2_5 VDD VSS QA5 WE2CLK WE2CLKb RA2 RB2 QB5 N5 slave_latch kQb='kQb'
x2_6 VDD VSS QA6 WE2CLK WE2CLKb RA2 RB2 QB6 N6 slave_latch kQb='kQb'
x2_7 VDD VSS QA7 WE2CLK WE2CLKb RA2 RB2 QB7 N7 slave_latch kQb='kQb'
x2_8 VDD VSS QA8 WE2CLK WE2CLKb RA2 RB2 QB8 N8 slave_latch kQb='kQb'
x2_9 VDD VSS QA9 WE2CLK WE2CLKb RA2 RB2 QB9 N9 slave_latch kQb='kQb'
x2_10 VDD VSS QA10 WE2CLK WE2CLKb RA2 RB2 QB10 N10 slave_latch kQb='kQb'
x2_11 VDD VSS QA11 WE2CLK WE2CLKb RA2 RB2 QB11 N11 slave_latch kQb='kQb'
x2_12 VDD VSS QA12 WE2CLK WE2CLKb RA2 RB2 QB12 N12 slave_latch kQb='kQb'
x2_13 VDD VSS QA13 WE2CLK WE2CLKb RA2 RB2 QB13 N13 slave_latch kQb='kQb'
x2_14 VDD VSS QA14 WE2CLK WE2CLKb RA2 RB2 QB14 N14 slave_latch kQb='kQb'
x2_15 VDD VSS QA15 WE2CLK WE2CLKb RA2 RB2 QB15 N15 slave_latch kQb='kQb'
x3_0 VDD VSS QA0 WE3CLK WE3CLKb RA3 RB3 QB0 N0 slave_latch kQb='kQb'
x3_1 VDD VSS QA1 WE3CLK WE3CLKb RA3 RB3 QB1 N1 slave_latch kQb='kQb'
x3_2 VDD VSS QA2 WE3CLK WE3CLKb RA3 RB3 QB2 N2 slave_latch kQb='kQb'
x3_3 VDD VSS QA3 WE3CLK WE3CLKb RA3 RB3 QB3 N3 slave_latch kQb='kQb'
x3_4 VDD VSS QA4 WE3CLK WE3CLKb RA3 RB3 QB4 N4 slave_latch kQb='kQb'
x3_5 VDD VSS QA5 WE3CLK WE3CLKb RA3 RB3 QB5 N5 slave_latch kQb='kQb'
x3_6 VDD VSS QA6 WE3CLK WE3CLKb RA3 RB3 QB6 N6 slave_latch kQb='kQb'
x3_7 VDD VSS QA7 WE3CLK WE3CLKb RA3 RB3 QB7 N7 slave_latch kQb='kQb'
x3_8 VDD VSS QA8 WE3CLK WE3CLKb RA3 RB3 QB8 N8 slave_latch kQb='kQb'
x3_9 VDD VSS QA9 WE3CLK WE3CLKb RA3 RB3 QB9 N9 slave_latch kQb='kQb'
x3_10 VDD VSS QA10 WE3CLK WE3CLKb RA3 RB3 QB10 N10 slave_latch kQb='kQb'
x3_11 VDD VSS QA11 WE3CLK WE3CLKb RA3 RB3 QB11 N11 slave_latch kQb='kQb'
x3_12 VDD VSS QA12 WE3CLK WE3CLKb RA3 RB3 QB12 N12 slave_latch kQb='kQb'
x3_13 VDD VSS QA13 WE3CLK WE3CLKb RA3 RB3 QB13 N13 slave_latch kQb='kQb'
x3_14 VDD VSS QA14 WE3CLK WE3CLKb RA3 RB3 QB14 N14 slave_latch kQb='kQb'
x3_15 VDD VSS QA15 WE3CLK WE3CLKb RA3 RB3 QB15 N15 slave_latch kQb='kQb'
x4_0 VDD VSS QA0 WE4CLK WE4CLKb RA4 RB4 QB0 N0 slave_latch kQb='kQb'
x4_1 VDD VSS QA1 WE4CLK WE4CLKb RA4 RB4 QB1 N1 slave_latch kQb='kQb'
x4_2 VDD VSS QA2 WE4CLK WE4CLKb RA4 RB4 QB2 N2 slave_latch kQb='kQb'
x4_3 VDD VSS QA3 WE4CLK WE4CLKb RA4 RB4 QB3 N3 slave_latch kQb='kQb'
x4_4 VDD VSS QA4 WE4CLK WE4CLKb RA4 RB4 QB4 N4 slave_latch kQb='kQb'
x4_5 VDD VSS QA5 WE4CLK WE4CLKb RA4 RB4 QB5 N5 slave_latch kQb='kQb'
x4_6 VDD VSS QA6 WE4CLK WE4CLKb RA4 RB4 QB6 N6 slave_latch kQb='kQb'
x4_7 VDD VSS QA7 WE4CLK WE4CLKb RA4 RB4 QB7 N7 slave_latch kQb='kQb'
x4_8 VDD VSS QA8 WE4CLK WE4CLKb RA4 RB4 QB8 N8 slave_latch kQb='kQb'
x4_9 VDD VSS QA9 WE4CLK WE4CLKb RA4 RB4 QB9 N9 slave_latch kQb='kQb'
x4_10 VDD VSS QA10 WE4CLK WE4CLKb RA4 RB4 QB10 N10 slave_latch kQb='kQb'
x4_11 VDD VSS QA11 WE4CLK WE4CLKb RA4 RB4 QB11 N11 slave_latch kQb='kQb'
x4_12 VDD VSS QA12 WE4CLK WE4CLKb RA4 RB4 QB12 N12 slave_latch kQb='kQb'
x4_13 VDD VSS QA13 WE4CLK WE4CLKb RA4 RB4 QB13 N13 slave_latch kQb='kQb'
x4_14 VDD VSS QA14 WE4CLK WE4CLKb RA4 RB4 QB14 N14 slave_latch kQb='kQb'
x4_15 VDD VSS QA15 WE4CLK WE4CLKb RA4 RB4 QB15 N15 slave_latch kQb='kQb'
x5_0 VDD VSS QA0 WE5CLK WE5CLKb RA5 RB5 QB0 N0 slave_latch kQb='kQb'
x5_1 VDD VSS QA1 WE5CLK WE5CLKb RA5 RB5 QB1 N1 slave_latch kQb='kQb'
x5_2 VDD VSS QA2 WE5CLK WE5CLKb RA5 RB5 QB2 N2 slave_latch kQb='kQb'
x5_3 VDD VSS QA3 WE5CLK WE5CLKb RA5 RB5 QB3 N3 slave_latch kQb='kQb'
x5_4 VDD VSS QA4 WE5CLK WE5CLKb RA5 RB5 QB4 N4 slave_latch kQb='kQb'
x5_5 VDD VSS QA5 WE5CLK WE5CLKb RA5 RB5 QB5 N5 slave_latch kQb='kQb'
x5_6 VDD VSS QA6 WE5CLK WE5CLKb RA5 RB5 QB6 N6 slave_latch kQb='kQb'
x5_7 VDD VSS QA7 WE5CLK WE5CLKb RA5 RB5 QB7 N7 slave_latch kQb='kQb'
x5_8 VDD VSS QA8 WE5CLK WE5CLKb RA5 RB5 QB8 N8 slave_latch kQb='kQb'
x5_9 VDD VSS QA9 WE5CLK WE5CLKb RA5 RB5 QB9 N9 slave_latch kQb='kQb'
x5_10 VDD VSS QA10 WE5CLK WE5CLKb RA5 RB5 QB10 N10 slave_latch kQb='kQb'
x5_11 VDD VSS QA11 WE5CLK WE5CLKb RA5 RB5 QB11 N11 slave_latch kQb='kQb'
x5_12 VDD VSS QA12 WE5CLK WE5CLKb RA5 RB5 QB12 N12 slave_latch kQb='kQb'
x5_13 VDD VSS QA13 WE5CLK WE5CLKb RA5 RB5 QB13 N13 slave_latch kQb='kQb'
x5_14 VDD VSS QA14 WE5CLK WE5CLKb RA5 RB5 QB14 N14 slave_latch kQb='kQb'
x5_15 VDD VSS QA15 WE5CLK WE5CLKb RA5 RB5 QB15 N15 slave_latch kQb='kQb'
x6_0 VDD VSS QA0 WE6CLK WE6CLKb RA6 RB6 QB0 N0 slave_latch kQb='kQb'
x6_1 VDD VSS QA1 WE6CLK WE6CLKb RA6 RB6 QB1 N1 slave_latch kQb='kQb'
x6_2 VDD VSS QA2 WE6CLK WE6CLKb RA6 RB6 QB2 N2 slave_latch kQb='kQb'
x6_3 VDD VSS QA3 WE6CLK WE6CLKb RA6 RB6 QB3 N3 slave_latch kQb='kQb'
x6_4 VDD VSS QA4 WE6CLK WE6CLKb RA6 RB6 QB4 N4 slave_latch kQb='kQb'
x6_5 VDD VSS QA5 WE6CLK WE6CLKb RA6 RB6 QB5 N5 slave_latch kQb='kQb'
x6_6 VDD VSS QA6 WE6CLK WE6CLKb RA6 RB6 QB6 N6 slave_latch kQb='kQb'
x6_7 VDD VSS QA7 WE6CLK WE6CLKb RA6 RB6 QB7 N7 slave_latch kQb='kQb'
x6_8 VDD VSS QA8 WE6CLK WE6CLKb RA6 RB6 QB8 N8 slave_latch kQb='kQb'
x6_9 VDD VSS QA9 WE6CLK WE6CLKb RA6 RB6 QB9 N9 slave_latch kQb='kQb'
x6_10 VDD VSS QA10 WE6CLK WE6CLKb RA6 RB6 QB10 N10 slave_latch kQb='kQb'
x6_11 VDD VSS QA11 WE6CLK WE6CLKb RA6 RB6 QB11 N11 slave_latch kQb='kQb'
x6_12 VDD VSS QA12 WE6CLK WE6CLKb RA6 RB6 QB12 N12 slave_latch kQb='kQb'
x6_13 VDD VSS QA13 WE6CLK WE6CLKb RA6 RB6 QB13 N13 slave_latch kQb='kQb'
x6_14 VDD VSS QA14 WE6CLK WE6CLKb RA6 RB6 QB14 N14 slave_latch kQb='kQb'
x6_15 VDD VSS QA15 WE6CLK WE6CLKb RA6 RB6 QB15 N15 slave_latch kQb='kQb'
x7_0 VDD VSS QA0 WE7CLK WE7CLKb RA7 RB7 QB0 N0 slave_latch kQb='kQb'
x7_1 VDD VSS QA1 WE7CLK WE7CLKb RA7 RB7 QB1 N1 slave_latch kQb='kQb'
x7_2 VDD VSS QA2 WE7CLK WE7CLKb RA7 RB7 QB2 N2 slave_latch kQb='kQb'
x7_3 VDD VSS QA3 WE7CLK WE7CLKb RA7 RB7 QB3 N3 slave_latch kQb='kQb'
x7_4 VDD VSS QA4 WE7CLK WE7CLKb RA7 RB7 QB4 N4 slave_latch kQb='kQb'
x7_5 VDD VSS QA5 WE7CLK WE7CLKb RA7 RB7 QB5 N5 slave_latch kQb='kQb'
x7_6 VDD VSS QA6 WE7CLK WE7CLKb RA7 RB7 QB6 N6 slave_latch kQb='kQb'
x7_7 VDD VSS QA7 WE7CLK WE7CLKb RA7 RB7 QB7 N7 slave_latch kQb='kQb'
x7_8 VDD VSS QA8 WE7CLK WE7CLKb RA7 RB7 QB8 N8 slave_latch kQb='kQb'
x7_9 VDD VSS QA9 WE7CLK WE7CLKb RA7 RB7 QB9 N9 slave_latch kQb='kQb'
x7_10 VDD VSS QA10 WE7CLK WE7CLKb RA7 RB7 QB10 N10 slave_latch kQb='kQb'
x7_11 VDD VSS QA11 WE7CLK WE7CLKb RA7 RB7 QB11 N11 slave_latch kQb='kQb'
x7_12 VDD VSS QA12 WE7CLK WE7CLKb RA7 RB7 QB12 N12 slave_latch kQb='kQb'
x7_13 VDD VSS QA13 WE7CLK WE7CLKb RA7 RB7 QB13 N13 slave_latch kQb='kQb'
x7_14 VDD VSS QA14 WE7CLK WE7CLKb RA7 RB7 QB14 N14 slave_latch kQb='kQb'
x7_15 VDD VSS QA15 WE7CLK WE7CLKb RA7 RB7 QB15 N15 slave_latch kQb='kQb'
x8_0 VDD VSS QA0 WE8CLK WE8CLKb RA8 RB8 QB0 N0 slave_latch kQb='kQb'
x8_1 VDD VSS QA1 WE8CLK WE8CLKb RA8 RB8 QB1 N1 slave_latch kQb='kQb'
x8_2 VDD VSS QA2 WE8CLK WE8CLKb RA8 RB8 QB2 N2 slave_latch kQb='kQb'
x8_3 VDD VSS QA3 WE8CLK WE8CLKb RA8 RB8 QB3 N3 slave_latch kQb='kQb'
x8_4 VDD VSS QA4 WE8CLK WE8CLKb RA8 RB8 QB4 N4 slave_latch kQb='kQb'
x8_5 VDD VSS QA5 WE8CLK WE8CLKb RA8 RB8 QB5 N5 slave_latch kQb='kQb'
x8_6 VDD VSS QA6 WE8CLK WE8CLKb RA8 RB8 QB6 N6 slave_latch kQb='kQb'
x8_7 VDD VSS QA7 WE8CLK WE8CLKb RA8 RB8 QB7 N7 slave_latch kQb='kQb'
x8_8 VDD VSS QA8 WE8CLK WE8CLKb RA8 RB8 QB8 N8 slave_latch kQb='kQb'
x8_9 VDD VSS QA9 WE8CLK WE8CLKb RA8 RB8 QB9 N9 slave_latch kQb='kQb'
x8_10 VDD VSS QA10 WE8CLK WE8CLKb RA8 RB8 QB10 N10 slave_latch kQb='kQb'
x8_11 VDD VSS QA11 WE8CLK WE8CLKb RA8 RB8 QB11 N11 slave_latch kQb='kQb'
x8_12 VDD VSS QA12 WE8CLK WE8CLKb RA8 RB8 QB12 N12 slave_latch kQb='kQb'
x8_13 VDD VSS QA13 WE8CLK WE8CLKb RA8 RB8 QB13 N13 slave_latch kQb='kQb'
x8_14 VDD VSS QA14 WE8CLK WE8CLKb RA8 RB8 QB14 N14 slave_latch kQb='kQb'
x8_15 VDD VSS QA15 WE8CLK WE8CLKb RA8 RB8 QB15 N15 slave_latch kQb='kQb'
x9_0 VDD VSS QA0 WE9CLK WE9CLKb RA9 RB9 QB0 N0 slave_latch kQb='kQb'
x9_1 VDD VSS QA1 WE9CLK WE9CLKb RA9 RB9 QB1 N1 slave_latch kQb='kQb'
x9_2 VDD VSS QA2 WE9CLK WE9CLKb RA9 RB9 QB2 N2 slave_latch kQb='kQb'
x9_3 VDD VSS QA3 WE9CLK WE9CLKb RA9 RB9 QB3 N3 slave_latch kQb='kQb'
x9_4 VDD VSS QA4 WE9CLK WE9CLKb RA9 RB9 QB4 N4 slave_latch kQb='kQb'
x9_5 VDD VSS QA5 WE9CLK WE9CLKb RA9 RB9 QB5 N5 slave_latch kQb='kQb'
x9_6 VDD VSS QA6 WE9CLK WE9CLKb RA9 RB9 QB6 N6 slave_latch kQb='kQb'
x9_7 VDD VSS QA7 WE9CLK WE9CLKb RA9 RB9 QB7 N7 slave_latch kQb='kQb'
x9_8 VDD VSS QA8 WE9CLK WE9CLKb RA9 RB9 QB8 N8 slave_latch kQb='kQb'
x9_9 VDD VSS QA9 WE9CLK WE9CLKb RA9 RB9 QB9 N9 slave_latch kQb='kQb'
x9_10 VDD VSS QA10 WE9CLK WE9CLKb RA9 RB9 QB10 N10 slave_latch kQb='kQb'
x9_11 VDD VSS QA11 WE9CLK WE9CLKb RA9 RB9 QB11 N11 slave_latch kQb='kQb'
x9_12 VDD VSS QA12 WE9CLK WE9CLKb RA9 RB9 QB12 N12 slave_latch kQb='kQb'
x9_13 VDD VSS QA13 WE9CLK WE9CLKb RA9 RB9 QB13 N13 slave_latch kQb='kQb'
x9_14 VDD VSS QA14 WE9CLK WE9CLKb RA9 RB9 QB14 N14 slave_latch kQb='kQb'
x9_15 VDD VSS QA15 WE9CLK WE9CLKb RA9 RB9 QB15 N15 slave_latch kQb='kQb'
x10_0 VDD VSS QA0 WE10CLK WE10CLKb RA10 RB10 QB0 N0 slave_latch kQb='kQb'
x10_1 VDD VSS QA1 WE10CLK WE10CLKb RA10 RB10 QB1 N1 slave_latch kQb='kQb'
x10_2 VDD VSS QA2 WE10CLK WE10CLKb RA10 RB10 QB2 N2 slave_latch kQb='kQb'
x10_3 VDD VSS QA3 WE10CLK WE10CLKb RA10 RB10 QB3 N3 slave_latch kQb='kQb'
x10_4 VDD VSS QA4 WE10CLK WE10CLKb RA10 RB10 QB4 N4 slave_latch kQb='kQb'
x10_5 VDD VSS QA5 WE10CLK WE10CLKb RA10 RB10 QB5 N5 slave_latch kQb='kQb'
x10_6 VDD VSS QA6 WE10CLK WE10CLKb RA10 RB10 QB6 N6 slave_latch kQb='kQb'
x10_7 VDD VSS QA7 WE10CLK WE10CLKb RA10 RB10 QB7 N7 slave_latch kQb='kQb'
x10_8 VDD VSS QA8 WE10CLK WE10CLKb RA10 RB10 QB8 N8 slave_latch kQb='kQb'
x10_9 VDD VSS QA9 WE10CLK WE10CLKb RA10 RB10 QB9 N9 slave_latch kQb='kQb'
x10_10 VDD VSS QA10 WE10CLK WE10CLKb RA10 RB10 QB10 N10 slave_latch kQb='kQb'
x10_11 VDD VSS QA11 WE10CLK WE10CLKb RA10 RB10 QB11 N11 slave_latch kQb='kQb'
x10_12 VDD VSS QA12 WE10CLK WE10CLKb RA10 RB10 QB12 N12 slave_latch kQb='kQb'
x10_13 VDD VSS QA13 WE10CLK WE10CLKb RA10 RB10 QB13 N13 slave_latch kQb='kQb'
x10_14 VDD VSS QA14 WE10CLK WE10CLKb RA10 RB10 QB14 N14 slave_latch kQb='kQb'
x10_15 VDD VSS QA15 WE10CLK WE10CLKb RA10 RB10 QB15 N15 slave_latch kQb='kQb'
x11_0 VDD VSS QA0 WE11CLK WE11CLKb RA11 RB11 QB0 N0 slave_latch kQb='kQb'
x11_1 VDD VSS QA1 WE11CLK WE11CLKb RA11 RB11 QB1 N1 slave_latch kQb='kQb'
x11_2 VDD VSS QA2 WE11CLK WE11CLKb RA11 RB11 QB2 N2 slave_latch kQb='kQb'
x11_3 VDD VSS QA3 WE11CLK WE11CLKb RA11 RB11 QB3 N3 slave_latch kQb='kQb'
x11_4 VDD VSS QA4 WE11CLK WE11CLKb RA11 RB11 QB4 N4 slave_latch kQb='kQb'
x11_5 VDD VSS QA5 WE11CLK WE11CLKb RA11 RB11 QB5 N5 slave_latch kQb='kQb'
x11_6 VDD VSS QA6 WE11CLK WE11CLKb RA11 RB11 QB6 N6 slave_latch kQb='kQb'
x11_7 VDD VSS QA7 WE11CLK WE11CLKb RA11 RB11 QB7 N7 slave_latch kQb='kQb'
x11_8 VDD VSS QA8 WE11CLK WE11CLKb RA11 RB11 QB8 N8 slave_latch kQb='kQb'
x11_9 VDD VSS QA9 WE11CLK WE11CLKb RA11 RB11 QB9 N9 slave_latch kQb='kQb'
x11_10 VDD VSS QA10 WE11CLK WE11CLKb RA11 RB11 QB10 N10 slave_latch kQb='kQb'
x11_11 VDD VSS QA11 WE11CLK WE11CLKb RA11 RB11 QB11 N11 slave_latch kQb='kQb'
x11_12 VDD VSS QA12 WE11CLK WE11CLKb RA11 RB11 QB12 N12 slave_latch kQb='kQb'
x11_13 VDD VSS QA13 WE11CLK WE11CLKb RA11 RB11 QB13 N13 slave_latch kQb='kQb'
x11_14 VDD VSS QA14 WE11CLK WE11CLKb RA11 RB11 QB14 N14 slave_latch kQb='kQb'
x11_15 VDD VSS QA15 WE11CLK WE11CLKb RA11 RB11 QB15 N15 slave_latch kQb='kQb'
x12_0 VDD VSS QA0 WE12CLK WE12CLKb RA12 RB12 QB0 N0 slave_latch kQb='kQb'
x12_1 VDD VSS QA1 WE12CLK WE12CLKb RA12 RB12 QB1 N1 slave_latch kQb='kQb'
x12_2 VDD VSS QA2 WE12CLK WE12CLKb RA12 RB12 QB2 N2 slave_latch kQb='kQb'
x12_3 VDD VSS QA3 WE12CLK WE12CLKb RA12 RB12 QB3 N3 slave_latch kQb='kQb'
x12_4 VDD VSS QA4 WE12CLK WE12CLKb RA12 RB12 QB4 N4 slave_latch kQb='kQb'
x12_5 VDD VSS QA5 WE12CLK WE12CLKb RA12 RB12 QB5 N5 slave_latch kQb='kQb'
x12_6 VDD VSS QA6 WE12CLK WE12CLKb RA12 RB12 QB6 N6 slave_latch kQb='kQb'
x12_7 VDD VSS QA7 WE12CLK WE12CLKb RA12 RB12 QB7 N7 slave_latch kQb='kQb'
x12_8 VDD VSS QA8 WE12CLK WE12CLKb RA12 RB12 QB8 N8 slave_latch kQb='kQb'
x12_9 VDD VSS QA9 WE12CLK WE12CLKb RA12 RB12 QB9 N9 slave_latch kQb='kQb'
x12_10 VDD VSS QA10 WE12CLK WE12CLKb RA12 RB12 QB10 N10 slave_latch kQb='kQb'
x12_11 VDD VSS QA11 WE12CLK WE12CLKb RA12 RB12 QB11 N11 slave_latch kQb='kQb'
x12_12 VDD VSS QA12 WE12CLK WE12CLKb RA12 RB12 QB12 N12 slave_latch kQb='kQb'
x12_13 VDD VSS QA13 WE12CLK WE12CLKb RA12 RB12 QB13 N13 slave_latch kQb='kQb'
x12_14 VDD VSS QA14 WE12CLK WE12CLKb RA12 RB12 QB14 N14 slave_latch kQb='kQb'
x12_15 VDD VSS QA15 WE12CLK WE12CLKb RA12 RB12 QB15 N15 slave_latch kQb='kQb'
x13_0 VDD VSS QA0 WE13CLK WE13CLKb RA13 RB13 QB0 N0 slave_latch kQb='kQb'
x13_1 VDD VSS QA1 WE13CLK WE13CLKb RA13 RB13 QB1 N1 slave_latch kQb='kQb'
x13_2 VDD VSS QA2 WE13CLK WE13CLKb RA13 RB13 QB2 N2 slave_latch kQb='kQb'
x13_3 VDD VSS QA3 WE13CLK WE13CLKb RA13 RB13 QB3 N3 slave_latch kQb='kQb'
x13_4 VDD VSS QA4 WE13CLK WE13CLKb RA13 RB13 QB4 N4 slave_latch kQb='kQb'
x13_5 VDD VSS QA5 WE13CLK WE13CLKb RA13 RB13 QB5 N5 slave_latch kQb='kQb'
x13_6 VDD VSS QA6 WE13CLK WE13CLKb RA13 RB13 QB6 N6 slave_latch kQb='kQb'
x13_7 VDD VSS QA7 WE13CLK WE13CLKb RA13 RB13 QB7 N7 slave_latch kQb='kQb'
x13_8 VDD VSS QA8 WE13CLK WE13CLKb RA13 RB13 QB8 N8 slave_latch kQb='kQb'
x13_9 VDD VSS QA9 WE13CLK WE13CLKb RA13 RB13 QB9 N9 slave_latch kQb='kQb'
x13_10 VDD VSS QA10 WE13CLK WE13CLKb RA13 RB13 QB10 N10 slave_latch kQb='kQb'
x13_11 VDD VSS QA11 WE13CLK WE13CLKb RA13 RB13 QB11 N11 slave_latch kQb='kQb'
x13_12 VDD VSS QA12 WE13CLK WE13CLKb RA13 RB13 QB12 N12 slave_latch kQb='kQb'
x13_13 VDD VSS QA13 WE13CLK WE13CLKb RA13 RB13 QB13 N13 slave_latch kQb='kQb'
x13_14 VDD VSS QA14 WE13CLK WE13CLKb RA13 RB13 QB14 N14 slave_latch kQb='kQb'
x13_15 VDD VSS QA15 WE13CLK WE13CLKb RA13 RB13 QB15 N15 slave_latch kQb='kQb'
x14_0 VDD VSS QA0 WE14CLK WE14CLKb RA14 RB14 QB0 N0 slave_latch kQb='kQb'
x14_1 VDD VSS QA1 WE14CLK WE14CLKb RA14 RB14 QB1 N1 slave_latch kQb='kQb'
x14_2 VDD VSS QA2 WE14CLK WE14CLKb RA14 RB14 QB2 N2 slave_latch kQb='kQb'
x14_3 VDD VSS QA3 WE14CLK WE14CLKb RA14 RB14 QB3 N3 slave_latch kQb='kQb'
x14_4 VDD VSS QA4 WE14CLK WE14CLKb RA14 RB14 QB4 N4 slave_latch kQb='kQb'
x14_5 VDD VSS QA5 WE14CLK WE14CLKb RA14 RB14 QB5 N5 slave_latch kQb='kQb'
x14_6 VDD VSS QA6 WE14CLK WE14CLKb RA14 RB14 QB6 N6 slave_latch kQb='kQb'
x14_7 VDD VSS QA7 WE14CLK WE14CLKb RA14 RB14 QB7 N7 slave_latch kQb='kQb'
x14_8 VDD VSS QA8 WE14CLK WE14CLKb RA14 RB14 QB8 N8 slave_latch kQb='kQb'
x14_9 VDD VSS QA9 WE14CLK WE14CLKb RA14 RB14 QB9 N9 slave_latch kQb='kQb'
x14_10 VDD VSS QA10 WE14CLK WE14CLKb RA14 RB14 QB10 N10 slave_latch kQb='kQb'
x14_11 VDD VSS QA11 WE14CLK WE14CLKb RA14 RB14 QB11 N11 slave_latch kQb='kQb'
x14_12 VDD VSS QA12 WE14CLK WE14CLKb RA14 RB14 QB12 N12 slave_latch kQb='kQb'
x14_13 VDD VSS QA13 WE14CLK WE14CLKb RA14 RB14 QB13 N13 slave_latch kQb='kQb'
x14_14 VDD VSS QA14 WE14CLK WE14CLKb RA14 RB14 QB14 N14 slave_latch kQb='kQb'
x14_15 VDD VSS QA15 WE14CLK WE14CLKb RA14 RB14 QB15 N15 slave_latch kQb='kQb'
x15_0 VDD VSS QA0 WE15CLK WE15CLKb RA15 RB15 QB0 N0 slave_latch kQb='kQb'
x15_1 VDD VSS QA1 WE15CLK WE15CLKb RA15 RB15 QB1 N1 slave_latch kQb='kQb'
x15_2 VDD VSS QA2 WE15CLK WE15CLKb RA15 RB15 QB2 N2 slave_latch kQb='kQb'
x15_3 VDD VSS QA3 WE15CLK WE15CLKb RA15 RB15 QB3 N3 slave_latch kQb='kQb'
x15_4 VDD VSS QA4 WE15CLK WE15CLKb RA15 RB15 QB4 N4 slave_latch kQb='kQb'
x15_5 VDD VSS QA5 WE15CLK WE15CLKb RA15 RB15 QB5 N5 slave_latch kQb='kQb'
x15_6 VDD VSS QA6 WE15CLK WE15CLKb RA15 RB15 QB6 N6 slave_latch kQb='kQb'
x15_7 VDD VSS QA7 WE15CLK WE15CLKb RA15 RB15 QB7 N7 slave_latch kQb='kQb'
x15_8 VDD VSS QA8 WE15CLK WE15CLKb RA15 RB15 QB8 N8 slave_latch kQb='kQb'
x15_9 VDD VSS QA9 WE15CLK WE15CLKb RA15 RB15 QB9 N9 slave_latch kQb='kQb'
x15_10 VDD VSS QA10 WE15CLK WE15CLKb RA15 RB15 QB10 N10 slave_latch kQb='kQb'
x15_11 VDD VSS QA11 WE15CLK WE15CLKb RA15 RB15 QB11 N11 slave_latch kQb='kQb'
x15_12 VDD VSS QA12 WE15CLK WE15CLKb RA15 RB15 QB12 N12 slave_latch kQb='kQb'
x15_13 VDD VSS QA13 WE15CLK WE15CLKb RA15 RB15 QB13 N13 slave_latch kQb='kQb'
x15_14 VDD VSS QA14 WE15CLK WE15CLKb RA15 RB15 QB14 N14 slave_latch kQb='kQb'
x15_15 VDD VSS QA15 WE15CLK WE15CLKb RA15 RB15 QB15 N15 slave_latch kQb='kQb'
x1 VDD VSS N0 WEM WEMb D0 master_latch kN='kN'
x2 VDD VSS N1 WEM WEMb D1 master_latch kN='kN'
x3 VDD VSS N2 WEM WEMb D2 master_latch kN='kN'
x4 VDD VSS N3 WEM WEMb D3 master_latch kN='kN'
x5 VDD VSS N4 WEM WEMb D4 master_latch kN='kN'
x6 VDD VSS N5 WEM WEMb D5 master_latch kN='kN'
x7 VDD VSS N6 WEM WEMb D6 master_latch kN='kN'
x8 VDD VSS N7 WEM WEMb D7 master_latch kN='kN'
x9 VDD VSS N8 WEM WEMb D8 master_latch kN='kN'
x10 VDD VSS N9 WEM WEMb D9 master_latch kN='kN'
x11 VDD VSS N10 WEM WEMb D10 master_latch kN='kN'
x12 VDD VSS N11 WEM WEMb D11 master_latch kN='kN'
x13 VDD VSS N12 WEM WEMb D12 master_latch kN='kN'
x14 VDD VSS N13 WEM WEMb D13 master_latch kN='kN'
x15 VDD VSS N14 WEM WEMb D14 master_latch kN='kN'
x16 VDD VSS N15 WEM WEMb D15 master_latch kN='kN'
x17 CLK WE15 WE15CLKb VDD VSS WE15CLK driver_cell kWECLK='kWECLK' kWECLKb='kWECLKb'
x18 CLK WE14 WE14CLKb VDD VSS WE14CLK driver_cell kWECLK='kWECLK' kWECLKb='kWECLKb'
x19 CLK WE13 WE13CLKb VDD VSS WE13CLK driver_cell kWECLK='kWECLK' kWECLKb='kWECLKb'
x20 CLK WE12 WE12CLKb VDD VSS WE12CLK driver_cell kWECLK='kWECLK' kWECLKb='kWECLKb'
x21 CLK WE11 WE11CLKb VDD VSS WE11CLK driver_cell kWECLK='kWECLK' kWECLKb='kWECLKb'
x22 CLK WE10 WE10CLKb VDD VSS WE10CLK driver_cell kWECLK='kWECLK' kWECLKb='kWECLKb'
x23 CLK WE9 WE9CLKb VDD VSS WE9CLK driver_cell kWECLK='kWECLK' kWECLKb='kWECLKb'
x24 CLK WE8 WE8CLKb VDD VSS WE8CLK driver_cell kWECLK='kWECLK' kWECLKb='kWECLKb'
x25 CLK WE7 WE7CLKb VDD VSS WE7CLK driver_cell kWECLK='kWECLK' kWECLKb='kWECLKb'
x26 CLK WE6 WE6CLKb VDD VSS WE6CLK driver_cell kWECLK='kWECLK' kWECLKb='kWECLKb'
x27 CLK WE5 WE5CLKb VDD VSS WE5CLK driver_cell kWECLK='kWECLK' kWECLKb='kWECLKb'
x28 CLK WE4 WE4CLKb VDD VSS WE4CLK driver_cell kWECLK='kWECLK' kWECLKb='kWECLKb'
x29 CLK WE3 WE3CLKb VDD VSS WE3CLK driver_cell kWECLK='kWECLK' kWECLKb='kWECLKb'
x30 CLK WE2 WE2CLKb VDD VSS WE2CLK driver_cell kWECLK='kWECLK' kWECLKb='kWECLKb'
x31 CLK WE1 WE1CLKb VDD VSS WE1CLK driver_cell kWECLK='kWECLK' kWECLKb='kWECLKb'
x32 CLK WE0 WE0CLKb VDD VSS WE0CLK driver_cell kWECLK='kWECLK' kWECLKb='kWECLKb'
x33 VDD VSS QA0b QA0 QB0 QB0b output_inverter
x34 VDD VSS QA1b QA1 QB1 QB1b output_inverter
x35 VDD VSS QA2b QA2 QB2 QB2b output_inverter
x36 VDD VSS QA3b QA3 QB3 QB3b output_inverter
x37 VDD VSS QA4b QA4 QB4 QB4b output_inverter
x38 VDD VSS QA5b QA5 QB5 QB5b output_inverter
x39 VDD VSS QA6b QA6 QB6 QB6b output_inverter
x40 VDD VSS QA7b QA7 QB7 QB7b output_inverter
x41 VDD VSS QA8b QA8 QB8 QB8b output_inverter
x42 VDD VSS QA9b QA9 QB9 QB9b output_inverter
x43 VDD VSS QA10b QA10 QB10 QB10b output_inverter
x44 VDD VSS QA11b QA11 QB11 QB11b output_inverter
x45 VDD VSS QA12b QA12 QB12 QB12b output_inverter
x46 VDD VSS QA13b QA13 QB13 QB13b output_inverter
x47 VDD VSS QA14b QA14 QB14 QB14b output_inverter
x48 VDD VSS QA15b QA15 QB15 QB15b output_inverter
x49 VDD WEM WEMb VSS wem_inverter kWEMb='kWEMb'
**** begin user architecture code

.param kWECLKb=1.34/0.36
.param kWECLK=1.27/0.36
.param kWEMb=1.26/0.36
.param kQb=0.36/0.36
.param kN=1.24/0.36

**** end user architecture code
.ends

* expanding   symbol:  engn1600-team1/CAD3/slave_latch.sym # of pins=9
** sym_path: /foss/designs/engn1600-team1/CAD3/slave_latch.sym
** sch_path: /foss/designs/engn1600-team1/CAD3/slave_latch.sch
.subckt slave_latch VDD VSS QA WECLK WECLKb RA RB QB D  kQb=1
*.PININFO D:I RA:I RB:I WECLKb:I WECLK:I QA:O QB:O VDD:B VSS:B
M1 net1 WECLKb net2 VDD pfet_03v3 L=0.28u W=0.36u nf=1 m=1
M2 net1 D VDD VDD pfet_03v3 L=0.28u W=0.72u nf=1 m=1
M3 net3 net2 VDD VDD pfet_03v3 L=0.28u W=0.72u nf=1 m=1
M4 net4 net2 VDD VDD pfet_03v3 L=0.28u W=0.36u nf=1 m=1
M5 VDD WECLK net8 VDD pfet_03v3 L=0.28u W=0.36u nf=1 m=1
M6 net8 net4 net2 VDD pfet_03v3 L=0.28u W=0.36u nf=1 m=1
M7 net1 D VSS VSS nfet_03v3 L=0.28u W=0.36u nf=1 m=1
M8 net1 WECLK net2 VSS nfet_03v3 L=0.28u W=0.36u nf=1 m=1
M9 net3 net2 VSS VSS nfet_03v3 L=0.28u W=0.36u nf=1 m=1
M10 net4 net2 VSS VSS nfet_03v3 L=0.28u W=0.36u nf=1 m=1
M11 net7 net4 net2 VSS nfet_03v3 L=0.28u W=0.36u nf=1 m=1
M12 VSS WECLKb net7 VSS nfet_03v3 L=0.28u W=0.36u nf=1 m=1
M13 net3 net5 QB VDD pfet_03v3 L=0.28u W='0.36/0.36*0.36u' nf=1 m=1
M14 net3 RB QB VSS nfet_03v3 L=0.28u W='0.36/0.36*0.36u' nf=1 m=1
M15 net5 RB VDD VDD pfet_03v3 L=0.28u W=0.72u nf=1 m=1
M16 net5 RB VSS VSS nfet_03v3 L=0.28u W=0.36u nf=1 m=1
M21 net3 net6 QA VDD pfet_03v3 L=0.28u W='0.36/0.36*0.36u' nf=1 m=1
M22 net3 RA QA VSS nfet_03v3 L=0.28u W='0.36/0.36*0.36u' nf=1 m=1
M23 net6 RA VDD VDD pfet_03v3 L=0.28u W=0.72u nf=1 m=1
M24 net6 RA VSS VSS nfet_03v3 L=0.28u W=0.36u nf=1 m=1
**** begin user architecture code

.param kQb=1

**** end user architecture code
.ends

* expanding   symbol:  engn1600-team1/CAD3/master_latch.sym # of pins=6
** sym_path: /foss/designs/engn1600-team1/CAD3/master_latch.sym
** sch_path: /foss/designs/engn1600-team1/CAD3/master_latch.sch
.subckt master_latch VDD VSS Q WEM WEMb D  kN=1
*.PININFO D:I WEMb:I WEM:I VSS:B VDD:B Q:O
M3 net1 WEMb net2 VDD pfet_03v3 L=0.28u W=0.36u nf=1 m=1
M7 net1 D VDD VDD pfet_03v3 L=0.28u W=0.72u nf=1 m=1
M8 Q net2 VDD VDD pfet_03v3 L=0.28u W='1.24/0.36*0.72u' nf=1 m=1
M9 net3 net2 VDD VDD pfet_03v3 L=0.28u W=0.36u nf=1 m=1
M10 VDD WEM net5 VDD pfet_03v3 L=0.28u W=0.36u nf=1 m=1
M12 net5 net3 net2 VDD pfet_03v3 L=0.28u W=0.36u nf=1 m=1
M19 net1 D VSS VSS nfet_03v3 L=0.28u W=0.36u nf=1 m=1
M20 net1 WEM net2 VSS nfet_03v3 L=0.28u W=0.36u nf=1 m=1
M21 Q net2 VSS VSS nfet_03v3 L=0.28u W='1.24/0.36*0.36u' nf=1 m=1
M22 net3 net2 VSS VSS nfet_03v3 L=0.28u W=0.36u nf=1 m=1
M23 net4 net3 net2 VSS nfet_03v3 L=0.28u W=0.36u nf=1 m=1
M24 VSS WEMb net4 VSS nfet_03v3 L=0.28u W=0.36u nf=1 m=1
**** begin user architecture code

.param kN=1

**** end user architecture code
.ends

* expanding   symbol:  engn1600-team1/CAD3/driver_cell.sym # of pins=6
** sym_path: /foss/designs/engn1600-team1/CAD3/driver_cell.sym
** sch_path: /foss/designs/engn1600-team1/CAD3/driver_cell.sch
.subckt driver_cell CLK WE WECLKb VDD VSS WECLK  kWECLK=1 kWECLKb=1
*.PININFO CLK:I WE:I VSS:B VDD:B WECLKb:O WECLK:O
M13 WECLK net1 VDD VDD pfet_03v3 L=0.28u W='1.27/0.36*0.72u' nf=1 m=1
M14 WECLK net1 VSS VSS nfet_03v3 L=0.28u W='1.27/0.36*0.36u' nf=1 m=1
M1 WECLKb WECLK VDD VDD pfet_03v3 L=0.28u W='1.34/0.36*0.72u' nf=1 m=1
M2 WECLKb WECLK VSS VSS nfet_03v3 L=0.28u W='1.34/0.36*0.36u' nf=1 m=1
M3 net1 CLK VDD VDD pfet_03v3 L=0.28u W=0.72u nf=1 m=1
M4 net1 WE VDD VDD pfet_03v3 L=0.28u W=0.72u nf=1 m=1
M5 net2 WE VSS VSS nfet_03v3 L=0.28u W=0.72u nf=1 m=1
M6 net1 CLK net2 VSS nfet_03v3 L=0.28u W=0.72u nf=1 m=1
**** begin user architecture code

.param kWECLKb=1
.param kWECLK=1

**** end user architecture code
.ends

* expanding   symbol:  engn1600-team1/CAD3/output_inverter.sym # of pins=6
** sym_path: /foss/designs/engn1600-team1/CAD3/output_inverter.sym
** sch_path: /foss/designs/engn1600-team1/CAD3/output_inverter.sch
.subckt output_inverter VDD VSS QAb QA QB QBb
*.PININFO QBb:O QAb:O VDD:B VSS:B QA:I QB:I
M3 QBb QB VDD VDD pfet_03v3 L=0.28u W=0.72u nf=1 m=1
M4 QBb QB VSS VSS nfet_03v3 L=0.28u W=0.36u nf=1 m=1
M35 QAb QA VDD VDD pfet_03v3 L=0.28u W=0.72u nf=1 m=1
M36 QAb QA VSS VSS nfet_03v3 L=0.28u W=0.36u nf=1 m=1
.ends

* expanding   symbol:  engn1600-team1/CAD3/wem_inverter.sym # of pins=4
** sym_path: /foss/designs/engn1600-team1/CAD3/wem_inverter.sym
** sch_path: /foss/designs/engn1600-team1/CAD3/wem_inverter.sch
.subckt wem_inverter VDD WEM WEMb VSS  kWEMb=1
*.PININFO WEM:I WEMb:O VDD:B VSS:B
M1 WEMb WEM VDD VDD pfet_03v3 L=0.28u W='1.26/0.36*0.72u' nf=1 m=1
M2 WEMb WEM VSS VSS nfet_03v3 L=0.28u W='1.26/0.36*0.36u' nf=1 m=1
**** begin user architecture code

.param kWEMb=1

**** end user architecture code
.ends
