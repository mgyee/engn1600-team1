* Extracted by KLayout with GF180MCU LVS runset on : 25/02/2026 08:02

.SUBCKT master_latch VSS WEM Q D WEMb VDD
M$1 \$3 D VDD VDD pfet_03v3 L=0.28U W=0.72U AS=0.3168P AD=0.2097P PS=2.32U
+ PD=1.38U
M$2 \$5 WEMb \$3 VDD pfet_03v3 L=0.28U W=0.36U AS=0.2097P AD=0.1278P PS=1.38U
+ PD=1.07U
M$3 \$18 \$11 \$5 VDD pfet_03v3 L=0.28U W=0.36U AS=0.1278P AD=0.0567P PS=1.07U
+ PD=0.675U
M$4 VDD WEM \$18 VDD pfet_03v3 L=0.28U W=0.36U AS=0.0567P AD=0.1584P PS=0.675U
+ PD=1.6U
M$5 VDD \$5 \$11 VDD pfet_03v3 L=0.28U W=0.36U AS=0.1584P AD=0.2196P PS=1.6U
+ PD=1.94U
M$6 Q \$5 VDD VDD pfet_03v3 L=0.28U W=2.48U AS=1.054P AD=1.1284P PS=5.42U
+ PD=5.54U
M$8 \$3 D VSS VSS nfet_03v3 L=0.28U W=0.36U AS=0.1584P AD=0.1188P PS=1.6U
+ PD=1.02U
M$9 \$5 WEM \$3 VSS nfet_03v3 L=0.28U W=0.36U AS=0.1188P AD=0.1278P PS=1.02U
+ PD=1.07U
M$10 \$9 \$11 \$5 VSS nfet_03v3 L=0.28U W=0.36U AS=0.1278P AD=0.0567P PS=1.07U
+ PD=0.675U
M$11 VSS WEMb \$9 VSS nfet_03v3 L=0.28U W=0.36U AS=0.0567P AD=0.1584P PS=0.675U
+ PD=1.6U
M$12 VSS \$5 \$11 VSS nfet_03v3 L=0.28U W=0.36U AS=0.1584P AD=0.2196P PS=1.6U
+ PD=1.94U
M$13 Q \$5 VSS VSS nfet_03v3 L=0.28U W=1.24U AS=0.527P AD=0.5642P PS=3.56U
+ PD=3.68U
.ENDS master_latch
