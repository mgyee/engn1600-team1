* Extracted by KLayout with GF180MCU LVS runset on : 23/02/2026 17:16

.SUBCKT master_latch VSS Q WEMb D WEM VDD
M$1 \$2 D VDD \$10 pfet_03v3 L=0.28U W=0.72U AS=0.4968P AD=0.3825P PS=2.82U
+ PD=1.895U
M$2 \$7 WEMb \$2 \$10 pfet_03v3 L=0.28U W=0.36U AS=0.3825P AD=0.3204P PS=1.895U
+ PD=2.5U
M$3 \$11 \$13 \$3 \$10 pfet_03v3 L=0.28U W=0.36U AS=0.1944P AD=0.1017P PS=1.8U
+ PD=0.925U
M$4 VDD WEM \$11 \$10 pfet_03v3 L=0.28U W=0.36U AS=0.1017P AD=0.4734P PS=0.925U
+ PD=3.35U
M$5 \$3 \$7 VDD \$10 pfet_03v3 L=0.28U W=0.36U AS=0.2835P AD=0.3474P PS=1.885U
+ PD=2.65U
M$6 Q \$7 VDD \$10 pfet_03v3 L=0.28U W=0.72U AS=0.2835P AD=0.4644P PS=1.885U
+ PD=2.73U
M$7 \$2 D VSS VSS nfet_03v3 L=0.28U W=0.36U AS=0.2502P AD=0.2124P PS=2.11U
+ PD=1.54U
M$8 \$7 WEM \$2 VSS nfet_03v3 L=0.28U W=0.36U AS=0.2124P AD=0.3186P PS=1.54U
+ PD=2.49U
M$9 \$12 \$13 \$3 VSS nfet_03v3 L=0.28U W=0.36U AS=0.1944P AD=0.1035P PS=1.8U
+ PD=0.935U
M$10 VSS WEMb \$12 VSS nfet_03v3 L=0.28U W=0.36U AS=0.1035P AD=0.4698P
+ PS=0.935U PD=3.33U
M$11 VSS \$7 \$3 VSS nfet_03v3 L=0.28U W=0.36U AS=0.3474P AD=0.2097P PS=2.65U
+ PD=1.525U
M$12 Q \$7 VSS VSS nfet_03v3 L=0.28U W=0.36U AS=0.2097P AD=0.2322P PS=1.525U
+ PD=2.01U
.ENDS master_latch
