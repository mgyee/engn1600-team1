* Extracted by KLayout with GF180MCU LVS runset on : 23/02/2026 23:11

.SUBCKT master_latch VSS WEM D VDD WEMb Q
M$1 \$7 D VDD VDD pfet_03v3 L=0.28U W=0.72U AS=0.4968P AD=0.3825P PS=2.82U
+ PD=1.895U
M$2 \$3 WEMb \$7 VDD pfet_03v3 L=0.28U W=0.36U AS=0.3825P AD=0.3906P PS=1.895U
+ PD=2.53U
M$3 \$15 \$13 \$3 VDD pfet_03v3 L=0.28U W=0.36U AS=0.3906P AD=0.1017P PS=2.53U
+ PD=0.925U
M$4 VDD WEM \$15 VDD pfet_03v3 L=0.28U W=0.36U AS=0.1017P AD=0.4734P PS=0.925U
+ PD=3.35U
M$5 \$13 \$3 VDD VDD pfet_03v3 L=0.28U W=0.36U AS=0.2835P AD=0.3474P PS=1.885U
+ PD=2.65U
M$6 Q \$3 VDD VDD pfet_03v3 L=0.28U W=0.72U AS=0.2835P AD=0.4644P PS=1.885U
+ PD=2.73U
M$7 \$7 D VSS VSS nfet_03v3 L=0.28U W=0.36U AS=0.2502P AD=0.2124P PS=2.11U
+ PD=1.54U
M$8 \$3 WEM \$7 VSS nfet_03v3 L=0.28U W=0.36U AS=0.2124P AD=0.3897P PS=1.54U
+ PD=2.525U
M$9 \$11 \$13 \$3 VSS nfet_03v3 L=0.28U W=0.36U AS=0.3897P AD=0.1035P PS=2.525U
+ PD=0.935U
M$10 VSS WEMb \$11 VSS nfet_03v3 L=0.28U W=0.36U AS=0.1035P AD=0.4698P
+ PS=0.935U PD=3.33U
M$11 VSS \$3 \$13 VSS nfet_03v3 L=0.28U W=0.36U AS=0.3474P AD=0.2097P PS=2.65U
+ PD=1.525U
M$12 Q \$3 VSS VSS nfet_03v3 L=0.28U W=0.36U AS=0.2097P AD=0.2322P PS=1.525U
+ PD=2.01U
.ENDS master_latch
