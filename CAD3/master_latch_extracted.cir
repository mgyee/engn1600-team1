* Extracted by KLayout with GF180MCU LVS runset on : 25/02/2026 22:50

.SUBCKT master_latch VSS WEM Q D WEMb VDD
M$1 \$2 D VDD VDD pfet_03v3 L=0.28U W=0.72U AS=0.3168P AD=0.2097P PS=2.32U
+ PD=1.38U
M$2 \$4 WEMb \$2 VDD pfet_03v3 L=0.28U W=0.36U AS=0.2097P AD=0.1278P PS=1.38U
+ PD=1.07U
M$3 \$16 \$11 \$4 VDD pfet_03v3 L=0.28U W=0.36U AS=0.1278P AD=0.0567P PS=1.07U
+ PD=0.675U
M$4 VDD WEM \$16 VDD pfet_03v3 L=0.28U W=0.36U AS=0.0567P AD=0.1584P PS=0.675U
+ PD=1.6U
M$5 VDD \$4 \$11 VDD pfet_03v3 L=0.28U W=0.36U AS=0.1584P AD=0.1584P PS=1.6U
+ PD=1.6U
M$6 Q \$4 VDD VDD pfet_03v3 L=0.28U W=2.48U AS=0.868P AD=0.868P PS=5.12U
+ PD=5.12U
M$8 \$2 D VSS VSS nfet_03v3 L=0.28U W=0.36U AS=0.1584P AD=0.1188P PS=1.6U
+ PD=1.02U
M$9 \$4 WEM \$2 VSS nfet_03v3 L=0.28U W=0.36U AS=0.1188P AD=0.1278P PS=1.02U
+ PD=1.07U
M$10 \$8 \$11 \$4 VSS nfet_03v3 L=0.28U W=0.36U AS=0.1278P AD=0.0567P PS=1.07U
+ PD=0.675U
M$11 VSS WEMb \$8 VSS nfet_03v3 L=0.28U W=0.36U AS=0.0567P AD=0.1584P PS=0.675U
+ PD=1.6U
M$12 VSS \$4 \$11 VSS nfet_03v3 L=0.28U W=0.36U AS=0.1584P AD=0.1584P PS=1.6U
+ PD=1.6U
M$13 Q \$4 VSS VSS nfet_03v3 L=0.28U W=1.24U AS=0.434P AD=0.434P PS=3.26U
+ PD=3.26U
.ENDS master_latch
