** sch_path: /foss/designs/engn1600-team1/CAD3/output_inverter.sch
.subckt output_inverter VDD VSS QAb QA QB QBb
*.PININFO QBb:O QAb:O VDD:B VSS:B QA:I QB:I
M3 QBb QB VDD VDD pfet_03v3 L=0.28u W=0.72u nf=1 m=1
M4 QBb QB VSS VSS nfet_03v3 L=0.28u W=0.36u nf=1 m=1
M35 QAb QA VDD VDD pfet_03v3 L=0.28u W=0.72u nf=1 m=1
M36 QAb QA VSS VSS nfet_03v3 L=0.28u W=0.36u nf=1 m=1
.ends
