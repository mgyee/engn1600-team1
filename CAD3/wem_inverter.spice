** sch_path: /foss/designs/engn1600-team1/CAD3/wem_inverter.sch
.subckt wem_inverter VDD WEM WEMb VSS
*.PININFO WEM:I WEMb:O VDD:B VSS:B
M1 WEMb WEM VDD VDD pfet_03v3 L=0.28u W='kWEMb*0.72u' nf=1 m=1
M2 WEMb WEM VSS VSS nfet_03v3 L=0.28u W='kWEMb*0.36u' nf=1 m=1
**** begin user architecture code

.param kWEMb=1

**** end user architecture code
.ends
